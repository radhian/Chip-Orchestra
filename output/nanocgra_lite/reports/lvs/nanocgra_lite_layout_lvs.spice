* NGSPICE file created from NanoCGRA_Lite.ext - technology: gf180mcuD

.subckt gf180mcu_fd_sc_mcu7t5v0__clkinv_1 I ZN VDD VNW VPW VSS
X0 ZN I VSS VPW nfet_05v0 ad=0.2112p pd=1.84u as=0.2112p ps=1.84u w=0.48u l=0.6u
X1 ZN I VDD VNW pfet_05v0 ad=0.5368p pd=3.32u as=0.5368p ps=3.32u w=1.22u l=0.5u
.ends

.subckt gf180mcu_fd_sc_mcu7t5v0__oai22_1 A1 A2 B1 B2 ZN VDD VNW VPW VSS
X0 ZN A1 a_36_68# VPW nfet_05v0 ad=0.2132p pd=1.34u as=0.2132p ps=1.34u w=0.82u l=0.6u
X1 VSS B2 a_36_68# VPW nfet_05v0 ad=0.2132p pd=1.34u as=0.3608p ps=2.52u w=0.82u l=0.6u
X2 a_244_472# B2 VDD VNW pfet_05v0 ad=0.3782p pd=1.84u as=0.6588p ps=3.52u w=1.22u l=0.5u
X3 a_692_472# A1 ZN VNW pfet_05v0 ad=0.3172p pd=1.74u as=0.3782p ps=1.84u w=1.22u l=0.5u
X4 VDD A2 a_692_472# VNW pfet_05v0 ad=0.5368p pd=3.32u as=0.3172p ps=1.74u w=1.22u l=0.5u
X5 a_36_68# A2 ZN VPW nfet_05v0 ad=0.3608p pd=2.52u as=0.2132p ps=1.34u w=0.82u l=0.6u
X6 a_36_68# B1 VSS VPW nfet_05v0 ad=0.2132p pd=1.34u as=0.2132p ps=1.34u w=0.82u l=0.6u
X7 ZN B1 a_244_472# VNW pfet_05v0 ad=0.3782p pd=1.84u as=0.3782p ps=1.84u w=1.22u l=0.5u
.ends

.subckt gf180mcu_fd_sc_mcu7t5v0__nand2_1 A1 A2 ZN VDD VNW VPW VSS
X0 ZN A2 VDD VNW pfet_05v0 ad=0.2938p pd=1.65u as=0.4972p ps=3.14u w=1.13u l=0.5u
X1 ZN A1 a_245_68# VPW nfet_05v0 ad=0.3608p pd=2.52u as=0.1312p ps=1.14u w=0.82u l=0.6u
X2 VDD A1 ZN VNW pfet_05v0 ad=0.4972p pd=3.14u as=0.2938p ps=1.65u w=1.13u l=0.5u
X3 a_245_68# A2 VSS VPW nfet_05v0 ad=0.1312p pd=1.14u as=0.3608p ps=2.52u w=0.82u l=0.6u
.ends

.subckt gf180mcu_fd_sc_mcu7t5v0__aoi22_1 A1 A2 B1 B2 ZN VDD VNW VPW VSS
X0 ZN B1 a_257_69# VPW nfet_05v0 ad=0.2119p pd=1.335u as=0.1304p ps=1.135u w=0.815u l=0.6u
X1 VDD B2 a_49_472# VNW pfet_05v0 ad=0.3159p pd=1.735u as=0.5346p ps=3.31u w=1.215u l=0.5u
X2 a_49_472# B1 VDD VNW pfet_05v0 ad=0.3159p pd=1.735u as=0.3159p ps=1.735u w=1.215u l=0.5u
X3 ZN A1 a_49_472# VNW pfet_05v0 ad=0.3159p pd=1.735u as=0.3159p ps=1.735u w=1.215u l=0.5u
X4 a_49_472# A2 ZN VNW pfet_05v0 ad=0.5346p pd=3.31u as=0.3159p ps=1.735u w=1.215u l=0.5u
X5 a_257_69# B2 VSS VPW nfet_05v0 ad=0.1304p pd=1.135u as=0.3586p ps=2.51u w=0.815u l=0.6u
X6 a_665_69# A1 ZN VPW nfet_05v0 ad=0.1304p pd=1.135u as=0.2119p ps=1.335u w=0.815u l=0.6u
X7 VSS A2 a_665_69# VPW nfet_05v0 ad=0.3586p pd=2.51u as=0.1304p ps=1.135u w=0.815u l=0.6u
.ends

.subckt gf180mcu_fd_sc_mcu7t5v0__xnor3_1 A1 A2 A3 ZN VDD VNW VPW VSS
X0 a_952_93# A1 a_728_93# VPW nfet_05v0 ad=57.599995f pd=0.68u as=93.59999f ps=0.88u w=0.36u l=0.6u
X1 a_244_567# A2 a_56_567# VNW pfet_05v0 ad=0.1026p pd=0.93u as=0.1584p ps=1.6u w=0.36u l=0.5u
X2 a_728_93# A1 a_718_527# VNW pfet_05v0 ad=0.1456p pd=1.08u as=0.1596p ps=1.13u w=0.56u l=0.5u
X3 ZN A3 a_1948_68# VPW nfet_05v0 ad=0.4161p pd=1.905u as=0.2132p ps=1.34u w=0.82u l=0.6u
X4 ZN a_1296_93# VDD VNW pfet_05v0 ad=0.33945p pd=1.715u as=0.352075p ps=1.895u w=1.095u l=0.5u
X5 VDD a_728_93# a_2172_497# VNW pfet_05v0 ad=0.4818p pd=3.07u as=0.5256p ps=2.055u w=1.095u l=0.5u
X6 a_718_527# a_56_567# VDD VNW pfet_05v0 ad=0.1596p pd=1.13u as=0.184p ps=1.36u w=0.56u l=0.5u
X7 a_718_527# A2 a_728_93# VNW pfet_05v0 ad=0.2464p pd=2u as=0.1456p ps=1.08u w=0.56u l=0.5u
X8 VSS A1 a_56_567# VPW nfet_05v0 ad=0.126p pd=1.06u as=93.59999f ps=0.88u w=0.36u l=0.6u
X9 VSS A3 a_1504_93# VPW nfet_05v0 ad=0.218p pd=1.52u as=57.599995f ps=0.68u w=0.36u l=0.6u
X10 a_1948_68# a_728_93# ZN VPW nfet_05v0 ad=0.3608p pd=2.52u as=0.4161p ps=1.905u w=0.82u l=0.6u
X11 a_2172_497# A3 ZN VNW pfet_05v0 ad=0.5256p pd=2.055u as=0.33945p ps=1.715u w=1.095u l=0.5u
X12 a_1504_93# a_728_93# a_1296_93# VPW nfet_05v0 ad=57.599995f pd=0.68u as=0.1584p ps=1.6u w=0.36u l=0.6u
X13 a_56_567# A2 VSS VPW nfet_05v0 ad=93.59999f pd=0.88u as=0.1584p ps=1.6u w=0.36u l=0.6u
X14 a_1948_68# a_1296_93# VSS VPW nfet_05v0 ad=0.2132p pd=1.34u as=0.218p ps=1.52u w=0.82u l=0.6u
X15 a_1296_93# a_728_93# VDD VNW pfet_05v0 ad=0.1456p pd=1.08u as=0.2464p ps=2u w=0.56u l=0.5u
X16 a_728_93# a_56_567# VSS VPW nfet_05v0 ad=93.59999f pd=0.88u as=0.126p ps=1.06u w=0.36u l=0.6u
X17 VDD A3 a_1296_93# VNW pfet_05v0 ad=0.352075p pd=1.895u as=0.1456p ps=1.08u w=0.56u l=0.5u
X18 VDD A1 a_244_567# VNW pfet_05v0 ad=0.184p pd=1.36u as=0.1026p ps=0.93u w=0.36u l=0.5u
X19 VSS A2 a_952_93# VPW nfet_05v0 ad=0.1584p pd=1.6u as=57.599995f ps=0.68u w=0.36u l=0.6u
.ends

.subckt gf180mcu_fd_sc_mcu7t5v0__and2_1 A1 A2 Z VDD VNW VPW VSS
X0 VDD A2 a_36_159# VNW pfet_05v0 ad=0.40575p pd=2.055u as=0.156p ps=1.12u w=0.6u l=0.5u
X1 Z a_36_159# VDD VNW pfet_05v0 ad=0.5346p pd=3.31u as=0.40575p ps=2.055u w=1.215u l=0.5u
X2 Z a_36_159# VSS VPW nfet_05v0 ad=0.3586p pd=2.51u as=0.23405p ps=1.555u w=0.815u l=0.6u
X3 VSS A2 a_244_159# VPW nfet_05v0 ad=0.23405p pd=1.555u as=58.399994f ps=0.685u w=0.365u l=0.6u
X4 a_244_159# A1 a_36_159# VPW nfet_05v0 ad=58.399994f pd=0.685u as=0.1606p ps=1.61u w=0.365u l=0.6u
X5 a_36_159# A1 VDD VNW pfet_05v0 ad=0.156p pd=1.12u as=0.264p ps=2.08u w=0.6u l=0.5u
.ends

.subckt gf180mcu_fd_sc_mcu7t5v0__oai21_1 A1 A2 B ZN VDD VNW VPW VSS
X0 VSS B a_36_68# VPW nfet_05v0 ad=0.3608p pd=2.52u as=0.2132p ps=1.34u w=0.82u l=0.6u
X1 ZN A2 a_36_68# VPW nfet_05v0 ad=0.2132p pd=1.34u as=0.3608p ps=2.52u w=0.82u l=0.6u
X2 VDD B ZN VNW pfet_05v0 ad=0.4972p pd=3.14u as=0.4248p ps=1.94u w=1.13u l=0.5u
X3 a_244_472# A2 VDD VNW pfet_05v0 ad=0.3172p pd=1.74u as=0.5978p ps=3.42u w=1.22u l=0.5u
X4 ZN A1 a_244_472# VNW pfet_05v0 ad=0.4248p pd=1.94u as=0.3172p ps=1.74u w=1.22u l=0.5u
X5 a_36_68# A1 ZN VPW nfet_05v0 ad=0.2132p pd=1.34u as=0.2132p ps=1.34u w=0.82u l=0.6u
.ends

.subckt gf180mcu_fd_sc_mcu7t5v0__nor2_1 A1 A2 ZN VDD VNW VPW VSS
X0 ZN A1 a_224_472# VNW pfet_05v0 ad=0.5368p pd=3.32u as=0.4087p ps=1.89u w=1.22u l=0.5u
X1 VSS A1 ZN VPW nfet_05v0 ad=0.2486p pd=2.01u as=0.1469p ps=1.085u w=0.565u l=0.6u
X2 a_224_472# A2 VDD VNW pfet_05v0 ad=0.4087p pd=1.89u as=0.5368p ps=3.32u w=1.22u l=0.5u
X3 ZN A2 VSS VPW nfet_05v0 ad=0.1469p pd=1.085u as=0.2486p ps=2.01u w=0.565u l=0.6u
.ends

.subckt gf180mcu_fd_sc_mcu7t5v0__nand2_2 A1 A2 ZN VDD VNW VPW VSS
X0 a_244_68# A2 VSS VPW nfet_05v0 ad=0.1312p pd=1.14u as=0.3608p ps=2.52u w=0.82u l=0.6u
X1 ZN A1 a_244_68# VPW nfet_05v0 ad=0.2132p pd=1.34u as=0.1312p ps=1.14u w=0.82u l=0.6u
X2 ZN A2 VDD VNW pfet_05v0 ad=0.2938p pd=1.65u as=0.4972p ps=3.14u w=1.13u l=0.5u
X3 VDD A1 ZN VNW pfet_05v0 ad=0.2938p pd=1.65u as=0.2938p ps=1.65u w=1.13u l=0.5u
X4 a_652_68# A1 ZN VPW nfet_05v0 ad=0.1312p pd=1.14u as=0.2132p ps=1.34u w=0.82u l=0.6u
X5 VSS A2 a_652_68# VPW nfet_05v0 ad=0.3608p pd=2.52u as=0.1312p ps=1.14u w=0.82u l=0.6u
X6 ZN A1 VDD VNW pfet_05v0 ad=0.2938p pd=1.65u as=0.2938p ps=1.65u w=1.13u l=0.5u
X7 VDD A2 ZN VNW pfet_05v0 ad=0.4972p pd=3.14u as=0.2938p ps=1.65u w=1.13u l=0.5u
.ends

.subckt gf180mcu_fd_sc_mcu7t5v0__dffq_1 D CLK Q VDD VNW VPW VSS
X0 VSS CLK a_36_151# VPW nfet_05v0 ad=0.1053p pd=0.925u as=0.1782p ps=1.69u w=0.405u l=0.6u
X1 Q a_2304_115# VSS VPW nfet_05v0 ad=0.3608p pd=2.52u as=0.3608p ps=2.52u w=0.82u l=0.6u
X2 a_2304_115# a_2011_527# VSS VPW nfet_05v0 ad=0.176p pd=1.68u as=0.142p ps=1.14u w=0.4u l=0.6u
X3 a_1004_159# D a_836_159# VPW nfet_05v0 ad=0.207p pd=1.51u as=43.199997f ps=0.6u w=0.36u l=0.6u
X4 a_1004_159# D a_880_527# VNW pfet_05v0 ad=0.1872p pd=1.4u as=53.999996f ps=0.66u w=0.36u l=0.5u
X5 a_2011_527# a_36_151# a_1376_115# VNW pfet_05v0 ad=0.1665p pd=1.285u as=0.1791p ps=1.355u w=0.36u l=0.5u
X6 a_2296_527# a_448_472# a_2011_527# VNW pfet_05v0 ad=50.399998f pd=0.64u as=0.1665p ps=1.285u w=0.36u l=0.5u
X7 a_1376_115# a_1004_159# VDD VNW pfet_05v0 ad=0.1791p pd=1.355u as=0.1044p ps=0.94u w=0.36u l=0.5u
X8 VDD CLK a_36_151# VNW pfet_05v0 ad=0.2249p pd=1.385u as=0.3806p ps=2.61u w=0.865u l=0.5u
X9 VSS a_1376_115# a_1328_159# VPW nfet_05v0 ad=0.2637p pd=1.825u as=43.199997f ps=0.6u w=0.36u l=0.6u
X10 a_2011_527# a_448_472# a_1376_115# VPW nfet_05v0 ad=93.59999f pd=0.88u as=93.59999f ps=0.88u w=0.36u l=0.6u
X11 a_448_472# a_36_151# VDD VNW pfet_05v0 ad=0.3806p pd=2.61u as=0.2249p ps=1.385u w=0.865u l=0.5u
X12 Q a_2304_115# VDD VNW pfet_05v0 ad=0.5368p pd=3.32u as=0.5368p ps=3.32u w=1.22u l=0.5u
X13 a_1376_115# a_1004_159# VSS VPW nfet_05v0 ad=93.59999f pd=0.88u as=0.2637p ps=1.825u w=0.36u l=0.6u
X14 VSS a_2304_115# a_2256_159# VPW nfet_05v0 ad=0.142p pd=1.14u as=43.199997f ps=0.6u w=0.36u l=0.6u
X15 a_836_159# a_36_151# VSS VPW nfet_05v0 ad=43.199997f pd=0.6u as=0.1584p ps=1.6u w=0.36u l=0.6u
X16 a_448_472# a_36_151# VSS VPW nfet_05v0 ad=0.1782p pd=1.69u as=0.1053p ps=0.925u w=0.405u l=0.6u
X17 a_2256_159# a_36_151# a_2011_527# VPW nfet_05v0 ad=43.199997f pd=0.6u as=93.59999f ps=0.88u w=0.36u l=0.6u
X18 a_880_527# a_448_472# VDD VNW pfet_05v0 ad=53.999996f pd=0.66u as=0.4554p ps=3.25u w=0.36u l=0.5u
X19 a_1348_527# a_36_151# a_1004_159# VNW pfet_05v0 ad=43.199997f pd=0.6u as=0.1872p ps=1.4u w=0.36u l=0.5u
X20 a_1328_159# a_448_472# a_1004_159# VPW nfet_05v0 ad=43.199997f pd=0.6u as=0.207p ps=1.51u w=0.36u l=0.6u
X21 VDD a_1376_115# a_1348_527# VNW pfet_05v0 ad=0.1044p pd=0.94u as=43.199997f ps=0.6u w=0.36u l=0.5u
X22 VDD a_2304_115# a_2296_527# VNW pfet_05v0 ad=0.23p pd=1.54u as=50.399998f ps=0.64u w=0.36u l=0.5u
X23 a_2304_115# a_2011_527# VDD VNW pfet_05v0 ad=0.352p pd=2.48u as=0.23p ps=1.54u w=0.8u l=0.5u
.ends

.subckt gf180mcu_fd_sc_mcu7t5v0__buf_8 I Z VDD VNW VPW VSS
X0 a_224_472# I VDD VNW pfet_05v0 ad=0.3782p pd=1.84u as=0.3782p ps=1.84u w=1.22u l=0.5u
X1 Z a_224_472# VDD VNW pfet_05v0 ad=0.3782p pd=1.84u as=0.3782p ps=1.84u w=1.22u l=0.5u
X2 a_224_472# I VSS VPW nfet_05v0 ad=0.2132p pd=1.34u as=0.2132p ps=1.34u w=0.82u l=0.6u
X3 VSS a_224_472# Z VPW nfet_05v0 ad=0.3608p pd=2.52u as=0.2132p ps=1.34u w=0.82u l=0.6u
X4 VDD a_224_472# Z VNW pfet_05v0 ad=0.3782p pd=1.84u as=0.3782p ps=1.84u w=1.22u l=0.5u
X5 Z a_224_472# VDD VNW pfet_05v0 ad=0.3782p pd=1.84u as=0.3782p ps=1.84u w=1.22u l=0.5u
X6 a_224_472# I VSS VPW nfet_05v0 ad=0.2132p pd=1.34u as=0.3608p ps=2.52u w=0.82u l=0.6u
X7 Z a_224_472# VSS VPW nfet_05v0 ad=0.2132p pd=1.34u as=0.2132p ps=1.34u w=0.82u l=0.6u
X8 VDD a_224_472# Z VNW pfet_05v0 ad=0.3782p pd=1.84u as=0.3782p ps=1.84u w=1.22u l=0.5u
X9 Z a_224_472# VSS VPW nfet_05v0 ad=0.2132p pd=1.34u as=0.2132p ps=1.34u w=0.82u l=0.6u
X10 Z a_224_472# VSS VPW nfet_05v0 ad=0.2132p pd=1.34u as=0.2132p ps=1.34u w=0.82u l=0.6u
X11 VDD I a_224_472# VNW pfet_05v0 ad=0.3782p pd=1.84u as=0.3782p ps=1.84u w=1.22u l=0.5u
X12 VDD a_224_472# Z VNW pfet_05v0 ad=0.3782p pd=1.84u as=0.3782p ps=1.84u w=1.22u l=0.5u
X13 Z a_224_472# VDD VNW pfet_05v0 ad=0.3782p pd=1.84u as=0.3782p ps=1.84u w=1.22u l=0.5u
X14 VSS a_224_472# Z VPW nfet_05v0 ad=0.2132p pd=1.34u as=0.2132p ps=1.34u w=0.82u l=0.6u
X15 VDD I a_224_472# VNW pfet_05v0 ad=0.3782p pd=1.84u as=0.3782p ps=1.84u w=1.22u l=0.5u
X16 VSS a_224_472# Z VPW nfet_05v0 ad=0.2132p pd=1.34u as=0.2132p ps=1.34u w=0.82u l=0.6u
X17 VDD a_224_472# Z VNW pfet_05v0 ad=0.5368p pd=3.32u as=0.3782p ps=1.84u w=1.22u l=0.5u
X18 VSS a_224_472# Z VPW nfet_05v0 ad=0.2132p pd=1.34u as=0.2132p ps=1.34u w=0.82u l=0.6u
X19 Z a_224_472# VDD VNW pfet_05v0 ad=0.3782p pd=1.84u as=0.3782p ps=1.84u w=1.22u l=0.5u
X20 VSS I a_224_472# VPW nfet_05v0 ad=0.2132p pd=1.34u as=0.2132p ps=1.34u w=0.82u l=0.6u
X21 a_224_472# I VDD VNW pfet_05v0 ad=0.3782p pd=1.84u as=0.5368p ps=3.32u w=1.22u l=0.5u
X22 VSS I a_224_472# VPW nfet_05v0 ad=0.2132p pd=1.34u as=0.2132p ps=1.34u w=0.82u l=0.6u
X23 Z a_224_472# VSS VPW nfet_05v0 ad=0.2132p pd=1.34u as=0.2132p ps=1.34u w=0.82u l=0.6u
.ends

.subckt gf180mcu_fd_sc_mcu7t5v0__and3_1 A1 A2 A3 Z VDD VNW VPW VSS
X0 Z a_36_148# VDD VNW pfet_05v0 ad=0.5346p pd=3.31u as=0.4268p ps=2.175u w=1.215u l=0.5u
X1 a_428_148# A2 a_244_148# VPW nfet_05v0 ad=79.799995f pd=0.8u as=60.8f ps=0.7u w=0.38u l=0.6u
X2 Z a_36_148# VSS VPW nfet_05v0 ad=0.341p pd=2.43u as=0.2424p ps=1.635u w=0.775u l=0.6u
X3 VSS A3 a_428_148# VPW nfet_05v0 ad=0.2424p pd=1.635u as=79.799995f ps=0.8u w=0.38u l=0.6u
X4 a_244_148# A1 a_36_148# VPW nfet_05v0 ad=60.8f pd=0.7u as=0.1672p ps=1.64u w=0.38u l=0.6u
X5 VDD A1 a_36_148# VNW pfet_05v0 ad=0.1391p pd=1.055u as=0.2354p ps=1.95u w=0.535u l=0.5u
X6 a_36_148# A2 VDD VNW pfet_05v0 ad=0.1391p pd=1.055u as=0.1391p ps=1.055u w=0.535u l=0.5u
X7 VDD A3 a_36_148# VNW pfet_05v0 ad=0.4268p pd=2.175u as=0.1391p ps=1.055u w=0.535u l=0.5u
.ends

.subckt gf180mcu_fd_sc_mcu7t5v0__and4_1 A1 A2 A3 A4 Z VDD VNW VPW VSS
X0 a_48_148# A1 VDD VNW pfet_05v0 ad=0.156p pd=1.12u as=0.264p ps=2.08u w=0.6u l=0.5u
X1 a_440_148# A2 a_256_148# VPW nfet_05v0 ad=88.2f pd=0.84u as=67.2f ps=0.74u w=0.42u l=0.6u
X2 Z a_48_148# VSS VPW nfet_05v0 ad=0.3586p pd=2.51u as=0.226p ps=1.515u w=0.815u l=0.6u
X3 VDD A2 a_48_148# VNW pfet_05v0 ad=0.156p pd=1.12u as=0.156p ps=1.12u w=0.6u l=0.5u
X4 Z a_48_148# VDD VNW pfet_05v0 ad=0.5368p pd=3.32u as=0.395p ps=2.02u w=1.22u l=0.5u
X5 a_644_148# A3 a_440_148# VPW nfet_05v0 ad=88.2f pd=0.84u as=88.2f ps=0.84u w=0.42u l=0.6u
X6 a_48_148# A3 VDD VNW pfet_05v0 ad=0.156p pd=1.12u as=0.156p ps=1.12u w=0.6u l=0.5u
X7 VSS A4 a_644_148# VPW nfet_05v0 ad=0.226p pd=1.515u as=88.2f ps=0.84u w=0.42u l=0.6u
X8 VDD A4 a_48_148# VNW pfet_05v0 ad=0.395p pd=2.02u as=0.156p ps=1.12u w=0.6u l=0.5u
X9 a_256_148# A1 a_48_148# VPW nfet_05v0 ad=67.2f pd=0.74u as=0.1848p ps=1.72u w=0.42u l=0.6u
.ends

.subckt gf180mcu_fd_sc_mcu7t5v0__mux2_4 I0 I1 S Z VDD VNW VPW VSS
X0 VSS a_135_24# Z VPW nfet_05v0 ad=0.2132p pd=1.34u as=0.2132p ps=1.34u w=0.82u l=0.6u
X1 a_1151_68# I1 VSS VPW nfet_05v0 ad=98.399994f pd=1.06u as=0.2132p ps=1.34u w=0.82u l=0.6u
X2 VDD a_135_24# Z VNW pfet_05v0 ad=0.3782p pd=1.84u as=0.3782p ps=1.84u w=1.22u l=0.5u
X3 VSS I0 a_1543_68# VPW nfet_05v0 ad=0.2132p pd=1.34u as=0.1968p ps=1.3u w=0.82u l=0.6u
X4 Z a_135_24# VSS VPW nfet_05v0 ad=0.2132p pd=1.34u as=0.2132p ps=1.34u w=0.82u l=0.6u
X5 Z a_135_24# VSS VPW nfet_05v0 ad=0.2132p pd=1.34u as=0.3608p ps=2.52u w=0.82u l=0.6u
X6 a_135_24# a_1307_380# a_1151_472# VNW pfet_05v0 ad=0.3172p pd=1.74u as=0.4758p ps=2u w=1.22u l=0.5u
X7 a_1307_380# S VSS VPW nfet_05v0 ad=0.3608p pd=2.52u as=0.2132p ps=1.34u w=0.82u l=0.6u
X8 a_1611_472# S a_135_24# VNW pfet_05v0 ad=0.1464p pd=1.46u as=0.3172p ps=1.74u w=1.22u l=0.5u
X9 Z a_135_24# VDD VNW pfet_05v0 ad=0.3782p pd=1.84u as=0.5368p ps=3.32u w=1.22u l=0.5u
X10 VDD I0 a_1611_472# VNW pfet_05v0 ad=0.3172p pd=1.74u as=0.1464p ps=1.46u w=1.22u l=0.5u
X11 a_135_24# S a_1151_68# VPW nfet_05v0 ad=0.2132p pd=1.34u as=98.399994f ps=1.06u w=0.82u l=0.6u
X12 a_1307_380# S VDD VNW pfet_05v0 ad=0.5368p pd=3.32u as=0.3172p ps=1.74u w=1.22u l=0.5u
X13 Z a_135_24# VDD VNW pfet_05v0 ad=0.3477p pd=1.79u as=0.3782p ps=1.84u w=1.22u l=0.5u
X14 a_1543_68# a_1307_380# a_135_24# VPW nfet_05v0 ad=0.1968p pd=1.3u as=0.2132p ps=1.34u w=0.82u l=0.6u
X15 VDD a_135_24# Z VNW pfet_05v0 ad=0.4392p pd=1.94u as=0.3477p ps=1.79u w=1.22u l=0.5u
X16 VSS a_135_24# Z VPW nfet_05v0 ad=0.2132p pd=1.34u as=0.2132p ps=1.34u w=0.82u l=0.6u
X17 a_1151_472# I1 VDD VNW pfet_05v0 ad=0.4758p pd=2u as=0.4392p ps=1.94u w=1.22u l=0.5u
.ends

.subckt gf180mcu_fd_sc_mcu7t5v0__nor2_2 A1 A2 ZN VDD VNW VPW VSS
X0 a_672_472# A1 ZN VNW pfet_05v0 ad=0.4087p pd=1.89u as=0.3477p ps=1.79u w=1.22u l=0.5u
X1 ZN A1 VSS VPW nfet_05v0 ad=0.1469p pd=1.085u as=0.1469p ps=1.085u w=0.565u l=0.6u
X2 ZN A1 a_234_472# VNW pfet_05v0 ad=0.3477p pd=1.79u as=0.3782p ps=1.84u w=1.22u l=0.5u
X3 VSS A1 ZN VPW nfet_05v0 ad=0.1469p pd=1.085u as=0.1469p ps=1.085u w=0.565u l=0.6u
X4 a_234_472# A2 VDD VNW pfet_05v0 ad=0.3782p pd=1.84u as=0.5368p ps=3.32u w=1.22u l=0.5u
X5 VDD A2 a_672_472# VNW pfet_05v0 ad=0.5368p pd=3.32u as=0.4087p ps=1.89u w=1.22u l=0.5u
X6 VSS A2 ZN VPW nfet_05v0 ad=0.2486p pd=2.01u as=0.1469p ps=1.085u w=0.565u l=0.6u
X7 ZN A2 VSS VPW nfet_05v0 ad=0.1469p pd=1.085u as=0.2486p ps=2.01u w=0.565u l=0.6u
.ends

.subckt gf180mcu_fd_sc_mcu7t5v0__oai22_2 A1 A2 B1 B2 ZN VDD VNW VPW VSS
X0 VDD A2 a_1612_497# VNW pfet_05v0 ad=0.4818p pd=3.07u as=0.4599p ps=1.935u w=1.095u l=0.5u
X1 ZN B1 a_244_497# VNW pfet_05v0 ad=0.2847p pd=1.615u as=0.33945p ps=1.715u w=1.095u l=0.5u
X2 a_672_497# B1 ZN VNW pfet_05v0 ad=0.33945p pd=1.715u as=0.2847p ps=1.615u w=1.095u l=0.5u
X3 a_1140_497# A2 VDD VNW pfet_05v0 ad=0.4599p pd=1.935u as=0.3942p ps=1.815u w=1.095u l=0.5u
X4 VSS B1 a_36_68# VPW nfet_05v0 ad=0.2132p pd=1.34u as=0.2132p ps=1.34u w=0.82u l=0.6u
X5 VSS B2 a_36_68# VPW nfet_05v0 ad=0.2132p pd=1.34u as=0.3608p ps=2.52u w=0.82u l=0.6u
X6 a_36_68# A2 ZN VPW nfet_05v0 ad=0.3608p pd=2.52u as=0.30965p ps=1.685u w=0.82u l=0.6u
X7 a_244_497# B2 VDD VNW pfet_05v0 ad=0.33945p pd=1.715u as=0.4818p ps=3.07u w=1.095u l=0.5u
X8 a_36_68# A1 ZN VPW nfet_05v0 ad=0.2132p pd=1.34u as=0.30965p ps=1.685u w=0.82u l=0.6u
X9 ZN A1 a_1140_497# VNW pfet_05v0 ad=0.2847p pd=1.615u as=0.4599p ps=1.935u w=1.095u l=0.5u
X10 VDD B2 a_672_497# VNW pfet_05v0 ad=0.3942p pd=1.815u as=0.33945p ps=1.715u w=1.095u l=0.5u
X11 a_1612_497# A1 ZN VNW pfet_05v0 ad=0.4599p pd=1.935u as=0.2847p ps=1.615u w=1.095u l=0.5u
X12 ZN A1 a_36_68# VPW nfet_05v0 ad=0.30965p pd=1.685u as=0.2132p ps=1.34u w=0.82u l=0.6u
X13 a_36_68# B2 VSS VPW nfet_05v0 ad=0.2132p pd=1.34u as=0.2132p ps=1.34u w=0.82u l=0.6u
X14 a_36_68# B1 VSS VPW nfet_05v0 ad=0.2132p pd=1.34u as=0.2132p ps=1.34u w=0.82u l=0.6u
X15 ZN A2 a_36_68# VPW nfet_05v0 ad=0.30965p pd=1.685u as=0.2132p ps=1.34u w=0.82u l=0.6u
.ends

.subckt gf180mcu_fd_sc_mcu7t5v0__nor2_4 A1 A2 ZN VDD VNW VPW VSS
X0 a_1140_472# A2 VDD VNW pfet_05v0 ad=0.3172p pd=1.74u as=0.4392p ps=1.94u w=1.22u l=0.5u
X1 ZN A1 VSS VPW nfet_05v0 ad=0.1469p pd=1.085u as=0.1469p ps=1.085u w=0.565u l=0.6u
X2 ZN A1 a_1140_472# VNW pfet_05v0 ad=0.4392p pd=1.94u as=0.3172p ps=1.74u w=1.22u l=0.5u
X3 ZN A2 VSS VPW nfet_05v0 ad=0.1469p pd=1.085u as=0.2486p ps=2.01u w=0.565u l=0.6u
X4 a_1588_472# A1 ZN VNW pfet_05v0 ad=0.3172p pd=1.74u as=0.4392p ps=1.94u w=1.22u l=0.5u
X5 VDD A2 a_1588_472# VNW pfet_05v0 ad=0.5978p pd=3.42u as=0.3172p ps=1.74u w=1.22u l=0.5u
X6 ZN A1 VSS VPW nfet_05v0 ad=0.1469p pd=1.085u as=0.1469p ps=1.085u w=0.565u l=0.6u
X7 a_244_472# A2 VDD VNW pfet_05v0 ad=0.3172p pd=1.74u as=0.5978p ps=3.42u w=1.22u l=0.5u
X8 ZN A1 a_244_472# VNW pfet_05v0 ad=0.4392p pd=1.94u as=0.3172p ps=1.74u w=1.22u l=0.5u
X9 a_692_472# A1 ZN VNW pfet_05v0 ad=0.3172p pd=1.74u as=0.4392p ps=1.94u w=1.22u l=0.5u
X10 VSS A2 ZN VPW nfet_05v0 ad=0.2486p pd=2.01u as=0.1469p ps=1.085u w=0.565u l=0.6u
X11 VDD A2 a_692_472# VNW pfet_05v0 ad=0.4392p pd=1.94u as=0.3172p ps=1.74u w=1.22u l=0.5u
X12 VSS A1 ZN VPW nfet_05v0 ad=0.1469p pd=1.085u as=0.1469p ps=1.085u w=0.565u l=0.6u
X13 VSS A2 ZN VPW nfet_05v0 ad=0.1469p pd=1.085u as=0.1469p ps=1.085u w=0.565u l=0.6u
X14 VSS A1 ZN VPW nfet_05v0 ad=0.1469p pd=1.085u as=0.1469p ps=1.085u w=0.565u l=0.6u
X15 ZN A2 VSS VPW nfet_05v0 ad=0.1469p pd=1.085u as=0.1469p ps=1.085u w=0.565u l=0.6u
.ends

.subckt gf180mcu_fd_sc_mcu7t5v0__dffq_2 D CLK Q VDD VNW VPW VSS
X0 VSS a_2304_115# Q VPW nfet_05v0 ad=0.3608p pd=2.52u as=0.2132p ps=1.34u w=0.82u l=0.6u
X1 VSS CLK a_36_151# VPW nfet_05v0 ad=0.1053p pd=0.925u as=0.1782p ps=1.69u w=0.405u l=0.6u
X2 Q a_2304_115# VSS VPW nfet_05v0 ad=0.2132p pd=1.34u as=0.3608p ps=2.52u w=0.82u l=0.6u
X3 a_2304_115# a_2011_527# VSS VPW nfet_05v0 ad=0.176p pd=1.68u as=0.142p ps=1.14u w=0.4u l=0.6u
X4 a_1004_159# D a_836_159# VPW nfet_05v0 ad=0.207p pd=1.51u as=43.199997f ps=0.6u w=0.36u l=0.6u
X5 a_1004_159# D a_880_527# VNW pfet_05v0 ad=0.1872p pd=1.4u as=53.999996f ps=0.66u w=0.36u l=0.5u
X6 a_2011_527# a_36_151# a_1376_115# VNW pfet_05v0 ad=0.1665p pd=1.285u as=0.1791p ps=1.355u w=0.36u l=0.5u
X7 a_2296_527# a_448_472# a_2011_527# VNW pfet_05v0 ad=50.399998f pd=0.64u as=0.1665p ps=1.285u w=0.36u l=0.5u
X8 a_1376_115# a_1004_159# VDD VNW pfet_05v0 ad=0.1791p pd=1.355u as=0.1044p ps=0.94u w=0.36u l=0.5u
X9 VDD CLK a_36_151# VNW pfet_05v0 ad=0.2249p pd=1.385u as=0.3806p ps=2.61u w=0.865u l=0.5u
X10 VDD a_2304_115# Q VNW pfet_05v0 ad=0.854p pd=3.84u as=0.3172p ps=1.74u w=1.22u l=0.5u
X11 VSS a_1376_115# a_1328_159# VPW nfet_05v0 ad=0.2637p pd=1.825u as=43.199997f ps=0.6u w=0.36u l=0.6u
X12 a_2011_527# a_448_472# a_1376_115# VPW nfet_05v0 ad=93.59999f pd=0.88u as=93.59999f ps=0.88u w=0.36u l=0.6u
X13 a_448_472# a_36_151# VDD VNW pfet_05v0 ad=0.3806p pd=2.61u as=0.2249p ps=1.385u w=0.865u l=0.5u
X14 Q a_2304_115# VDD VNW pfet_05v0 ad=0.3172p pd=1.74u as=0.5368p ps=3.32u w=1.22u l=0.5u
X15 a_1376_115# a_1004_159# VSS VPW nfet_05v0 ad=93.59999f pd=0.88u as=0.2637p ps=1.825u w=0.36u l=0.6u
X16 VSS a_2304_115# a_2256_159# VPW nfet_05v0 ad=0.142p pd=1.14u as=43.199997f ps=0.6u w=0.36u l=0.6u
X17 a_836_159# a_36_151# VSS VPW nfet_05v0 ad=43.199997f pd=0.6u as=0.1584p ps=1.6u w=0.36u l=0.6u
X18 a_448_472# a_36_151# VSS VPW nfet_05v0 ad=0.1782p pd=1.69u as=0.1053p ps=0.925u w=0.405u l=0.6u
X19 a_2256_159# a_36_151# a_2011_527# VPW nfet_05v0 ad=43.199997f pd=0.6u as=93.59999f ps=0.88u w=0.36u l=0.6u
X20 a_880_527# a_448_472# VDD VNW pfet_05v0 ad=53.999996f pd=0.66u as=0.4554p ps=3.25u w=0.36u l=0.5u
X21 a_1348_527# a_36_151# a_1004_159# VNW pfet_05v0 ad=43.199997f pd=0.6u as=0.1872p ps=1.4u w=0.36u l=0.5u
X22 a_1328_159# a_448_472# a_1004_159# VPW nfet_05v0 ad=43.199997f pd=0.6u as=0.207p ps=1.51u w=0.36u l=0.6u
X23 VDD a_1376_115# a_1348_527# VNW pfet_05v0 ad=0.1044p pd=0.94u as=43.199997f ps=0.6u w=0.36u l=0.5u
X24 VDD a_2304_115# a_2296_527# VNW pfet_05v0 ad=0.23p pd=1.54u as=50.399998f ps=0.64u w=0.36u l=0.5u
X25 a_2304_115# a_2011_527# VDD VNW pfet_05v0 ad=0.352p pd=2.48u as=0.23p ps=1.54u w=0.8u l=0.5u
.ends

.subckt gf180mcu_fd_sc_mcu7t5v0__aoi221_1 A1 A2 B1 B2 C ZN VDD VNW VPW VSS
X0 a_672_472# C a_56_472# VNW pfet_05v0 ad=0.3402p pd=1.775u as=0.37665p ps=1.835u w=1.215u l=0.5u
X1 VDD B2 a_56_472# VNW pfet_05v0 ad=0.3159p pd=1.735u as=0.5346p ps=3.31u w=1.215u l=0.5u
X2 ZN A1 a_940_90# VPW nfet_05v0 ad=0.3124p pd=2.3u as=85.2f ps=0.95u w=0.71u l=0.6u
X3 a_56_472# B1 VDD VNW pfet_05v0 ad=0.37665p pd=1.835u as=0.3159p ps=1.735u w=1.215u l=0.5u
X4 a_672_472# A1 ZN VNW pfet_05v0 ad=0.5346p pd=3.31u as=0.37665p ps=1.835u w=1.215u l=0.5u
X5 ZN A2 a_672_472# VNW pfet_05v0 ad=0.37665p pd=1.835u as=0.3402p ps=1.775u w=1.215u l=0.5u
X6 a_244_90# B2 VSS VPW nfet_05v0 ad=85.2f pd=0.95u as=0.3124p ps=2.3u w=0.71u l=0.6u
X7 ZN B1 a_244_90# VPW nfet_05v0 ad=0.21175p pd=1.41u as=85.2f ps=0.95u w=0.71u l=0.6u
X8 a_940_90# A2 VSS VPW nfet_05v0 ad=85.2f pd=0.95u as=0.22595p ps=1.45u w=0.71u l=0.6u
X9 VSS C ZN VPW nfet_05v0 ad=0.22595p pd=1.45u as=0.21175p ps=1.41u w=0.465u l=0.6u
.ends

.subckt gf180mcu_fd_sc_mcu7t5v0__aoi222_2 A1 A2 B1 B2 C1 C2 ZN VDD VNW VPW VSS
X0 VSS C2 a_251_68# VPW nfet_05v0 ad=0.316p pd=1.59u as=96f ps=1.04u w=0.8u l=0.6u
X1 ZN C1 a_697_68# VPW nfet_05v0 ad=0.384p pd=1.76u as=0.124p ps=1.11u w=0.8u l=0.6u
X2 a_231_472# C1 VDD VNW pfet_05v0 ad=0.3172p pd=1.74u as=0.5368p ps=3.32u w=1.22u l=0.5u
X3 a_1003_472# B2 a_231_472# VNW pfet_05v0 ad=0.3172p pd=1.74u as=0.3172p ps=1.74u w=1.22u l=0.5u
X4 ZN A2 a_1003_472# VNW pfet_05v0 ad=0.3172p pd=1.74u as=0.3172p ps=1.74u w=1.22u l=0.5u
X5 ZN A1 a_1003_472# VNW pfet_05v0 ad=0.3172p pd=1.74u as=0.32635p ps=1.755u w=1.22u l=0.5u
X6 VSS B2 a_1191_68# VPW nfet_05v0 ad=0.208p pd=1.32u as=0.168p ps=1.22u w=0.8u l=0.6u
X7 a_231_472# B2 a_1003_472# VNW pfet_05v0 ad=0.3172p pd=1.74u as=0.3172p ps=1.74u w=1.22u l=0.5u
X8 a_1003_472# A1 ZN VNW pfet_05v0 ad=0.5368p pd=3.32u as=0.3172p ps=1.74u w=1.22u l=0.5u
X9 VDD C2 a_231_472# VNW pfet_05v0 ad=0.3172p pd=1.74u as=0.3172p ps=1.74u w=1.22u l=0.5u
X10 a_231_472# C2 VDD VNW pfet_05v0 ad=0.3172p pd=1.74u as=0.3172p ps=1.74u w=1.22u l=0.5u
X11 ZN B1 a_1619_68# VPW nfet_05v0 ad=0.214p pd=1.335u as=0.128p ps=1.12u w=0.8u l=0.6u
X12 VDD C1 a_231_472# VNW pfet_05v0 ad=0.5368p pd=3.32u as=0.3172p ps=1.74u w=1.22u l=0.5u
X13 a_2438_68# A2 VSS VPW nfet_05v0 ad=0.128p pd=1.12u as=0.208p ps=1.32u w=0.8u l=0.6u
X14 a_2030_68# A1 ZN VPW nfet_05v0 ad=0.128p pd=1.12u as=0.214p ps=1.335u w=0.8u l=0.6u
X15 a_251_68# C1 ZN VPW nfet_05v0 ad=96f pd=1.04u as=0.352p ps=2.48u w=0.8u l=0.6u
X16 a_1003_472# B1 a_231_472# VNW pfet_05v0 ad=0.32635p pd=1.755u as=0.3172p ps=1.74u w=1.22u l=0.5u
X17 VSS A2 a_2030_68# VPW nfet_05v0 ad=0.208p pd=1.32u as=0.128p ps=1.12u w=0.8u l=0.6u
X18 a_1191_68# B1 ZN VPW nfet_05v0 ad=0.168p pd=1.22u as=0.384p ps=1.76u w=0.8u l=0.6u
X19 a_1619_68# B2 VSS VPW nfet_05v0 ad=0.128p pd=1.12u as=0.208p ps=1.32u w=0.8u l=0.6u
X20 ZN A1 a_2438_68# VPW nfet_05v0 ad=0.352p pd=2.48u as=0.128p ps=1.12u w=0.8u l=0.6u
X21 a_231_472# B1 a_1003_472# VNW pfet_05v0 ad=0.3172p pd=1.74u as=0.5368p ps=3.32u w=1.22u l=0.5u
X22 a_697_68# C2 VSS VPW nfet_05v0 ad=0.124p pd=1.11u as=0.316p ps=1.59u w=0.8u l=0.6u
X23 a_1003_472# A2 ZN VNW pfet_05v0 ad=0.3172p pd=1.74u as=0.3172p ps=1.74u w=1.22u l=0.5u
.ends

.subckt gf180mcu_fd_sc_mcu7t5v0__xor3_1 A1 A2 A3 Z VDD VNW VPW VSS
X0 a_952_93# A1 a_728_93# VPW nfet_05v0 ad=57.599995f pd=0.68u as=93.59999f ps=0.88u w=0.36u l=0.6u
X1 a_728_93# A1 a_718_524# VNW pfet_05v0 ad=0.1469p pd=1.085u as=0.161025p ps=1.135u w=0.565u l=0.5u
X2 a_1524_472# a_728_93# a_1336_472# VNW pfet_05v0 ad=90.4f pd=0.885u as=0.2486p ps=2.01u w=0.565u l=0.5u
X3 a_244_524# A2 a_56_524# VNW pfet_05v0 ad=93.59999f pd=0.88u as=0.1584p ps=1.6u w=0.36u l=0.5u
X4 a_718_524# a_56_524# VDD VNW pfet_05v0 ad=0.161025p pd=1.135u as=0.194p ps=1.415u w=0.565u l=0.5u
X5 a_718_524# A2 a_728_93# VNW pfet_05v0 ad=0.2486p pd=2.01u as=0.1469p ps=1.085u w=0.565u l=0.5u
X6 VSS A1 a_56_524# VPW nfet_05v0 ad=0.126p pd=1.06u as=93.59999f ps=0.88u w=0.36u l=0.6u
X7 a_1336_472# a_728_93# VSS VPW nfet_05v0 ad=93.59999f pd=0.88u as=0.1584p ps=1.6u w=0.36u l=0.6u
X8 VDD A1 a_244_524# VNW pfet_05v0 ad=0.194p pd=1.415u as=93.59999f ps=0.88u w=0.36u l=0.5u
X9 a_56_524# A2 VSS VPW nfet_05v0 ad=93.59999f pd=0.88u as=0.1584p ps=1.6u w=0.36u l=0.6u
X10 VSS A3 a_1336_472# VPW nfet_05v0 ad=0.218p pd=1.52u as=93.59999f ps=0.88u w=0.36u l=0.6u
X11 a_2215_68# A3 Z VPW nfet_05v0 ad=0.1312p pd=1.14u as=0.2132p ps=1.34u w=0.82u l=0.6u
X12 VSS a_728_93# a_2215_68# VPW nfet_05v0 ad=0.3608p pd=2.52u as=0.1312p ps=1.14u w=0.82u l=0.6u
X13 Z a_1336_472# VSS VPW nfet_05v0 ad=0.2132p pd=1.34u as=0.218p ps=1.52u w=0.82u l=0.6u
X14 Z A3 a_1936_472# VNW pfet_05v0 ad=0.3172p pd=1.74u as=0.3172p ps=1.74u w=1.22u l=0.5u
X15 a_728_93# a_56_524# VSS VPW nfet_05v0 ad=93.59999f pd=0.88u as=0.126p ps=1.06u w=0.36u l=0.6u
X16 a_1936_472# a_728_93# Z VNW pfet_05v0 ad=0.5368p pd=3.32u as=0.3172p ps=1.74u w=1.22u l=0.5u
X17 VSS A2 a_952_93# VPW nfet_05v0 ad=0.1584p pd=1.6u as=57.599995f ps=0.68u w=0.36u l=0.6u
X18 VDD A3 a_1524_472# VNW pfet_05v0 ad=0.35315p pd=1.96u as=90.4f ps=0.885u w=0.565u l=0.5u
X19 a_1936_472# a_1336_472# VDD VNW pfet_05v0 ad=0.3172p pd=1.74u as=0.35315p ps=1.96u w=1.22u l=0.5u
.ends

.subckt gf180mcu_fd_sc_mcu7t5v0__aoi21_1 A1 A2 B ZN VDD VNW VPW VSS
X0 a_244_68# A2 VSS VPW nfet_05v0 ad=0.1312p pd=1.14u as=0.3608p ps=2.52u w=0.82u l=0.6u
X1 ZN A1 a_244_68# VPW nfet_05v0 ad=0.2569p pd=1.56u as=0.1312p ps=1.14u w=0.82u l=0.6u
X2 VDD B a_36_472# VNW pfet_05v0 ad=0.5346p pd=3.31u as=0.44955p ps=1.955u w=1.215u l=0.5u
X3 ZN A2 a_36_472# VNW pfet_05v0 ad=0.3159p pd=1.735u as=0.5346p ps=3.31u w=1.215u l=0.5u
X4 a_36_472# A1 ZN VNW pfet_05v0 ad=0.44955p pd=1.955u as=0.3159p ps=1.735u w=1.215u l=0.5u
X5 VSS B ZN VPW nfet_05v0 ad=0.2244p pd=1.9u as=0.2569p ps=1.56u w=0.51u l=0.6u
.ends

.subckt gf180mcu_fd_sc_mcu7t5v0__nand2_4 A1 A2 ZN VDD VNW VPW VSS
X0 ZN A1 VDD VNW pfet_05v0 ad=0.2938p pd=1.65u as=0.2938p ps=1.65u w=1.13u l=0.5u
X1 VSS A2 a_661_68# VPW nfet_05v0 ad=0.22755p pd=1.375u as=98.399994f ps=1.06u w=0.82u l=0.6u
X2 VDD A2 ZN VNW pfet_05v0 ad=0.2938p pd=1.65u as=0.2938p ps=1.65u w=1.13u l=0.5u
X3 ZN A1 a_260_68# VPW nfet_05v0 ad=0.23165p pd=1.385u as=98.399994f ps=1.06u w=0.82u l=0.6u
X4 a_1468_68# A1 ZN VPW nfet_05v0 ad=0.1312p pd=1.14u as=0.2132p ps=1.34u w=0.82u l=0.6u
X5 ZN A2 VDD VNW pfet_05v0 ad=0.2938p pd=1.65u as=0.2938p ps=1.65u w=1.13u l=0.5u
X6 VDD A1 ZN VNW pfet_05v0 ad=0.2938p pd=1.65u as=0.2938p ps=1.65u w=1.13u l=0.5u
X7 ZN A1 a_1060_68# VPW nfet_05v0 ad=0.2132p pd=1.34u as=0.1312p ps=1.14u w=0.82u l=0.6u
X8 ZN A1 VDD VNW pfet_05v0 ad=0.2938p pd=1.65u as=0.2938p ps=1.65u w=1.13u l=0.5u
X9 a_661_68# A1 ZN VPW nfet_05v0 ad=98.399994f pd=1.06u as=0.23165p ps=1.385u w=0.82u l=0.6u
X10 a_1060_68# A2 VSS VPW nfet_05v0 ad=0.1312p pd=1.14u as=0.22755p ps=1.375u w=0.82u l=0.6u
X11 VDD A2 ZN VNW pfet_05v0 ad=0.4972p pd=3.14u as=0.2938p ps=1.65u w=1.13u l=0.5u
X12 a_260_68# A2 VSS VPW nfet_05v0 ad=98.399994f pd=1.06u as=0.3608p ps=2.52u w=0.82u l=0.6u
X13 VSS A2 a_1468_68# VPW nfet_05v0 ad=0.3608p pd=2.52u as=0.1312p ps=1.14u w=0.82u l=0.6u
X14 ZN A2 VDD VNW pfet_05v0 ad=0.2938p pd=1.65u as=0.4972p ps=3.14u w=1.13u l=0.5u
X15 VDD A1 ZN VNW pfet_05v0 ad=0.2938p pd=1.65u as=0.2938p ps=1.65u w=1.13u l=0.5u
.ends

.subckt gf180mcu_fd_sc_mcu7t5v0__aoi221_4 A1 A2 B1 B2 C ZN VDD VNW VPW VSS
X0 VSS B2 a_1070_69# VPW nfet_05v0 ad=0.2002p pd=1.29u as=0.1232p ps=1.09u w=0.77u l=0.6u
X1 VDD B2 a_234_508# VNW pfet_05v0 ad=0.2691p pd=1.555u as=0.2691p ps=1.555u w=1.035u l=0.5u
X2 VSS A2 a_3728_69# VPW nfet_05v0 ad=0.2002p pd=1.29u as=0.1232p ps=1.09u w=0.77u l=0.6u
X3 a_234_508# C a_1822_472# VNW pfet_05v0 ad=0.346275p pd=1.785u as=0.3159p ps=1.735u w=1.215u l=0.5u
X4 a_1822_472# A1 ZN VNW pfet_05v0 ad=0.3159p pd=1.735u as=0.3159p ps=1.735u w=1.215u l=0.5u
X5 a_234_508# C a_1822_472# VNW pfet_05v0 ad=0.3159p pd=1.735u as=0.5346p ps=3.31u w=1.215u l=0.5u
X6 ZN A2 a_1822_472# VNW pfet_05v0 ad=0.3159p pd=1.735u as=0.3159p ps=1.735u w=1.215u l=0.5u
X7 a_1070_69# B1 ZN VPW nfet_05v0 ad=0.1232p pd=1.09u as=0.2002p ps=1.29u w=0.77u l=0.6u
X8 a_234_508# B2 VDD VNW pfet_05v0 ad=0.2691p pd=1.555u as=0.2691p ps=1.555u w=1.035u l=0.5u
X9 ZN A1 a_1822_472# VNW pfet_05v0 ad=0.3159p pd=1.735u as=0.3159p ps=1.735u w=1.215u l=0.5u
X10 a_1822_472# A1 ZN VNW pfet_05v0 ad=0.5346p pd=3.31u as=0.3159p ps=1.735u w=1.215u l=0.5u
X11 VDD B1 a_234_508# VNW pfet_05v0 ad=0.4554p pd=2.95u as=0.2691p ps=1.555u w=1.035u l=0.5u
X12 a_1822_472# A2 ZN VNW pfet_05v0 ad=0.3159p pd=1.735u as=0.3159p ps=1.735u w=1.215u l=0.5u
X13 a_2912_69# A1 ZN VPW nfet_05v0 ad=0.1232p pd=1.09u as=0.226p ps=1.47u w=0.77u l=0.6u
X14 VSS A2 a_2912_69# VPW nfet_05v0 ad=0.2002p pd=1.29u as=0.1232p ps=1.09u w=0.77u l=0.6u
X15 a_234_508# B1 VDD VNW pfet_05v0 ad=0.2691p pd=1.555u as=0.4554p ps=2.95u w=1.035u l=0.5u
X16 a_3728_69# A1 ZN VPW nfet_05v0 ad=0.1232p pd=1.09u as=0.2002p ps=1.29u w=0.77u l=0.6u
X17 ZN A1 a_4136_69# VPW nfet_05v0 ad=0.3388p pd=2.42u as=0.1232p ps=1.09u w=0.77u l=0.6u
X18 a_244_69# B1 ZN VPW nfet_05v0 ad=0.14245p pd=1.14u as=0.3388p ps=2.42u w=0.77u l=0.6u
X19 VSS C ZN VPW nfet_05v0 ad=0.1248p pd=1u as=0.1248p ps=1u w=0.48u l=0.6u
X20 VDD B2 a_234_508# VNW pfet_05v0 ad=0.2691p pd=1.555u as=0.2691p ps=1.555u w=1.035u l=0.5u
X21 ZN B1 a_1478_69# VPW nfet_05v0 ad=0.29915p pd=1.66u as=0.1617p ps=1.19u w=0.77u l=0.6u
X22 a_234_508# B2 VDD VNW pfet_05v0 ad=0.2691p pd=1.555u as=0.2691p ps=1.555u w=1.035u l=0.5u
X23 VSS B2 a_244_69# VPW nfet_05v0 ad=0.2002p pd=1.29u as=0.14245p ps=1.14u w=0.77u l=0.6u
X24 a_1478_69# B2 VSS VPW nfet_05v0 ad=0.1617p pd=1.19u as=0.2002p ps=1.29u w=0.77u l=0.6u
X25 VDD B1 a_234_508# VNW pfet_05v0 ad=0.2691p pd=1.555u as=0.2691p ps=1.555u w=1.035u l=0.5u
X26 ZN A1 a_1822_472# VNW pfet_05v0 ad=0.3159p pd=1.735u as=0.486p ps=2.015u w=1.215u l=0.5u
X27 ZN C VSS VPW nfet_05v0 ad=0.226p pd=1.47u as=0.1248p ps=1u w=0.48u l=0.6u
X28 a_3320_69# A2 VSS VPW nfet_05v0 ad=0.1232p pd=1.09u as=0.2002p ps=1.29u w=0.77u l=0.6u
X29 ZN A1 a_3320_69# VPW nfet_05v0 ad=0.2002p pd=1.29u as=0.1232p ps=1.09u w=0.77u l=0.6u
X30 a_234_508# B1 VDD VNW pfet_05v0 ad=0.2691p pd=1.555u as=0.2691p ps=1.555u w=1.035u l=0.5u
X31 ZN C VSS VPW nfet_05v0 ad=0.1248p pd=1u as=0.1248p ps=1u w=0.48u l=0.6u
X32 a_1822_472# C a_234_508# VNW pfet_05v0 ad=0.486p pd=2.015u as=0.346275p ps=1.785u w=1.215u l=0.5u
X33 a_1822_472# A2 ZN VNW pfet_05v0 ad=0.3159p pd=1.735u as=0.3159p ps=1.735u w=1.215u l=0.5u
X34 ZN B1 a_662_69# VPW nfet_05v0 ad=0.2002p pd=1.29u as=0.1232p ps=1.09u w=0.77u l=0.6u
X35 a_662_69# B2 VSS VPW nfet_05v0 ad=0.1232p pd=1.09u as=0.2002p ps=1.29u w=0.77u l=0.6u
X36 VSS C ZN VPW nfet_05v0 ad=0.1248p pd=1u as=0.29915p ps=1.66u w=0.48u l=0.6u
X37 a_1822_472# C a_234_508# VNW pfet_05v0 ad=0.3159p pd=1.735u as=0.3159p ps=1.735u w=1.215u l=0.5u
X38 ZN A2 a_1822_472# VNW pfet_05v0 ad=0.3159p pd=1.735u as=0.3159p ps=1.735u w=1.215u l=0.5u
X39 a_4136_69# A2 VSS VPW nfet_05v0 ad=0.1232p pd=1.09u as=0.2002p ps=1.29u w=0.77u l=0.6u
.ends

.subckt gf180mcu_fd_sc_mcu7t5v0__clkbuf_16 I Z VDD VNW VPW VSS
X0 VSS I a_224_552# VPW nfet_05v0 ad=0.1053p pd=0.925u as=0.1053p ps=0.925u w=0.405u l=0.6u
X1 VSS a_224_552# Z VPW nfet_05v0 ad=0.1261p pd=1.005u as=0.1261p ps=1.005u w=0.485u l=0.6u
X2 a_224_552# I VDD VNW pfet_05v0 ad=0.2542p pd=1.44u as=0.2542p ps=1.44u w=0.82u l=0.5u
X3 Z a_224_552# VDD VNW pfet_05v0 ad=0.3782p pd=1.84u as=0.3782p ps=1.84u w=1.22u l=0.5u
X4 Z a_224_552# VSS VPW nfet_05v0 ad=0.1261p pd=1.005u as=0.1261p ps=1.005u w=0.485u l=0.6u
X5 VDD a_224_552# Z VNW pfet_05v0 ad=0.3782p pd=1.84u as=0.3782p ps=1.84u w=1.22u l=0.5u
X6 VDD a_224_552# Z VNW pfet_05v0 ad=0.3782p pd=1.84u as=0.3782p ps=1.84u w=1.22u l=0.5u
X7 Z a_224_552# VDD VNW pfet_05v0 ad=0.3782p pd=1.84u as=0.3782p ps=1.84u w=1.22u l=0.5u
X8 a_224_552# I VDD VNW pfet_05v0 ad=0.2542p pd=1.44u as=0.3608p ps=2.52u w=0.82u l=0.5u
X9 VDD a_224_552# Z VNW pfet_05v0 ad=0.3782p pd=1.84u as=0.3782p ps=1.84u w=1.22u l=0.5u
X10 Z a_224_552# VSS VPW nfet_05v0 ad=0.1261p pd=1.005u as=0.1261p ps=1.005u w=0.485u l=0.6u
X11 VSS a_224_552# Z VPW nfet_05v0 ad=0.1261p pd=1.005u as=0.1261p ps=1.005u w=0.485u l=0.6u
X12 VSS a_224_552# Z VPW nfet_05v0 ad=0.1261p pd=1.005u as=0.1261p ps=1.005u w=0.485u l=0.6u
X13 VDD a_224_552# Z VNW pfet_05v0 ad=0.5368p pd=3.32u as=0.3782p ps=1.84u w=1.22u l=0.5u
X14 Z a_224_552# VSS VPW nfet_05v0 ad=0.1261p pd=1.005u as=0.1261p ps=1.005u w=0.485u l=0.6u
X15 VSS I a_224_552# VPW nfet_05v0 ad=0.1053p pd=0.925u as=0.1782p ps=1.69u w=0.405u l=0.6u
X16 a_224_552# I VDD VNW pfet_05v0 ad=0.2542p pd=1.44u as=0.2542p ps=1.44u w=0.82u l=0.5u
X17 a_224_552# I VSS VPW nfet_05v0 ad=0.1053p pd=0.925u as=0.1053p ps=0.925u w=0.405u l=0.6u
X18 VSS a_224_552# Z VPW nfet_05v0 ad=0.1261p pd=1.005u as=0.1261p ps=1.005u w=0.485u l=0.6u
X19 Z a_224_552# VDD VNW pfet_05v0 ad=0.3782p pd=1.84u as=0.428p ps=2.02u w=1.22u l=0.5u
X20 VDD I a_224_552# VNW pfet_05v0 ad=0.2542p pd=1.44u as=0.2542p ps=1.44u w=0.82u l=0.5u
X21 Z a_224_552# VDD VNW pfet_05v0 ad=0.3782p pd=1.84u as=0.3782p ps=1.84u w=1.22u l=0.5u
X22 Z a_224_552# VDD VNW pfet_05v0 ad=0.3782p pd=1.84u as=0.3782p ps=1.84u w=1.22u l=0.5u
X23 VSS I a_224_552# VPW nfet_05v0 ad=0.1053p pd=0.925u as=0.1053p ps=0.925u w=0.405u l=0.6u
X24 VDD a_224_552# Z VNW pfet_05v0 ad=0.3782p pd=1.84u as=0.3782p ps=1.84u w=1.22u l=0.5u
X25 Z a_224_552# VSS VPW nfet_05v0 ad=0.1261p pd=1.005u as=0.1261p ps=1.005u w=0.485u l=0.6u
X26 VSS a_224_552# Z VPW nfet_05v0 ad=0.1261p pd=1.005u as=0.1261p ps=1.005u w=0.485u l=0.6u
X27 VSS a_224_552# Z VPW nfet_05v0 ad=0.1261p pd=1.005u as=0.1261p ps=1.005u w=0.485u l=0.6u
X28 VDD I a_224_552# VNW pfet_05v0 ad=0.428p pd=2.02u as=0.2542p ps=1.44u w=0.82u l=0.5u
X29 Z a_224_552# VDD VNW pfet_05v0 ad=0.3782p pd=1.84u as=0.3782p ps=1.84u w=1.22u l=0.5u
X30 a_224_552# I VSS VPW nfet_05v0 ad=0.1782p pd=1.69u as=0.1053p ps=0.925u w=0.405u l=0.6u
X31 Z a_224_552# VSS VPW nfet_05v0 ad=0.1261p pd=1.005u as=0.1261p ps=1.005u w=0.485u l=0.6u
X32 VSS a_224_552# Z VPW nfet_05v0 ad=0.1261p pd=1.005u as=0.1261p ps=1.005u w=0.485u l=0.6u
X33 Z a_224_552# VDD VNW pfet_05v0 ad=0.3782p pd=1.84u as=0.3782p ps=1.84u w=1.22u l=0.5u
X34 VSS a_224_552# Z VPW nfet_05v0 ad=0.2134p pd=1.85u as=0.1261p ps=1.005u w=0.485u l=0.6u
X35 VDD I a_224_552# VNW pfet_05v0 ad=0.2542p pd=1.44u as=0.2542p ps=1.44u w=0.82u l=0.5u
X36 VDD a_224_552# Z VNW pfet_05v0 ad=0.3782p pd=1.84u as=0.3782p ps=1.84u w=1.22u l=0.5u
X37 VDD a_224_552# Z VNW pfet_05v0 ad=0.3782p pd=1.84u as=0.3782p ps=1.84u w=1.22u l=0.5u
X38 Z a_224_552# VDD VNW pfet_05v0 ad=0.3782p pd=1.84u as=0.3782p ps=1.84u w=1.22u l=0.5u
X39 a_224_552# I VDD VNW pfet_05v0 ad=0.2542p pd=1.44u as=0.2542p ps=1.44u w=0.82u l=0.5u
X40 a_224_552# I VSS VPW nfet_05v0 ad=0.1053p pd=0.925u as=0.1053p ps=0.925u w=0.405u l=0.6u
X41 Z a_224_552# VSS VPW nfet_05v0 ad=0.1261p pd=1.005u as=0.2134p ps=1.85u w=0.485u l=0.6u
X42 VDD I a_224_552# VNW pfet_05v0 ad=0.2542p pd=1.44u as=0.2542p ps=1.44u w=0.82u l=0.5u
X43 VDD a_224_552# Z VNW pfet_05v0 ad=0.3782p pd=1.84u as=0.3782p ps=1.84u w=1.22u l=0.5u
X44 Z a_224_552# VSS VPW nfet_05v0 ad=0.1261p pd=1.005u as=0.1261p ps=1.005u w=0.485u l=0.6u
X45 Z a_224_552# VSS VPW nfet_05v0 ad=0.1261p pd=1.005u as=0.1261p ps=1.005u w=0.485u l=0.6u
.ends

.subckt gf180mcu_fd_sc_mcu7t5v0__aoi21_4 A1 A2 B ZN VDD VNW VPW VSS
X0 VDD B a_76_476# VNW pfet_05v0 ad=0.312p pd=1.72u as=0.312p ps=1.72u w=1.2u l=0.5u
X1 a_680_68# A1 ZN VPW nfet_05v0 ad=98.399994f pd=1.06u as=0.2132p ps=1.34u w=0.82u l=0.6u
X2 VDD B a_76_476# VNW pfet_05v0 ad=0.312p pd=1.72u as=0.48p ps=2u w=1.2u l=0.5u
X3 a_76_476# B VDD VNW pfet_05v0 ad=0.528p pd=3.28u as=0.312p ps=1.72u w=1.2u l=0.5u
X4 ZN B VSS VPW nfet_05v0 ad=0.1326p pd=1.03u as=0.1326p ps=1.03u w=0.51u l=0.6u
X5 ZN A2 a_76_476# VNW pfet_05v0 ad=0.312p pd=1.72u as=0.528p ps=3.28u w=1.2u l=0.5u
X6 a_76_476# A1 ZN VNW pfet_05v0 ad=0.312p pd=1.72u as=0.312p ps=1.72u w=1.2u l=0.5u
X7 a_1464_68# A1 ZN VPW nfet_05v0 ad=98.399994f pd=1.06u as=0.2132p ps=1.34u w=0.82u l=0.6u
X8 ZN A1 a_76_476# VNW pfet_05v0 ad=0.312p pd=1.72u as=0.312p ps=1.72u w=1.2u l=0.5u
X9 VSS A2 a_1464_68# VPW nfet_05v0 ad=0.2405p pd=1.52u as=98.399994f ps=1.06u w=0.82u l=0.6u
X10 a_76_476# A2 ZN VNW pfet_05v0 ad=0.312p pd=1.72u as=0.312p ps=1.72u w=1.2u l=0.5u
X11 VSS A2 a_680_68# VPW nfet_05v0 ad=0.2132p pd=1.34u as=98.399994f ps=1.06u w=0.82u l=0.6u
X12 ZN A2 a_76_476# VNW pfet_05v0 ad=0.312p pd=1.72u as=0.312p ps=1.72u w=1.2u l=0.5u
X13 VSS B ZN VPW nfet_05v0 ad=0.1326p pd=1.03u as=0.1326p ps=1.03u w=0.51u l=0.6u
X14 ZN A1 a_1072_68# VPW nfet_05v0 ad=0.2132p pd=1.34u as=98.399994f ps=1.06u w=0.82u l=0.6u
X15 a_288_68# A2 VSS VPW nfet_05v0 ad=98.399994f pd=1.06u as=0.3608p ps=2.52u w=0.82u l=0.6u
X16 a_1072_68# A2 VSS VPW nfet_05v0 ad=98.399994f pd=1.06u as=0.2132p ps=1.34u w=0.82u l=0.6u
X17 VSS B ZN VPW nfet_05v0 ad=0.2244p pd=1.9u as=0.1326p ps=1.03u w=0.51u l=0.6u
X18 a_76_476# A1 ZN VNW pfet_05v0 ad=0.312p pd=1.72u as=0.312p ps=1.72u w=1.2u l=0.5u
X19 ZN A1 a_288_68# VPW nfet_05v0 ad=0.2132p pd=1.34u as=98.399994f ps=1.06u w=0.82u l=0.6u
X20 ZN A1 a_76_476# VNW pfet_05v0 ad=0.312p pd=1.72u as=0.312p ps=1.72u w=1.2u l=0.5u
X21 a_76_476# A2 ZN VNW pfet_05v0 ad=0.48p pd=2u as=0.312p ps=1.72u w=1.2u l=0.5u
X22 a_76_476# B VDD VNW pfet_05v0 ad=0.312p pd=1.72u as=0.312p ps=1.72u w=1.2u l=0.5u
X23 ZN B VSS VPW nfet_05v0 ad=0.1326p pd=1.03u as=0.2405p ps=1.52u w=0.51u l=0.6u
.ends

.subckt gf180mcu_fd_sc_mcu7t5v0__xnor2_1 A1 A2 ZN VDD VNW VPW VSS
X0 ZN a_64_93# VDD VNW pfet_05v0 ad=0.312075p pd=1.665u as=0.344375p ps=1.895u w=1.095u l=0.5u
X1 a_272_93# A2 a_64_93# VPW nfet_05v0 ad=57.599995f pd=0.68u as=0.1584p ps=1.6u w=0.36u l=0.6u
X2 VSS A1 a_272_93# VPW nfet_05v0 ad=0.218p pd=1.52u as=57.599995f ps=0.68u w=0.36u l=0.6u
X3 a_716_68# a_64_93# VSS VPW nfet_05v0 ad=0.2132p pd=1.34u as=0.218p ps=1.52u w=0.82u l=0.6u
X4 VDD A2 a_930_497# VNW pfet_05v0 ad=0.4818p pd=3.07u as=0.552975p ps=2.105u w=1.095u l=0.5u
X5 ZN A1 a_716_68# VPW nfet_05v0 ad=0.4161p pd=1.905u as=0.2132p ps=1.34u w=0.82u l=0.6u
X6 a_64_93# A2 VDD VNW pfet_05v0 ad=0.1456p pd=1.08u as=0.2464p ps=2u w=0.56u l=0.5u
X7 a_716_68# A2 ZN VPW nfet_05v0 ad=0.3608p pd=2.52u as=0.4161p ps=1.905u w=0.82u l=0.6u
X8 VDD A1 a_64_93# VNW pfet_05v0 ad=0.344375p pd=1.895u as=0.1456p ps=1.08u w=0.56u l=0.5u
X9 a_930_497# A1 ZN VNW pfet_05v0 ad=0.552975p pd=2.105u as=0.312075p ps=1.665u w=1.095u l=0.5u
.ends

.subckt gf180mcu_fd_sc_mcu7t5v0__aoi222_4 A1 A2 B1 B2 C1 C2 ZN VDD VNW VPW VSS
X0 ZN A2 a_1812_472# VNW pfet_05v0 ad=0.3172p pd=1.74u as=0.3172p ps=1.74u w=1.22u l=0.5u
X1 a_224_472# C2 VDD VNW pfet_05v0 ad=0.3172p pd=1.74u as=0.3172p ps=1.74u w=1.22u l=0.5u
X2 ZN A1 a_4876_68# VPW nfet_05v0 ad=0.3608p pd=2.52u as=0.1312p ps=1.14u w=0.82u l=0.6u
X3 a_1812_472# A1 ZN VNW pfet_05v0 ad=0.5368p pd=3.32u as=0.3172p ps=1.74u w=1.22u l=0.5u
X4 a_2010_68# B1 ZN VPW nfet_05v0 ad=0.1517p pd=1.19u as=0.4879p ps=2.01u w=0.82u l=0.6u
X5 VSS A2 a_3652_68# VPW nfet_05v0 ad=0.2132p pd=1.34u as=0.1312p ps=1.14u w=0.82u l=0.6u
X6 a_3652_68# A1 ZN VPW nfet_05v0 ad=0.1312p pd=1.14u as=0.2132p ps=1.34u w=0.82u l=0.6u
X7 VDD C1 a_224_472# VNW pfet_05v0 ad=0.3172p pd=1.74u as=0.3172p ps=1.74u w=1.22u l=0.5u
X8 a_244_68# C1 ZN VPW nfet_05v0 ad=0.1312p pd=1.14u as=0.3608p ps=2.52u w=0.82u l=0.6u
X9 VSS C2 a_244_68# VPW nfet_05v0 ad=0.2132p pd=1.34u as=0.1312p ps=1.14u w=0.82u l=0.6u
X10 a_1812_472# B2 a_224_472# VNW pfet_05v0 ad=0.3172p pd=1.74u as=0.3172p ps=1.74u w=1.22u l=0.5u
X11 a_1468_68# C2 VSS VPW nfet_05v0 ad=0.1312p pd=1.14u as=0.2132p ps=1.34u w=0.82u l=0.6u
X12 a_2428_68# B2 VSS VPW nfet_05v0 ad=0.1312p pd=1.14u as=0.2132p ps=1.34u w=0.82u l=0.6u
X13 a_224_472# C1 VDD VNW pfet_05v0 ad=0.3172p pd=1.74u as=0.3172p ps=1.74u w=1.22u l=0.5u
X14 a_4468_68# A1 ZN VPW nfet_05v0 ad=0.1312p pd=1.14u as=0.2132p ps=1.34u w=0.82u l=0.6u
X15 a_224_472# B2 a_1812_472# VNW pfet_05v0 ad=0.3172p pd=1.74u as=0.3172p ps=1.74u w=1.22u l=0.5u
X16 a_224_472# B1 a_1812_472# VNW pfet_05v0 ad=0.3172p pd=1.74u as=0.5368p ps=3.32u w=1.22u l=0.5u
X17 a_4060_68# A2 VSS VPW nfet_05v0 ad=0.1312p pd=1.14u as=0.2132p ps=1.34u w=0.82u l=0.6u
X18 a_1812_472# B1 a_224_472# VNW pfet_05v0 ad=0.3172p pd=1.74u as=0.3172p ps=1.74u w=1.22u l=0.5u
X19 a_652_68# C2 VSS VPW nfet_05v0 ad=0.1312p pd=1.14u as=0.2132p ps=1.34u w=0.82u l=0.6u
X20 ZN C1 a_652_68# VPW nfet_05v0 ad=0.2132p pd=1.34u as=0.1312p ps=1.14u w=0.82u l=0.6u
X21 VDD C2 a_224_472# VNW pfet_05v0 ad=0.3172p pd=1.74u as=0.3172p ps=1.74u w=1.22u l=0.5u
X22 a_2836_68# B1 ZN VPW nfet_05v0 ad=0.1312p pd=1.14u as=0.2132p ps=1.34u w=0.82u l=0.6u
X23 a_224_472# B2 a_1812_472# VNW pfet_05v0 ad=0.3172p pd=1.74u as=0.3172p ps=1.74u w=1.22u l=0.5u
X24 a_224_472# B1 a_1812_472# VNW pfet_05v0 ad=0.3172p pd=1.74u as=0.3172p ps=1.74u w=1.22u l=0.5u
X25 VSS C2 a_1060_68# VPW nfet_05v0 ad=0.2132p pd=1.34u as=0.1312p ps=1.14u w=0.82u l=0.6u
X26 a_224_472# C2 VDD VNW pfet_05v0 ad=0.3172p pd=1.74u as=0.3172p ps=1.74u w=1.22u l=0.5u
X27 VSS B2 a_2010_68# VPW nfet_05v0 ad=0.2132p pd=1.34u as=0.1517p ps=1.19u w=0.82u l=0.6u
X28 a_4876_68# A2 VSS VPW nfet_05v0 ad=0.1312p pd=1.14u as=0.2132p ps=1.34u w=0.82u l=0.6u
X29 a_1812_472# B1 a_224_472# VNW pfet_05v0 ad=0.3172p pd=1.74u as=0.3172p ps=1.74u w=1.22u l=0.5u
X30 a_1812_472# B2 a_224_472# VNW pfet_05v0 ad=0.3172p pd=1.74u as=0.3172p ps=1.74u w=1.22u l=0.5u
X31 a_1060_68# C1 ZN VPW nfet_05v0 ad=0.1312p pd=1.14u as=0.2132p ps=1.34u w=0.82u l=0.6u
X32 ZN A1 a_4060_68# VPW nfet_05v0 ad=0.2132p pd=1.34u as=0.1312p ps=1.14u w=0.82u l=0.6u
X33 VDD C1 a_224_472# VNW pfet_05v0 ad=0.5368p pd=3.32u as=0.3172p ps=1.74u w=1.22u l=0.5u
X34 ZN A1 a_1812_472# VNW pfet_05v0 ad=0.3172p pd=1.74u as=0.3172p ps=1.74u w=1.22u l=0.5u
X35 a_1812_472# A1 ZN VNW pfet_05v0 ad=0.3172p pd=1.74u as=0.3172p ps=1.74u w=1.22u l=0.5u
X36 ZN C1 a_1468_68# VPW nfet_05v0 ad=0.4879p pd=2.01u as=0.1312p ps=1.14u w=0.82u l=0.6u
X37 a_1812_472# A2 ZN VNW pfet_05v0 ad=0.3172p pd=1.74u as=0.3172p ps=1.74u w=1.22u l=0.5u
X38 ZN B1 a_2428_68# VPW nfet_05v0 ad=0.2132p pd=1.34u as=0.1312p ps=1.14u w=0.82u l=0.6u
X39 ZN A2 a_1812_472# VNW pfet_05v0 ad=0.3172p pd=1.74u as=0.3172p ps=1.74u w=1.22u l=0.5u
X40 ZN A1 a_1812_472# VNW pfet_05v0 ad=0.3172p pd=1.74u as=0.3172p ps=1.74u w=1.22u l=0.5u
X41 VSS A2 a_4468_68# VPW nfet_05v0 ad=0.2132p pd=1.34u as=0.1312p ps=1.14u w=0.82u l=0.6u
X42 a_224_472# C1 VDD VNW pfet_05v0 ad=0.3172p pd=1.74u as=0.5368p ps=3.32u w=1.22u l=0.5u
X43 a_1812_472# A2 ZN VNW pfet_05v0 ad=0.3172p pd=1.74u as=0.3172p ps=1.74u w=1.22u l=0.5u
X44 ZN B1 a_3244_68# VPW nfet_05v0 ad=0.2132p pd=1.34u as=0.1312p ps=1.14u w=0.82u l=0.6u
X45 a_3244_68# B2 VSS VPW nfet_05v0 ad=0.1312p pd=1.14u as=0.2132p ps=1.34u w=0.82u l=0.6u
X46 VDD C2 a_224_472# VNW pfet_05v0 ad=0.3172p pd=1.74u as=0.3172p ps=1.74u w=1.22u l=0.5u
X47 VSS B2 a_2836_68# VPW nfet_05v0 ad=0.2132p pd=1.34u as=0.1312p ps=1.14u w=0.82u l=0.6u
.ends

.subckt gf180mcu_fd_sc_mcu7t5v0__nand3_4 A1 A2 A3 ZN VDD VNW VPW VSS
X0 VDD A1 ZN VNW pfet_05v0 ad=0.4334p pd=2.85u as=0.52205p ps=2.045u w=0.985u l=0.5u
X1 a_36_68# A1 ZN VPW nfet_05v0 ad=0.2132p pd=1.34u as=0.4161p ps=1.905u w=0.82u l=0.6u
X2 ZN A2 VDD VNW pfet_05v0 ad=0.2561p pd=1.505u as=0.30535p ps=1.605u w=0.985u l=0.5u
X3 a_36_68# A2 a_672_68# VPW nfet_05v0 ad=0.2132p pd=1.34u as=0.1722p ps=1.24u w=0.82u l=0.6u
X4 a_1732_68# A2 a_1528_68# VPW nfet_05v0 ad=0.1722p pd=1.24u as=0.1722p ps=1.24u w=0.82u l=0.6u
X5 ZN A3 VDD VNW pfet_05v0 ad=0.2561p pd=1.505u as=0.30535p ps=1.605u w=0.985u l=0.5u
X6 a_244_68# A2 a_36_68# VPW nfet_05v0 ad=0.1722p pd=1.24u as=0.3608p ps=2.52u w=0.82u l=0.6u
X7 a_1528_68# A3 VSS VPW nfet_05v0 ad=0.1722p pd=1.24u as=0.2132p ps=1.34u w=0.82u l=0.6u
X8 VDD A2 ZN VNW pfet_05v0 ad=0.2561p pd=1.505u as=0.2561p ps=1.505u w=0.985u l=0.5u
X9 ZN A1 a_36_68# VPW nfet_05v0 ad=0.4161p pd=1.905u as=0.2132p ps=1.34u w=0.82u l=0.6u
X10 VDD A3 ZN VNW pfet_05v0 ad=0.30535p pd=1.605u as=0.2561p ps=1.505u w=0.985u l=0.5u
X11 VDD A1 ZN VNW pfet_05v0 ad=0.30535p pd=1.605u as=0.52205p ps=2.045u w=0.985u l=0.5u
X12 a_1100_68# A2 a_36_68# VPW nfet_05v0 ad=0.1722p pd=1.24u as=0.2132p ps=1.34u w=0.82u l=0.6u
X13 ZN A1 VDD VNW pfet_05v0 ad=0.52205p pd=2.045u as=0.2561p ps=1.505u w=0.985u l=0.5u
X14 ZN A3 VDD VNW pfet_05v0 ad=0.2561p pd=1.505u as=0.30535p ps=1.605u w=0.985u l=0.5u
X15 ZN A1 a_1732_68# VPW nfet_05v0 ad=0.4161p pd=1.905u as=0.1722p ps=1.24u w=0.82u l=0.6u
X16 VSS A3 a_244_68# VPW nfet_05v0 ad=0.2132p pd=1.34u as=0.1722p ps=1.24u w=0.82u l=0.6u
X17 VDD A2 ZN VNW pfet_05v0 ad=0.30535p pd=1.605u as=0.2561p ps=1.505u w=0.985u l=0.5u
X18 VSS A3 a_1100_68# VPW nfet_05v0 ad=0.2132p pd=1.34u as=0.1722p ps=1.24u w=0.82u l=0.6u
X19 a_36_68# A1 ZN VPW nfet_05v0 ad=0.3608p pd=2.52u as=0.4161p ps=1.905u w=0.82u l=0.6u
X20 ZN A2 VDD VNW pfet_05v0 ad=0.2561p pd=1.505u as=0.4334p ps=2.85u w=0.985u l=0.5u
X21 a_672_68# A3 VSS VPW nfet_05v0 ad=0.1722p pd=1.24u as=0.2132p ps=1.34u w=0.82u l=0.6u
X22 VDD A3 ZN VNW pfet_05v0 ad=0.30535p pd=1.605u as=0.2561p ps=1.505u w=0.985u l=0.5u
X23 ZN A1 VDD VNW pfet_05v0 ad=0.52205p pd=2.045u as=0.30535p ps=1.605u w=0.985u l=0.5u
.ends

.subckt gf180mcu_fd_sc_mcu7t5v0__xor2_1 A1 A2 Z VDD VNW VPW VSS
X0 a_728_472# a_56_604# VDD VNW pfet_05v0 ad=0.3172p pd=1.74u as=0.4005p ps=2.12u w=1.22u l=0.5u
X1 Z A1 a_728_472# VNW pfet_05v0 ad=0.3172p pd=1.74u as=0.3172p ps=1.74u w=1.22u l=0.5u
X2 VSS A1 a_56_604# VPW nfet_05v0 ad=0.218p pd=1.52u as=93.59999f ps=0.88u w=0.36u l=0.6u
X3 a_728_472# A2 Z VNW pfet_05v0 ad=0.5368p pd=3.32u as=0.3172p ps=1.74u w=1.22u l=0.5u
X4 Z a_56_604# VSS VPW nfet_05v0 ad=0.2132p pd=1.34u as=0.218p ps=1.52u w=0.82u l=0.6u
X5 VSS A2 a_952_68# VPW nfet_05v0 ad=0.3608p pd=2.52u as=0.1312p ps=1.14u w=0.82u l=0.6u
X6 a_244_604# A2 a_56_604# VNW pfet_05v0 ad=0.1456p pd=1.08u as=0.2464p ps=2u w=0.56u l=0.5u
X7 a_56_604# A2 VSS VPW nfet_05v0 ad=93.59999f pd=0.88u as=0.1584p ps=1.6u w=0.36u l=0.6u
X8 a_952_68# A1 Z VPW nfet_05v0 ad=0.1312p pd=1.14u as=0.2132p ps=1.34u w=0.82u l=0.6u
X9 VDD A1 a_244_604# VNW pfet_05v0 ad=0.4005p pd=2.12u as=0.1456p ps=1.08u w=0.56u l=0.5u
.ends

.subckt gf180mcu_fd_sc_mcu7t5v0__aoi222_1 A1 A2 B1 B2 C1 C2 ZN VDD VNW VPW VSS
X0 a_291_68# C2 VSS VPW nfet_05v0 ad=98.399994f pd=1.06u as=0.3608p ps=2.52u w=0.82u l=0.6u
X1 a_1235_68# A2 VSS VPW nfet_05v0 ad=0.1722p pd=1.24u as=0.2132p ps=1.34u w=0.82u l=0.6u
X2 a_619_484# A1 ZN VNW pfet_05v0 ad=0.5104p pd=3.2u as=0.3596p ps=1.78u w=1.16u l=0.5u
X3 a_255_484# B1 a_619_484# VNW pfet_05v0 ad=0.3016p pd=1.68u as=0.5104p ps=3.2u w=1.16u l=0.5u
X4 a_619_484# B2 a_255_484# VNW pfet_05v0 ad=0.3016p pd=1.68u as=0.3016p ps=1.68u w=1.16u l=0.5u
X5 a_255_484# C2 VDD VNW pfet_05v0 ad=0.3016p pd=1.68u as=0.5104p ps=3.2u w=1.16u l=0.5u
X6 ZN C1 a_291_68# VPW nfet_05v0 ad=0.33825p pd=1.645u as=98.399994f ps=1.06u w=0.82u l=0.6u
X7 ZN A1 a_1235_68# VPW nfet_05v0 ad=0.3608p pd=2.52u as=0.1722p ps=1.24u w=0.82u l=0.6u
X8 VSS B2 a_744_68# VPW nfet_05v0 ad=0.2132p pd=1.34u as=0.30135p ps=1.555u w=0.82u l=0.6u
X9 VDD C1 a_255_484# VNW pfet_05v0 ad=0.5104p pd=3.2u as=0.3016p ps=1.68u w=1.16u l=0.5u
X10 ZN A2 a_619_484# VNW pfet_05v0 ad=0.3596p pd=1.78u as=0.3016p ps=1.68u w=1.16u l=0.5u
X11 a_744_68# B1 ZN VPW nfet_05v0 ad=0.30135p pd=1.555u as=0.33825p ps=1.645u w=0.82u l=0.6u
.ends

.subckt gf180mcu_fd_sc_mcu7t5v0__nand3_2 A1 A2 A3 ZN VDD VNW VPW VSS
X0 ZN A1 VDD VNW pfet_05v0 ad=0.2561p pd=1.505u as=0.2561p ps=1.505u w=0.985u l=0.5u
X1 VDD A1 ZN VNW pfet_05v0 ad=0.2561p pd=1.505u as=0.2561p ps=1.505u w=0.985u l=0.5u
X2 a_1044_68# A2 a_860_68# VPW nfet_05v0 ad=0.1722p pd=1.24u as=0.1312p ps=1.14u w=0.82u l=0.6u
X3 a_860_68# A1 ZN VPW nfet_05v0 ad=0.1312p pd=1.14u as=0.2132p ps=1.34u w=0.82u l=0.6u
X4 ZN A2 VDD VNW pfet_05v0 ad=0.2561p pd=1.505u as=0.2561p ps=1.505u w=0.985u l=0.5u
X5 VDD A3 ZN VNW pfet_05v0 ad=0.4334p pd=2.85u as=0.2561p ps=1.505u w=0.985u l=0.5u
X6 VSS A3 a_1044_68# VPW nfet_05v0 ad=0.3608p pd=2.52u as=0.1722p ps=1.24u w=0.82u l=0.6u
X7 a_276_68# A3 VSS VPW nfet_05v0 ad=0.1148p pd=1.1u as=0.3608p ps=2.52u w=0.82u l=0.6u
X8 ZN A3 VDD VNW pfet_05v0 ad=0.2561p pd=1.505u as=0.4334p ps=2.85u w=0.985u l=0.5u
X9 VDD A2 ZN VNW pfet_05v0 ad=0.2561p pd=1.505u as=0.2561p ps=1.505u w=0.985u l=0.5u
X10 a_452_68# A2 a_276_68# VPW nfet_05v0 ad=0.1312p pd=1.14u as=0.1148p ps=1.1u w=0.82u l=0.6u
X11 ZN A1 a_452_68# VPW nfet_05v0 ad=0.2132p pd=1.34u as=0.1312p ps=1.14u w=0.82u l=0.6u
.ends

.subckt gf180mcu_fd_sc_mcu7t5v0__nand3_1 A1 A2 A3 ZN VDD VNW VPW VSS
X0 ZN A1 a_455_68# VPW nfet_05v0 ad=0.3608p pd=2.52u as=0.1722p ps=1.24u w=0.82u l=0.6u
X1 ZN A3 VDD VNW pfet_05v0 ad=0.2561p pd=1.505u as=0.4334p ps=2.85u w=0.985u l=0.5u
X2 VDD A2 ZN VNW pfet_05v0 ad=0.2561p pd=1.505u as=0.2561p ps=1.505u w=0.985u l=0.5u
X3 ZN A1 VDD VNW pfet_05v0 ad=0.4334p pd=2.85u as=0.2561p ps=1.505u w=0.985u l=0.5u
X4 a_271_68# A3 VSS VPW nfet_05v0 ad=0.1312p pd=1.14u as=0.3608p ps=2.52u w=0.82u l=0.6u
X5 a_455_68# A2 a_271_68# VPW nfet_05v0 ad=0.1722p pd=1.24u as=0.1312p ps=1.14u w=0.82u l=0.6u
.ends

.subckt gf180mcu_fd_sc_mcu7t5v0__oai221_4 A1 A2 B1 B2 C ZN VDD VNW VPW VSS
X0 VDD B2 a_244_497# VNW pfet_05v0 ad=0.2847p pd=1.615u as=0.33945p ps=1.715u w=1.095u l=0.5u
X1 ZN A1 a_1972_93# VPW nfet_05v0 ad=0.2132p pd=1.34u as=0.2132p ps=1.34u w=0.82u l=0.6u
X2 VDD A2 a_3076_497# VNW pfet_05v0 ad=0.2847p pd=1.615u as=0.33945p ps=1.715u w=1.095u l=0.5u
X3 a_244_68# C a_1972_93# VPW nfet_05v0 ad=0.2132p pd=1.34u as=0.2132p ps=1.34u w=0.82u l=0.6u
X4 a_1972_93# A2 ZN VPW nfet_05v0 ad=0.2132p pd=1.34u as=0.2132p ps=1.34u w=0.82u l=0.6u
X5 a_672_497# B2 VDD VNW pfet_05v0 ad=0.3942p pd=1.815u as=0.2847p ps=1.615u w=1.095u l=0.5u
X6 a_244_68# B2 VSS VPW nfet_05v0 ad=0.2132p pd=1.34u as=0.2132p ps=1.34u w=0.82u l=0.6u
X7 ZN A1 a_1972_93# VPW nfet_05v0 ad=0.2132p pd=1.34u as=0.2132p ps=1.34u w=0.82u l=0.6u
X8 ZN B1 a_1568_497# VNW pfet_05v0 ad=0.66645p pd=2.435u as=0.3942p ps=1.815u w=1.095u l=0.5u
X9 a_3504_497# A2 VDD VNW pfet_05v0 ad=0.3942p pd=1.815u as=0.2847p ps=1.615u w=1.095u l=0.5u
X10 VDD A2 a_3952_497# VNW pfet_05v0 ad=0.2847p pd=1.615u as=0.3942p ps=1.815u w=1.095u l=0.5u
X11 a_244_68# B1 VSS VPW nfet_05v0 ad=0.2132p pd=1.34u as=0.3608p ps=2.52u w=0.82u l=0.6u
X12 ZN A2 a_1972_93# VPW nfet_05v0 ad=0.2132p pd=1.34u as=0.2132p ps=1.34u w=0.82u l=0.6u
X13 a_1972_93# A1 ZN VPW nfet_05v0 ad=0.3608p pd=2.52u as=0.30965p ps=1.685u w=0.82u l=0.6u
X14 ZN A1 a_3504_497# VNW pfet_05v0 ad=0.2847p pd=1.615u as=0.3942p ps=1.815u w=1.095u l=0.5u
X15 ZN A2 a_1972_93# VPW nfet_05v0 ad=0.30965p pd=1.685u as=0.2132p ps=1.34u w=0.82u l=0.6u
X16 a_244_68# B2 VSS VPW nfet_05v0 ad=0.2132p pd=1.34u as=0.2132p ps=1.34u w=0.82u l=0.6u
X17 a_1972_93# C a_244_68# VPW nfet_05v0 ad=0.2132p pd=1.34u as=0.2132p ps=1.34u w=0.82u l=0.6u
X18 a_3952_497# A1 ZN VNW pfet_05v0 ad=0.3942p pd=1.815u as=0.2847p ps=1.615u w=1.095u l=0.5u
X19 VDD C ZN VNW pfet_05v0 ad=0.2431p pd=1.455u as=0.66645p ps=2.435u w=0.935u l=0.5u
X20 a_1972_93# C a_244_68# VPW nfet_05v0 ad=0.2132p pd=1.34u as=0.2132p ps=1.34u w=0.82u l=0.6u
X21 a_244_497# B1 ZN VNW pfet_05v0 ad=0.33945p pd=1.715u as=0.4818p ps=3.07u w=1.095u l=0.5u
X22 ZN B1 a_672_497# VNW pfet_05v0 ad=0.2847p pd=1.615u as=0.3942p ps=1.815u w=1.095u l=0.5u
X23 ZN C VDD VNW pfet_05v0 ad=0.3366p pd=1.655u as=0.2431p ps=1.455u w=0.935u l=0.5u
X24 a_3076_497# A1 ZN VNW pfet_05v0 ad=0.33945p pd=1.715u as=0.3686p ps=1.815u w=1.095u l=0.5u
X25 a_4400_497# A2 VDD VNW pfet_05v0 ad=0.4599p pd=1.935u as=0.2847p ps=1.615u w=1.095u l=0.5u
X26 a_1972_93# A2 ZN VPW nfet_05v0 ad=0.2132p pd=1.34u as=0.2132p ps=1.34u w=0.82u l=0.6u
X27 VSS B1 a_244_68# VPW nfet_05v0 ad=0.3608p pd=2.52u as=0.2132p ps=1.34u w=0.82u l=0.6u
X28 a_1120_497# B1 ZN VNW pfet_05v0 ad=0.3942p pd=1.815u as=0.2847p ps=1.615u w=1.095u l=0.5u
X29 VSS B2 a_244_68# VPW nfet_05v0 ad=0.2132p pd=1.34u as=0.2132p ps=1.34u w=0.82u l=0.6u
X30 VDD B2 a_1120_497# VNW pfet_05v0 ad=0.2847p pd=1.615u as=0.3942p ps=1.815u w=1.095u l=0.5u
X31 a_244_68# C a_1972_93# VPW nfet_05v0 ad=0.2132p pd=1.34u as=0.3608p ps=2.52u w=0.82u l=0.6u
X32 ZN A1 a_4400_497# VNW pfet_05v0 ad=0.4818p pd=3.07u as=0.4599p ps=1.935u w=1.095u l=0.5u
X33 VSS B1 a_244_68# VPW nfet_05v0 ad=0.2132p pd=1.34u as=0.2132p ps=1.34u w=0.82u l=0.6u
X34 a_1568_497# B2 VDD VNW pfet_05v0 ad=0.3942p pd=1.815u as=0.2847p ps=1.615u w=1.095u l=0.5u
X35 VDD C ZN VNW pfet_05v0 ad=0.2431p pd=1.455u as=0.3366p ps=1.655u w=0.935u l=0.5u
X36 VSS B2 a_244_68# VPW nfet_05v0 ad=0.2132p pd=1.34u as=0.2132p ps=1.34u w=0.82u l=0.6u
X37 a_1972_93# A1 ZN VPW nfet_05v0 ad=0.2132p pd=1.34u as=0.2132p ps=1.34u w=0.82u l=0.6u
X38 ZN C VDD VNW pfet_05v0 ad=0.3686p pd=1.815u as=0.2431p ps=1.455u w=0.935u l=0.5u
X39 a_244_68# B1 VSS VPW nfet_05v0 ad=0.2132p pd=1.34u as=0.2132p ps=1.34u w=0.82u l=0.6u
.ends

.subckt gf180mcu_fd_sc_mcu7t5v0__oai21_4 A1 A2 B ZN VDD VNW VPW VSS
X0 ZN A1 a_36_68# VPW nfet_05v0 ad=0.2132p pd=1.34u as=0.2132p ps=1.34u w=0.82u l=0.6u
X1 a_716_497# A1 ZN VNW pfet_05v0 ad=0.3942p pd=1.815u as=0.2847p ps=1.615u w=1.095u l=0.5u
X2 VDD B ZN VNW pfet_05v0 ad=0.4202p pd=2.79u as=0.2483p ps=1.475u w=0.955u l=0.5u
X3 VSS B a_36_68# VPW nfet_05v0 ad=0.2132p pd=1.34u as=0.2132p ps=1.34u w=0.82u l=0.6u
X4 VDD A2 a_716_497# VNW pfet_05v0 ad=0.2847p pd=1.615u as=0.3942p ps=1.815u w=1.095u l=0.5u
X5 VSS B a_36_68# VPW nfet_05v0 ad=0.2132p pd=1.34u as=0.30715p ps=1.685u w=0.82u l=0.6u
X6 ZN A2 a_36_68# VPW nfet_05v0 ad=0.30965p pd=1.685u as=0.3608p ps=2.52u w=0.82u l=0.6u
X7 a_36_68# A2 ZN VPW nfet_05v0 ad=0.2132p pd=1.34u as=0.2132p ps=1.34u w=0.82u l=0.6u
X8 a_1164_497# A2 VDD VNW pfet_05v0 ad=0.3942p pd=1.815u as=0.2847p ps=1.615u w=1.095u l=0.5u
X9 VDD A2 a_1612_497# VNW pfet_05v0 ad=0.5246p pd=2.135u as=0.33945p ps=1.715u w=1.095u l=0.5u
X10 a_36_68# A1 ZN VPW nfet_05v0 ad=0.2132p pd=1.34u as=0.30965p ps=1.685u w=0.82u l=0.6u
X11 a_36_68# A2 ZN VPW nfet_05v0 ad=0.30715p pd=1.685u as=0.2132p ps=1.34u w=0.82u l=0.6u
X12 a_36_68# A1 ZN VPW nfet_05v0 ad=0.2132p pd=1.34u as=0.2132p ps=1.34u w=0.82u l=0.6u
X13 ZN A1 a_1164_497# VNW pfet_05v0 ad=0.2847p pd=1.615u as=0.3942p ps=1.815u w=1.095u l=0.5u
X14 a_1612_497# A1 ZN VNW pfet_05v0 ad=0.33945p pd=1.715u as=0.2847p ps=1.615u w=1.095u l=0.5u
X15 ZN B VDD VNW pfet_05v0 ad=0.2483p pd=1.475u as=0.5246p ps=2.135u w=0.955u l=0.5u
X16 a_36_68# B VSS VPW nfet_05v0 ad=0.3608p pd=2.52u as=0.2132p ps=1.34u w=0.82u l=0.6u
X17 ZN A1 a_36_68# VPW nfet_05v0 ad=0.2132p pd=1.34u as=0.2132p ps=1.34u w=0.82u l=0.6u
X18 a_36_68# B VSS VPW nfet_05v0 ad=0.2132p pd=1.34u as=0.2132p ps=1.34u w=0.82u l=0.6u
X19 VDD B ZN VNW pfet_05v0 ad=0.2483p pd=1.475u as=0.2483p ps=1.475u w=0.955u l=0.5u
X20 ZN A2 a_36_68# VPW nfet_05v0 ad=0.2132p pd=1.34u as=0.2132p ps=1.34u w=0.82u l=0.6u
X21 a_224_497# A2 VDD VNW pfet_05v0 ad=0.51465p pd=2.035u as=0.4818p ps=3.07u w=1.095u l=0.5u
X22 ZN B VDD VNW pfet_05v0 ad=0.2483p pd=1.475u as=0.2483p ps=1.475u w=0.955u l=0.5u
X23 ZN A1 a_224_497# VNW pfet_05v0 ad=0.2847p pd=1.615u as=0.51465p ps=2.035u w=1.095u l=0.5u
.ends

.subckt gf180mcu_fd_sc_mcu7t5v0__and2_2 A1 A2 Z VDD VNW VPW VSS
X0 a_247_68# A1 a_39_68# VPW nfet_05v0 ad=0.1304p pd=1.135u as=0.3586p ps=2.51u w=0.815u l=0.6u
X1 Z a_39_68# VDD VNW pfet_05v0 ad=0.3159p pd=1.735u as=0.4278p ps=1.955u w=1.215u l=0.5u
X2 Z a_39_68# VSS VPW nfet_05v0 ad=0.22005p pd=1.355u as=0.2119p ps=1.335u w=0.815u l=0.6u
X3 VDD a_39_68# Z VNW pfet_05v0 ad=0.5346p pd=3.31u as=0.3159p ps=1.735u w=1.215u l=0.5u
X4 a_39_68# A1 VDD VNW pfet_05v0 ad=0.2782p pd=1.59u as=0.4708p ps=3.02u w=1.07u l=0.5u
X5 VSS a_39_68# Z VPW nfet_05v0 ad=0.3586p pd=2.51u as=0.22005p ps=1.355u w=0.815u l=0.6u
X6 VDD A2 a_39_68# VNW pfet_05v0 ad=0.4278p pd=1.955u as=0.2782p ps=1.59u w=1.07u l=0.5u
X7 VSS A2 a_247_68# VPW nfet_05v0 ad=0.2119p pd=1.335u as=0.1304p ps=1.135u w=0.815u l=0.6u
.ends

.subckt gf180mcu_fd_sc_mcu7t5v0__nor3_1 A1 A2 A3 ZN VDD VNW VPW VSS
X0 ZN A1 a_448_472# VNW pfet_05v0 ad=0.5368p pd=3.32u as=0.3782p ps=1.84u w=1.22u l=0.5u
X1 ZN A1 VSS VPW nfet_05v0 ad=0.2046p pd=1.81u as=0.1209p ps=0.985u w=0.465u l=0.6u
X2 a_244_472# A3 VDD VNW pfet_05v0 ad=0.3172p pd=1.74u as=0.5368p ps=3.32u w=1.22u l=0.5u
X3 a_448_472# A2 a_244_472# VNW pfet_05v0 ad=0.3782p pd=1.84u as=0.3172p ps=1.74u w=1.22u l=0.5u
X4 VSS A2 ZN VPW nfet_05v0 ad=0.1209p pd=0.985u as=0.1209p ps=0.985u w=0.465u l=0.6u
X5 ZN A3 VSS VPW nfet_05v0 ad=0.1209p pd=0.985u as=0.2046p ps=1.81u w=0.465u l=0.6u
.ends

.subckt gf180mcu_fd_sc_mcu7t5v0__clkinv_2 I ZN VDD VNW VPW VSS
X0 ZN I VSS VPW nfet_05v0 ad=0.1248p pd=1u as=0.2112p ps=1.84u w=0.48u l=0.6u
X1 VDD I ZN VNW pfet_05v0 ad=0.5368p pd=3.32u as=0.3782p ps=1.84u w=1.22u l=0.5u
X2 ZN I VDD VNW pfet_05v0 ad=0.3782p pd=1.84u as=0.5368p ps=3.32u w=1.22u l=0.5u
X3 VSS I ZN VPW nfet_05v0 ad=0.2112p pd=1.84u as=0.1248p ps=1u w=0.48u l=0.6u
.ends

.subckt gf180mcu_fd_sc_mcu7t5v0__inv_2 I ZN VDD VNW VPW VSS
X0 VDD I ZN VNW pfet_05v0 ad=0.5368p pd=3.32u as=0.4575p ps=1.97u w=1.22u l=0.5u
X1 ZN I VSS VPW nfet_05v0 ad=0.2255p pd=1.37u as=0.3608p ps=2.52u w=0.82u l=0.6u
X2 VSS I ZN VPW nfet_05v0 ad=0.3608p pd=2.52u as=0.2255p ps=1.37u w=0.82u l=0.6u
X3 ZN I VDD VNW pfet_05v0 ad=0.4575p pd=1.97u as=0.5368p ps=3.32u w=1.22u l=0.5u
.ends

.subckt gf180mcu_fd_sc_mcu7t5v0__aoi211_1 A1 A2 B C ZN VDD VNW VPW VSS
X0 ZN A2 a_37_472# VNW pfet_05v0 ad=0.3159p pd=1.735u as=0.5346p ps=3.31u w=1.215u l=0.5u
X1 VSS B ZN VPW nfet_05v0 ad=0.1209p pd=0.985u as=0.21175p ps=1.41u w=0.465u l=0.6u
X2 a_37_472# A1 ZN VNW pfet_05v0 ad=0.37665p pd=1.835u as=0.3159p ps=1.735u w=1.215u l=0.5u
X3 VDD C a_653_472# VNW pfet_05v0 ad=0.5346p pd=3.31u as=0.37665p ps=1.835u w=1.215u l=0.5u
X4 a_245_90# A2 VSS VPW nfet_05v0 ad=85.2f pd=0.95u as=0.3124p ps=2.3u w=0.71u l=0.6u
X5 ZN A1 a_245_90# VPW nfet_05v0 ad=0.21175p pd=1.41u as=85.2f ps=0.95u w=0.71u l=0.6u
X6 a_653_472# B a_37_472# VNW pfet_05v0 ad=0.37665p pd=1.835u as=0.37665p ps=1.835u w=1.215u l=0.5u
X7 ZN C VSS VPW nfet_05v0 ad=0.2046p pd=1.81u as=0.1209p ps=0.985u w=0.465u l=0.6u
.ends

.subckt gf180mcu_fd_sc_mcu7t5v0__oai21_2 A1 A2 B ZN VDD VNW VPW VSS
X0 ZN A1 a_692_497# VNW pfet_05v0 ad=0.2847p pd=1.615u as=0.4599p ps=1.935u w=1.095u l=0.5u
X1 ZN A2 a_36_68# VPW nfet_05v0 ad=0.30965p pd=1.685u as=0.2132p ps=1.34u w=0.82u l=0.6u
X2 VSS B a_36_68# VPW nfet_05v0 ad=0.2132p pd=1.34u as=0.3608p ps=2.52u w=0.82u l=0.6u
X3 a_36_68# A2 ZN VPW nfet_05v0 ad=0.3608p pd=2.52u as=0.31215p ps=1.685u w=0.82u l=0.6u
X4 a_36_68# A1 ZN VPW nfet_05v0 ad=0.2132p pd=1.34u as=0.30965p ps=1.685u w=0.82u l=0.6u
X5 a_1164_497# A1 ZN VNW pfet_05v0 ad=0.4599p pd=1.935u as=0.2847p ps=1.615u w=1.095u l=0.5u
X6 ZN B VDD VNW pfet_05v0 ad=0.2483p pd=1.475u as=0.4202p ps=2.79u w=0.955u l=0.5u
X7 a_692_497# A2 VDD VNW pfet_05v0 ad=0.4599p pd=1.935u as=0.3718p ps=1.815u w=1.095u l=0.5u
X8 VDD B ZN VNW pfet_05v0 ad=0.3718p pd=1.815u as=0.2483p ps=1.475u w=0.955u l=0.5u
X9 VDD A2 a_1164_497# VNW pfet_05v0 ad=0.4818p pd=3.07u as=0.4599p ps=1.935u w=1.095u l=0.5u
X10 a_36_68# B VSS VPW nfet_05v0 ad=0.2132p pd=1.34u as=0.2132p ps=1.34u w=0.82u l=0.6u
X11 ZN A1 a_36_68# VPW nfet_05v0 ad=0.31215p pd=1.685u as=0.2132p ps=1.34u w=0.82u l=0.6u
.ends

.subckt gf180mcu_fd_sc_mcu7t5v0__aoi221_2 A1 A2 B1 B2 C ZN VDD VNW VPW VSS
X0 a_56_492# A2 ZN VNW pfet_05v0 ad=0.2912p pd=1.64u as=0.2912p ps=1.64u w=1.12u l=0.5u
X1 a_512_68# B2 VSS VPW nfet_05v0 ad=0.16445p pd=1.175u as=0.21805p ps=1.455u w=0.715u l=0.6u
X2 ZN C VSS VPW nfet_05v0 ad=0.23355p pd=1.43u as=0.6525p ps=2.695u w=0.575u l=0.6u
X3 a_244_492# B2 VDD VNW pfet_05v0 ad=0.7056p pd=2.38u as=0.5664p ps=2.24u w=1.12u l=0.5u
X4 a_948_68# B1 ZN VPW nfet_05v0 ad=0.10725p pd=1.015u as=0.1859p ps=1.235u w=0.715u l=0.6u
X5 VSS B2 a_948_68# VPW nfet_05v0 ad=0.6525p pd=2.695u as=0.10725p ps=1.015u w=0.715u l=0.6u
X6 a_56_492# C a_244_492# VNW pfet_05v0 ad=0.3108p pd=1.675u as=0.7056p ps=2.38u w=1.12u l=0.5u
X7 VSS C ZN VPW nfet_05v0 ad=0.21805p pd=1.455u as=0.1782p ps=1.69u w=0.405u l=0.6u
X8 VDD B1 a_244_492# VNW pfet_05v0 ad=0.5664p pd=2.24u as=0.3024p ps=1.66u w=1.12u l=0.5u
X9 a_2267_68# A2 VSS VPW nfet_05v0 ad=85.799995f pd=0.955u as=0.1859p ps=1.235u w=0.715u l=0.6u
X10 a_1875_68# A1 ZN VPW nfet_05v0 ad=85.799995f pd=0.955u as=0.23355p ps=1.43u w=0.715u l=0.6u
X11 VSS A2 a_1875_68# VPW nfet_05v0 ad=0.1859p pd=1.235u as=85.799995f ps=0.955u w=0.715u l=0.6u
X12 ZN A1 a_2267_68# VPW nfet_05v0 ad=0.3146p pd=2.31u as=85.799995f ps=0.955u w=0.715u l=0.6u
X13 a_244_492# B1 VDD VNW pfet_05v0 ad=0.3024p pd=1.66u as=0.5664p ps=2.24u w=1.12u l=0.5u
X14 ZN B1 a_512_68# VPW nfet_05v0 ad=0.1859p pd=1.235u as=0.16445p ps=1.175u w=0.715u l=0.6u
X15 a_244_492# C a_56_492# VNW pfet_05v0 ad=0.2912p pd=1.64u as=0.4928p ps=3.12u w=1.12u l=0.5u
X16 ZN A2 a_56_492# VNW pfet_05v0 ad=0.2912p pd=1.64u as=0.2912p ps=1.64u w=1.12u l=0.5u
X17 VDD B2 a_244_492# VNW pfet_05v0 ad=0.5664p pd=2.24u as=0.2912p ps=1.64u w=1.12u l=0.5u
X18 ZN A1 a_56_492# VNW pfet_05v0 ad=0.2912p pd=1.64u as=0.3108p ps=1.675u w=1.12u l=0.5u
X19 a_56_492# A1 ZN VNW pfet_05v0 ad=0.4928p pd=3.12u as=0.2912p ps=1.64u w=1.12u l=0.5u
.ends

.subckt gf180mcu_fd_sc_mcu7t5v0__aoi22_2 A1 A2 B1 B2 ZN VDD VNW VPW VSS
X0 VDD B1 a_36_472# VNW pfet_05v0 ad=0.3159p pd=1.735u as=0.3159p ps=1.735u w=1.215u l=0.5u
X1 VSS A2 a_1468_69# VPW nfet_05v0 ad=0.3586p pd=2.51u as=0.1304p ps=1.135u w=0.815u l=0.6u
X2 a_36_472# B2 VDD VNW pfet_05v0 ad=0.3159p pd=1.735u as=0.3159p ps=1.735u w=1.215u l=0.5u
X3 ZN A2 a_36_472# VNW pfet_05v0 ad=0.3159p pd=1.735u as=0.3159p ps=1.735u w=1.215u l=0.5u
X4 a_36_472# A1 ZN VNW pfet_05v0 ad=0.3159p pd=1.735u as=0.3159p ps=1.735u w=1.215u l=0.5u
X5 ZN B1 a_244_69# VPW nfet_05v0 ad=0.22615p pd=1.37u as=0.1304p ps=1.135u w=0.815u l=0.6u
X6 a_659_69# B1 ZN VPW nfet_05v0 ad=0.116125p pd=1.1u as=0.22615p ps=1.37u w=0.815u l=0.6u
X7 a_244_69# B2 VSS VPW nfet_05v0 ad=0.1304p pd=1.135u as=0.3586p ps=2.51u w=0.815u l=0.6u
X8 ZN A1 a_36_472# VNW pfet_05v0 ad=0.3159p pd=1.735u as=0.3159p ps=1.735u w=1.215u l=0.5u
X9 a_1468_69# A1 ZN VPW nfet_05v0 ad=0.1304p pd=1.135u as=0.2119p ps=1.335u w=0.815u l=0.6u
X10 a_36_472# A2 ZN VNW pfet_05v0 ad=0.5346p pd=3.31u as=0.3159p ps=1.735u w=1.215u l=0.5u
X11 VSS B2 a_659_69# VPW nfet_05v0 ad=0.2119p pd=1.335u as=0.116125p ps=1.1u w=0.815u l=0.6u
X12 VDD B2 a_36_472# VNW pfet_05v0 ad=0.3159p pd=1.735u as=0.5346p ps=3.31u w=1.215u l=0.5u
X13 ZN A1 a_1060_69# VPW nfet_05v0 ad=0.2119p pd=1.335u as=0.1304p ps=1.135u w=0.815u l=0.6u
X14 a_36_472# B1 VDD VNW pfet_05v0 ad=0.3159p pd=1.735u as=0.3159p ps=1.735u w=1.215u l=0.5u
X15 a_1060_69# A2 VSS VPW nfet_05v0 ad=0.1304p pd=1.135u as=0.2119p ps=1.335u w=0.815u l=0.6u
.ends

.subckt gf180mcu_fd_sc_mcu7t5v0__nor3_4 A1 A2 A3 ZN VDD VNW VPW VSS
X0 a_672_472# A3 VDD VNW pfet_05v0 ad=0.3782p pd=1.84u as=0.3782p ps=1.84u w=1.22u l=0.5u
X1 ZN A1 a_36_472# VNW pfet_05v0 ad=0.3782p pd=1.84u as=0.3782p ps=1.84u w=1.22u l=0.5u
X2 ZN A1 VSS VPW nfet_05v0 ad=0.1209p pd=0.985u as=0.1209p ps=0.985u w=0.465u l=0.6u
X3 VDD A3 a_1120_472# VNW pfet_05v0 ad=0.3782p pd=1.84u as=0.3782p ps=1.84u w=1.22u l=0.5u
X4 ZN A1 a_1792_472# VNW pfet_05v0 ad=0.3782p pd=1.84u as=0.3782p ps=1.84u w=1.22u l=0.5u
X5 VSS A2 ZN VPW nfet_05v0 ad=0.1209p pd=0.985u as=0.1209p ps=0.985u w=0.465u l=0.6u
X6 VSS A3 ZN VPW nfet_05v0 ad=0.1209p pd=0.985u as=0.1209p ps=0.985u w=0.465u l=0.6u
X7 a_1792_472# A2 a_1568_472# VNW pfet_05v0 ad=0.3782p pd=1.84u as=0.3782p ps=1.84u w=1.22u l=0.5u
X8 VSS A1 ZN VPW nfet_05v0 ad=0.1209p pd=0.985u as=0.1209p ps=0.985u w=0.465u l=0.6u
X9 VDD A3 a_224_472# VNW pfet_05v0 ad=0.3782p pd=1.84u as=0.3782p ps=1.84u w=1.22u l=0.5u
X10 VSS A2 ZN VPW nfet_05v0 ad=0.1209p pd=0.985u as=0.1209p ps=0.985u w=0.465u l=0.6u
X11 a_36_472# A1 ZN VNW pfet_05v0 ad=0.3782p pd=1.84u as=0.3782p ps=1.84u w=1.22u l=0.5u
X12 VSS A3 ZN VPW nfet_05v0 ad=0.1209p pd=0.985u as=0.1209p ps=0.985u w=0.465u l=0.6u
X13 a_1120_472# A2 a_36_472# VNW pfet_05v0 ad=0.3782p pd=1.84u as=0.3782p ps=1.84u w=1.22u l=0.5u
X14 ZN A2 VSS VPW nfet_05v0 ad=0.1209p pd=0.985u as=0.1209p ps=0.985u w=0.465u l=0.6u
X15 a_36_472# A2 a_672_472# VNW pfet_05v0 ad=0.3782p pd=1.84u as=0.3782p ps=1.84u w=1.22u l=0.5u
X16 a_36_472# A1 ZN VNW pfet_05v0 ad=0.5368p pd=3.32u as=0.3782p ps=1.84u w=1.22u l=0.5u
X17 a_1568_472# A3 VDD VNW pfet_05v0 ad=0.3782p pd=1.84u as=0.3782p ps=1.84u w=1.22u l=0.5u
X18 ZN A3 VSS VPW nfet_05v0 ad=0.1209p pd=0.985u as=0.1209p ps=0.985u w=0.465u l=0.6u
X19 VSS A1 ZN VPW nfet_05v0 ad=0.2046p pd=1.81u as=0.1209p ps=0.985u w=0.465u l=0.6u
X20 ZN A2 VSS VPW nfet_05v0 ad=0.1209p pd=0.985u as=0.2046p ps=1.81u w=0.465u l=0.6u
X21 a_224_472# A2 a_36_472# VNW pfet_05v0 ad=0.3782p pd=1.84u as=0.5368p ps=3.32u w=1.22u l=0.5u
X22 ZN A1 VSS VPW nfet_05v0 ad=0.1209p pd=0.985u as=0.1209p ps=0.985u w=0.465u l=0.6u
X23 ZN A3 VSS VPW nfet_05v0 ad=0.1209p pd=0.985u as=0.1209p ps=0.985u w=0.465u l=0.6u
.ends

.subckt gf180mcu_fd_sc_mcu7t5v0__inv_3 I ZN VDD VNW VPW VSS
X0 ZN I VDD VNW pfet_05v0 ad=0.5368p pd=3.32u as=0.3172p ps=1.74u w=1.22u l=0.5u
X1 ZN I VSS VPW nfet_05v0 ad=0.3608p pd=2.52u as=0.2132p ps=1.34u w=0.82u l=0.6u
X2 ZN I VSS VPW nfet_05v0 ad=0.2132p pd=1.34u as=0.3608p ps=2.52u w=0.82u l=0.6u
X3 ZN I VDD VNW pfet_05v0 ad=0.4392p pd=1.94u as=0.5368p ps=3.32u w=1.22u l=0.5u
X4 VSS I ZN VPW nfet_05v0 ad=0.2132p pd=1.34u as=0.2132p ps=1.34u w=0.82u l=0.6u
X5 VDD I ZN VNW pfet_05v0 ad=0.3172p pd=1.74u as=0.4392p ps=1.94u w=1.22u l=0.5u
.ends

.subckt gf180mcu_fd_sc_mcu7t5v0__dffq_4 D CLK Q VDD VNW VPW VSS
X0 VSS CLK a_36_151# VPW nfet_05v0 ad=0.1053p pd=0.925u as=0.1782p ps=1.69u w=0.405u l=0.6u
X1 VDD a_2011_527# a_2304_115# VNW pfet_05v0 ad=0.38575p pd=1.92u as=0.2457p ps=1.465u w=0.945u l=0.5u
X2 a_1004_159# D a_836_159# VPW nfet_05v0 ad=0.207p pd=1.51u as=43.199997f ps=0.6u w=0.36u l=0.6u
X3 VSS a_2304_115# Q VPW nfet_05v0 ad=0.3586p pd=2.51u as=0.2119p ps=1.335u w=0.815u l=0.6u
X4 a_2304_115# a_2011_527# VSS VPW nfet_05v0 ad=0.2119p pd=1.335u as=0.2333p ps=1.555u w=0.815u l=0.6u
X5 a_1004_159# D a_880_527# VNW pfet_05v0 ad=0.1872p pd=1.4u as=53.999996f ps=0.66u w=0.36u l=0.5u
X6 a_2011_527# a_36_151# a_1376_115# VNW pfet_05v0 ad=0.1665p pd=1.285u as=0.1791p ps=1.355u w=0.36u l=0.5u
X7 a_2296_527# a_448_472# a_2011_527# VNW pfet_05v0 ad=50.399998f pd=0.64u as=0.1665p ps=1.285u w=0.36u l=0.5u
X8 Q a_2304_115# VDD VNW pfet_05v0 ad=0.4392p pd=1.94u as=0.38575p ps=1.92u w=1.22u l=0.5u
X9 VSS a_2304_115# Q VPW nfet_05v0 ad=0.2119p pd=1.335u as=0.2119p ps=1.335u w=0.815u l=0.6u
X10 a_1376_115# a_1004_159# VDD VNW pfet_05v0 ad=0.1791p pd=1.355u as=0.1044p ps=0.94u w=0.36u l=0.5u
X11 VDD CLK a_36_151# VNW pfet_05v0 ad=0.2249p pd=1.385u as=0.3806p ps=2.61u w=0.865u l=0.5u
X12 VDD a_2304_115# Q VNW pfet_05v0 ad=0.3172p pd=1.74u as=0.4392p ps=1.94u w=1.22u l=0.5u
X13 VSS a_1376_115# a_1328_159# VPW nfet_05v0 ad=0.2637p pd=1.825u as=43.199997f ps=0.6u w=0.36u l=0.6u
X14 a_2011_527# a_448_472# a_1376_115# VPW nfet_05v0 ad=93.59999f pd=0.88u as=93.59999f ps=0.88u w=0.36u l=0.6u
X15 Q a_2304_115# VDD VNW pfet_05v0 ad=0.4392p pd=1.94u as=0.3172p ps=1.74u w=1.22u l=0.5u
X16 a_448_472# a_36_151# VDD VNW pfet_05v0 ad=0.3806p pd=2.61u as=0.2249p ps=1.385u w=0.865u l=0.5u
X17 Q a_2304_115# VSS VPW nfet_05v0 ad=0.2119p pd=1.335u as=0.2119p ps=1.335u w=0.815u l=0.6u
X18 a_1376_115# a_1004_159# VSS VPW nfet_05v0 ad=93.59999f pd=0.88u as=0.2637p ps=1.825u w=0.36u l=0.6u
X19 VSS a_2304_115# a_2256_159# VPW nfet_05v0 ad=0.2333p pd=1.555u as=43.199997f ps=0.6u w=0.36u l=0.6u
X20 Q a_2304_115# VSS VPW nfet_05v0 ad=0.2119p pd=1.335u as=0.2608p ps=1.455u w=0.815u l=0.6u
X21 a_836_159# a_36_151# VSS VPW nfet_05v0 ad=43.199997f pd=0.6u as=0.1584p ps=1.6u w=0.36u l=0.6u
X22 a_448_472# a_36_151# VSS VPW nfet_05v0 ad=0.1782p pd=1.69u as=0.1053p ps=0.925u w=0.405u l=0.6u
X23 a_2256_159# a_36_151# a_2011_527# VPW nfet_05v0 ad=43.199997f pd=0.6u as=93.59999f ps=0.88u w=0.36u l=0.6u
X24 a_880_527# a_448_472# VDD VNW pfet_05v0 ad=53.999996f pd=0.66u as=0.4554p ps=3.25u w=0.36u l=0.5u
X25 a_1348_527# a_36_151# a_1004_159# VNW pfet_05v0 ad=43.199997f pd=0.6u as=0.1872p ps=1.4u w=0.36u l=0.5u
X26 VDD a_2304_115# Q VNW pfet_05v0 ad=0.5368p pd=3.32u as=0.4392p ps=1.94u w=1.22u l=0.5u
X27 a_1328_159# a_448_472# a_1004_159# VPW nfet_05v0 ad=43.199997f pd=0.6u as=0.207p ps=1.51u w=0.36u l=0.6u
X28 VDD a_1376_115# a_1348_527# VNW pfet_05v0 ad=0.1044p pd=0.94u as=43.199997f ps=0.6u w=0.36u l=0.5u
X29 VSS a_2011_527# a_2304_115# VPW nfet_05v0 ad=0.2608p pd=1.455u as=0.2119p ps=1.335u w=0.815u l=0.6u
X30 VDD a_2304_115# a_2296_527# VNW pfet_05v0 ad=0.2619p pd=1.685u as=50.399998f ps=0.64u w=0.36u l=0.5u
X31 a_2304_115# a_2011_527# VDD VNW pfet_05v0 ad=0.2457p pd=1.465u as=0.2619p ps=1.685u w=0.945u l=0.5u
.ends

.subckt gf180mcu_fd_sc_mcu7t5v0__buf_12 I Z VDD VNW VPW VSS
X0 a_224_472# I VDD VNW pfet_05v0 ad=0.3782p pd=1.84u as=0.3782p ps=1.84u w=1.22u l=0.5u
X1 VDD a_224_472# Z VNW pfet_05v0 ad=0.3782p pd=1.84u as=0.3782p ps=1.84u w=1.22u l=0.5u
X2 Z a_224_472# VDD VNW pfet_05v0 ad=0.3782p pd=1.84u as=0.3782p ps=1.84u w=1.22u l=0.5u
X3 a_224_472# I VSS VPW nfet_05v0 ad=0.2132p pd=1.34u as=0.2132p ps=1.34u w=0.82u l=0.6u
X4 VSS a_224_472# Z VPW nfet_05v0 ad=0.2132p pd=1.34u as=0.2132p ps=1.34u w=0.82u l=0.6u
X5 VSS a_224_472# Z VPW nfet_05v0 ad=0.3608p pd=2.52u as=0.2132p ps=1.34u w=0.82u l=0.6u
X6 VDD I a_224_472# VNW pfet_05v0 ad=0.3782p pd=1.84u as=0.3782p ps=1.84u w=1.22u l=0.5u
X7 Z a_224_472# VDD VNW pfet_05v0 ad=0.3782p pd=1.84u as=0.3782p ps=1.84u w=1.22u l=0.5u
X8 a_224_472# I VSS VPW nfet_05v0 ad=0.2132p pd=1.34u as=0.3608p ps=2.52u w=0.82u l=0.6u
X9 Z a_224_472# VSS VPW nfet_05v0 ad=0.2132p pd=1.34u as=0.2132p ps=1.34u w=0.82u l=0.6u
X10 VSS a_224_472# Z VPW nfet_05v0 ad=0.2132p pd=1.34u as=0.2132p ps=1.34u w=0.82u l=0.6u
X11 VSS a_224_472# Z VPW nfet_05v0 ad=0.2132p pd=1.34u as=0.2132p ps=1.34u w=0.82u l=0.6u
X12 VDD a_224_472# Z VNW pfet_05v0 ad=0.3782p pd=1.84u as=0.3782p ps=1.84u w=1.22u l=0.5u
X13 Z a_224_472# VSS VPW nfet_05v0 ad=0.2132p pd=1.34u as=0.2132p ps=1.34u w=0.82u l=0.6u
X14 Z a_224_472# VSS VPW nfet_05v0 ad=0.2132p pd=1.34u as=0.2132p ps=1.34u w=0.82u l=0.6u
X15 Z a_224_472# VDD VNW pfet_05v0 ad=0.3782p pd=1.84u as=0.3782p ps=1.84u w=1.22u l=0.5u
X16 Z a_224_472# VSS VPW nfet_05v0 ad=0.2132p pd=1.34u as=0.2132p ps=1.34u w=0.82u l=0.6u
X17 VDD I a_224_472# VNW pfet_05v0 ad=0.3782p pd=1.84u as=0.3782p ps=1.84u w=1.22u l=0.5u
X18 VDD a_224_472# Z VNW pfet_05v0 ad=0.5368p pd=3.32u as=0.3782p ps=1.84u w=1.22u l=0.5u
X19 VDD a_224_472# Z VNW pfet_05v0 ad=0.3782p pd=1.84u as=0.3782p ps=1.84u w=1.22u l=0.5u
X20 Z a_224_472# VDD VNW pfet_05v0 ad=0.3782p pd=1.84u as=0.3782p ps=1.84u w=1.22u l=0.5u
X21 Z a_224_472# VSS VPW nfet_05v0 ad=0.2132p pd=1.34u as=0.2132p ps=1.34u w=0.82u l=0.6u
X22 a_224_472# I VDD VNW pfet_05v0 ad=0.3782p pd=1.84u as=0.3782p ps=1.84u w=1.22u l=0.5u
X23 VSS a_224_472# Z VPW nfet_05v0 ad=0.2132p pd=1.34u as=0.2132p ps=1.34u w=0.82u l=0.6u
X24 VDD I a_224_472# VNW pfet_05v0 ad=0.3782p pd=1.84u as=0.3782p ps=1.84u w=1.22u l=0.5u
X25 VSS I a_224_472# VPW nfet_05v0 ad=0.2132p pd=1.34u as=0.2132p ps=1.34u w=0.82u l=0.6u
X26 VDD a_224_472# Z VNW pfet_05v0 ad=0.3782p pd=1.84u as=0.3782p ps=1.84u w=1.22u l=0.5u
X27 VSS a_224_472# Z VPW nfet_05v0 ad=0.2132p pd=1.34u as=0.2132p ps=1.34u w=0.82u l=0.6u
X28 Z a_224_472# VDD VNW pfet_05v0 ad=0.3782p pd=1.84u as=0.3782p ps=1.84u w=1.22u l=0.5u
X29 VSS I a_224_472# VPW nfet_05v0 ad=0.2132p pd=1.34u as=0.2132p ps=1.34u w=0.82u l=0.6u
X30 a_224_472# I VDD VNW pfet_05v0 ad=0.3782p pd=1.84u as=0.5368p ps=3.32u w=1.22u l=0.5u
X31 VDD a_224_472# Z VNW pfet_05v0 ad=0.3782p pd=1.84u as=0.3782p ps=1.84u w=1.22u l=0.5u
X32 VSS I a_224_472# VPW nfet_05v0 ad=0.2132p pd=1.34u as=0.2132p ps=1.34u w=0.82u l=0.6u
X33 Z a_224_472# VSS VPW nfet_05v0 ad=0.2132p pd=1.34u as=0.2132p ps=1.34u w=0.82u l=0.6u
X34 Z a_224_472# VDD VNW pfet_05v0 ad=0.3782p pd=1.84u as=0.3782p ps=1.84u w=1.22u l=0.5u
X35 a_224_472# I VSS VPW nfet_05v0 ad=0.2132p pd=1.34u as=0.2132p ps=1.34u w=0.82u l=0.6u
.ends

.subckt gf180mcu_fd_sc_mcu7t5v0__oai211_1 A1 A2 B C ZN VDD VNW VPW VSS
X0 a_692_68# B a_36_68# VPW nfet_05v0 ad=0.2132p pd=1.34u as=0.2132p ps=1.34u w=0.82u l=0.6u
X1 ZN A2 a_36_68# VPW nfet_05v0 ad=0.2132p pd=1.34u as=0.3608p ps=2.52u w=0.82u l=0.6u
X2 a_244_472# A2 VDD VNW pfet_05v0 ad=0.3172p pd=1.74u as=0.5978p ps=3.42u w=1.22u l=0.5u
X3 VDD B ZN VNW pfet_05v0 ad=0.2561p pd=1.505u as=0.4016p ps=1.94u w=0.985u l=0.5u
X4 ZN A1 a_244_472# VNW pfet_05v0 ad=0.4016p pd=1.94u as=0.3172p ps=1.74u w=1.22u l=0.5u
X5 ZN C VDD VNW pfet_05v0 ad=0.44325p pd=2.87u as=0.2561p ps=1.505u w=0.985u l=0.5u
X6 VSS C a_692_68# VPW nfet_05v0 ad=0.3608p pd=2.52u as=0.2132p ps=1.34u w=0.82u l=0.6u
X7 a_36_68# A1 ZN VPW nfet_05v0 ad=0.2132p pd=1.34u as=0.2132p ps=1.34u w=0.82u l=0.6u
.ends

.subckt gf180mcu_fd_sc_mcu7t5v0__nand4_2 A1 A2 A3 A4 ZN VDD VNW VPW VSS
X0 a_1458_68# A3 a_1254_68# VPW nfet_05v0 ad=0.1517p pd=1.19u as=0.1722p ps=1.24u w=0.82u l=0.6u
X1 a_632_68# A2 a_438_68# VPW nfet_05v0 ad=0.1722p pd=1.24u as=0.1517p ps=1.19u w=0.82u l=0.6u
X2 VDD A4 ZN VNW pfet_05v0 ad=0.2197p pd=1.365u as=0.3718p ps=2.57u w=0.845u l=0.5u
X3 a_244_68# A4 VSS VPW nfet_05v0 ad=0.1517p pd=1.19u as=0.3608p ps=2.52u w=0.82u l=0.6u
X4 ZN A3 VDD VNW pfet_05v0 ad=0.2197p pd=1.365u as=0.2197p ps=1.365u w=0.845u l=0.5u
X5 a_438_68# A3 a_244_68# VPW nfet_05v0 ad=0.1517p pd=1.19u as=0.1517p ps=1.19u w=0.82u l=0.6u
X6 VDD A2 ZN VNW pfet_05v0 ad=0.2197p pd=1.365u as=0.2197p ps=1.365u w=0.845u l=0.5u
X7 ZN A1 a_632_68# VPW nfet_05v0 ad=0.2132p pd=1.34u as=0.1722p ps=1.24u w=0.82u l=0.6u
X8 ZN A1 VDD VNW pfet_05v0 ad=0.2197p pd=1.365u as=0.2197p ps=1.365u w=0.845u l=0.5u
X9 VDD A1 ZN VNW pfet_05v0 ad=0.2197p pd=1.365u as=0.2197p ps=1.365u w=0.845u l=0.5u
X10 a_1060_68# A1 ZN VPW nfet_05v0 ad=0.1517p pd=1.19u as=0.2132p ps=1.34u w=0.82u l=0.6u
X11 a_1254_68# A2 a_1060_68# VPW nfet_05v0 ad=0.1722p pd=1.24u as=0.1517p ps=1.19u w=0.82u l=0.6u
X12 ZN A2 VDD VNW pfet_05v0 ad=0.2197p pd=1.365u as=0.2197p ps=1.365u w=0.845u l=0.5u
X13 VSS A4 a_1458_68# VPW nfet_05v0 ad=0.3608p pd=2.52u as=0.1517p ps=1.19u w=0.82u l=0.6u
X14 VDD A3 ZN VNW pfet_05v0 ad=0.2197p pd=1.365u as=0.2197p ps=1.365u w=0.845u l=0.5u
X15 ZN A4 VDD VNW pfet_05v0 ad=0.3718p pd=2.57u as=0.2197p ps=1.365u w=0.845u l=0.5u
.ends

.subckt gf180mcu_fd_sc_mcu7t5v0__aoi22_4 A1 A2 B1 B2 ZN VDD VNW VPW VSS
X0 a_36_497# B1 VDD VNW pfet_05v0 ad=0.2847p pd=1.615u as=0.2847p ps=1.615u w=1.095u l=0.5u
X1 a_2356_68# A1 ZN VPW nfet_05v0 ad=0.1312p pd=1.14u as=0.2132p ps=1.34u w=0.82u l=0.6u
X2 VDD B1 a_36_497# VNW pfet_05v0 ad=0.2847p pd=1.615u as=0.2847p ps=1.615u w=1.095u l=0.5u
X3 a_244_68# B2 VSS VPW nfet_05v0 ad=0.1312p pd=1.14u as=0.3608p ps=2.52u w=0.82u l=0.6u
X4 ZN B1 a_244_68# VPW nfet_05v0 ad=0.2132p pd=1.34u as=0.1312p ps=1.14u w=0.82u l=0.6u
X5 a_1468_68# B1 ZN VPW nfet_05v0 ad=0.1312p pd=1.14u as=0.2132p ps=1.34u w=0.82u l=0.6u
X6 a_36_497# B2 VDD VNW pfet_05v0 ad=0.2847p pd=1.615u as=0.2847p ps=1.615u w=1.095u l=0.5u
X7 ZN A1 a_2764_68# VPW nfet_05v0 ad=0.4161p pd=1.905u as=0.1312p ps=1.14u w=0.82u l=0.6u
X8 a_2764_68# A2 VSS VPW nfet_05v0 ad=0.1312p pd=1.14u as=0.2132p ps=1.34u w=0.82u l=0.6u
X9 VDD B2 a_36_497# VNW pfet_05v0 ad=0.2847p pd=1.615u as=0.2847p ps=1.615u w=1.095u l=0.5u
X10 ZN A1 a_36_497# VNW pfet_05v0 ad=0.2847p pd=1.615u as=0.5256p ps=2.055u w=1.095u l=0.5u
X11 ZN A1 a_1948_68# VPW nfet_05v0 ad=0.2132p pd=1.34u as=0.1312p ps=1.14u w=0.82u l=0.6u
X12 a_652_68# B1 ZN VPW nfet_05v0 ad=0.1312p pd=1.14u as=0.2132p ps=1.34u w=0.82u l=0.6u
X13 VSS B2 a_652_68# VPW nfet_05v0 ad=0.2132p pd=1.34u as=0.1312p ps=1.14u w=0.82u l=0.6u
X14 VSS A2 a_3260_68# VPW nfet_05v0 ad=0.3608p pd=2.52u as=0.1312p ps=1.14u w=0.82u l=0.6u
X15 a_36_497# A2 ZN VNW pfet_05v0 ad=0.4818p pd=3.07u as=0.2847p ps=1.615u w=1.095u l=0.5u
X16 a_3260_68# A1 ZN VPW nfet_05v0 ad=0.1312p pd=1.14u as=0.4161p ps=1.905u w=0.82u l=0.6u
X17 a_36_497# A1 ZN VNW pfet_05v0 ad=0.2847p pd=1.615u as=0.2847p ps=1.615u w=1.095u l=0.5u
X18 a_36_497# B1 VDD VNW pfet_05v0 ad=0.2847p pd=1.615u as=0.2847p ps=1.615u w=1.095u l=0.5u
X19 ZN B1 a_1060_68# VPW nfet_05v0 ad=0.2132p pd=1.34u as=0.1312p ps=1.14u w=0.82u l=0.6u
X20 ZN A1 a_36_497# VNW pfet_05v0 ad=0.2847p pd=1.615u as=0.2847p ps=1.615u w=1.095u l=0.5u
X21 a_1948_68# A2 VSS VPW nfet_05v0 ad=0.1312p pd=1.14u as=0.3608p ps=1.7u w=0.82u l=0.6u
X22 VSS A2 a_2356_68# VPW nfet_05v0 ad=0.2132p pd=1.34u as=0.1312p ps=1.14u w=0.82u l=0.6u
X23 a_1060_68# B2 VSS VPW nfet_05v0 ad=0.1312p pd=1.14u as=0.2132p ps=1.34u w=0.82u l=0.6u
X24 VDD B1 a_36_497# VNW pfet_05v0 ad=0.2847p pd=1.615u as=0.2847p ps=1.615u w=1.095u l=0.5u
X25 ZN A2 a_36_497# VNW pfet_05v0 ad=0.2847p pd=1.615u as=0.4818p ps=1.975u w=1.095u l=0.5u
X26 a_36_497# A2 ZN VNW pfet_05v0 ad=0.2847p pd=1.615u as=0.2847p ps=1.615u w=1.095u l=0.5u
X27 a_36_497# B2 VDD VNW pfet_05v0 ad=0.4818p pd=1.975u as=0.2847p ps=1.615u w=1.095u l=0.5u
X28 VSS B2 a_1468_68# VPW nfet_05v0 ad=0.3608p pd=1.7u as=0.1312p ps=1.14u w=0.82u l=0.6u
X29 ZN A2 a_36_497# VNW pfet_05v0 ad=0.2847p pd=1.615u as=0.2847p ps=1.615u w=1.095u l=0.5u
X30 a_36_497# A1 ZN VNW pfet_05v0 ad=0.5256p pd=2.055u as=0.2847p ps=1.615u w=1.095u l=0.5u
X31 VDD B2 a_36_497# VNW pfet_05v0 ad=0.2847p pd=1.615u as=0.4818p ps=3.07u w=1.095u l=0.5u
.ends

.subckt gf180mcu_fd_sc_mcu7t5v0__oai211_2 A1 A2 B C ZN VDD VNW VPW VSS
X0 a_1229_68# B a_36_68# VPW nfet_05v0 ad=0.1722p pd=1.24u as=0.21525p ps=1.345u w=0.82u l=0.6u
X1 VDD B ZN VNW pfet_05v0 ad=0.4334p pd=2.85u as=0.2561p ps=1.505u w=0.985u l=0.5u
X2 ZN A1 a_36_68# VPW nfet_05v0 ad=0.30965p pd=1.685u as=0.2132p ps=1.34u w=0.82u l=0.6u
X3 a_716_497# A1 ZN VNW pfet_05v0 ad=0.4599p pd=1.935u as=0.2847p ps=1.615u w=1.095u l=0.5u
X4 a_36_68# B a_1657_68# VPW nfet_05v0 ad=0.3608p pd=2.52u as=0.1312p ps=1.14u w=0.82u l=0.6u
X5 ZN A2 a_36_68# VPW nfet_05v0 ad=0.31215p pd=1.685u as=0.3608p ps=2.52u w=0.82u l=0.6u
X6 VDD A2 a_716_497# VNW pfet_05v0 ad=0.37905p pd=1.82u as=0.4599p ps=1.935u w=1.095u l=0.5u
X7 a_36_68# A1 ZN VPW nfet_05v0 ad=0.2132p pd=1.34u as=0.31215p ps=1.685u w=0.82u l=0.6u
X8 a_244_497# A2 VDD VNW pfet_05v0 ad=0.4599p pd=1.935u as=0.4818p ps=3.07u w=1.095u l=0.5u
X9 a_36_68# A2 ZN VPW nfet_05v0 ad=0.21525p pd=1.345u as=0.30965p ps=1.685u w=0.82u l=0.6u
X10 a_1657_68# C VSS VPW nfet_05v0 ad=0.1312p pd=1.14u as=0.2132p ps=1.34u w=0.82u l=0.6u
X11 ZN B VDD VNW pfet_05v0 ad=0.2561p pd=1.505u as=0.37905p ps=1.82u w=0.985u l=0.5u
X12 VDD C ZN VNW pfet_05v0 ad=0.2561p pd=1.505u as=0.2561p ps=1.505u w=0.985u l=0.5u
X13 VSS C a_1229_68# VPW nfet_05v0 ad=0.2132p pd=1.34u as=0.1722p ps=1.24u w=0.82u l=0.6u
X14 ZN A1 a_244_497# VNW pfet_05v0 ad=0.2847p pd=1.615u as=0.4599p ps=1.935u w=1.095u l=0.5u
X15 ZN C VDD VNW pfet_05v0 ad=0.2561p pd=1.505u as=0.2561p ps=1.505u w=0.985u l=0.5u
.ends

.subckt gf180mcu_fd_sc_mcu7t5v0__clkinv_4 I ZN VDD VNW VPW VSS
X0 ZN I VDD VNW pfet_05v0 ad=0.4392p pd=1.94u as=0.3172p ps=1.74u w=1.22u l=0.5u
X1 VSS I ZN VPW nfet_05v0 ad=0.2112p pd=1.84u as=0.1248p ps=1u w=0.48u l=0.6u
X2 ZN I VSS VPW nfet_05v0 ad=0.1248p pd=1u as=0.2112p ps=1.84u w=0.48u l=0.6u
X3 VDD I ZN VNW pfet_05v0 ad=0.5368p pd=3.32u as=0.4392p ps=1.94u w=1.22u l=0.5u
X4 ZN I VSS VPW nfet_05v0 ad=0.1248p pd=1u as=0.1248p ps=1u w=0.48u l=0.6u
X5 ZN I VDD VNW pfet_05v0 ad=0.4392p pd=1.94u as=0.5368p ps=3.32u w=1.22u l=0.5u
X6 VDD I ZN VNW pfet_05v0 ad=0.3172p pd=1.74u as=0.4392p ps=1.94u w=1.22u l=0.5u
X7 VSS I ZN VPW nfet_05v0 ad=0.1248p pd=1u as=0.1248p ps=1u w=0.48u l=0.6u
.ends

.subckt gf180mcu_fd_sc_mcu7t5v0__buf_16 I Z VDD VNW VPW VSS
X0 Z a_224_472# VSS VPW nfet_05v0 ad=0.2132p pd=1.34u as=0.2132p ps=1.34u w=0.82u l=0.6u
X1 a_224_472# I VDD VNW pfet_05v0 ad=0.3782p pd=1.84u as=0.3782p ps=1.84u w=1.22u l=0.5u
X2 VDD a_224_472# Z VNW pfet_05v0 ad=0.3782p pd=1.84u as=0.3782p ps=1.84u w=1.22u l=0.5u
X3 Z a_224_472# VDD VNW pfet_05v0 ad=0.3782p pd=1.84u as=0.3782p ps=1.84u w=1.22u l=0.5u
X4 Z a_224_472# VSS VPW nfet_05v0 ad=0.2132p pd=1.34u as=0.2132p ps=1.34u w=0.82u l=0.6u
X5 a_224_472# I VSS VPW nfet_05v0 ad=0.2132p pd=1.34u as=0.2132p ps=1.34u w=0.82u l=0.6u
X6 VSS a_224_472# Z VPW nfet_05v0 ad=0.2132p pd=1.34u as=0.2132p ps=1.34u w=0.82u l=0.6u
X7 VSS a_224_472# Z VPW nfet_05v0 ad=0.2132p pd=1.34u as=0.2132p ps=1.34u w=0.82u l=0.6u
X8 VDD I a_224_472# VNW pfet_05v0 ad=0.3782p pd=1.84u as=0.3782p ps=1.84u w=1.22u l=0.5u
X9 Z a_224_472# VDD VNW pfet_05v0 ad=0.3782p pd=1.84u as=0.3782p ps=1.84u w=1.22u l=0.5u
X10 Z a_224_472# VDD VNW pfet_05v0 ad=0.3782p pd=1.84u as=0.3782p ps=1.84u w=1.22u l=0.5u
X11 a_224_472# I VSS VPW nfet_05v0 ad=0.2132p pd=1.34u as=0.3608p ps=2.52u w=0.82u l=0.6u
X12 Z a_224_472# VSS VPW nfet_05v0 ad=0.2132p pd=1.34u as=0.2132p ps=1.34u w=0.82u l=0.6u
X13 Z a_224_472# VSS VPW nfet_05v0 ad=0.2132p pd=1.34u as=0.2132p ps=1.34u w=0.82u l=0.6u
X14 VSS a_224_472# Z VPW nfet_05v0 ad=0.2132p pd=1.34u as=0.2132p ps=1.34u w=0.82u l=0.6u
X15 Z a_224_472# VDD VNW pfet_05v0 ad=0.3782p pd=1.84u as=0.3782p ps=1.84u w=1.22u l=0.5u
X16 VSS a_224_472# Z VPW nfet_05v0 ad=0.2132p pd=1.34u as=0.2132p ps=1.34u w=0.82u l=0.6u
X17 VDD I a_224_472# VNW pfet_05v0 ad=0.3782p pd=1.84u as=0.3782p ps=1.84u w=1.22u l=0.5u
X18 a_224_472# I VSS VPW nfet_05v0 ad=0.2132p pd=1.34u as=0.2132p ps=1.34u w=0.82u l=0.6u
X19 Z a_224_472# VSS VPW nfet_05v0 ad=0.2132p pd=1.34u as=0.2132p ps=1.34u w=0.82u l=0.6u
X20 VSS a_224_472# Z VPW nfet_05v0 ad=0.2132p pd=1.34u as=0.2132p ps=1.34u w=0.82u l=0.6u
X21 VDD a_224_472# Z VNW pfet_05v0 ad=0.3782p pd=1.84u as=0.3782p ps=1.84u w=1.22u l=0.5u
X22 Z a_224_472# VDD VNW pfet_05v0 ad=0.3782p pd=1.84u as=0.3782p ps=1.84u w=1.22u l=0.5u
X23 Z a_224_472# VSS VPW nfet_05v0 ad=0.2132p pd=1.34u as=0.2132p ps=1.34u w=0.82u l=0.6u
X24 VDD I a_224_472# VNW pfet_05v0 ad=0.3782p pd=1.84u as=0.3782p ps=1.84u w=1.22u l=0.5u
X25 VDD a_224_472# Z VNW pfet_05v0 ad=0.3782p pd=1.84u as=0.3782p ps=1.84u w=1.22u l=0.5u
X26 VDD a_224_472# Z VNW pfet_05v0 ad=0.3782p pd=1.84u as=0.3782p ps=1.84u w=1.22u l=0.5u
X27 Z a_224_472# VDD VNW pfet_05v0 ad=0.3782p pd=1.84u as=0.3782p ps=1.84u w=1.22u l=0.5u
X28 Z a_224_472# VSS VPW nfet_05v0 ad=0.2132p pd=1.34u as=0.2132p ps=1.34u w=0.82u l=0.6u
X29 a_224_472# I VDD VNW pfet_05v0 ad=0.3782p pd=1.84u as=0.3782p ps=1.84u w=1.22u l=0.5u
X30 VSS I a_224_472# VPW nfet_05v0 ad=0.2132p pd=1.34u as=0.2132p ps=1.34u w=0.82u l=0.6u
X31 VDD I a_224_472# VNW pfet_05v0 ad=0.3782p pd=1.84u as=0.3782p ps=1.84u w=1.22u l=0.5u
X32 VSS I a_224_472# VPW nfet_05v0 ad=0.2132p pd=1.34u as=0.2132p ps=1.34u w=0.82u l=0.6u
X33 VDD a_224_472# Z VNW pfet_05v0 ad=0.3782p pd=1.84u as=0.3782p ps=1.84u w=1.22u l=0.5u
X34 VSS a_224_472# Z VPW nfet_05v0 ad=0.2132p pd=1.34u as=0.2132p ps=1.34u w=0.82u l=0.6u
X35 VSS a_224_472# Z VPW nfet_05v0 ad=0.2132p pd=1.34u as=0.2132p ps=1.34u w=0.82u l=0.6u
X36 a_224_472# I VDD VNW pfet_05v0 ad=0.3782p pd=1.84u as=0.3782p ps=1.84u w=1.22u l=0.5u
X37 VDD a_224_472# Z VNW pfet_05v0 ad=0.5368p pd=3.32u as=0.3782p ps=1.84u w=1.22u l=0.5u
X38 Z a_224_472# VDD VNW pfet_05v0 ad=0.3782p pd=1.84u as=0.3782p ps=1.84u w=1.22u l=0.5u
X39 VSS I a_224_472# VPW nfet_05v0 ad=0.2132p pd=1.34u as=0.2132p ps=1.34u w=0.82u l=0.6u
X40 VDD a_224_472# Z VNW pfet_05v0 ad=0.3782p pd=1.84u as=0.3782p ps=1.84u w=1.22u l=0.5u
X41 a_224_472# I VDD VNW pfet_05v0 ad=0.3782p pd=1.84u as=0.5368p ps=3.32u w=1.22u l=0.5u
X42 VDD a_224_472# Z VNW pfet_05v0 ad=0.3782p pd=1.84u as=0.3782p ps=1.84u w=1.22u l=0.5u
X43 VSS I a_224_472# VPW nfet_05v0 ad=0.2132p pd=1.34u as=0.2132p ps=1.34u w=0.82u l=0.6u
X44 Z a_224_472# VSS VPW nfet_05v0 ad=0.2132p pd=1.34u as=0.2132p ps=1.34u w=0.82u l=0.6u
X45 VSS a_224_472# Z VPW nfet_05v0 ad=0.3608p pd=2.52u as=0.2132p ps=1.34u w=0.82u l=0.6u
X46 Z a_224_472# VDD VNW pfet_05v0 ad=0.3782p pd=1.84u as=0.3782p ps=1.84u w=1.22u l=0.5u
X47 a_224_472# I VSS VPW nfet_05v0 ad=0.2132p pd=1.34u as=0.2132p ps=1.34u w=0.82u l=0.6u
.ends

.subckt gf180mcu_fd_sc_mcu7t5v0__oai221_1 A1 A2 B1 B2 C ZN VDD VNW VPW VSS
X0 a_692_68# C a_36_68# VPW nfet_05v0 ad=0.246p pd=1.42u as=0.2132p ps=1.34u w=0.82u l=0.6u
X1 a_932_472# A2 VDD VNW pfet_05v0 ad=0.3172p pd=1.74u as=0.38575p ps=1.92u w=1.22u l=0.5u
X2 VSS B2 a_36_68# VPW nfet_05v0 ad=0.2132p pd=1.34u as=0.3608p ps=2.52u w=0.82u l=0.6u
X3 ZN A2 a_692_68# VPW nfet_05v0 ad=0.2132p pd=1.34u as=0.246p ps=1.42u w=0.82u l=0.6u
X4 a_244_472# B2 VDD VNW pfet_05v0 ad=0.3172p pd=1.74u as=0.6588p ps=3.52u w=1.22u l=0.5u
X5 ZN A1 a_932_472# VNW pfet_05v0 ad=0.5368p pd=3.32u as=0.3172p ps=1.74u w=1.22u l=0.5u
X6 VDD C ZN VNW pfet_05v0 ad=0.38575p pd=1.92u as=0.3952p ps=1.94u w=0.945u l=0.5u
X7 ZN B1 a_244_472# VNW pfet_05v0 ad=0.3952p pd=1.94u as=0.3172p ps=1.74u w=1.22u l=0.5u
X8 a_36_68# B1 VSS VPW nfet_05v0 ad=0.2132p pd=1.34u as=0.2132p ps=1.34u w=0.82u l=0.6u
X9 a_692_68# A1 ZN VPW nfet_05v0 ad=0.3608p pd=2.52u as=0.2132p ps=1.34u w=0.82u l=0.6u
.ends

.subckt gf180mcu_fd_sc_mcu7t5v0__or4_1 A1 A2 A3 A4 Z VDD VNW VPW VSS
X0 VSS A4 a_56_604# VPW nfet_05v0 ad=0.218p pd=1.52u as=93.59999f ps=0.88u w=0.36u l=0.6u
X1 Z a_56_604# VSS VPW nfet_05v0 ad=0.3608p pd=2.52u as=0.218p ps=1.52u w=0.82u l=0.6u
X2 Z a_56_604# VDD VNW pfet_05v0 ad=0.5368p pd=3.32u as=0.389p ps=2.02u w=1.22u l=0.5u
X3 VSS A2 a_56_604# VPW nfet_05v0 ad=93.59999f pd=0.88u as=0.126p ps=1.06u w=0.36u l=0.6u
X4 VDD A4 a_708_604# VNW pfet_05v0 ad=0.389p pd=2.02u as=0.1736p ps=1.18u w=0.56u l=0.5u
X5 a_244_604# A1 a_56_604# VNW pfet_05v0 ad=0.196p pd=1.26u as=0.2464p ps=2u w=0.56u l=0.5u
X6 a_56_604# A1 VSS VPW nfet_05v0 ad=0.126p pd=1.06u as=0.1584p ps=1.6u w=0.36u l=0.6u
X7 a_56_604# A3 VSS VPW nfet_05v0 ad=93.59999f pd=0.88u as=93.59999f ps=0.88u w=0.36u l=0.6u
X8 a_708_604# A3 a_484_604# VNW pfet_05v0 ad=0.1736p pd=1.18u as=0.1736p ps=1.18u w=0.56u l=0.5u
X9 a_484_604# A2 a_244_604# VNW pfet_05v0 ad=0.1736p pd=1.18u as=0.196p ps=1.26u w=0.56u l=0.5u
.ends

.subckt gf180mcu_fd_sc_mcu7t5v0__oai31_4 A1 A2 A3 B ZN VDD VNW VPW VSS
X0 ZN A1 a_2060_497# VNW pfet_05v0 ad=0.2847p pd=1.615u as=0.3942p ps=1.815u w=1.095u l=0.5u
X1 a_36_68# B VSS VPW nfet_05v0 ad=0.2132p pd=1.34u as=0.2132p ps=1.34u w=0.82u l=0.6u
X2 VDD B ZN VNW pfet_05v0 ad=0.3942p pd=1.815u as=0.2847p ps=1.615u w=1.095u l=0.5u
X3 ZN A3 a_36_68# VPW nfet_05v0 ad=0.2132p pd=1.34u as=0.2132p ps=1.34u w=0.82u l=0.6u
X4 VSS B a_36_68# VPW nfet_05v0 ad=0.2132p pd=1.34u as=0.43265p ps=1.985u w=0.82u l=0.6u
X5 a_2508_497# A1 ZN VNW pfet_05v0 ad=0.33945p pd=1.715u as=0.2847p ps=1.615u w=1.095u l=0.5u
X6 ZN B VDD VNW pfet_05v0 ad=0.2847p pd=1.615u as=0.4818p ps=3.07u w=1.095u l=0.5u
X7 ZN A3 a_36_68# VPW nfet_05v0 ad=0.30965p pd=1.685u as=0.3608p ps=2.52u w=0.82u l=0.6u
X8 a_56_497# A3 VDD VNW pfet_05v0 ad=0.3942p pd=1.815u as=0.40515p ps=1.835u w=1.095u l=0.5u
X9 a_36_68# A3 ZN VPW nfet_05v0 ad=0.2132p pd=1.34u as=0.2132p ps=1.34u w=0.82u l=0.6u
X10 ZN A1 a_36_68# VPW nfet_05v0 ad=0.2132p pd=1.34u as=0.2132p ps=1.34u w=0.82u l=0.6u
X11 ZN B VDD VNW pfet_05v0 ad=0.2847p pd=1.615u as=0.3942p ps=1.815u w=1.095u l=0.5u
X12 a_36_68# A3 ZN VPW nfet_05v0 ad=0.2132p pd=1.34u as=0.30965p ps=1.685u w=0.82u l=0.6u
X13 VDD A3 a_56_497# VNW pfet_05v0 ad=0.40515p pd=1.835u as=0.4818p ps=3.07u w=1.095u l=0.5u
X14 VDD B ZN VNW pfet_05v0 ad=0.53655p pd=3.17u as=0.2847p ps=1.615u w=1.095u l=0.5u
X15 a_36_68# A2 ZN VPW nfet_05v0 ad=0.2132p pd=1.34u as=0.2132p ps=1.34u w=0.82u l=0.6u
X16 VDD A3 a_56_497# VNW pfet_05v0 ad=0.2847p pd=1.615u as=0.3942p ps=1.815u w=1.095u l=0.5u
X17 a_36_68# A1 ZN VPW nfet_05v0 ad=0.2132p pd=1.34u as=0.2132p ps=1.34u w=0.82u l=0.6u
X18 a_36_68# A2 ZN VPW nfet_05v0 ad=0.43265p pd=1.985u as=0.2132p ps=1.34u w=0.82u l=0.6u
X19 a_940_497# A3 VDD VNW pfet_05v0 ad=0.3942p pd=1.815u as=0.2847p ps=1.615u w=1.095u l=0.5u
X20 VSS B a_36_68# VPW nfet_05v0 ad=0.2132p pd=1.34u as=0.2132p ps=1.34u w=0.82u l=0.6u
X21 ZN A1 a_1184_497# VNW pfet_05v0 ad=0.2847p pd=1.615u as=0.33945p ps=1.715u w=1.095u l=0.5u
X22 a_56_497# A2 a_2508_497# VNW pfet_05v0 ad=0.4818p pd=3.07u as=0.33945p ps=1.715u w=1.095u l=0.5u
X23 a_36_68# A1 ZN VPW nfet_05v0 ad=0.2132p pd=1.34u as=0.2132p ps=1.34u w=0.82u l=0.6u
X24 ZN A2 a_36_68# VPW nfet_05v0 ad=0.2132p pd=1.34u as=0.2132p ps=1.34u w=0.82u l=0.6u
X25 a_1612_497# A1 ZN VNW pfet_05v0 ad=0.3942p pd=1.815u as=0.2847p ps=1.615u w=1.095u l=0.5u
X26 ZN A1 a_36_68# VPW nfet_05v0 ad=0.2132p pd=1.34u as=0.2132p ps=1.34u w=0.82u l=0.6u
X27 a_1184_497# A2 a_940_497# VNW pfet_05v0 ad=0.33945p pd=1.715u as=0.3942p ps=1.815u w=1.095u l=0.5u
X28 a_56_497# A2 a_1612_497# VNW pfet_05v0 ad=0.2847p pd=1.615u as=0.3942p ps=1.815u w=1.095u l=0.5u
X29 ZN A2 a_36_68# VPW nfet_05v0 ad=0.2132p pd=1.34u as=0.2132p ps=1.34u w=0.82u l=0.6u
X30 a_2060_497# A2 a_56_497# VNW pfet_05v0 ad=0.3942p pd=1.815u as=0.2847p ps=1.615u w=1.095u l=0.5u
X31 a_36_68# B VSS VPW nfet_05v0 ad=0.3608p pd=2.52u as=0.2132p ps=1.34u w=0.82u l=0.6u
.ends

.subckt gf180mcu_fd_sc_mcu7t5v0__or2_1 A1 A2 Z VDD VNW VPW VSS
X0 a_255_603# A1 a_67_603# VNW pfet_05v0 ad=0.1469p pd=1.085u as=0.2486p ps=2.01u w=0.565u l=0.5u
X1 Z a_67_603# VSS VPW nfet_05v0 ad=0.3608p pd=2.52u as=0.2288p ps=1.58u w=0.82u l=0.6u
X2 VDD A2 a_255_603# VNW pfet_05v0 ad=0.38705p pd=2.08u as=0.1469p ps=1.085u w=0.565u l=0.5u
X3 VSS A2 a_67_603# VPW nfet_05v0 ad=0.2288p pd=1.58u as=93.59999f ps=0.88u w=0.36u l=0.6u
X4 Z a_67_603# VDD VNW pfet_05v0 ad=0.5368p pd=3.32u as=0.38705p ps=2.08u w=1.22u l=0.5u
X5 a_67_603# A1 VSS VPW nfet_05v0 ad=93.59999f pd=0.88u as=0.1584p ps=1.6u w=0.36u l=0.6u
.ends

.subckt gf180mcu_fd_sc_mcu7t5v0__clkinv_3 I ZN VDD VNW VPW VSS
X0 ZN I VDD VNW pfet_05v0 ad=0.5368p pd=3.32u as=0.3782p ps=1.84u w=1.22u l=0.5u
X1 ZN I VSS VPW nfet_05v0 ad=0.1248p pd=1u as=0.2112p ps=1.84u w=0.48u l=0.6u
X2 VDD I ZN VNW pfet_05v0 ad=0.3782p pd=1.84u as=0.3782p ps=1.84u w=1.22u l=0.5u
X3 ZN I VSS VPW nfet_05v0 ad=0.2112p pd=1.84u as=0.1248p ps=1u w=0.48u l=0.6u
X4 ZN I VDD VNW pfet_05v0 ad=0.3782p pd=1.84u as=0.5368p ps=3.32u w=1.22u l=0.5u
X5 VSS I ZN VPW nfet_05v0 ad=0.1248p pd=1u as=0.1248p ps=1u w=0.48u l=0.6u
.ends

.subckt gf180mcu_fd_sc_mcu7t5v0__clkbuf_20 I Z VDD VNW VPW VSS
X0 Z a_224_552# VSS VPW nfet_05v0 ad=0.1222p pd=0.99u as=0.1222p ps=0.99u w=0.47u l=0.6u
X1 VSS a_224_552# Z VPW nfet_05v0 ad=0.2068p pd=1.82u as=0.1222p ps=0.99u w=0.47u l=0.6u
X2 a_224_552# I VDD VNW pfet_05v0 ad=0.2542p pd=1.44u as=0.2542p ps=1.44u w=0.82u l=0.5u
X3 Z a_224_552# VDD VNW pfet_05v0 ad=0.3782p pd=1.84u as=0.3782p ps=1.84u w=1.22u l=0.5u
X4 Z a_224_552# VSS VPW nfet_05v0 ad=0.1222p pd=0.99u as=0.1222p ps=0.99u w=0.47u l=0.6u
X5 Z a_224_552# VDD VNW pfet_05v0 ad=0.3782p pd=1.84u as=0.3782p ps=1.84u w=1.22u l=0.5u
X6 VDD a_224_552# Z VNW pfet_05v0 ad=0.3782p pd=1.84u as=0.3782p ps=1.84u w=1.22u l=0.5u
X7 VDD a_224_552# Z VNW pfet_05v0 ad=0.3782p pd=1.84u as=0.3782p ps=1.84u w=1.22u l=0.5u
X8 VSS a_224_552# Z VPW nfet_05v0 ad=0.1222p pd=0.99u as=0.1222p ps=0.99u w=0.47u l=0.6u
X9 Z a_224_552# VDD VNW pfet_05v0 ad=0.3782p pd=1.84u as=0.3782p ps=1.84u w=1.22u l=0.5u
X10 a_224_552# I VDD VNW pfet_05v0 ad=0.2542p pd=1.44u as=0.3608p ps=2.52u w=0.82u l=0.5u
X11 a_224_552# I VSS VPW nfet_05v0 ad=98.799995f pd=0.9u as=98.799995f ps=0.9u w=0.38u l=0.6u
X12 VDD a_224_552# Z VNW pfet_05v0 ad=0.3782p pd=1.84u as=0.3782p ps=1.84u w=1.22u l=0.5u
X13 Z a_224_552# VSS VPW nfet_05v0 ad=0.1222p pd=0.99u as=0.1222p ps=0.99u w=0.47u l=0.6u
X14 Z a_224_552# VDD VNW pfet_05v0 ad=0.4392p pd=1.94u as=0.3782p ps=1.84u w=1.22u l=0.5u
X15 Z a_224_552# VSS VPW nfet_05v0 ad=0.1222p pd=0.99u as=0.1222p ps=0.99u w=0.47u l=0.6u
X16 VDD I a_224_552# VNW pfet_05v0 ad=0.367p pd=1.92u as=0.2952p ps=1.54u w=0.82u l=0.5u
X17 VDD a_224_552# Z VNW pfet_05v0 ad=0.3782p pd=1.84u as=0.3782p ps=1.84u w=1.22u l=0.5u
X18 VSS a_224_552# Z VPW nfet_05v0 ad=0.1222p pd=0.99u as=0.1222p ps=0.99u w=0.47u l=0.6u
X19 VSS I a_224_552# VPW nfet_05v0 ad=98.799995f pd=0.9u as=98.799995f ps=0.9u w=0.38u l=0.6u
X20 VSS a_224_552# Z VPW nfet_05v0 ad=0.1222p pd=0.99u as=0.1222p ps=0.99u w=0.47u l=0.6u
X21 a_224_552# I VDD VNW pfet_05v0 ad=0.2542p pd=1.44u as=0.2542p ps=1.44u w=0.82u l=0.5u
X22 VDD a_224_552# Z VNW pfet_05v0 ad=0.5368p pd=3.32u as=0.4392p ps=1.94u w=1.22u l=0.5u
X23 a_224_552# I VSS VPW nfet_05v0 ad=0.1672p pd=1.64u as=98.799995f ps=0.9u w=0.38u l=0.6u
X24 Z a_224_552# VSS VPW nfet_05v0 ad=0.1222p pd=0.99u as=0.1222p ps=0.99u w=0.47u l=0.6u
X25 VSS a_224_552# Z VPW nfet_05v0 ad=0.1222p pd=0.99u as=0.1222p ps=0.99u w=0.47u l=0.6u
X26 Z a_224_552# VSS VPW nfet_05v0 ad=0.1222p pd=0.99u as=0.1222p ps=0.99u w=0.47u l=0.6u
X27 VSS a_224_552# Z VPW nfet_05v0 ad=0.1222p pd=0.99u as=0.1222p ps=0.99u w=0.47u l=0.6u
X28 VDD I a_224_552# VNW pfet_05v0 ad=0.2542p pd=1.44u as=0.2542p ps=1.44u w=0.82u l=0.5u
X29 Z a_224_552# VDD VNW pfet_05v0 ad=0.3782p pd=1.84u as=0.3782p ps=1.84u w=1.22u l=0.5u
X30 VDD a_224_552# Z VNW pfet_05v0 ad=0.3782p pd=1.84u as=0.3782p ps=1.84u w=1.22u l=0.5u
X31 VSS I a_224_552# VPW nfet_05v0 ad=98.799995f pd=0.9u as=98.799995f ps=0.9u w=0.38u l=0.6u
X32 a_224_552# I VDD VNW pfet_05v0 ad=0.2952p pd=1.54u as=0.2542p ps=1.44u w=0.82u l=0.5u
X33 Z a_224_552# VDD VNW pfet_05v0 ad=0.3782p pd=1.84u as=0.3782p ps=1.84u w=1.22u l=0.5u
X34 VDD a_224_552# Z VNW pfet_05v0 ad=0.3782p pd=1.84u as=0.3782p ps=1.84u w=1.22u l=0.5u
X35 VDD I a_224_552# VNW pfet_05v0 ad=0.2542p pd=1.44u as=0.2542p ps=1.44u w=0.82u l=0.5u
X36 Z a_224_552# VDD VNW pfet_05v0 ad=0.3782p pd=1.84u as=0.367p ps=1.92u w=1.22u l=0.5u
X37 VSS I a_224_552# VPW nfet_05v0 ad=98.799995f pd=0.9u as=0.1672p ps=1.64u w=0.38u l=0.6u
X38 Z a_224_552# VSS VPW nfet_05v0 ad=0.1222p pd=0.99u as=0.1222p ps=0.99u w=0.47u l=0.6u
X39 VSS a_224_552# Z VPW nfet_05v0 ad=0.1222p pd=0.99u as=0.1222p ps=0.99u w=0.47u l=0.6u
X40 VDD a_224_552# Z VNW pfet_05v0 ad=0.3782p pd=1.84u as=0.3782p ps=1.84u w=1.22u l=0.5u
X41 Z a_224_552# VSS VPW nfet_05v0 ad=0.1222p pd=0.99u as=0.1222p ps=0.99u w=0.47u l=0.6u
X42 a_224_552# I VSS VPW nfet_05v0 ad=98.799995f pd=0.9u as=98.799995f ps=0.9u w=0.38u l=0.6u
X43 VSS a_224_552# Z VPW nfet_05v0 ad=0.1222p pd=0.99u as=0.1222p ps=0.99u w=0.47u l=0.6u
X44 Z a_224_552# VDD VNW pfet_05v0 ad=0.3782p pd=1.84u as=0.3782p ps=1.84u w=1.22u l=0.5u
X45 VDD I a_224_552# VNW pfet_05v0 ad=0.2542p pd=1.44u as=0.2542p ps=1.44u w=0.82u l=0.5u
X46 VDD a_224_552# Z VNW pfet_05v0 ad=0.3782p pd=1.84u as=0.3782p ps=1.84u w=1.22u l=0.5u
X47 Z a_224_552# VSS VPW nfet_05v0 ad=0.1222p pd=0.99u as=0.2914p ps=2.18u w=0.47u l=0.6u
X48 Z a_224_552# VDD VNW pfet_05v0 ad=0.3782p pd=1.84u as=0.3782p ps=1.84u w=1.22u l=0.5u
X49 VSS I a_224_552# VPW nfet_05v0 ad=98.799995f pd=0.9u as=98.799995f ps=0.9u w=0.38u l=0.6u
X50 a_224_552# I VDD VNW pfet_05v0 ad=0.2542p pd=1.44u as=0.2542p ps=1.44u w=0.82u l=0.5u
X51 VSS a_224_552# Z VPW nfet_05v0 ad=0.1222p pd=0.99u as=0.1222p ps=0.99u w=0.47u l=0.6u
X52 Z a_224_552# VDD VNW pfet_05v0 ad=0.3782p pd=1.84u as=0.3782p ps=1.84u w=1.22u l=0.5u
X53 a_224_552# I VSS VPW nfet_05v0 ad=98.799995f pd=0.9u as=98.799995f ps=0.9u w=0.38u l=0.6u
X54 Z a_224_552# VSS VPW nfet_05v0 ad=0.1222p pd=0.99u as=0.1222p ps=0.99u w=0.47u l=0.6u
X55 VDD I a_224_552# VNW pfet_05v0 ad=0.2542p pd=1.44u as=0.2542p ps=1.44u w=0.82u l=0.5u
X56 VDD a_224_552# Z VNW pfet_05v0 ad=0.3782p pd=1.84u as=0.3782p ps=1.84u w=1.22u l=0.5u
X57 VSS a_224_552# Z VPW nfet_05v0 ad=0.1222p pd=0.99u as=0.1222p ps=0.99u w=0.47u l=0.6u
.ends

.subckt gf180mcu_fd_sc_mcu7t5v0__inv_20 I ZN VDD VNW VPW VSS
X0 ZN I VDD VNW pfet_05v0 ad=0.3782p pd=1.84u as=0.3782p ps=1.84u w=1.22u l=0.5u
X1 VDD I ZN VNW pfet_05v0 ad=0.3782p pd=1.84u as=0.3782p ps=1.84u w=1.22u l=0.5u
X2 ZN I VDD VNW pfet_05v0 ad=0.3782p pd=1.84u as=0.3782p ps=1.84u w=1.22u l=0.5u
X3 ZN I VSS VPW nfet_05v0 ad=0.2132p pd=1.34u as=0.2132p ps=1.34u w=0.82u l=0.6u
X4 ZN I VSS VPW nfet_05v0 ad=0.2132p pd=1.34u as=0.2132p ps=1.34u w=0.82u l=0.6u
X5 VSS I ZN VPW nfet_05v0 ad=0.2132p pd=1.34u as=0.2132p ps=1.34u w=0.82u l=0.6u
X6 VSS I ZN VPW nfet_05v0 ad=0.2132p pd=1.34u as=0.2132p ps=1.34u w=0.82u l=0.6u
X7 VDD I ZN VNW pfet_05v0 ad=0.3782p pd=1.84u as=0.3782p ps=1.84u w=1.22u l=0.5u
X8 ZN I VDD VNW pfet_05v0 ad=0.3782p pd=1.84u as=0.3782p ps=1.84u w=1.22u l=0.5u
X9 ZN I VSS VPW nfet_05v0 ad=0.2132p pd=1.34u as=0.3608p ps=2.52u w=0.82u l=0.6u
X10 ZN I VSS VPW nfet_05v0 ad=0.2132p pd=1.34u as=0.2132p ps=1.34u w=0.82u l=0.6u
X11 VSS I ZN VPW nfet_05v0 ad=0.2132p pd=1.34u as=0.2132p ps=1.34u w=0.82u l=0.6u
X12 VSS I ZN VPW nfet_05v0 ad=0.2132p pd=1.34u as=0.2132p ps=1.34u w=0.82u l=0.6u
X13 VDD I ZN VNW pfet_05v0 ad=0.3782p pd=1.84u as=0.3782p ps=1.84u w=1.22u l=0.5u
X14 ZN I VSS VPW nfet_05v0 ad=0.2132p pd=1.34u as=0.2132p ps=1.34u w=0.82u l=0.6u
X15 ZN I VSS VPW nfet_05v0 ad=0.2132p pd=1.34u as=0.2132p ps=1.34u w=0.82u l=0.6u
X16 VSS I ZN VPW nfet_05v0 ad=0.3608p pd=2.52u as=0.2132p ps=1.34u w=0.82u l=0.6u
X17 VDD I ZN VNW pfet_05v0 ad=0.5368p pd=3.32u as=0.3782p ps=1.84u w=1.22u l=0.5u
X18 ZN I VDD VNW pfet_05v0 ad=0.3782p pd=1.84u as=0.3782p ps=1.84u w=1.22u l=0.5u
X19 ZN I VSS VPW nfet_05v0 ad=0.2132p pd=1.34u as=0.2132p ps=1.34u w=0.82u l=0.6u
X20 VDD I ZN VNW pfet_05v0 ad=0.3782p pd=1.84u as=0.3782p ps=1.84u w=1.22u l=0.5u
X21 VDD I ZN VNW pfet_05v0 ad=0.3782p pd=1.84u as=0.3782p ps=1.84u w=1.22u l=0.5u
X22 VDD I ZN VNW pfet_05v0 ad=0.3782p pd=1.84u as=0.3782p ps=1.84u w=1.22u l=0.5u
X23 ZN I VDD VNW pfet_05v0 ad=0.3782p pd=1.84u as=0.3782p ps=1.84u w=1.22u l=0.5u
X24 ZN I VSS VPW nfet_05v0 ad=0.2132p pd=1.34u as=0.2132p ps=1.34u w=0.82u l=0.6u
X25 ZN I VDD VNW pfet_05v0 ad=0.3782p pd=1.84u as=0.3782p ps=1.84u w=1.22u l=0.5u
X26 VSS I ZN VPW nfet_05v0 ad=0.2132p pd=1.34u as=0.2132p ps=1.34u w=0.82u l=0.6u
X27 VDD I ZN VNW pfet_05v0 ad=0.3782p pd=1.84u as=0.3782p ps=1.84u w=1.22u l=0.5u
X28 VSS I ZN VPW nfet_05v0 ad=0.2132p pd=1.34u as=0.2132p ps=1.34u w=0.82u l=0.6u
X29 VDD I ZN VNW pfet_05v0 ad=0.3782p pd=1.84u as=0.3782p ps=1.84u w=1.22u l=0.5u
X30 VSS I ZN VPW nfet_05v0 ad=0.2132p pd=1.34u as=0.2132p ps=1.34u w=0.82u l=0.6u
X31 ZN I VDD VNW pfet_05v0 ad=0.3782p pd=1.84u as=0.3782p ps=1.84u w=1.22u l=0.5u
X32 ZN I VDD VNW pfet_05v0 ad=0.3782p pd=1.84u as=0.3782p ps=1.84u w=1.22u l=0.5u
X33 VSS I ZN VPW nfet_05v0 ad=0.2132p pd=1.34u as=0.2132p ps=1.34u w=0.82u l=0.6u
X34 ZN I VDD VNW pfet_05v0 ad=0.3782p pd=1.84u as=0.5368p ps=3.32u w=1.22u l=0.5u
X35 VDD I ZN VNW pfet_05v0 ad=0.3782p pd=1.84u as=0.3782p ps=1.84u w=1.22u l=0.5u
X36 VSS I ZN VPW nfet_05v0 ad=0.2132p pd=1.34u as=0.2132p ps=1.34u w=0.82u l=0.6u
X37 ZN I VSS VPW nfet_05v0 ad=0.2132p pd=1.34u as=0.2132p ps=1.34u w=0.82u l=0.6u
X38 ZN I VDD VNW pfet_05v0 ad=0.3782p pd=1.84u as=0.3782p ps=1.84u w=1.22u l=0.5u
X39 ZN I VSS VPW nfet_05v0 ad=0.2132p pd=1.34u as=0.2132p ps=1.34u w=0.82u l=0.6u
.ends

.subckt gf180mcu_fd_sc_mcu7t5v0__or3_1 A1 A2 A3 Z VDD VNW VPW VSS
X0 a_224_604# A1 a_36_88# VNW pfet_05v0 ad=0.1736p pd=1.18u as=0.2464p ps=2u w=0.56u l=0.5u
X1 a_36_88# A2 VSS VPW nfet_05v0 ad=0.14p pd=1.1u as=0.104p ps=0.92u w=0.4u l=0.6u
X2 Z a_36_88# VDD VNW pfet_05v0 ad=0.5368p pd=3.32u as=0.389p ps=2.02u w=1.22u l=0.5u
X3 VSS A1 a_36_88# VPW nfet_05v0 ad=0.104p pd=0.92u as=0.176p ps=1.68u w=0.4u l=0.6u
X4 a_448_604# A2 a_224_604# VNW pfet_05v0 ad=0.224p pd=1.36u as=0.1736p ps=1.18u w=0.56u l=0.5u
X5 VSS A3 a_36_88# VPW nfet_05v0 ad=0.224p pd=1.52u as=0.14p ps=1.1u w=0.4u l=0.6u
X6 VDD A3 a_448_604# VNW pfet_05v0 ad=0.389p pd=2.02u as=0.224p ps=1.36u w=0.56u l=0.5u
X7 Z a_36_88# VSS VPW nfet_05v0 ad=0.3608p pd=2.52u as=0.224p ps=1.52u w=0.82u l=0.6u
.ends

.subckt gf180mcu_fd_sc_mcu7t5v0__or2_4 A1 A2 Z VDD VNW VPW VSS
X0 Z a_244_68# VSS VPW nfet_05v0 ad=0.2132p pd=1.34u as=0.2706p ps=1.48u w=0.82u l=0.6u
X1 a_244_68# A1 VSS VPW nfet_05v0 ad=0.2132p pd=1.34u as=0.2132p ps=1.34u w=0.82u l=0.6u
X2 VSS a_244_68# Z VPW nfet_05v0 ad=0.3608p pd=2.52u as=0.2132p ps=1.34u w=0.82u l=0.6u
X3 a_244_68# A2 VSS VPW nfet_05v0 ad=0.2132p pd=1.34u as=0.3608p ps=2.52u w=0.82u l=0.6u
X4 a_244_68# A1 a_244_472# VNW pfet_05v0 ad=0.3782p pd=1.84u as=0.3477p ps=1.79u w=1.22u l=0.5u
X5 VSS a_244_68# Z VPW nfet_05v0 ad=0.2132p pd=1.34u as=0.2132p ps=1.34u w=0.82u l=0.6u
X6 a_244_472# A2 VDD VNW pfet_05v0 ad=0.3477p pd=1.79u as=0.5368p ps=3.32u w=1.22u l=0.5u
X7 VDD a_244_68# Z VNW pfet_05v0 ad=0.5368p pd=3.32u as=0.3477p ps=1.79u w=1.22u l=0.5u
X8 VDD a_244_68# Z VNW pfet_05v0 ad=0.3477p pd=1.79u as=0.3782p ps=1.84u w=1.22u l=0.5u
X9 VDD A2 a_682_472# VNW pfet_05v0 ad=0.5246p pd=2.08u as=0.3477p ps=1.79u w=1.22u l=0.5u
X10 Z a_244_68# VDD VNW pfet_05v0 ad=0.3477p pd=1.79u as=0.3477p ps=1.79u w=1.22u l=0.5u
X11 a_682_472# A1 a_244_68# VNW pfet_05v0 ad=0.3477p pd=1.79u as=0.3782p ps=1.84u w=1.22u l=0.5u
X12 VSS A2 a_244_68# VPW nfet_05v0 ad=0.2706p pd=1.48u as=0.2132p ps=1.34u w=0.82u l=0.6u
X13 VSS A1 a_244_68# VPW nfet_05v0 ad=0.2132p pd=1.34u as=0.2132p ps=1.34u w=0.82u l=0.6u
X14 Z a_244_68# VDD VNW pfet_05v0 ad=0.3782p pd=1.84u as=0.5246p ps=2.08u w=1.22u l=0.5u
X15 Z a_244_68# VSS VPW nfet_05v0 ad=0.2132p pd=1.34u as=0.2132p ps=1.34u w=0.82u l=0.6u
.ends

.subckt gf180mcu_fd_sc_mcu7t5v0__aoi21_2 A1 A2 B ZN VDD VNW VPW VSS
X0 VSS A2 a_1133_69# VPW nfet_05v0 ad=0.341p pd=2.43u as=92.99999f ps=1.015u w=0.775u l=0.6u
X1 VDD B a_49_472# VNW pfet_05v0 ad=0.37665p pd=1.835u as=0.5346p ps=3.31u w=1.215u l=0.5u
X2 ZN A1 a_49_472# VNW pfet_05v0 ad=0.3159p pd=1.735u as=0.32805p ps=1.755u w=1.215u l=0.5u
X3 a_741_69# A2 VSS VPW nfet_05v0 ad=92.99999f pd=1.015u as=0.23975p ps=1.475u w=0.775u l=0.6u
X4 a_49_472# A1 ZN VNW pfet_05v0 ad=0.32805p pd=1.755u as=0.37665p ps=1.835u w=1.215u l=0.5u
X5 ZN B VSS VPW nfet_05v0 ad=0.1469p pd=1.085u as=0.2486p ps=2.01u w=0.565u l=0.6u
X6 a_49_472# A2 ZN VNW pfet_05v0 ad=0.5346p pd=3.31u as=0.3159p ps=1.735u w=1.215u l=0.5u
X7 a_49_472# B VDD VNW pfet_05v0 ad=0.3159p pd=1.735u as=0.37665p ps=1.835u w=1.215u l=0.5u
X8 ZN A2 a_49_472# VNW pfet_05v0 ad=0.37665p pd=1.835u as=0.3159p ps=1.735u w=1.215u l=0.5u
X9 VSS B ZN VPW nfet_05v0 ad=0.23975p pd=1.475u as=0.1469p ps=1.085u w=0.565u l=0.6u
X10 ZN A1 a_741_69# VPW nfet_05v0 ad=0.2015p pd=1.295u as=92.99999f ps=1.015u w=0.775u l=0.6u
X11 a_1133_69# A1 ZN VPW nfet_05v0 ad=92.99999f pd=1.015u as=0.2015p ps=1.295u w=0.775u l=0.6u
.ends

.subckt gf180mcu_fd_sc_mcu7t5v0__inv_1 I ZN VDD VNW VPW VSS
X0 ZN I VSS VPW nfet_05v0 ad=0.3608p pd=2.52u as=0.3608p ps=2.52u w=0.82u l=0.6u
X1 ZN I VDD VNW pfet_05v0 ad=0.5368p pd=3.32u as=0.5368p ps=3.32u w=1.22u l=0.5u
.ends

.subckt gf180mcu_fd_sc_mcu7t5v0__nand4_1 A1 A2 A3 A4 ZN VDD VNW VPW VSS
X0 ZN A4 VDD VNW pfet_05v0 ad=0.2197p pd=1.365u as=0.3718p ps=2.57u w=0.845u l=0.5u
X1 VDD A3 ZN VNW pfet_05v0 ad=0.2197p pd=1.365u as=0.2197p ps=1.365u w=0.845u l=0.5u
X2 ZN A2 VDD VNW pfet_05v0 ad=0.2197p pd=1.365u as=0.2197p ps=1.365u w=0.845u l=0.5u
X3 VDD A1 ZN VNW pfet_05v0 ad=0.3718p pd=2.57u as=0.2197p ps=1.365u w=0.845u l=0.5u
X4 a_275_68# A4 VSS VPW nfet_05v0 ad=0.1517p pd=1.19u as=0.3608p ps=2.52u w=0.82u l=0.6u
X5 a_673_68# A2 a_469_68# VPW nfet_05v0 ad=0.1517p pd=1.19u as=0.1722p ps=1.24u w=0.82u l=0.6u
X6 a_469_68# A3 a_275_68# VPW nfet_05v0 ad=0.1722p pd=1.24u as=0.1517p ps=1.19u w=0.82u l=0.6u
X7 ZN A1 a_673_68# VPW nfet_05v0 ad=0.3608p pd=2.52u as=0.1517p ps=1.19u w=0.82u l=0.6u
.ends

.subckt gf180mcu_fd_sc_mcu7t5v0__oai32_1 A1 A2 A3 B1 B2 ZN VDD VNW VPW VSS
X0 ZN A1 a_468_472# VNW pfet_05v0 ad=0.4392p pd=1.94u as=0.3172p ps=1.74u w=1.22u l=0.5u
X1 a_244_68# A1 VSS VPW nfet_05v0 ad=0.2132p pd=1.34u as=0.2132p ps=1.34u w=0.82u l=0.6u
X2 a_244_68# A3 VSS VPW nfet_05v0 ad=0.2132p pd=1.34u as=0.3608p ps=2.52u w=0.82u l=0.6u
X3 a_916_472# B1 ZN VNW pfet_05v0 ad=0.3172p pd=1.74u as=0.4392p ps=1.94u w=1.22u l=0.5u
X4 VDD B2 a_916_472# VNW pfet_05v0 ad=0.5368p pd=3.32u as=0.3172p ps=1.74u w=1.22u l=0.5u
X5 ZN B1 a_244_68# VPW nfet_05v0 ad=0.2132p pd=1.34u as=0.2132p ps=1.34u w=0.82u l=0.6u
X6 a_224_472# A3 VDD VNW pfet_05v0 ad=0.4392p pd=1.94u as=0.5368p ps=3.32u w=1.22u l=0.5u
X7 VSS A2 a_244_68# VPW nfet_05v0 ad=0.2132p pd=1.34u as=0.2132p ps=1.34u w=0.82u l=0.6u
X8 a_244_68# B2 ZN VPW nfet_05v0 ad=0.3608p pd=2.52u as=0.2132p ps=1.34u w=0.82u l=0.6u
X9 a_468_472# A2 a_224_472# VNW pfet_05v0 ad=0.3172p pd=1.74u as=0.4392p ps=1.94u w=1.22u l=0.5u
.ends

.subckt gf180mcu_fd_sc_mcu7t5v0__buf_20 I Z VDD VNW VPW VSS
X0 Z a_224_472# VSS VPW nfet_05v0 ad=0.2132p pd=1.34u as=0.2132p ps=1.34u w=0.82u l=0.6u
X1 VSS a_224_472# Z VPW nfet_05v0 ad=0.2132p pd=1.34u as=0.2132p ps=1.34u w=0.82u l=0.6u
X2 a_224_472# I VDD VNW pfet_05v0 ad=0.3782p pd=1.84u as=0.3782p ps=1.84u w=1.22u l=0.5u
X3 VDD a_224_472# Z VNW pfet_05v0 ad=0.3782p pd=1.84u as=0.3782p ps=1.84u w=1.22u l=0.5u
X4 Z a_224_472# VDD VNW pfet_05v0 ad=0.3782p pd=1.84u as=0.3782p ps=1.84u w=1.22u l=0.5u
X5 Z a_224_472# VSS VPW nfet_05v0 ad=0.2132p pd=1.34u as=0.2132p ps=1.34u w=0.82u l=0.6u
X6 Z a_224_472# VSS VPW nfet_05v0 ad=0.2132p pd=1.34u as=0.2132p ps=1.34u w=0.82u l=0.6u
X7 VDD a_224_472# Z VNW pfet_05v0 ad=0.3782p pd=1.84u as=0.3782p ps=1.84u w=1.22u l=0.5u
X8 a_224_472# I VSS VPW nfet_05v0 ad=0.2132p pd=1.34u as=0.2132p ps=1.34u w=0.82u l=0.6u
X9 VSS a_224_472# Z VPW nfet_05v0 ad=0.2132p pd=1.34u as=0.2132p ps=1.34u w=0.82u l=0.6u
X10 VSS a_224_472# Z VPW nfet_05v0 ad=0.2132p pd=1.34u as=0.2132p ps=1.34u w=0.82u l=0.6u
X11 VDD I a_224_472# VNW pfet_05v0 ad=0.3782p pd=1.84u as=0.3782p ps=1.84u w=1.22u l=0.5u
X12 Z a_224_472# VDD VNW pfet_05v0 ad=0.3782p pd=1.84u as=0.3782p ps=1.84u w=1.22u l=0.5u
X13 a_224_472# I VDD VNW pfet_05v0 ad=0.3782p pd=1.84u as=0.3782p ps=1.84u w=1.22u l=0.5u
X14 VDD a_224_472# Z VNW pfet_05v0 ad=0.3782p pd=1.84u as=0.3782p ps=1.84u w=1.22u l=0.5u
X15 a_224_472# I VSS VPW nfet_05v0 ad=0.2132p pd=1.34u as=0.3608p ps=2.52u w=0.82u l=0.6u
X16 Z a_224_472# VSS VPW nfet_05v0 ad=0.2132p pd=1.34u as=0.2132p ps=1.34u w=0.82u l=0.6u
X17 a_224_472# I VSS VPW nfet_05v0 ad=0.2132p pd=1.34u as=0.2132p ps=1.34u w=0.82u l=0.6u
X18 VSS a_224_472# Z VPW nfet_05v0 ad=0.2132p pd=1.34u as=0.2132p ps=1.34u w=0.82u l=0.6u
X19 Z a_224_472# VDD VNW pfet_05v0 ad=0.3782p pd=1.84u as=0.3782p ps=1.84u w=1.22u l=0.5u
X20 VSS a_224_472# Z VPW nfet_05v0 ad=0.2132p pd=1.34u as=0.2132p ps=1.34u w=0.82u l=0.6u
X21 VDD I a_224_472# VNW pfet_05v0 ad=0.3782p pd=1.84u as=0.3782p ps=1.84u w=1.22u l=0.5u
X22 a_224_472# I VSS VPW nfet_05v0 ad=0.2132p pd=1.34u as=0.2132p ps=1.34u w=0.82u l=0.6u
X23 Z a_224_472# VSS VPW nfet_05v0 ad=0.2132p pd=1.34u as=0.2132p ps=1.34u w=0.82u l=0.6u
X24 VSS a_224_472# Z VPW nfet_05v0 ad=0.2132p pd=1.34u as=0.2132p ps=1.34u w=0.82u l=0.6u
X25 VDD a_224_472# Z VNW pfet_05v0 ad=0.3782p pd=1.84u as=0.3782p ps=1.84u w=1.22u l=0.5u
X26 Z a_224_472# VDD VNW pfet_05v0 ad=0.3782p pd=1.84u as=0.3782p ps=1.84u w=1.22u l=0.5u
X27 Z a_224_472# VSS VPW nfet_05v0 ad=0.2132p pd=1.34u as=0.2132p ps=1.34u w=0.82u l=0.6u
X28 VDD I a_224_472# VNW pfet_05v0 ad=0.3782p pd=1.84u as=0.3782p ps=1.84u w=1.22u l=0.5u
X29 VDD a_224_472# Z VNW pfet_05v0 ad=0.3782p pd=1.84u as=0.3782p ps=1.84u w=1.22u l=0.5u
X30 VDD I a_224_472# VNW pfet_05v0 ad=0.3782p pd=1.84u as=0.3782p ps=1.84u w=1.22u l=0.5u
X31 Z a_224_472# VSS VPW nfet_05v0 ad=0.2132p pd=1.34u as=0.2132p ps=1.34u w=0.82u l=0.6u
X32 Z a_224_472# VDD VNW pfet_05v0 ad=0.3782p pd=1.84u as=0.3782p ps=1.84u w=1.22u l=0.5u
X33 VDD a_224_472# Z VNW pfet_05v0 ad=0.5368p pd=3.32u as=0.3782p ps=1.84u w=1.22u l=0.5u
X34 Z a_224_472# VSS VPW nfet_05v0 ad=0.2132p pd=1.34u as=0.2132p ps=1.34u w=0.82u l=0.6u
X35 a_224_472# I VDD VNW pfet_05v0 ad=0.3782p pd=1.84u as=0.3782p ps=1.84u w=1.22u l=0.5u
X36 VSS I a_224_472# VPW nfet_05v0 ad=0.2132p pd=1.34u as=0.2132p ps=1.34u w=0.82u l=0.6u
X37 Z a_224_472# VDD VNW pfet_05v0 ad=0.3782p pd=1.84u as=0.3782p ps=1.84u w=1.22u l=0.5u
X38 VDD I a_224_472# VNW pfet_05v0 ad=0.3782p pd=1.84u as=0.3782p ps=1.84u w=1.22u l=0.5u
X39 VSS I a_224_472# VPW nfet_05v0 ad=0.2132p pd=1.34u as=0.2132p ps=1.34u w=0.82u l=0.6u
X40 VDD a_224_472# Z VNW pfet_05v0 ad=0.3782p pd=1.84u as=0.3782p ps=1.84u w=1.22u l=0.5u
X41 VSS a_224_472# Z VPW nfet_05v0 ad=0.2132p pd=1.34u as=0.2132p ps=1.34u w=0.82u l=0.6u
X42 Z a_224_472# VSS VPW nfet_05v0 ad=0.2132p pd=1.34u as=0.2132p ps=1.34u w=0.82u l=0.6u
X43 Z a_224_472# VDD VNW pfet_05v0 ad=0.3782p pd=1.84u as=0.3782p ps=1.84u w=1.22u l=0.5u
X44 VSS I a_224_472# VPW nfet_05v0 ad=0.2132p pd=1.34u as=0.2132p ps=1.34u w=0.82u l=0.6u
X45 a_224_472# I VDD VNW pfet_05v0 ad=0.3782p pd=1.84u as=0.3782p ps=1.84u w=1.22u l=0.5u
X46 VDD a_224_472# Z VNW pfet_05v0 ad=0.3782p pd=1.84u as=0.3782p ps=1.84u w=1.22u l=0.5u
X47 VSS a_224_472# Z VPW nfet_05v0 ad=0.2132p pd=1.34u as=0.2132p ps=1.34u w=0.82u l=0.6u
X48 Z a_224_472# VDD VNW pfet_05v0 ad=0.3782p pd=1.84u as=0.3782p ps=1.84u w=1.22u l=0.5u
X49 Z a_224_472# VDD VNW pfet_05v0 ad=0.3782p pd=1.84u as=0.3782p ps=1.84u w=1.22u l=0.5u
X50 VSS I a_224_472# VPW nfet_05v0 ad=0.2132p pd=1.34u as=0.2132p ps=1.34u w=0.82u l=0.6u
X51 VDD a_224_472# Z VNW pfet_05v0 ad=0.3782p pd=1.84u as=0.3782p ps=1.84u w=1.22u l=0.5u
X52 a_224_472# I VDD VNW pfet_05v0 ad=0.3782p pd=1.84u as=0.5368p ps=3.32u w=1.22u l=0.5u
X53 VDD a_224_472# Z VNW pfet_05v0 ad=0.3782p pd=1.84u as=0.3782p ps=1.84u w=1.22u l=0.5u
X54 VSS I a_224_472# VPW nfet_05v0 ad=0.2132p pd=1.34u as=0.2132p ps=1.34u w=0.82u l=0.6u
X55 Z a_224_472# VSS VPW nfet_05v0 ad=0.2132p pd=1.34u as=0.2132p ps=1.34u w=0.82u l=0.6u
X56 VSS a_224_472# Z VPW nfet_05v0 ad=0.2132p pd=1.34u as=0.2132p ps=1.34u w=0.82u l=0.6u
X57 VSS a_224_472# Z VPW nfet_05v0 ad=0.3608p pd=2.52u as=0.2132p ps=1.34u w=0.82u l=0.6u
X58 Z a_224_472# VDD VNW pfet_05v0 ad=0.3782p pd=1.84u as=0.3782p ps=1.84u w=1.22u l=0.5u
X59 a_224_472# I VSS VPW nfet_05v0 ad=0.2132p pd=1.34u as=0.2132p ps=1.34u w=0.82u l=0.6u
.ends

.subckt gf180mcu_fd_sc_mcu7t5v0__nor4_1 A1 A2 A3 A4 ZN VDD VNW VPW VSS
X0 a_672_472# A2 a_448_472# VNW pfet_05v0 ad=0.3782p pd=1.84u as=0.3782p ps=1.84u w=1.22u l=0.5u
X1 VSS A1 ZN VPW nfet_05v0 ad=0.1584p pd=1.6u as=93.59999f ps=0.88u w=0.36u l=0.6u
X2 VSS A3 ZN VPW nfet_05v0 ad=93.59999f pd=0.88u as=93.59999f ps=0.88u w=0.36u l=0.6u
X3 a_244_472# A4 VDD VNW pfet_05v0 ad=0.3172p pd=1.74u as=0.5368p ps=3.32u w=1.22u l=0.5u
X4 a_448_472# A3 a_244_472# VNW pfet_05v0 ad=0.3782p pd=1.84u as=0.3172p ps=1.74u w=1.22u l=0.5u
X5 ZN A2 VSS VPW nfet_05v0 ad=93.59999f pd=0.88u as=93.59999f ps=0.88u w=0.36u l=0.6u
X6 ZN A4 VSS VPW nfet_05v0 ad=93.59999f pd=0.88u as=0.1584p ps=1.6u w=0.36u l=0.6u
X7 ZN A1 a_672_472# VNW pfet_05v0 ad=0.5368p pd=3.32u as=0.3782p ps=1.84u w=1.22u l=0.5u
.ends

.subckt gf180mcu_fd_sc_mcu7t5v0__mux2_1 I0 I1 S Z VDD VNW VPW VSS
X0 a_896_593# S a_124_24# VNW pfet_05v0 ad=73.799995f pd=0.855u as=0.1599p ps=1.135u w=0.615u l=0.5u
X1 VSS a_124_24# Z VPW nfet_05v0 ad=0.218p pd=1.52u as=0.3608p ps=2.52u w=0.82u l=0.6u
X2 a_124_24# S a_504_104# VPW nfet_05v0 ad=93.59999f pd=0.88u as=43.199997f ps=0.6u w=0.36u l=0.6u
X3 VDD a_124_24# Z VNW pfet_05v0 ad=0.429825p pd=2.185u as=0.5368p ps=3.32u w=1.22u l=0.5u
X4 VDD I0 a_896_593# VNW pfet_05v0 ad=0.1599p pd=1.135u as=73.799995f ps=0.855u w=0.615u l=0.5u
X5 a_592_407# S VSS VPW nfet_05v0 ad=0.1584p pd=1.6u as=93.59999f ps=0.88u w=0.36u l=0.6u
X6 a_504_104# I1 VSS VPW nfet_05v0 ad=43.199997f pd=0.6u as=0.218p ps=1.52u w=0.36u l=0.6u
X7 a_592_407# S VDD VNW pfet_05v0 ad=0.2706p pd=2.11u as=0.1599p ps=1.135u w=0.615u l=0.5u
X8 a_537_593# I1 VDD VNW pfet_05v0 ad=84.549995f pd=0.89u as=0.429825p ps=2.185u w=0.615u l=0.5u
X9 VSS I0 a_896_104# VPW nfet_05v0 ad=93.59999f pd=0.88u as=43.199997f ps=0.6u w=0.36u l=0.6u
X10 a_896_104# a_592_407# a_124_24# VPW nfet_05v0 ad=43.199997f pd=0.6u as=93.59999f ps=0.88u w=0.36u l=0.6u
X11 a_124_24# a_592_407# a_537_593# VNW pfet_05v0 ad=0.1599p pd=1.135u as=84.549995f ps=0.89u w=0.615u l=0.5u
.ends

.subckt gf180mcu_fd_sc_mcu7t5v0__oai31_1 A1 A2 A3 B ZN VDD VNW VPW VSS
X0 a_468_497# A1 ZN VNW pfet_05v0 ad=0.58035p pd=2.155u as=0.4012p ps=1.85u w=1.095u l=0.5u
X1 a_244_69# A2 ZN VPW nfet_05v0 ad=0.2119p pd=1.335u as=0.4137p ps=1.9u w=0.815u l=0.6u
X2 a_780_497# A2 a_468_497# VNW pfet_05v0 ad=0.2847p pd=1.615u as=0.58035p ps=2.155u w=1.095u l=0.5u
X3 ZN A1 a_244_69# VPW nfet_05v0 ad=0.4137p pd=1.9u as=0.2119p ps=1.335u w=0.815u l=0.6u
X4 VDD A3 a_780_497# VNW pfet_05v0 ad=0.5913p pd=3.27u as=0.2847p ps=1.615u w=1.095u l=0.5u
X5 a_244_69# B VSS VPW nfet_05v0 ad=0.2119p pd=1.335u as=0.3586p ps=2.51u w=0.815u l=0.6u
X6 ZN B VDD VNW pfet_05v0 ad=0.4012p pd=1.85u as=0.4972p ps=3.14u w=1.13u l=0.5u
X7 ZN A3 a_244_69# VPW nfet_05v0 ad=0.3586p pd=2.51u as=0.2119p ps=1.335u w=0.815u l=0.6u
.ends

.subckt gf180mcu_fd_sc_mcu7t5v0__clkbuf_12 I Z VDD VNW VPW VSS
X0 VSS I a_224_552# VPW nfet_05v0 ad=94.899994f pd=0.885u as=94.899994f ps=0.885u w=0.365u l=0.6u
X1 VSS a_224_552# Z VPW nfet_05v0 ad=0.1248p pd=1u as=0.1248p ps=1u w=0.48u l=0.6u
X2 a_224_552# I VSS VPW nfet_05v0 ad=0.1606p pd=1.61u as=94.899994f ps=0.885u w=0.365u l=0.6u
X3 VDD a_224_552# Z VNW pfet_05v0 ad=0.3782p pd=1.84u as=0.3782p ps=1.84u w=1.22u l=0.5u
X4 Z a_224_552# VDD VNW pfet_05v0 ad=0.3782p pd=1.84u as=0.3782p ps=1.84u w=1.22u l=0.5u
X5 VSS I a_224_552# VPW nfet_05v0 ad=94.899994f pd=0.885u as=94.899994f ps=0.885u w=0.365u l=0.6u
X6 a_224_552# I VDD VNW pfet_05v0 ad=0.2542p pd=1.44u as=0.3608p ps=2.52u w=0.82u l=0.5u
X7 VDD a_224_552# Z VNW pfet_05v0 ad=0.3782p pd=1.84u as=0.3782p ps=1.84u w=1.22u l=0.5u
X8 VSS a_224_552# Z VPW nfet_05v0 ad=0.1248p pd=1u as=0.1248p ps=1u w=0.48u l=0.6u
X9 Z a_224_552# VDD VNW pfet_05v0 ad=0.3782p pd=1.84u as=0.408p ps=2.02u w=1.22u l=0.5u
X10 Z a_224_552# VSS VPW nfet_05v0 ad=0.1248p pd=1u as=0.1248p ps=1u w=0.48u l=0.6u
X11 a_224_552# I VDD VNW pfet_05v0 ad=0.2542p pd=1.44u as=0.2542p ps=1.44u w=0.82u l=0.5u
X12 VSS a_224_552# Z VPW nfet_05v0 ad=0.1248p pd=1u as=0.1248p ps=1u w=0.48u l=0.6u
X13 a_224_552# I VSS VPW nfet_05v0 ad=94.899994f pd=0.885u as=0.1606p ps=1.61u w=0.365u l=0.6u
X14 Z a_224_552# VSS VPW nfet_05v0 ad=0.1248p pd=1u as=0.2112p ps=1.84u w=0.48u l=0.6u
X15 Z a_224_552# VDD VNW pfet_05v0 ad=0.3782p pd=1.84u as=0.3782p ps=1.84u w=1.22u l=0.5u
X16 VDD I a_224_552# VNW pfet_05v0 ad=0.408p pd=2.02u as=0.2542p ps=1.44u w=0.82u l=0.5u
X17 VDD a_224_552# Z VNW pfet_05v0 ad=0.3782p pd=1.84u as=0.3782p ps=1.84u w=1.22u l=0.5u
X18 a_224_552# I VSS VPW nfet_05v0 ad=94.899994f pd=0.885u as=94.899994f ps=0.885u w=0.365u l=0.6u
X19 Z a_224_552# VSS VPW nfet_05v0 ad=0.1248p pd=1u as=0.1248p ps=1u w=0.48u l=0.6u
X20 Z a_224_552# VDD VNW pfet_05v0 ad=0.3782p pd=1.84u as=0.3782p ps=1.84u w=1.22u l=0.5u
X21 VSS a_224_552# Z VPW nfet_05v0 ad=0.1248p pd=1u as=0.1248p ps=1u w=0.48u l=0.6u
X22 Z a_224_552# VDD VNW pfet_05v0 ad=0.3782p pd=1.84u as=0.3782p ps=1.84u w=1.22u l=0.5u
X23 Z a_224_552# VSS VPW nfet_05v0 ad=0.1248p pd=1u as=0.1248p ps=1u w=0.48u l=0.6u
X24 VDD I a_224_552# VNW pfet_05v0 ad=0.2542p pd=1.44u as=0.2542p ps=1.44u w=0.82u l=0.5u
X25 VDD a_224_552# Z VNW pfet_05v0 ad=0.3782p pd=1.84u as=0.3782p ps=1.84u w=1.22u l=0.5u
X26 VDD a_224_552# Z VNW pfet_05v0 ad=0.5368p pd=3.32u as=0.3782p ps=1.84u w=1.22u l=0.5u
X27 Z a_224_552# VDD VNW pfet_05v0 ad=0.3782p pd=1.84u as=0.3782p ps=1.84u w=1.22u l=0.5u
X28 a_224_552# I VDD VNW pfet_05v0 ad=0.2542p pd=1.44u as=0.2542p ps=1.44u w=0.82u l=0.5u
X29 VDD a_224_552# Z VNW pfet_05v0 ad=0.3782p pd=1.84u as=0.3782p ps=1.84u w=1.22u l=0.5u
X30 Z a_224_552# VSS VPW nfet_05v0 ad=0.1248p pd=1u as=0.1248p ps=1u w=0.48u l=0.6u
X31 VSS a_224_552# Z VPW nfet_05v0 ad=0.1248p pd=1u as=0.1248p ps=1u w=0.48u l=0.6u
X32 VSS a_224_552# Z VPW nfet_05v0 ad=0.2112p pd=1.84u as=0.1248p ps=1u w=0.48u l=0.6u
X33 VDD I a_224_552# VNW pfet_05v0 ad=0.2542p pd=1.44u as=0.2542p ps=1.44u w=0.82u l=0.5u
X34 Z a_224_552# VSS VPW nfet_05v0 ad=0.1248p pd=1u as=0.1248p ps=1u w=0.48u l=0.6u
.ends

.subckt gf180mcu_fd_sc_mcu7t5v0__oai221_2 A1 A2 B1 B2 C ZN VDD VNW VPW VSS
X0 ZN B1 a_224_497# VNW pfet_05v0 ad=0.2847p pd=1.615u as=0.3942p ps=1.815u w=1.095u l=0.5u
X1 a_672_497# B1 ZN VNW pfet_05v0 ad=0.3942p pd=1.815u as=0.2847p ps=1.615u w=1.095u l=0.5u
X2 a_244_68# B1 VSS VPW nfet_05v0 ad=0.2132p pd=1.34u as=0.2132p ps=1.34u w=0.82u l=0.6u
X3 a_244_68# B2 VSS VPW nfet_05v0 ad=0.2132p pd=1.34u as=0.3608p ps=2.52u w=0.82u l=0.6u
X4 a_1076_93# A2 ZN VPW nfet_05v0 ad=0.2132p pd=1.34u as=0.2132p ps=1.34u w=0.82u l=0.6u
X5 a_1076_93# C a_244_68# VPW nfet_05v0 ad=0.2132p pd=1.34u as=0.2132p ps=1.34u w=0.82u l=0.6u
X6 VDD C ZN VNW pfet_05v0 ad=0.2561p pd=1.505u as=0.5319p ps=3.05u w=0.985u l=0.5u
X7 a_2160_497# A2 VDD VNW pfet_05v0 ad=0.4599p pd=1.935u as=0.2847p ps=1.615u w=1.095u l=0.5u
X8 ZN C VDD VNW pfet_05v0 ad=0.3766p pd=1.815u as=0.2561p ps=1.505u w=0.985u l=0.5u
X9 VDD B2 a_672_497# VNW pfet_05v0 ad=0.4818p pd=3.07u as=0.3942p ps=1.815u w=1.095u l=0.5u
X10 VDD A2 a_1732_497# VNW pfet_05v0 ad=0.2847p pd=1.615u as=0.33945p ps=1.715u w=1.095u l=0.5u
X11 ZN A1 a_1076_93# VPW nfet_05v0 ad=0.2132p pd=1.34u as=0.2132p ps=1.34u w=0.82u l=0.6u
X12 a_1076_93# A1 ZN VPW nfet_05v0 ad=0.3608p pd=2.52u as=0.30965p ps=1.685u w=0.82u l=0.6u
X13 a_244_68# C a_1076_93# VPW nfet_05v0 ad=0.2132p pd=1.34u as=0.3608p ps=2.52u w=0.82u l=0.6u
X14 ZN A2 a_1076_93# VPW nfet_05v0 ad=0.30965p pd=1.685u as=0.2132p ps=1.34u w=0.82u l=0.6u
X15 VSS B2 a_244_68# VPW nfet_05v0 ad=0.3608p pd=2.52u as=0.2132p ps=1.34u w=0.82u l=0.6u
X16 VSS B1 a_244_68# VPW nfet_05v0 ad=0.2132p pd=1.34u as=0.2132p ps=1.34u w=0.82u l=0.6u
X17 ZN A1 a_2160_497# VNW pfet_05v0 ad=0.4818p pd=3.07u as=0.4599p ps=1.935u w=1.095u l=0.5u
X18 a_224_497# B2 VDD VNW pfet_05v0 ad=0.3942p pd=1.815u as=0.4818p ps=3.07u w=1.095u l=0.5u
X19 a_1732_497# A1 ZN VNW pfet_05v0 ad=0.33945p pd=1.715u as=0.3766p ps=1.815u w=1.095u l=0.5u
.ends

.subckt gf180mcu_fd_sc_mcu7t5v0__inv_12 I ZN VDD VNW VPW VSS
X0 ZN I VDD VNW pfet_05v0 ad=0.3782p pd=1.84u as=0.3782p ps=1.84u w=1.22u l=0.5u
X1 ZN I VDD VNW pfet_05v0 ad=0.3782p pd=1.84u as=0.3782p ps=1.84u w=1.22u l=0.5u
X2 ZN I VSS VPW nfet_05v0 ad=0.2132p pd=1.34u as=0.2132p ps=1.34u w=0.82u l=0.6u
X3 VSS I ZN VPW nfet_05v0 ad=0.3608p pd=2.52u as=0.2132p ps=1.34u w=0.82u l=0.6u
X4 VDD I ZN VNW pfet_05v0 ad=0.3782p pd=1.84u as=0.3782p ps=1.84u w=1.22u l=0.5u
X5 ZN I VDD VNW pfet_05v0 ad=0.3782p pd=1.84u as=0.3782p ps=1.84u w=1.22u l=0.5u
X6 ZN I VSS VPW nfet_05v0 ad=0.2132p pd=1.34u as=0.3608p ps=2.52u w=0.82u l=0.6u
X7 ZN I VSS VPW nfet_05v0 ad=0.2132p pd=1.34u as=0.2132p ps=1.34u w=0.82u l=0.6u
X8 VDD I ZN VNW pfet_05v0 ad=0.3782p pd=1.84u as=0.3782p ps=1.84u w=1.22u l=0.5u
X9 ZN I VSS VPW nfet_05v0 ad=0.2132p pd=1.34u as=0.2132p ps=1.34u w=0.82u l=0.6u
X10 ZN I VSS VPW nfet_05v0 ad=0.2132p pd=1.34u as=0.2132p ps=1.34u w=0.82u l=0.6u
X11 VDD I ZN VNW pfet_05v0 ad=0.3782p pd=1.84u as=0.3782p ps=1.84u w=1.22u l=0.5u
X12 VDD I ZN VNW pfet_05v0 ad=0.3782p pd=1.84u as=0.3782p ps=1.84u w=1.22u l=0.5u
X13 ZN I VDD VNW pfet_05v0 ad=0.3782p pd=1.84u as=0.3782p ps=1.84u w=1.22u l=0.5u
X14 VSS I ZN VPW nfet_05v0 ad=0.2132p pd=1.34u as=0.2132p ps=1.34u w=0.82u l=0.6u
X15 VDD I ZN VNW pfet_05v0 ad=0.3782p pd=1.84u as=0.3782p ps=1.84u w=1.22u l=0.5u
X16 VSS I ZN VPW nfet_05v0 ad=0.2132p pd=1.34u as=0.2132p ps=1.34u w=0.82u l=0.6u
X17 VDD I ZN VNW pfet_05v0 ad=0.5368p pd=3.32u as=0.3782p ps=1.84u w=1.22u l=0.5u
X18 VSS I ZN VPW nfet_05v0 ad=0.2132p pd=1.34u as=0.2132p ps=1.34u w=0.82u l=0.6u
X19 ZN I VDD VNW pfet_05v0 ad=0.3782p pd=1.84u as=0.3782p ps=1.84u w=1.22u l=0.5u
X20 VSS I ZN VPW nfet_05v0 ad=0.2132p pd=1.34u as=0.2132p ps=1.34u w=0.82u l=0.6u
X21 ZN I VDD VNW pfet_05v0 ad=0.3782p pd=1.84u as=0.5368p ps=3.32u w=1.22u l=0.5u
X22 VSS I ZN VPW nfet_05v0 ad=0.2132p pd=1.34u as=0.2132p ps=1.34u w=0.82u l=0.6u
X23 ZN I VSS VPW nfet_05v0 ad=0.2132p pd=1.34u as=0.2132p ps=1.34u w=0.82u l=0.6u
.ends

.subckt gf180mcu_fd_sc_mcu7t5v0__mux4_4 I0 I1 I2 I3 S0 S1 Z VDD VNW VPW VSS
X0 a_2595_156# S0 a_3216_156# VPW nfet_05v0 ad=94.899994f pd=0.885u as=94.899994f ps=0.885u w=0.365u l=0.6u
X1 Z a_1108_112# VSS VPW nfet_05v0 ad=98.799995f pd=0.9u as=98.799995f ps=0.9u w=0.38u l=0.6u
X2 a_728_472# a_348_112# a_468_156# VNW pfet_05v0 ad=0.3042p pd=1.56u as=0.2028p ps=1.3u w=0.78u l=0.5u
X3 VSS I3 a_728_472# VPW nfet_05v0 ad=98.799995f pd=0.9u as=98.799995f ps=0.9u w=0.38u l=0.6u
X4 Z a_1108_112# VDD VNW pfet_05v0 ad=0.2028p pd=1.3u as=0.3198p ps=1.6u w=0.78u l=0.5u
X5 a_348_112# S0 VDD VNW pfet_05v0 ad=0.2618p pd=2.07u as=0.18445p ps=1.215u w=0.595u l=0.5u
X6 Z a_1108_112# VSS VPW nfet_05v0 ad=98.799995f pd=0.9u as=98.799995f ps=0.9u w=0.38u l=0.6u
X7 a_3216_156# I1 VSS VPW nfet_05v0 ad=94.899994f pd=0.885u as=94.899994f ps=0.885u w=0.365u l=0.6u
X8 VDD I3 a_728_472# VNW pfet_05v0 ad=0.3198p pd=1.6u as=0.3042p ps=1.56u w=0.78u l=0.5u
X9 VDD a_1108_112# Z VNW pfet_05v0 ad=0.2028p pd=1.3u as=0.2028p ps=1.3u w=0.78u l=0.5u
X10 VSS I0 a_3624_509# VPW nfet_05v0 ad=94.899994f pd=0.885u as=94.899994f ps=0.885u w=0.365u l=0.6u
X11 a_3216_156# I1 VDD VNW pfet_05v0 ad=0.1547p pd=1.115u as=0.18445p ps=1.215u w=0.595u l=0.5u
X12 Z a_1108_112# VDD VNW pfet_05v0 ad=0.2028p pd=1.3u as=0.2028p ps=1.3u w=0.78u l=0.5u
X13 a_468_156# a_348_112# a_224_472# VPW nfet_05v0 ad=0.1824p pd=1.34u as=98.799995f ps=0.9u w=0.38u l=0.6u
X14 a_2595_156# a_348_112# a_3216_156# VNW pfet_05v0 ad=0.1547p pd=1.115u as=0.1547p ps=1.115u w=0.595u l=0.5u
X15 VDD a_1108_112# Z VNW pfet_05v0 ad=0.4524p pd=2.72u as=0.2028p ps=1.3u w=0.78u l=0.5u
X16 a_3624_509# S0 a_2595_156# VNW pfet_05v0 ad=0.2142p pd=1.315u as=0.1547p ps=1.115u w=0.595u l=0.5u
X17 a_728_472# S0 a_468_156# VPW nfet_05v0 ad=98.799995f pd=0.9u as=0.1824p ps=1.34u w=0.38u l=0.6u
X18 a_2595_156# S1 a_1108_112# VNW pfet_05v0 ad=0.2618p pd=2.07u as=0.2618p ps=1.475u w=0.595u l=0.5u
X19 VDD I0 a_3624_509# VNW pfet_05v0 ad=0.18445p pd=1.215u as=0.2142p ps=1.315u w=0.595u l=0.5u
X20 a_2595_156# a_2220_369# a_1108_112# VPW nfet_05v0 ad=0.162425p pd=1.62u as=0.112225p ps=0.98u w=0.365u l=0.6u
X21 VSS a_1108_112# Z VPW nfet_05v0 ad=98.799995f pd=0.9u as=98.799995f ps=0.9u w=0.38u l=0.6u
X22 a_3624_509# a_348_112# a_2595_156# VPW nfet_05v0 ad=94.899994f pd=0.885u as=94.899994f ps=0.885u w=0.365u l=0.6u
X23 VDD S1 a_2220_369# VNW pfet_05v0 ad=0.18445p pd=1.215u as=0.2618p ps=2.07u w=0.595u l=0.5u
X24 a_1108_112# S1 a_468_156# VPW nfet_05v0 ad=0.112225p pd=0.98u as=0.27375p ps=2.23u w=0.365u l=0.6u
X25 a_224_472# I2 VSS VPW nfet_05v0 ad=98.799995f pd=0.9u as=0.1672p ps=1.64u w=0.38u l=0.6u
X26 VSS a_1108_112# Z VPW nfet_05v0 ad=0.1672p pd=1.64u as=98.799995f ps=0.9u w=0.38u l=0.6u
X27 a_348_112# S0 VSS VPW nfet_05v0 ad=0.1606p pd=1.61u as=94.899994f ps=0.885u w=0.365u l=0.6u
X28 VSS S1 a_2220_369# VPW nfet_05v0 ad=94.899994f pd=0.885u as=0.1606p ps=1.61u w=0.365u l=0.6u
X29 a_224_472# I2 VDD VNW pfet_05v0 ad=0.39p pd=1.78u as=0.3432p ps=2.44u w=0.78u l=0.5u
X30 a_1108_112# a_2220_369# a_468_156# VNW pfet_05v0 ad=0.2618p pd=1.475u as=0.401625p ps=2.54u w=0.595u l=0.5u
X31 a_468_156# S0 a_224_472# VNW pfet_05v0 ad=0.2028p pd=1.3u as=0.39p ps=1.78u w=0.78u l=0.5u
.ends

.subckt gf180mcu_fd_sc_mcu7t5v0__nor4_4 A1 A2 A3 A4 ZN VDD VNW VPW VSS
X0 a_66_473# A3 a_692_473# VNW pfet_05v0 ad=0.486p pd=2.015u as=0.486p ps=2.015u w=1.215u l=0.5u
X1 VSS A3 ZN VPW nfet_05v0 ad=0.126p pd=1.06u as=0.126p ps=1.06u w=0.36u l=0.6u
X2 a_2180_473# A2 a_1920_473# VNW pfet_05v0 ad=0.486p pd=2.015u as=0.486p ps=2.015u w=1.215u l=0.5u
X3 a_3220_473# A2 a_66_473# VNW pfet_05v0 ad=0.486p pd=2.015u as=0.486p ps=2.015u w=1.215u l=0.5u
X4 a_3740_473# A1 ZN VNW pfet_05v0 ad=0.455625p pd=1.965u as=0.486p ps=2.015u w=1.215u l=0.5u
X5 a_1212_473# A3 a_66_473# VNW pfet_05v0 ad=0.37665p pd=1.835u as=0.486p ps=2.015u w=1.215u l=0.5u
X6 VSS A3 ZN VPW nfet_05v0 ad=0.126p pd=1.06u as=0.126p ps=1.06u w=0.36u l=0.6u
X7 a_66_473# A2 a_2700_473# VNW pfet_05v0 ad=0.486p pd=2.015u as=0.486p ps=2.015u w=1.215u l=0.5u
X8 a_66_473# A2 a_3740_473# VNW pfet_05v0 ad=0.5346p pd=3.31u as=0.455625p ps=1.965u w=1.215u l=0.5u
X9 ZN A1 a_2180_473# VNW pfet_05v0 ad=0.486p pd=2.015u as=0.486p ps=2.015u w=1.215u l=0.5u
X10 ZN A2 VSS VPW nfet_05v0 ad=0.126p pd=1.06u as=0.126p ps=1.06u w=0.36u l=0.6u
X11 VDD A4 a_254_473# VNW pfet_05v0 ad=0.37665p pd=1.835u as=0.346275p ps=1.785u w=1.215u l=0.5u
X12 VSS A4 ZN VPW nfet_05v0 ad=93.59999f pd=0.88u as=93.59999f ps=0.88u w=0.36u l=0.6u
X13 ZN A1 VSS VPW nfet_05v0 ad=0.126p pd=1.06u as=0.126p ps=1.06u w=0.36u l=0.6u
X14 a_1660_473# A4 VDD VNW pfet_05v0 ad=0.486p pd=2.015u as=0.37665p ps=1.835u w=1.215u l=0.5u
X15 a_2700_473# A1 ZN VNW pfet_05v0 ad=0.486p pd=2.015u as=0.486p ps=2.015u w=1.215u l=0.5u
X16 VSS A1 ZN VPW nfet_05v0 ad=0.126p pd=1.06u as=0.126p ps=1.06u w=0.36u l=0.6u
X17 a_254_473# A3 a_66_473# VNW pfet_05v0 ad=0.346275p pd=1.785u as=0.5346p ps=3.31u w=1.215u l=0.5u
X18 VSS A4 ZN VPW nfet_05v0 ad=93.59999f pd=0.88u as=93.59999f ps=0.88u w=0.36u l=0.6u
X19 a_1920_473# A3 a_1660_473# VNW pfet_05v0 ad=0.486p pd=2.015u as=0.486p ps=2.015u w=1.215u l=0.5u
X20 VSS A2 ZN VPW nfet_05v0 ad=0.126p pd=1.06u as=0.126p ps=1.06u w=0.36u l=0.6u
X21 ZN A4 VSS VPW nfet_05v0 ad=0.126p pd=1.06u as=93.59999f ps=0.88u w=0.36u l=0.6u
X22 ZN A3 VSS VPW nfet_05v0 ad=93.59999f pd=0.88u as=0.126p ps=1.06u w=0.36u l=0.6u
X23 ZN A4 VSS VPW nfet_05v0 ad=0.126p pd=1.06u as=93.59999f ps=0.88u w=0.36u l=0.6u
X24 ZN A3 VSS VPW nfet_05v0 ad=93.59999f pd=0.88u as=0.1584p ps=1.6u w=0.36u l=0.6u
X25 VDD A4 a_1212_473# VNW pfet_05v0 ad=0.37665p pd=1.835u as=0.37665p ps=1.835u w=1.215u l=0.5u
X26 VSS A1 ZN VPW nfet_05v0 ad=0.126p pd=1.06u as=0.126p ps=1.06u w=0.36u l=0.6u
X27 a_692_473# A4 VDD VNW pfet_05v0 ad=0.486p pd=2.015u as=0.37665p ps=1.835u w=1.215u l=0.5u
X28 ZN A2 VSS VPW nfet_05v0 ad=0.126p pd=1.06u as=0.126p ps=1.06u w=0.36u l=0.6u
X29 VSS A2 ZN VPW nfet_05v0 ad=0.1584p pd=1.6u as=0.126p ps=1.06u w=0.36u l=0.6u
X30 ZN A1 a_3220_473# VNW pfet_05v0 ad=0.486p pd=2.015u as=0.486p ps=2.015u w=1.215u l=0.5u
X31 ZN A1 VSS VPW nfet_05v0 ad=0.126p pd=1.06u as=0.126p ps=1.06u w=0.36u l=0.6u
.ends

.subckt gf180mcu_fd_sc_mcu7t5v0__oai211_4 A1 A2 B C ZN VDD VNW VPW VSS
X0 VDD A2 a_1612_497# VNW pfet_05v0 ad=0.3766p pd=1.815u as=0.4599p ps=1.935u w=1.095u l=0.5u
X1 VDD C ZN VNW pfet_05v0 ad=0.2561p pd=1.505u as=0.2561p ps=1.505u w=0.985u l=0.5u
X2 ZN A1 a_36_68# VPW nfet_05v0 ad=0.2132p pd=1.34u as=0.2132p ps=1.34u w=0.82u l=0.6u
X3 a_716_497# A1 ZN VNW pfet_05v0 ad=0.3942p pd=1.815u as=0.2847p ps=1.615u w=1.095u l=0.5u
X4 VDD A2 a_716_497# VNW pfet_05v0 ad=0.2847p pd=1.615u as=0.3942p ps=1.815u w=1.095u l=0.5u
X5 ZN C VDD VNW pfet_05v0 ad=0.2561p pd=1.505u as=0.2561p ps=1.505u w=0.985u l=0.5u
X6 a_2124_68# B a_36_68# VPW nfet_05v0 ad=0.1722p pd=1.24u as=0.2132p ps=1.34u w=0.82u l=0.6u
X7 VDD C ZN VNW pfet_05v0 ad=0.2561p pd=1.505u as=0.2561p ps=1.505u w=0.985u l=0.5u
X8 ZN A2 a_36_68# VPW nfet_05v0 ad=0.30965p pd=1.685u as=0.3608p ps=2.52u w=0.82u l=0.6u
X9 a_36_68# A2 ZN VPW nfet_05v0 ad=0.2132p pd=1.34u as=0.30965p ps=1.685u w=0.82u l=0.6u
X10 VSS C a_2960_68# VPW nfet_05v0 ad=0.2132p pd=1.34u as=0.1312p ps=1.14u w=0.82u l=0.6u
X11 VDD B ZN VNW pfet_05v0 ad=0.2561p pd=1.505u as=0.2561p ps=1.505u w=0.985u l=0.5u
X12 ZN C VDD VNW pfet_05v0 ad=0.2561p pd=1.505u as=0.2561p ps=1.505u w=0.985u l=0.5u
X13 a_36_68# A2 ZN VPW nfet_05v0 ad=0.2132p pd=1.34u as=0.2132p ps=1.34u w=0.82u l=0.6u
X14 a_1164_497# A2 VDD VNW pfet_05v0 ad=0.3942p pd=1.815u as=0.2847p ps=1.615u w=1.095u l=0.5u
X15 ZN B VDD VNW pfet_05v0 ad=0.2561p pd=1.505u as=0.2561p ps=1.505u w=0.985u l=0.5u
X16 VDD B ZN VNW pfet_05v0 ad=0.4334p pd=2.85u as=0.2561p ps=1.505u w=0.985u l=0.5u
X17 a_36_68# A1 ZN VPW nfet_05v0 ad=0.2132p pd=1.34u as=0.30965p ps=1.685u w=0.82u l=0.6u
X18 a_36_68# B a_3368_68# VPW nfet_05v0 ad=0.3608p pd=2.52u as=0.1312p ps=1.14u w=0.82u l=0.6u
X19 a_244_497# A2 VDD VNW pfet_05v0 ad=0.4599p pd=1.935u as=0.4818p ps=3.07u w=1.095u l=0.5u
X20 VSS C a_2124_68# VPW nfet_05v0 ad=0.2132p pd=1.34u as=0.1722p ps=1.24u w=0.82u l=0.6u
X21 a_36_68# A1 ZN VPW nfet_05v0 ad=0.2132p pd=1.34u as=0.2132p ps=1.34u w=0.82u l=0.6u
X22 ZN A1 a_1164_497# VNW pfet_05v0 ad=0.2847p pd=1.615u as=0.3942p ps=1.815u w=1.095u l=0.5u
X23 a_36_68# B a_2552_68# VPW nfet_05v0 ad=0.2132p pd=1.34u as=0.1312p ps=1.14u w=0.82u l=0.6u
X24 a_2552_68# C VSS VPW nfet_05v0 ad=0.1312p pd=1.14u as=0.2132p ps=1.34u w=0.82u l=0.6u
X25 a_1612_497# A1 ZN VNW pfet_05v0 ad=0.4599p pd=1.935u as=0.2847p ps=1.615u w=1.095u l=0.5u
X26 ZN A1 a_36_68# VPW nfet_05v0 ad=0.30965p pd=1.685u as=0.2132p ps=1.34u w=0.82u l=0.6u
X27 ZN A2 a_36_68# VPW nfet_05v0 ad=0.2132p pd=1.34u as=0.2132p ps=1.34u w=0.82u l=0.6u
X28 a_3368_68# C VSS VPW nfet_05v0 ad=0.1312p pd=1.14u as=0.2132p ps=1.34u w=0.82u l=0.6u
X29 ZN B VDD VNW pfet_05v0 ad=0.2561p pd=1.505u as=0.3766p ps=1.815u w=0.985u l=0.5u
X30 a_2960_68# B a_36_68# VPW nfet_05v0 ad=0.1312p pd=1.14u as=0.2132p ps=1.34u w=0.82u l=0.6u
X31 ZN A1 a_244_497# VNW pfet_05v0 ad=0.2847p pd=1.615u as=0.4599p ps=1.935u w=1.095u l=0.5u
.ends

.subckt gf180mcu_fd_sc_mcu7t5v0__nor4_2 A1 A2 A3 A4 ZN VDD VNW VPW VSS
X0 VSS A3 ZN VPW nfet_05v0 ad=0.126p pd=1.06u as=0.126p ps=1.06u w=0.36u l=0.6u
X1 a_1213_472# A2 a_943_472# VNW pfet_05v0 ad=0.3477p pd=1.79u as=0.5185p ps=2.07u w=1.22u l=0.5u
X2 VSS A2 ZN VPW nfet_05v0 ad=0.1584p pd=1.6u as=93.59999f ps=0.88u w=0.36u l=0.6u
X3 a_943_472# A3 a_683_472# VNW pfet_05v0 ad=0.5185p pd=2.07u as=0.488p ps=2.02u w=1.22u l=0.5u
X4 VSS A1 ZN VPW nfet_05v0 ad=93.59999f pd=0.88u as=93.59999f ps=0.88u w=0.36u l=0.6u
X5 a_1661_472# A1 ZN VNW pfet_05v0 ad=0.3172p pd=1.74u as=0.4087p ps=1.89u w=1.22u l=0.5u
X6 VSS A4 ZN VPW nfet_05v0 ad=93.59999f pd=0.88u as=93.59999f ps=0.88u w=0.36u l=0.6u
X7 a_57_472# A2 a_1661_472# VNW pfet_05v0 ad=0.5368p pd=3.32u as=0.3172p ps=1.74u w=1.22u l=0.5u
X8 ZN A1 VSS VPW nfet_05v0 ad=93.59999f pd=0.88u as=93.59999f ps=0.88u w=0.36u l=0.6u
X9 VDD A4 a_245_472# VNW pfet_05v0 ad=0.3782p pd=1.84u as=0.3477p ps=1.79u w=1.22u l=0.5u
X10 ZN A2 VSS VPW nfet_05v0 ad=93.59999f pd=0.88u as=0.126p ps=1.06u w=0.36u l=0.6u
X11 ZN A4 VSS VPW nfet_05v0 ad=0.126p pd=1.06u as=93.59999f ps=0.88u w=0.36u l=0.6u
X12 a_245_472# A3 a_57_472# VNW pfet_05v0 ad=0.3477p pd=1.79u as=0.5368p ps=3.32u w=1.22u l=0.5u
X13 ZN A3 VSS VPW nfet_05v0 ad=93.59999f pd=0.88u as=0.1584p ps=1.6u w=0.36u l=0.6u
X14 ZN A1 a_1213_472# VNW pfet_05v0 ad=0.4087p pd=1.89u as=0.3477p ps=1.79u w=1.22u l=0.5u
X15 a_683_472# A4 VDD VNW pfet_05v0 ad=0.488p pd=2.02u as=0.3782p ps=1.84u w=1.22u l=0.5u
.ends

.subckt gf180mcu_fd_sc_mcu7t5v0__nor3_2 A1 A2 A3 ZN VDD VNW VPW VSS
X0 VDD A3 a_1130_472# VNW pfet_05v0 ad=0.5368p pd=3.32u as=0.3477p ps=1.79u w=1.22u l=0.5u
X1 a_1130_472# A2 a_906_472# VNW pfet_05v0 ad=0.3477p pd=1.79u as=0.3782p ps=1.84u w=1.22u l=0.5u
X2 ZN A3 VSS VPW nfet_05v0 ad=0.2046p pd=1.81u as=0.1209p ps=0.985u w=0.465u l=0.6u
X3 a_244_472# A3 VDD VNW pfet_05v0 ad=0.3782p pd=1.84u as=0.5368p ps=3.32u w=1.22u l=0.5u
X4 ZN A1 VSS VPW nfet_05v0 ad=0.1209p pd=0.985u as=0.1209p ps=0.985u w=0.465u l=0.6u
X5 ZN A2 VSS VPW nfet_05v0 ad=0.1209p pd=0.985u as=0.1209p ps=0.985u w=0.465u l=0.6u
X6 VSS A2 ZN VPW nfet_05v0 ad=0.1209p pd=0.985u as=0.1209p ps=0.985u w=0.465u l=0.6u
X7 a_906_472# A1 ZN VNW pfet_05v0 ad=0.3782p pd=1.84u as=0.3782p ps=1.84u w=1.22u l=0.5u
X8 ZN A1 a_468_472# VNW pfet_05v0 ad=0.3782p pd=1.84u as=0.3477p ps=1.79u w=1.22u l=0.5u
X9 VSS A1 ZN VPW nfet_05v0 ad=0.1209p pd=0.985u as=0.1209p ps=0.985u w=0.465u l=0.6u
X10 VSS A3 ZN VPW nfet_05v0 ad=0.1209p pd=0.985u as=0.2046p ps=1.81u w=0.465u l=0.6u
X11 a_468_472# A2 a_244_472# VNW pfet_05v0 ad=0.3477p pd=1.79u as=0.3782p ps=1.84u w=1.22u l=0.5u
.ends

.subckt gf180mcu_fd_sc_mcu7t5v0__oai31_2 A1 A2 A3 B ZN VDD VNW VPW VSS
X0 VDD A3 a_1612_497# VNW pfet_05v0 ad=0.4818p pd=3.07u as=0.4599p ps=1.935u w=1.095u l=0.5u
X1 a_960_497# A2 a_692_497# VNW pfet_05v0 ad=0.33945p pd=1.715u as=0.4599p ps=1.935u w=1.095u l=0.5u
X2 ZN A3 a_36_68# VPW nfet_05v0 ad=0.30965p pd=1.685u as=0.2132p ps=1.34u w=0.82u l=0.6u
X3 VSS B a_36_68# VPW nfet_05v0 ad=0.2132p pd=1.34u as=0.3608p ps=2.52u w=0.82u l=0.6u
X4 a_36_68# A3 ZN VPW nfet_05v0 ad=0.3608p pd=2.52u as=0.30965p ps=1.685u w=0.82u l=0.6u
X5 a_36_68# A2 ZN VPW nfet_05v0 ad=0.2132p pd=1.34u as=0.30965p ps=1.685u w=0.82u l=0.6u
X6 ZN B VDD VNW pfet_05v0 ad=0.2808p pd=1.6u as=0.5292p ps=3.14u w=1.08u l=0.5u
X7 a_36_68# A1 ZN VPW nfet_05v0 ad=0.2132p pd=1.34u as=0.2132p ps=1.34u w=0.82u l=0.6u
X8 a_692_497# A3 VDD VNW pfet_05v0 ad=0.4599p pd=1.935u as=0.3918p ps=1.815u w=1.095u l=0.5u
X9 VDD B ZN VNW pfet_05v0 ad=0.3918p pd=1.815u as=0.2808p ps=1.6u w=1.08u l=0.5u
X10 a_1612_497# A2 a_1388_497# VNW pfet_05v0 ad=0.4599p pd=1.935u as=0.33945p ps=1.715u w=1.095u l=0.5u
X11 ZN A2 a_36_68# VPW nfet_05v0 ad=0.30965p pd=1.685u as=0.2132p ps=1.34u w=0.82u l=0.6u
X12 ZN A1 a_960_497# VNW pfet_05v0 ad=0.2847p pd=1.615u as=0.33945p ps=1.715u w=1.095u l=0.5u
X13 a_36_68# B VSS VPW nfet_05v0 ad=0.2132p pd=1.34u as=0.2132p ps=1.34u w=0.82u l=0.6u
X14 ZN A1 a_36_68# VPW nfet_05v0 ad=0.2132p pd=1.34u as=0.2132p ps=1.34u w=0.82u l=0.6u
X15 a_1388_497# A1 ZN VNW pfet_05v0 ad=0.33945p pd=1.715u as=0.2847p ps=1.615u w=1.095u l=0.5u
.ends

.subckt gf180mcu_fd_sc_mcu7t5v0__and2_4 A1 A2 Z VDD VNW VPW VSS
X0 Z a_224_490# VSS VPW nfet_05v0 ad=0.2015p pd=1.295u as=0.2015p ps=1.295u w=0.775u l=0.6u
X1 VSS a_224_490# Z VPW nfet_05v0 ad=0.341p pd=2.43u as=0.2015p ps=1.295u w=0.775u l=0.6u
X2 a_224_490# A1 a_244_69# VPW nfet_05v0 ad=0.21505p pd=1.33u as=0.124p ps=1.095u w=0.775u l=0.6u
X3 a_659_69# A1 a_224_490# VPW nfet_05v0 ad=0.110425p pd=1.06u as=0.21505p ps=1.33u w=0.775u l=0.6u
X4 a_244_69# A2 VSS VPW nfet_05v0 ad=0.124p pd=1.095u as=0.341p ps=2.43u w=0.775u l=0.6u
X5 a_224_490# A2 VDD VNW pfet_05v0 ad=0.2925p pd=1.645u as=0.495p ps=3.13u w=1.125u l=0.5u
X6 Z a_224_490# VDD VNW pfet_05v0 ad=0.3159p pd=1.735u as=0.41175p ps=1.915u w=1.215u l=0.5u
X7 VSS a_224_490# Z VPW nfet_05v0 ad=0.2015p pd=1.295u as=0.2015p ps=1.295u w=0.775u l=0.6u
X8 VDD A1 a_224_490# VNW pfet_05v0 ad=0.2925p pd=1.645u as=0.2925p ps=1.645u w=1.125u l=0.5u
X9 VDD a_224_490# Z VNW pfet_05v0 ad=0.3159p pd=1.735u as=0.3159p ps=1.735u w=1.215u l=0.5u
X10 VSS A2 a_659_69# VPW nfet_05v0 ad=0.2015p pd=1.295u as=0.110425p ps=1.06u w=0.775u l=0.6u
X11 a_224_490# A1 VDD VNW pfet_05v0 ad=0.2925p pd=1.645u as=0.2925p ps=1.645u w=1.125u l=0.5u
X12 Z a_224_490# VDD VNW pfet_05v0 ad=0.3159p pd=1.735u as=0.3159p ps=1.735u w=1.215u l=0.5u
X13 VDD A2 a_224_490# VNW pfet_05v0 ad=0.41175p pd=1.915u as=0.2925p ps=1.645u w=1.125u l=0.5u
X14 VDD a_224_490# Z VNW pfet_05v0 ad=0.5346p pd=3.31u as=0.3159p ps=1.735u w=1.215u l=0.5u
X15 Z a_224_490# VSS VPW nfet_05v0 ad=0.2015p pd=1.295u as=0.2015p ps=1.295u w=0.775u l=0.6u
.ends

.subckt gf180mcu_fd_sc_mcu7t5v0__inv_4 I ZN VDD VNW VPW VSS
X0 ZN I VDD VNW pfet_05v0 ad=0.4392p pd=1.94u as=0.3172p ps=1.74u w=1.22u l=0.5u
X1 ZN I VSS VPW nfet_05v0 ad=0.2132p pd=1.34u as=0.2132p ps=1.34u w=0.82u l=0.6u
X2 ZN I VSS VPW nfet_05v0 ad=0.2132p pd=1.34u as=0.3608p ps=2.52u w=0.82u l=0.6u
X3 VDD I ZN VNW pfet_05v0 ad=0.5368p pd=3.32u as=0.4392p ps=1.94u w=1.22u l=0.5u
X4 VSS I ZN VPW nfet_05v0 ad=0.3608p pd=2.52u as=0.2132p ps=1.34u w=0.82u l=0.6u
X5 ZN I VDD VNW pfet_05v0 ad=0.4392p pd=1.94u as=0.5368p ps=3.32u w=1.22u l=0.5u
X6 VSS I ZN VPW nfet_05v0 ad=0.2132p pd=1.34u as=0.2132p ps=1.34u w=0.82u l=0.6u
X7 VDD I ZN VNW pfet_05v0 ad=0.3172p pd=1.74u as=0.4392p ps=1.94u w=1.22u l=0.5u
.ends

.subckt gf180mcu_fd_sc_mcu7t5v0__nand4_4 A1 A2 A3 A4 ZN VDD VNW VPW VSS
X0 ZN A2 VDD VNW pfet_05v0 ad=0.2197p pd=1.365u as=0.2197p ps=1.365u w=0.845u l=0.5u
X1 VDD A1 ZN VNW pfet_05v0 ad=0.4056p pd=1.805u as=0.2197p ps=1.365u w=0.845u l=0.5u
X2 ZN A3 VDD VNW pfet_05v0 ad=0.2197p pd=1.365u as=0.3718p ps=2.57u w=0.845u l=0.5u
X3 a_244_68# A3 a_36_68# VPW nfet_05v0 ad=0.1312p pd=1.14u as=0.3608p ps=2.52u w=0.82u l=0.6u
X4 VSS A4 a_244_68# VPW nfet_05v0 ad=0.2132p pd=1.34u as=0.1312p ps=1.14u w=0.82u l=0.6u
X5 a_1468_68# A4 VSS VPW nfet_05v0 ad=0.1517p pd=1.19u as=0.2132p ps=1.34u w=0.82u l=0.6u
X6 VDD A4 ZN VNW pfet_05v0 ad=0.2197p pd=1.365u as=0.2197p ps=1.365u w=0.845u l=0.5u
X7 a_1866_68# A2 a_1662_68# VPW nfet_05v0 ad=0.1517p pd=1.19u as=0.1722p ps=1.24u w=0.82u l=0.6u
X8 ZN A4 VDD VNW pfet_05v0 ad=0.2197p pd=1.365u as=0.2197p ps=1.365u w=0.845u l=0.5u
X9 ZN A1 VDD VNW pfet_05v0 ad=0.2197p pd=1.365u as=0.4056p ps=1.805u w=0.845u l=0.5u
X10 a_3276_68# A1 ZN VPW nfet_05v0 ad=0.1312p pd=1.14u as=0.4161p ps=1.905u w=0.82u l=0.6u
X11 a_652_68# A4 VSS VPW nfet_05v0 ad=0.1312p pd=1.14u as=0.2132p ps=1.34u w=0.82u l=0.6u
X12 a_36_68# A3 a_652_68# VPW nfet_05v0 ad=0.2132p pd=1.34u as=0.1312p ps=1.14u w=0.82u l=0.6u
X13 VDD A2 ZN VNW pfet_05v0 ad=0.3718p pd=2.57u as=0.2197p ps=1.365u w=0.845u l=0.5u
X14 VDD A3 ZN VNW pfet_05v0 ad=0.2197p pd=1.365u as=0.2197p ps=1.365u w=0.845u l=0.5u
X15 VSS A4 a_1060_68# VPW nfet_05v0 ad=0.2132p pd=1.34u as=0.1312p ps=1.14u w=0.82u l=0.6u
X16 ZN A3 VDD VNW pfet_05v0 ad=0.2197p pd=1.365u as=0.2197p ps=1.365u w=0.845u l=0.5u
X17 a_2372_68# A1 ZN VPW nfet_05v0 ad=0.1312p pd=1.14u as=0.4161p ps=1.905u w=0.82u l=0.6u
X18 a_36_68# A2 a_2372_68# VPW nfet_05v0 ad=0.2132p pd=1.34u as=0.1312p ps=1.14u w=0.82u l=0.6u
X19 ZN A1 VDD VNW pfet_05v0 ad=0.2197p pd=1.365u as=0.4056p ps=1.805u w=0.845u l=0.5u
X20 a_1060_68# A3 a_36_68# VPW nfet_05v0 ad=0.1312p pd=1.14u as=0.2132p ps=1.34u w=0.82u l=0.6u
X21 VDD A2 ZN VNW pfet_05v0 ad=0.2197p pd=1.365u as=0.2197p ps=1.365u w=0.845u l=0.5u
X22 VDD A4 ZN VNW pfet_05v0 ad=0.2197p pd=1.365u as=0.2197p ps=1.365u w=0.845u l=0.5u
X23 ZN A2 VDD VNW pfet_05v0 ad=0.2197p pd=1.365u as=0.2197p ps=1.365u w=0.845u l=0.5u
X24 ZN A1 a_2780_68# VPW nfet_05v0 ad=0.4161p pd=1.905u as=0.1312p ps=1.14u w=0.82u l=0.6u
X25 a_2780_68# A2 a_36_68# VPW nfet_05v0 ad=0.1312p pd=1.14u as=0.2132p ps=1.34u w=0.82u l=0.6u
X26 ZN A4 VDD VNW pfet_05v0 ad=0.2197p pd=1.365u as=0.2197p ps=1.365u w=0.845u l=0.5u
X27 VDD A1 ZN VNW pfet_05v0 ad=0.4056p pd=1.805u as=0.2197p ps=1.365u w=0.845u l=0.5u
X28 a_36_68# A2 a_3276_68# VPW nfet_05v0 ad=0.3608p pd=2.52u as=0.1312p ps=1.14u w=0.82u l=0.6u
X29 VDD A3 ZN VNW pfet_05v0 ad=0.2197p pd=1.365u as=0.2197p ps=1.365u w=0.845u l=0.5u
X30 a_1662_68# A3 a_1468_68# VPW nfet_05v0 ad=0.1722p pd=1.24u as=0.1517p ps=1.19u w=0.82u l=0.6u
X31 ZN A1 a_1866_68# VPW nfet_05v0 ad=0.4161p pd=1.905u as=0.1517p ps=1.19u w=0.82u l=0.6u
.ends

.subckt gf180mcu_fd_sc_mcu7t5v0__or2_2 A1 A2 Z VDD VNW VPW VSS
X0 Z a_56_472# VSS VPW nfet_05v0 ad=0.2132p pd=1.34u as=0.2132p ps=1.34u w=0.82u l=0.6u
X1 a_56_472# A1 VSS VPW nfet_05v0 ad=0.2132p pd=1.34u as=0.3608p ps=2.52u w=0.82u l=0.6u
X2 a_244_472# A1 a_56_472# VNW pfet_05v0 ad=0.3172p pd=1.74u as=0.5368p ps=3.32u w=1.22u l=0.5u
X3 VDD A2 a_244_472# VNW pfet_05v0 ad=0.4087p pd=1.89u as=0.3172p ps=1.74u w=1.22u l=0.5u
X4 VDD a_56_472# Z VNW pfet_05v0 ad=0.5368p pd=3.32u as=0.3477p ps=1.79u w=1.22u l=0.5u
X5 Z a_56_472# VDD VNW pfet_05v0 ad=0.3477p pd=1.79u as=0.4087p ps=1.89u w=1.22u l=0.5u
X6 VSS a_56_472# Z VPW nfet_05v0 ad=0.3608p pd=2.52u as=0.2132p ps=1.34u w=0.82u l=0.6u
X7 VSS A2 a_56_472# VPW nfet_05v0 ad=0.2132p pd=1.34u as=0.2132p ps=1.34u w=0.82u l=0.6u
.ends

.subckt gf180mcu_fd_sc_mcu7t5v0__clkbuf_2 I Z VDD VNW VPW VSS
X0 VDD I a_36_160# VNW pfet_05v0 ad=0.458p pd=2.02u as=0.4488p ps=2.92u w=1.02u l=0.5u
X1 VSS I a_36_160# VPW nfet_05v0 ad=0.151p pd=1.185u as=0.1584p ps=1.6u w=0.36u l=0.6u
X2 VDD a_36_160# Z VNW pfet_05v0 ad=0.5368p pd=3.32u as=0.3782p ps=1.84u w=1.22u l=0.5u
X3 Z a_36_160# VDD VNW pfet_05v0 ad=0.3782p pd=1.84u as=0.458p ps=2.02u w=1.22u l=0.5u
X4 VSS a_36_160# Z VPW nfet_05v0 ad=0.2134p pd=1.85u as=0.1261p ps=1.005u w=0.485u l=0.6u
X5 Z a_36_160# VSS VPW nfet_05v0 ad=0.1261p pd=1.005u as=0.151p ps=1.185u w=0.485u l=0.6u
.ends

.subckt gf180mcu_fd_sc_mcu7t5v0__xor2_2 A1 A2 Z VDD VNW VPW VSS
X0 VSS a_730_497# Z VPW nfet_05v0 ad=0.3608p pd=2.52u as=0.2132p ps=1.34u w=0.82u l=0.6u
X1 a_954_497# A1 a_730_497# VNW pfet_05v0 ad=0.5256p pd=2.055u as=0.33945p ps=1.715u w=1.095u l=0.5u
X2 a_286_93# A2 a_78_93# VPW nfet_05v0 ad=57.599995f pd=0.68u as=0.1584p ps=1.6u w=0.36u l=0.6u
X3 Z a_730_497# VSS VPW nfet_05v0 ad=0.2132p pd=1.34u as=0.3608p ps=2.52u w=0.82u l=0.6u
X4 a_730_497# a_78_93# VDD VNW pfet_05v0 ad=0.33945p pd=1.715u as=0.344375p ps=1.895u w=1.095u l=0.5u
X5 Z a_730_497# VDD VNW pfet_05v0 ad=0.3172p pd=1.74u as=0.5368p ps=3.32u w=1.22u l=0.5u
X6 a_78_93# A2 VDD VNW pfet_05v0 ad=0.1456p pd=1.08u as=0.2464p ps=2u w=0.56u l=0.5u
X7 a_730_497# A1 a_730_68# VPW nfet_05v0 ad=0.4161p pd=1.905u as=0.2132p ps=1.34u w=0.82u l=0.6u
X8 VDD A1 a_78_93# VNW pfet_05v0 ad=0.344375p pd=1.895u as=0.1456p ps=1.08u w=0.56u l=0.5u
X9 VDD a_730_497# Z VNW pfet_05v0 ad=0.5368p pd=3.32u as=0.3172p ps=1.74u w=1.22u l=0.5u
X10 VSS A1 a_286_93# VPW nfet_05v0 ad=0.218p pd=1.52u as=57.599995f ps=0.68u w=0.36u l=0.6u
X11 a_730_68# A2 a_730_497# VPW nfet_05v0 ad=0.3608p pd=2.52u as=0.4161p ps=1.905u w=0.82u l=0.6u
X12 a_730_68# a_78_93# VSS VPW nfet_05v0 ad=0.2132p pd=1.34u as=0.218p ps=1.52u w=0.82u l=0.6u
X13 VDD A2 a_954_497# VNW pfet_05v0 ad=0.4818p pd=3.07u as=0.5256p ps=2.055u w=1.095u l=0.5u
.ends

.subckt gf180mcu_fd_sc_mcu7t5v0__clkinv_8 I ZN VDD VNW VPW VSS
X0 ZN I VDD VNW pfet_05v0 ad=0.3782p pd=1.84u as=0.3782p ps=1.84u w=1.22u l=0.5u
X1 ZN I VSS VPW nfet_05v0 ad=0.1248p pd=1u as=0.1248p ps=1u w=0.48u l=0.6u
X2 VSS I ZN VPW nfet_05v0 ad=0.1248p pd=1u as=0.1248p ps=1u w=0.48u l=0.6u
X3 VDD I ZN VNW pfet_05v0 ad=0.3782p pd=1.84u as=0.3782p ps=1.84u w=1.22u l=0.5u
X4 ZN I VSS VPW nfet_05v0 ad=0.1248p pd=1u as=0.1248p ps=1u w=0.48u l=0.6u
X5 VDD I ZN VNW pfet_05v0 ad=0.5368p pd=3.32u as=0.3782p ps=1.84u w=1.22u l=0.5u
X6 ZN I VSS VPW nfet_05v0 ad=0.1248p pd=1u as=0.2112p ps=1.84u w=0.48u l=0.6u
X7 VDD I ZN VNW pfet_05v0 ad=0.3782p pd=1.84u as=0.3782p ps=1.84u w=1.22u l=0.5u
X8 ZN I VSS VPW nfet_05v0 ad=0.1248p pd=1u as=0.1248p ps=1u w=0.48u l=0.6u
X9 ZN I VDD VNW pfet_05v0 ad=0.3782p pd=1.84u as=0.3782p ps=1.84u w=1.22u l=0.5u
X10 VDD I ZN VNW pfet_05v0 ad=0.3782p pd=1.84u as=0.3782p ps=1.84u w=1.22u l=0.5u
X11 VSS I ZN VPW nfet_05v0 ad=0.1248p pd=1u as=0.1248p ps=1u w=0.48u l=0.6u
X12 ZN I VDD VNW pfet_05v0 ad=0.3782p pd=1.84u as=0.3782p ps=1.84u w=1.22u l=0.5u
X13 VSS I ZN VPW nfet_05v0 ad=0.2112p pd=1.84u as=0.1248p ps=1u w=0.48u l=0.6u
X14 ZN I VDD VNW pfet_05v0 ad=0.3782p pd=1.84u as=0.5368p ps=3.32u w=1.22u l=0.5u
X15 VSS I ZN VPW nfet_05v0 ad=0.1248p pd=1u as=0.1248p ps=1u w=0.48u l=0.6u
.ends

.subckt gf180mcu_fd_sc_mcu7t5v0__xnor3_2 A1 A2 A3 ZN VDD VNW VPW VSS
X0 a_244_561# A2 a_56_561# VNW pfet_05v0 ad=0.11935p pd=1.005u as=0.1694p ps=1.65u w=0.385u l=0.5u
X1 a_952_93# A1 a_728_93# VPW nfet_05v0 ad=57.599995f pd=0.68u as=93.59999f ps=0.88u w=0.36u l=0.6u
X2 a_2004_472# a_1347_526# VDD VNW pfet_05v0 ad=0.36295p pd=1.815u as=0.3692p ps=2.02u w=1.22u l=0.5u
X3 VSS A1 a_56_561# VPW nfet_05v0 ad=0.126p pd=1.06u as=93.59999f ps=0.88u w=0.36u l=0.6u
X4 VSS a_728_93# a_2228_68# VPW nfet_05v0 ad=0.3608p pd=2.52u as=0.1312p ps=1.14u w=0.82u l=0.6u
X5 ZN a_2004_68# VDD VNW pfet_05v0 ad=0.5368p pd=3.32u as=0.3782p ps=1.84u w=1.22u l=0.5u
X6 VSS a_2004_68# ZN VPW nfet_05v0 ad=0.2132p pd=1.34u as=0.3608p ps=2.52u w=0.82u l=0.6u
X7 VDD A3 a_1535_526# VNW pfet_05v0 ad=0.3692p pd=2.02u as=0.1526p ps=1.105u w=0.56u l=0.5u
X8 a_2004_68# A3 a_2004_472# VNW pfet_05v0 ad=0.3172p pd=1.74u as=0.36295p ps=1.815u w=1.22u l=0.5u
X9 a_1535_526# a_728_93# a_1347_526# VNW pfet_05v0 ad=0.1526p pd=1.105u as=0.2464p ps=2u w=0.56u l=0.5u
X10 a_56_561# A2 VSS VPW nfet_05v0 ad=93.59999f pd=0.88u as=0.1584p ps=1.6u w=0.36u l=0.6u
X11 VDD A1 a_244_561# VNW pfet_05v0 ad=0.189p pd=1.36u as=0.11935p ps=1.005u w=0.385u l=0.5u
X12 VSS A3 a_1347_526# VPW nfet_05v0 ad=0.218p pd=1.52u as=93.59999f ps=0.88u w=0.36u l=0.6u
X13 a_728_526# a_56_561# VDD VNW pfet_05v0 ad=0.1456p pd=1.08u as=0.189p ps=1.36u w=0.56u l=0.5u
X14 a_2004_472# a_728_93# a_2004_68# VNW pfet_05v0 ad=0.5368p pd=3.32u as=0.3172p ps=1.74u w=1.22u l=0.5u
X15 VDD a_2004_68# ZN VNW pfet_05v0 ad=0.3782p pd=1.84u as=0.5368p ps=3.32u w=1.22u l=0.5u
X16 a_2228_68# A3 a_2004_68# VPW nfet_05v0 ad=0.1312p pd=1.14u as=0.2132p ps=1.34u w=0.82u l=0.6u
X17 a_728_93# A1 a_728_526# VNW pfet_05v0 ad=0.1456p pd=1.08u as=0.1456p ps=1.08u w=0.56u l=0.5u
X18 ZN a_2004_68# VSS VPW nfet_05v0 ad=0.3608p pd=2.52u as=0.2132p ps=1.34u w=0.82u l=0.6u
X19 a_728_93# a_56_561# VSS VPW nfet_05v0 ad=93.59999f pd=0.88u as=0.126p ps=1.06u w=0.36u l=0.6u
X20 a_2004_68# a_1347_526# VSS VPW nfet_05v0 ad=0.2132p pd=1.34u as=0.218p ps=1.52u w=0.82u l=0.6u
X21 VSS A2 a_952_93# VPW nfet_05v0 ad=0.1584p pd=1.6u as=57.599995f ps=0.68u w=0.36u l=0.6u
X22 a_728_526# A2 a_728_93# VNW pfet_05v0 ad=0.2464p pd=2u as=0.1456p ps=1.08u w=0.56u l=0.5u
X23 a_1347_526# a_728_93# VSS VPW nfet_05v0 ad=93.59999f pd=0.88u as=0.1584p ps=1.6u w=0.36u l=0.6u
.ends

.subckt gf180mcu_fd_sc_mcu7t5v0__or4_2 A1 A2 A3 A4 Z VDD VNW VPW VSS
X0 Z a_56_472# VSS VPW nfet_05v0 ad=0.2132p pd=1.34u as=0.23375p ps=1.52u w=0.82u l=0.6u
X1 a_244_472# A1 a_56_472# VNW pfet_05v0 ad=0.3782p pd=1.84u as=0.5368p ps=3.32u w=1.22u l=0.5u
X2 VDD A4 a_692_472# VNW pfet_05v0 ad=0.4575p pd=1.97u as=0.3782p ps=1.84u w=1.22u l=0.5u
X3 VDD a_56_472# Z VNW pfet_05v0 ad=0.5368p pd=3.32u as=0.3477p ps=1.79u w=1.22u l=0.5u
X4 VSS A4 a_56_472# VPW nfet_05v0 ad=0.23375p pd=1.52u as=0.1209p ps=0.985u w=0.465u l=0.6u
X5 VSS a_56_472# Z VPW nfet_05v0 ad=0.3608p pd=2.52u as=0.2132p ps=1.34u w=0.82u l=0.6u
X6 a_692_472# A3 a_468_472# VNW pfet_05v0 ad=0.3782p pd=1.84u as=0.3782p ps=1.84u w=1.22u l=0.5u
X7 VSS A2 a_56_472# VPW nfet_05v0 ad=0.1209p pd=0.985u as=0.1209p ps=0.985u w=0.465u l=0.6u
X8 Z a_56_472# VDD VNW pfet_05v0 ad=0.3477p pd=1.79u as=0.4575p ps=1.97u w=1.22u l=0.5u
X9 a_56_472# A3 VSS VPW nfet_05v0 ad=0.1209p pd=0.985u as=0.1209p ps=0.985u w=0.465u l=0.6u
X10 a_56_472# A1 VSS VPW nfet_05v0 ad=0.1209p pd=0.985u as=0.2046p ps=1.81u w=0.465u l=0.6u
X11 a_468_472# A2 a_244_472# VNW pfet_05v0 ad=0.3782p pd=1.84u as=0.3782p ps=1.84u w=1.22u l=0.5u
.ends

.subckt gf180mcu_fd_sc_mcu7t5v0__tiel ZN VDD VNW VPW VSS
X0 ZN a_124_24# VSS VPW nfet_05v0 ad=0.3608p pd=2.52u as=0.3608p ps=2.52u w=0.82u l=0.6u
X1 a_124_24# a_124_24# VDD VNW pfet_05v0 ad=0.5368p pd=3.32u as=0.5368p ps=3.32u w=1.22u l=0.5u
.ends

.subckt gf180mcu_fd_sc_mcu7t5v0__xor3_2 A1 A2 A3 Z VDD VNW VPW VSS
X0 VDD a_725_93# a_2153_497# VNW pfet_05v0 ad=0.5694p pd=3.23u as=0.312075p ps=1.665u w=1.095u l=0.5u
X1 a_89_534# A2 VSS VPW nfet_05v0 ad=93.59999f pd=0.88u as=0.1584p ps=1.6u w=0.36u l=0.6u
X2 VSS A2 a_949_93# VPW nfet_05v0 ad=0.1584p pd=1.6u as=57.599995f ps=0.68u w=0.36u l=0.6u
X3 a_1943_497# A3 a_1949_68# VPW nfet_05v0 ad=0.4161p pd=1.905u as=0.2132p ps=1.34u w=0.82u l=0.6u
X4 Z a_1943_497# VDD VNW pfet_05v0 ad=0.5368p pd=3.32u as=0.3782p ps=1.84u w=1.22u l=0.5u
X5 a_1297_93# a_725_93# VDD VNW pfet_05v0 ad=0.1456p pd=1.08u as=0.2464p ps=2u w=0.56u l=0.5u
X6 a_2153_497# A3 a_1943_497# VNW pfet_05v0 ad=0.312075p pd=1.665u as=0.301125p ps=1.645u w=1.095u l=0.5u
X7 VSS A1 a_89_534# VPW nfet_05v0 ad=93.59999f pd=0.88u as=93.59999f ps=0.88u w=0.36u l=0.6u
X8 VDD A3 a_1297_93# VNW pfet_05v0 ad=0.3249p pd=1.835u as=0.1456p ps=1.08u w=0.56u l=0.5u
X9 a_1943_497# a_1297_93# VDD VNW pfet_05v0 ad=0.301125p pd=1.645u as=0.3249p ps=1.835u w=1.095u l=0.5u
X10 a_1949_68# a_725_93# a_1943_497# VPW nfet_05v0 ad=0.3608p pd=2.52u as=0.4161p ps=1.905u w=0.82u l=0.6u
X11 VSS A3 a_1505_93# VPW nfet_05v0 ad=0.218p pd=1.52u as=57.599995f ps=0.68u w=0.36u l=0.6u
X12 a_1505_93# a_725_93# a_1297_93# VPW nfet_05v0 ad=57.599995f pd=0.68u as=0.1584p ps=1.6u w=0.36u l=0.6u
X13 VDD a_1943_497# Z VNW pfet_05v0 ad=0.3782p pd=1.84u as=0.5368p ps=3.32u w=1.22u l=0.5u
X14 VDD A1 a_277_534# VNW pfet_05v0 ad=0.166p pd=1.26u as=0.1026p ps=0.93u w=0.36u l=0.5u
X15 a_1949_68# a_1297_93# VSS VPW nfet_05v0 ad=0.2132p pd=1.34u as=0.218p ps=1.52u w=0.82u l=0.6u
X16 a_949_93# A1 a_725_93# VPW nfet_05v0 ad=57.599995f pd=0.68u as=93.59999f ps=0.88u w=0.36u l=0.6u
X17 Z a_1943_497# VSS VPW nfet_05v0 ad=0.3608p pd=2.52u as=0.2132p ps=1.34u w=0.82u l=0.6u
X18 a_731_494# a_89_534# VDD VNW pfet_05v0 ad=0.1456p pd=1.08u as=0.166p ps=1.26u w=0.56u l=0.5u
X19 a_277_534# A2 a_89_534# VNW pfet_05v0 ad=0.1026p pd=0.93u as=0.1584p ps=1.6u w=0.36u l=0.5u
X20 a_725_93# A1 a_731_494# VNW pfet_05v0 ad=0.1456p pd=1.08u as=0.1456p ps=1.08u w=0.56u l=0.5u
X21 a_725_93# a_89_534# VSS VPW nfet_05v0 ad=93.59999f pd=0.88u as=93.59999f ps=0.88u w=0.36u l=0.6u
X22 VSS a_1943_497# Z VPW nfet_05v0 ad=0.2132p pd=1.34u as=0.3608p ps=2.52u w=0.82u l=0.6u
X23 a_731_494# A2 a_725_93# VNW pfet_05v0 ad=0.2464p pd=2u as=0.1456p ps=1.08u w=0.56u l=0.5u
.ends

.subckt gf180mcu_fd_sc_mcu7t5v0__aoi211_2 A1 A2 B C ZN VDD VNW VPW VSS
X0 VSS B ZN VPW nfet_05v0 ad=0.2266p pd=1.91u as=0.1339p ps=1.035u w=0.515u l=0.6u
X1 VSS C ZN VPW nfet_05v0 ad=0.1339p pd=1.035u as=0.1339p ps=1.035u w=0.515u l=0.6u
X2 a_244_68# A2 VSS VPW nfet_05v0 ad=93.59999f pd=1.02u as=0.3432p ps=2.44u w=0.78u l=0.6u
X3 ZN A1 a_244_68# VPW nfet_05v0 ad=0.2028p pd=1.3u as=93.59999f ps=1.02u w=0.78u l=0.6u
X4 ZN C VSS VPW nfet_05v0 ad=0.1339p pd=1.035u as=0.1339p ps=1.035u w=0.515u l=0.6u
X5 VDD C a_1044_488# VNW pfet_05v0 ad=0.3534p pd=1.76u as=0.3534p ps=1.76u w=1.14u l=0.5u
X6 ZN A1 a_36_488# VNW pfet_05v0 ad=0.2964p pd=1.66u as=0.3078p ps=1.68u w=1.14u l=0.5u
X7 ZN B VSS VPW nfet_05v0 ad=0.1339p pd=1.035u as=0.23325p ps=1.48u w=0.515u l=0.6u
X8 ZN A2 a_36_488# VNW pfet_05v0 ad=0.2964p pd=1.66u as=0.5016p ps=3.16u w=1.14u l=0.5u
X9 a_36_488# A2 ZN VNW pfet_05v0 ad=0.2964p pd=1.66u as=0.2964p ps=1.66u w=1.14u l=0.5u
X10 a_1044_488# B a_36_488# VNW pfet_05v0 ad=0.3534p pd=1.76u as=0.2964p ps=1.66u w=1.14u l=0.5u
X11 a_36_488# A1 ZN VNW pfet_05v0 ad=0.3078p pd=1.68u as=0.2964p ps=1.66u w=1.14u l=0.5u
X12 a_36_488# B a_1492_488# VNW pfet_05v0 ad=0.5016p pd=3.16u as=0.3534p ps=1.76u w=1.14u l=0.5u
X13 a_636_68# A1 ZN VPW nfet_05v0 ad=93.59999f pd=1.02u as=0.2028p ps=1.3u w=0.78u l=0.6u
X14 a_1492_488# C VDD VNW pfet_05v0 ad=0.3534p pd=1.76u as=0.3534p ps=1.76u w=1.14u l=0.5u
X15 VSS A2 a_636_68# VPW nfet_05v0 ad=0.23325p pd=1.48u as=93.59999f ps=1.02u w=0.78u l=0.6u
.ends

.subckt gf180mcu_fd_sc_mcu7t5v0__xnor2_2 A1 A2 ZN VDD VNW VPW VSS
X0 a_728_472# a_56_565# VDD VNW pfet_05v0 ad=0.3172p pd=1.74u as=0.371125p ps=2.07u w=1.22u l=0.5u
X1 ZN a_728_68# VSS VPW nfet_05v0 ad=0.2132p pd=1.34u as=0.3608p ps=2.52u w=0.82u l=0.6u
X2 a_728_68# A1 a_728_472# VNW pfet_05v0 ad=0.3172p pd=1.74u as=0.3172p ps=1.74u w=1.22u l=0.5u
X3 VDD A1 a_244_565# VNW pfet_05v0 ad=0.371125p pd=2.07u as=0.161025p ps=1.135u w=0.565u l=0.5u
X4 VSS A1 a_56_565# VPW nfet_05v0 ad=0.218p pd=1.52u as=93.59999f ps=0.88u w=0.36u l=0.6u
X5 a_244_565# A2 a_56_565# VNW pfet_05v0 ad=0.161025p pd=1.135u as=0.2486p ps=2.01u w=0.565u l=0.5u
X6 a_728_472# A2 a_728_68# VNW pfet_05v0 ad=0.5368p pd=3.32u as=0.3172p ps=1.74u w=1.22u l=0.5u
X7 a_728_68# a_56_565# VSS VPW nfet_05v0 ad=0.2132p pd=1.34u as=0.218p ps=1.52u w=0.82u l=0.6u
X8 VSS A2 a_952_68# VPW nfet_05v0 ad=0.3608p pd=2.52u as=0.1312p ps=1.14u w=0.82u l=0.6u
X9 a_56_565# A2 VSS VPW nfet_05v0 ad=93.59999f pd=0.88u as=0.1584p ps=1.6u w=0.36u l=0.6u
X10 a_952_68# A1 a_728_68# VPW nfet_05v0 ad=0.1312p pd=1.14u as=0.2132p ps=1.34u w=0.82u l=0.6u
X11 VDD a_728_68# ZN VNW pfet_05v0 ad=0.5368p pd=3.32u as=0.3782p ps=1.84u w=1.22u l=0.5u
X12 VSS a_728_68# ZN VPW nfet_05v0 ad=0.3608p pd=2.52u as=0.2132p ps=1.34u w=0.82u l=0.6u
X13 ZN a_728_68# VDD VNW pfet_05v0 ad=0.3782p pd=1.84u as=0.5368p ps=3.32u w=1.22u l=0.5u
.ends

.subckt gf180mcu_fd_sc_mcu7t5v0__aoi211_4 A1 A2 B C ZN VDD VNW VPW VSS
X0 a_170_472# B a_3662_472# VNW pfet_05v0 ad=0.5978p pd=3.42u as=0.3172p ps=1.74u w=1.22u l=0.5u
X1 a_1194_69# A2 VSS VPW nfet_05v0 ad=0.1232p pd=1.09u as=0.2002p ps=1.29u w=0.77u l=0.6u
X2 ZN A1 a_1194_69# VPW nfet_05v0 ad=0.2002p pd=1.29u as=0.1232p ps=1.09u w=0.77u l=0.6u
X3 VSS C ZN VPW nfet_05v0 ad=0.2541p pd=1.605u as=0.1196p ps=0.98u w=0.46u l=0.6u
X4 a_170_472# A1 ZN VNW pfet_05v0 ad=0.3172p pd=1.74u as=0.3172p ps=1.74u w=1.22u l=0.5u
X5 ZN B VSS VPW nfet_05v0 ad=0.1196p pd=0.98u as=0.2384p ps=1.51u w=0.46u l=0.6u
X6 a_3126_472# B a_170_472# VNW pfet_05v0 ad=0.3172p pd=1.74u as=0.7076p ps=2.38u w=1.22u l=0.5u
X7 ZN A1 a_170_472# VNW pfet_05v0 ad=0.3172p pd=1.74u as=0.3172p ps=1.74u w=1.22u l=0.5u
X8 ZN A1 a_358_69# VPW nfet_05v0 ad=0.2002p pd=1.29u as=0.1617p ps=1.19u w=0.77u l=0.6u
X9 ZN C VSS VPW nfet_05v0 ad=0.1196p pd=0.98u as=0.2541p ps=1.605u w=0.46u l=0.6u
X10 VDD C a_3126_472# VNW pfet_05v0 ad=0.7076p pd=2.38u as=0.3172p ps=1.74u w=1.22u l=0.5u
X11 VSS A2 a_1602_69# VPW nfet_05v0 ad=0.2384p pd=1.51u as=0.1232p ps=1.09u w=0.77u l=0.6u
X12 VSS B ZN VPW nfet_05v0 ad=0.2541p pd=1.605u as=0.1196p ps=0.98u w=0.46u l=0.6u
X13 a_1602_69# A1 ZN VPW nfet_05v0 ad=0.1232p pd=1.09u as=0.2002p ps=1.29u w=0.77u l=0.6u
X14 a_170_472# A2 ZN VNW pfet_05v0 ad=0.4514p pd=1.96u as=0.3172p ps=1.74u w=1.22u l=0.5u
X15 a_2034_472# B a_170_472# VNW pfet_05v0 ad=0.3782p pd=1.84u as=0.4514p ps=1.96u w=1.22u l=0.5u
X16 a_2590_472# C VDD VNW pfet_05v0 ad=0.3172p pd=1.74u as=0.7076p ps=2.38u w=1.22u l=0.5u
X17 a_358_69# A2 VSS VPW nfet_05v0 ad=0.1617p pd=1.19u as=0.4466p ps=2.7u w=0.77u l=0.6u
X18 VSS A2 a_786_69# VPW nfet_05v0 ad=0.2002p pd=1.29u as=0.1232p ps=1.09u w=0.77u l=0.6u
X19 a_170_472# B a_2590_472# VNW pfet_05v0 ad=0.7076p pd=2.38u as=0.3172p ps=1.74u w=1.22u l=0.5u
X20 VSS C ZN VPW nfet_05v0 ad=0.264p pd=1.66u as=0.1196p ps=0.98u w=0.46u l=0.6u
X21 ZN B VSS VPW nfet_05v0 ad=0.1196p pd=0.98u as=0.2541p ps=1.605u w=0.46u l=0.6u
X22 ZN A2 a_170_472# VNW pfet_05v0 ad=0.3172p pd=1.74u as=0.5368p ps=3.32u w=1.22u l=0.5u
X23 a_170_472# A1 ZN VNW pfet_05v0 ad=0.3172p pd=1.74u as=0.3172p ps=1.74u w=1.22u l=0.5u
X24 ZN C VSS VPW nfet_05v0 ad=0.1196p pd=0.98u as=0.264p ps=1.66u w=0.46u l=0.6u
X25 VDD C a_2034_472# VNW pfet_05v0 ad=0.7076p pd=2.38u as=0.3782p ps=1.84u w=1.22u l=0.5u
X26 ZN A1 a_170_472# VNW pfet_05v0 ad=0.3172p pd=1.74u as=0.3172p ps=1.74u w=1.22u l=0.5u
X27 a_170_472# A2 ZN VNW pfet_05v0 ad=0.3172p pd=1.74u as=0.3172p ps=1.74u w=1.22u l=0.5u
X28 VSS B ZN VPW nfet_05v0 ad=0.2024p pd=1.8u as=0.1196p ps=0.98u w=0.46u l=0.6u
X29 a_786_69# A1 ZN VPW nfet_05v0 ad=0.1232p pd=1.09u as=0.2002p ps=1.29u w=0.77u l=0.6u
X30 a_3662_472# C VDD VNW pfet_05v0 ad=0.3172p pd=1.74u as=0.7076p ps=2.38u w=1.22u l=0.5u
X31 ZN A2 a_170_472# VNW pfet_05v0 ad=0.3172p pd=1.74u as=0.3172p ps=1.74u w=1.22u l=0.5u
.ends

.subckt NanoCGRA_Lite bus_addr[0] bus_addr[1] bus_addr[2] bus_addr[3] bus_addr[4]
+ bus_addr[5] bus_addr[6] bus_addr[7] bus_rdata[0] bus_rdata[1] bus_rdata[2] bus_rdata[3]
+ bus_rdata[4] bus_rdata[5] bus_rdata[6] bus_rdata[7] bus_re bus_wdata[0] bus_wdata[1]
+ bus_wdata[2] bus_wdata[3] bus_wdata[4] bus_wdata[5] bus_wdata[6] bus_wdata[7] bus_we
+ cgra_status[0] cgra_status[1] cgra_status[2] cgra_status[3] cgra_status[4] cgra_status[5]
+ cgra_status[6] cgra_status[7] clk rst_n uart_rx uart_tx
X_05903_ _10190_/Q _07748_/B2 VDD VDD VSS VSS gf180mcu_fd_sc_mcu7t5v0__clkinv_1
X_09671_ _09832_/A1 _09671_/A2 _09671_/B1 _09671_/B2 _11050_/D VDD VDD
+ VSS VSS gf180mcu_fd_sc_mcu7t5v0__oai22_1
X_06883_ _09940_/A1 _06889_/A2 _06889_/B1 _06883_/B2 _10054_/D VDD VDD
+ VSS VSS gf180mcu_fd_sc_mcu7t5v0__oai22_1
X_05834_ _10434_/Q _08819_/B2 VDD VDD VSS VSS gf180mcu_fd_sc_mcu7t5v0__clkinv_1
X_08622_ _08654_/B _08622_/A2 _08623_/C VDD VDD VSS VSS gf180mcu_fd_sc_mcu7t5v0__nand2_1
X_08553_ _11117_/Q _09834_/A2 _08877_/A2 _10466_/Q _08554_/A3 VDD VDD
+ VSS VSS gf180mcu_fd_sc_mcu7t5v0__aoi22_1
X_05765_ _10689_/Q _09180_/B2 VDD VDD VSS VSS gf180mcu_fd_sc_mcu7t5v0__clkinv_1
X_08484_ _11033_/Q _08559_/A2 _06112_/I _11041_/Q _08487_/A1 VDD VDD VSS
+ VSS gf180mcu_fd_sc_mcu7t5v0__aoi22_1
X_07504_ _10124_/Q _07601_/B _07551_/A1 VDD VDD VSS VSS gf180mcu_fd_sc_mcu7t5v0__nand2_1
X_05696_ _10021_/Q _06519_/B2 VDD VDD VSS VSS gf180mcu_fd_sc_mcu7t5v0__clkinv_1
X_07435_ _07435_/A1 _07468_/B2 _07434_/B _07436_/B VDD VDD VSS VSS
+ gf180mcu_fd_sc_mcu7t5v0__xnor3_1
X_07366_ _10114_/Q _07367_/A2 _07409_/B VDD VDD VSS VSS gf180mcu_fd_sc_mcu7t5v0__and2_1
X_09105_ _09940_/A1 _09111_/A2 _09111_/B1 _09105_/B2 _10628_/D VDD VDD
+ VSS VSS gf180mcu_fd_sc_mcu7t5v0__oai22_1
X_07297_ _06047_/Z _07311_/A2 _07297_/B _10106_/D VDD VDD VSS VSS
+ gf180mcu_fd_sc_mcu7t5v0__oai21_1
X_06317_ _06362_/B _06362_/A2 _06318_/A2 VDD VDD VSS VSS gf180mcu_fd_sc_mcu7t5v0__nor2_1
X_09036_ _09893_/A1 _09041_/A2 _09041_/B1 _09036_/B2 _10573_/D VDD VDD
+ VSS VSS gf180mcu_fd_sc_mcu7t5v0__oai22_1
X_06248_ _06270_/A1 _06270_/A2 _06271_/A1 VDD VDD VSS VSS gf180mcu_fd_sc_mcu7t5v0__nor2_1
X_06179_ _10331_/Q _08675_/A2 _08672_/B _06180_/B VDD VDD VSS VSS
+ gf180mcu_fd_sc_mcu7t5v0__oai21_1
X_09938_ _09754_/B _09946_/A2 _09946_/B1 VDD VDD VSS VSS gf180mcu_fd_sc_mcu7t5v0__nand2_2
X_09869_ _09945_/A1 _09870_/A2 _09870_/B1 _09869_/B2 _11132_/D VDD VDD
+ VSS VSS gf180mcu_fd_sc_mcu7t5v0__oai22_1
X_10713_ _10713_/D _10905_/CLK _10713_/Q VDD VDD VSS VSS gf180mcu_fd_sc_mcu7t5v0__dffq_1
X_10644_ _10644_/D _11176_/CLK _10644_/Q VDD VDD VSS VSS gf180mcu_fd_sc_mcu7t5v0__dffq_1
X_10575_ _10575_/D _10666_/CLK _10575_/Q VDD VDD VSS VSS gf180mcu_fd_sc_mcu7t5v0__dffq_1
X_11127_ _11127_/D _11149_/CLK _11127_/Q VDD VDD VSS VSS gf180mcu_fd_sc_mcu7t5v0__dffq_1
X_11058_ _11058_/D _11097_/CLK _11058_/Q VDD VDD VSS VSS gf180mcu_fd_sc_mcu7t5v0__dffq_1
X_10009_ _10009_/D _10327_/CLK _10009_/Q VDD VDD VSS VSS gf180mcu_fd_sc_mcu7t5v0__dffq_1
X_05550_ _10663_/Q _09148_/B2 VDD VDD VSS VSS gf180mcu_fd_sc_mcu7t5v0__clkinv_1
X_05481_ _10138_/Q _07663_/B2 VDD VDD VSS VSS gf180mcu_fd_sc_mcu7t5v0__clkinv_1
Xrepeater60 rst_n _08654_/B VDD VDD VSS VSS gf180mcu_fd_sc_mcu7t5v0__buf_8
X_07220_ _10001_/Q _07243_/A2 _07230_/A2 VDD VDD VSS VSS gf180mcu_fd_sc_mcu7t5v0__nand2_1
X_07151_ _07152_/A1 _07152_/A2 _07152_/B _07151_/Z VDD VDD VSS VSS
+ gf180mcu_fd_sc_mcu7t5v0__and3_1
X_06102_ _06047_/Z _06109_/A2 _06109_/B1 _06102_/B2 _09963_/D VDD VDD
+ VSS VSS gf180mcu_fd_sc_mcu7t5v0__oai22_1
X_07082_ _10004_/Q _10003_/Q _07222_/A2 _07181_/A2 _07082_/Z VDD VDD VSS
+ VSS gf180mcu_fd_sc_mcu7t5v0__and4_1
X_06033_ _10321_/Q bus_addr[5] _08619_/B _06034_/I VDD VDD VSS VSS
+ gf180mcu_fd_sc_mcu7t5v0__mux2_4
X_07984_ _10619_/Q _06023_/I _08564_/C1 _10627_/Q _07986_/A2 VDD VDD VSS
+ VSS gf180mcu_fd_sc_mcu7t5v0__aoi22_1
X_09723_ _11052_/Q _10289_/Q _09724_/A4 VDD VDD VSS VSS gf180mcu_fd_sc_mcu7t5v0__nand2_1
X_06935_ _06952_/A1 _10078_/Q _07014_/A1 VDD VDD VSS VSS gf180mcu_fd_sc_mcu7t5v0__nor2_2
X_09654_ _11039_/Q _09660_/A2 _09655_/B VDD VDD VSS VSS gf180mcu_fd_sc_mcu7t5v0__nand2_1
X_06866_ _10007_/Q _06869_/A2 _06872_/S VDD VDD VSS VSS gf180mcu_fd_sc_mcu7t5v0__nand2_1
X_05817_ _10793_/Q _09310_/B2 VDD VDD VSS VSS gf180mcu_fd_sc_mcu7t5v0__clkinv_1
X_08605_ _06061_/Z _08608_/A2 _08608_/B1 _08605_/B2 _10296_/D VDD VDD
+ VSS VSS gf180mcu_fd_sc_mcu7t5v0__oai22_1
X_09585_ _09896_/A1 _09587_/A2 _09587_/B1 _09585_/B2 _11000_/D VDD VDD
+ VSS VSS gf180mcu_fd_sc_mcu7t5v0__oai22_1
X_06797_ _10003_/Q _06823_/A1 _06855_/A1 VDD VDD VSS VSS gf180mcu_fd_sc_mcu7t5v0__nand2_1
X_08536_ _10514_/Q _06112_/I _08589_/B1 _10898_/Q _08539_/A1 VDD VDD VSS
+ VSS gf180mcu_fd_sc_mcu7t5v0__aoi22_1
X_05748_ _10553_/Q _09010_/B2 VDD VDD VSS VSS gf180mcu_fd_sc_mcu7t5v0__clkinv_1
X_08467_ _09390_/B2 _08542_/A2 _08581_/A2 _09360_/B2 _08468_/C VDD VDD
+ VSS VSS gf180mcu_fd_sc_mcu7t5v0__oai22_2
X_05679_ _11179_/Q _09944_/B2 VDD VDD VSS VSS gf180mcu_fd_sc_mcu7t5v0__clkinv_1
X_08398_ _10808_/Q _08560_/B1 _07255_/I _10816_/Q _08402_/A1 VDD VDD VSS
+ VSS gf180mcu_fd_sc_mcu7t5v0__aoi22_1
X_07418_ _10002_/Q _07393_/I _07418_/B1 _07633_/C _07422_/B1 VDD VDD VSS
+ VSS gf180mcu_fd_sc_mcu7t5v0__oai22_1
X_07349_ _07353_/A3 _07349_/A2 _07635_/A1 VDD VDD VSS VSS gf180mcu_fd_sc_mcu7t5v0__nor2_4
X_10360_ _10360_/D _11017_/CLK _10360_/Q VDD VDD VSS VSS gf180mcu_fd_sc_mcu7t5v0__dffq_1
X_09019_ _09944_/A1 _09021_/A2 _09021_/B1 _09019_/B2 _10560_/D VDD VDD
+ VSS VSS gf180mcu_fd_sc_mcu7t5v0__oai22_1
X_10291_ _10291_/D _11097_/CLK _10291_/Q VDD VDD VSS VSS gf180mcu_fd_sc_mcu7t5v0__dffq_2
X_10627_ _10627_/D _10978_/CLK _10627_/Q VDD VDD VSS VSS gf180mcu_fd_sc_mcu7t5v0__dffq_1
X_10558_ _10558_/D _11138_/CLK _10558_/Q VDD VDD VSS VSS gf180mcu_fd_sc_mcu7t5v0__dffq_1
X_10489_ _10489_/D _11164_/CLK _10489_/Q VDD VDD VSS VSS gf180mcu_fd_sc_mcu7t5v0__dffq_1
X_04981_ _11088_/Q _09791_/A1 VDD VDD VSS VSS gf180mcu_fd_sc_mcu7t5v0__clkinv_1
X_06720_ _06739_/A1 _06718_/Z _06720_/B _06737_/B1 VDD VDD VSS VSS
+ gf180mcu_fd_sc_mcu7t5v0__oai21_1
X_06651_ _10044_/Q _10043_/Q _06651_/Z VDD VDD VSS VSS gf180mcu_fd_sc_mcu7t5v0__and2_1
X_05602_ _10767_/Q _09278_/B2 VDD VDD VSS VSS gf180mcu_fd_sc_mcu7t5v0__clkinv_1
X_09370_ _09945_/A1 _09371_/A2 _09371_/B1 _09370_/B2 _10841_/D VDD VDD
+ VSS VSS gf180mcu_fd_sc_mcu7t5v0__oai22_1
X_06582_ _06582_/I _06618_/A1 VDD VDD VSS VSS gf180mcu_fd_sc_mcu7t5v0__clkinv_1
X_05533_ _10527_/Q _08978_/B2 VDD VDD VSS VSS gf180mcu_fd_sc_mcu7t5v0__clkinv_1
X_08321_ _10671_/Q _08563_/A2 _08584_/A2 _10703_/Q _08321_/C _08322_/A3 VDD
+ VDD VSS VSS gf180mcu_fd_sc_mcu7t5v0__aoi221_1
X_08252_ _10622_/Q _06023_/I _08582_/A2 _10654_/Q _08564_/C1 _10630_/Q _08253_/A3
+ VDD VDD VSS VSS gf180mcu_fd_sc_mcu7t5v0__aoi222_2
X_05464_ _10035_/Q _06537_/B2 VDD VDD VSS VSS gf180mcu_fd_sc_mcu7t5v0__clkinv_1
X_07203_ _06470_/B _07239_/A1 _07200_/Z _07203_/Z VDD VDD VSS VSS
+ gf180mcu_fd_sc_mcu7t5v0__xor3_1
X_05395_ _10805_/Q _09326_/B2 VDD VDD VSS VSS gf180mcu_fd_sc_mcu7t5v0__clkinv_1
X_08183_ _08183_/I _10282_/D VDD VDD VSS VSS gf180mcu_fd_sc_mcu7t5v0__clkinv_1
X_07134_ _10005_/Q _07222_/A2 _07181_/A2 _10004_/Q _07177_/B1 VDD VDD
+ VSS VSS gf180mcu_fd_sc_mcu7t5v0__aoi22_1
X_07065_ _10085_/Q _07601_/B _07065_/B _07066_/A2 VDD VDD VSS VSS
+ gf180mcu_fd_sc_mcu7t5v0__aoi21_1
X_06016_ _06016_/I _06110_/A1 VDD VDD VSS VSS gf180mcu_fd_sc_mcu7t5v0__clkinv_1
X_07967_ _10915_/Q _08591_/A2 _08584_/B1 _10747_/Q _07970_/A1 VDD VDD
+ VSS VSS gf180mcu_fd_sc_mcu7t5v0__aoi22_1
X_09706_ _09706_/A1 _09706_/A2 _11057_/D VDD VDD VSS VSS gf180mcu_fd_sc_mcu7t5v0__nor2_1
X_06918_ _10244_/Q _08675_/A2 _08674_/B _06919_/B VDD VDD VSS VSS
+ gf180mcu_fd_sc_mcu7t5v0__oai21_1
X_07898_ bus_wdata[3] _07905_/A2 _08658_/B _07899_/B VDD VDD VSS VSS
+ gf180mcu_fd_sc_mcu7t5v0__oai21_1
X_09637_ _06061_/Z _09643_/A2 _09637_/B _11031_/D VDD VDD VSS VSS
+ gf180mcu_fd_sc_mcu7t5v0__oai21_1
X_06849_ _06849_/A1 _06852_/A1 _06849_/B _06856_/A1 VDD VDD VSS VSS
+ gf180mcu_fd_sc_mcu7t5v0__oai21_1
X_09568_ _09937_/A2 _09568_/A2 _09577_/A2 VDD VDD VSS VSS gf180mcu_fd_sc_mcu7t5v0__nand2_4
X_08519_ _10039_/Q _08528_/A2 _08532_/A2 _11173_/Q _08519_/C _08534_/A2 VDD
+ VDD VSS VSS gf180mcu_fd_sc_mcu7t5v0__aoi221_4
X_09499_ _09896_/A1 _09501_/A2 _09501_/B1 _09499_/B2 _10944_/D VDD VDD
+ VSS VSS gf180mcu_fd_sc_mcu7t5v0__oai22_1
X_10412_ _10412_/D _11164_/CLK _10412_/Q VDD VDD VSS VSS gf180mcu_fd_sc_mcu7t5v0__dffq_1
X_10343_ _10343_/D _11142_/CLK _10343_/Q VDD VDD VSS VSS gf180mcu_fd_sc_mcu7t5v0__dffq_1
X_10274_ _10274_/D _11052_/CLK _10274_/Q VDD VDD VSS VSS gf180mcu_fd_sc_mcu7t5v0__dffq_1
Xclkbuf_opt_2_0_clk clkbuf_1_1_0_clk/Z clkbuf_opt_2_0_clk/Z VDD VDD VSS
+ VSS gf180mcu_fd_sc_mcu7t5v0__clkbuf_16
X_05180_ _10779_/Q _09294_/B2 VDD VDD VSS VSS gf180mcu_fd_sc_mcu7t5v0__clkinv_1
X_08870_ _08868_/Z _08870_/A2 _10456_/D VDD VDD VSS VSS gf180mcu_fd_sc_mcu7t5v0__nor2_1
X_07821_ _09944_/A1 _07825_/A2 _07821_/B _10236_/D VDD VDD VSS VSS
+ gf180mcu_fd_sc_mcu7t5v0__oai21_1
X_07752_ _09940_/A1 _07758_/A2 _07758_/B1 _07752_/B2 _10192_/D VDD VDD
+ VSS VSS gf180mcu_fd_sc_mcu7t5v0__oai22_1
X_07683_ _07809_/A2 _08563_/C1 _09900_/B _07698_/A2 VDD VDD VSS VSS
+ gf180mcu_fd_sc_mcu7t5v0__aoi21_4
X_06703_ _06704_/A2 _06704_/A3 _06751_/B VDD VDD VSS VSS gf180mcu_fd_sc_mcu7t5v0__nor2_1
X_09422_ _09502_/A1 _09889_/A2 _09431_/A2 VDD VDD VSS VSS gf180mcu_fd_sc_mcu7t5v0__nand2_4
X_06634_ _06850_/A2 _06636_/A3 _06635_/A2 VDD VDD VSS VSS gf180mcu_fd_sc_mcu7t5v0__xnor2_1
X_09353_ _09599_/A1 _09361_/A2 _09361_/B1 VDD VDD VSS VSS gf180mcu_fd_sc_mcu7t5v0__nand2_2
X_08304_ _10308_/Q _08590_/A2 _08590_/B1 _10943_/Q _08591_/C1 _10391_/Q _08305_/A3
+ VDD VDD VSS VSS gf180mcu_fd_sc_mcu7t5v0__aoi222_4
X_06565_ _06578_/A1 _10041_/Q _06579_/A3 _06832_/A1 VDD VDD VSS VSS
+ gf180mcu_fd_sc_mcu7t5v0__nand3_4
X_05516_ _10431_/Q _08816_/B2 VDD VDD VSS VSS gf180mcu_fd_sc_mcu7t5v0__clkinv_1
X_09284_ _06047_/Z _09291_/A2 _09291_/B1 _09284_/B2 _10771_/D VDD VDD
+ VSS VSS gf180mcu_fd_sc_mcu7t5v0__oai22_1
X_06496_ _06496_/A1 _06495_/Z _06496_/Z VDD VDD VSS VSS gf180mcu_fd_sc_mcu7t5v0__xor2_1
X_08235_ _10382_/Q _08591_/A2 _08576_/B1 _10926_/Q _08589_/B1 _10398_/Q _08238_/A1
+ VDD VDD VSS VSS gf180mcu_fd_sc_mcu7t5v0__aoi222_1
X_05447_ _10686_/Q _09177_/B2 VDD VDD VSS VSS gf180mcu_fd_sc_mcu7t5v0__clkinv_1
X_08166_ _08166_/A1 _08166_/A2 _08166_/A3 _08171_/A2 VDD VDD VSS VSS
+ gf180mcu_fd_sc_mcu7t5v0__nand3_2
X_05378_ _10018_/Q _06516_/B2 VDD VDD VSS VSS gf180mcu_fd_sc_mcu7t5v0__clkinv_1
X_07117_ _10086_/Q _07636_/B _07118_/A3 VDD VDD VSS VSS gf180mcu_fd_sc_mcu7t5v0__nor2_1
X_08097_ _08097_/A1 _08097_/A2 _08097_/A3 _08101_/B VDD VDD VSS VSS
+ gf180mcu_fd_sc_mcu7t5v0__nand3_1
X_07048_ _10085_/Q _07046_/Z _07048_/Z VDD VDD VSS VSS gf180mcu_fd_sc_mcu7t5v0__xor2_1
X_08999_ _09944_/A1 _09001_/A2 _09001_/B1 _08999_/B2 _10544_/D VDD VDD
+ VSS VSS gf180mcu_fd_sc_mcu7t5v0__oai22_1
X_10961_ _10961_/D _11149_/CLK _10961_/Q VDD VDD VSS VSS gf180mcu_fd_sc_mcu7t5v0__dffq_1
X_10892_ _10892_/D _11109_/CLK _10892_/Q VDD VDD VSS VSS gf180mcu_fd_sc_mcu7t5v0__dffq_1
X_10326_ _10326_/D _11150_/CLK _10326_/Q VDD VDD VSS VSS gf180mcu_fd_sc_mcu7t5v0__dffq_1
X_10257_ _10257_/D _10327_/CLK _10257_/Q VDD VDD VSS VSS gf180mcu_fd_sc_mcu7t5v0__dffq_1
X_10188_ _10188_/D _10905_/CLK _10188_/Q VDD VDD VSS VSS gf180mcu_fd_sc_mcu7t5v0__dffq_1
X_06350_ _06351_/A1 _06351_/A2 _06350_/B _06380_/B VDD VDD VSS VSS
+ gf180mcu_fd_sc_mcu7t5v0__oai21_1
X_05301_ _10485_/Q _08926_/B2 VDD VDD VSS VSS gf180mcu_fd_sc_mcu7t5v0__clkinv_1
X_06281_ _10002_/Q _06278_/Z _06281_/Z VDD VDD VSS VSS gf180mcu_fd_sc_mcu7t5v0__xor2_1
X_08020_ _08020_/A1 _08020_/A2 _08020_/A3 _08030_/A2 VDD VDD VSS VSS
+ gf180mcu_fd_sc_mcu7t5v0__nand3_1
X_05232_ _10660_/Q _09145_/B2 VDD VDD VSS VSS gf180mcu_fd_sc_mcu7t5v0__clkinv_1
X_05163_ _10135_/Q _07660_/B2 VDD VDD VSS VSS gf180mcu_fd_sc_mcu7t5v0__clkinv_1
X_05094_ _11158_/Q _09919_/B2 VDD VDD VSS VSS gf180mcu_fd_sc_mcu7t5v0__clkinv_1
X_09971_ _09971_/D _11181_/CLK _09971_/Q VDD VDD VSS VSS gf180mcu_fd_sc_mcu7t5v0__dffq_1
X_08922_ _09502_/A1 _09917_/A2 _08931_/A2 VDD VDD VSS VSS gf180mcu_fd_sc_mcu7t5v0__nand2_4
X_08853_ _10451_/Q _08850_/Z _08853_/Z VDD VDD VSS VSS gf180mcu_fd_sc_mcu7t5v0__and2_1
X_07804_ _06061_/Z _07807_/A2 _07807_/B1 _07804_/B2 _10227_/D VDD VDD
+ VSS VSS gf180mcu_fd_sc_mcu7t5v0__oai22_1
X_05996_ _05996_/A1 _05988_/Z _05996_/B1 _09728_/A1 _05996_/C bus_rdata[1] VDD
+ VDD VSS VSS gf180mcu_fd_sc_mcu7t5v0__oai221_4
X_08784_ _09941_/A1 _08789_/A2 _08789_/B1 _08784_/B2 _10405_/D VDD VDD
+ VSS VSS gf180mcu_fd_sc_mcu7t5v0__oai22_1
X_07735_ _06061_/Z _07738_/A2 _07738_/B1 _07735_/B2 _10179_/D VDD VDD
+ VSS VSS gf180mcu_fd_sc_mcu7t5v0__oai22_1
X_09405_ _09920_/A1 _09411_/A2 _09411_/B1 _09405_/B2 _10868_/D VDD VDD
+ VSS VSS gf180mcu_fd_sc_mcu7t5v0__oai22_1
X_07666_ _09945_/A1 _07667_/A2 _07667_/B1 _07666_/B2 _10141_/D VDD VDD
+ VSS VSS gf180mcu_fd_sc_mcu7t5v0__oai22_1
X_07597_ _10006_/Q _07632_/I0 _07629_/A2 _07599_/A1 VDD VDD VSS VSS
+ gf180mcu_fd_sc_mcu7t5v0__nand3_1
X_06617_ _10047_/Q _07601_/B _06648_/A1 VDD VDD VSS VSS gf180mcu_fd_sc_mcu7t5v0__nand2_1
X_09336_ _09921_/A1 _09341_/A2 _09341_/B1 _09336_/B2 _10813_/D VDD VDD
+ VSS VSS gf180mcu_fd_sc_mcu7t5v0__oai22_1
X_06548_ _10252_/Q _08675_/A2 _08672_/B _06549_/B VDD VDD VSS VSS
+ gf180mcu_fd_sc_mcu7t5v0__oai21_1
X_09267_ _06058_/Z _09271_/A2 _09271_/B1 _09267_/B2 _10758_/D VDD VDD
+ VSS VSS gf180mcu_fd_sc_mcu7t5v0__oai22_1
X_08218_ _10854_/Q _08591_/A2 _07255_/I _10878_/Q _08221_/A1 VDD VDD VSS
+ VSS gf180mcu_fd_sc_mcu7t5v0__aoi22_1
X_06479_ _10005_/Q _06479_/A2 _06492_/A1 VDD VDD VSS VSS gf180mcu_fd_sc_mcu7t5v0__nand2_1
X_09198_ _06061_/Z _09201_/A2 _09201_/B1 _09198_/B2 _10703_/D VDD VDD
+ VSS VSS gf180mcu_fd_sc_mcu7t5v0__oai22_1
X_08149_ _10341_/Q _08591_/A2 _07680_/I _10225_/Q _06125_/I _10349_/Q _08150_/A3 VDD
+ VDD VSS VSS gf180mcu_fd_sc_mcu7t5v0__aoi222_1
X_11160_ _11160_/D _11163_/CLK _11160_/Q VDD VDD VSS VSS gf180mcu_fd_sc_mcu7t5v0__dffq_1
X_10111_ _10111_/D _11163_/CLK _10111_/Q VDD VDD VSS VSS gf180mcu_fd_sc_mcu7t5v0__dffq_1
X_11091_ _11091_/D _11097_/CLK _11091_/Q VDD VDD VSS VSS gf180mcu_fd_sc_mcu7t5v0__dffq_1
X_10042_ _10042_/D _11150_/CLK _10042_/Q VDD VDD VSS VSS gf180mcu_fd_sc_mcu7t5v0__dffq_2
X_10944_ _10944_/D _11018_/CLK _10944_/Q VDD VDD VSS VSS gf180mcu_fd_sc_mcu7t5v0__dffq_1
X_10875_ _10875_/D _11138_/CLK _10875_/Q VDD VDD VSS VSS gf180mcu_fd_sc_mcu7t5v0__dffq_1
X_10309_ _10309_/D _11018_/CLK _10309_/Q VDD VDD VSS VSS gf180mcu_fd_sc_mcu7t5v0__dffq_1
X_05850_ _10522_/Q _08971_/B2 VDD VDD VSS VSS gf180mcu_fd_sc_mcu7t5v0__clkinv_1
X_07520_ _06420_/B _07365_/I _07573_/B VDD VDD VSS VSS gf180mcu_fd_sc_mcu7t5v0__nor2_1
X_05781_ _10059_/Q _06888_/B2 VDD VDD VSS VSS gf180mcu_fd_sc_mcu7t5v0__clkinv_1
X_07451_ _07451_/A1 _07451_/A2 _07451_/B _07492_/A2 VDD VDD VSS VSS
+ gf180mcu_fd_sc_mcu7t5v0__aoi21_1
X_06402_ _06402_/A1 _06402_/A2 _06402_/Z VDD VDD VSS VSS gf180mcu_fd_sc_mcu7t5v0__xor2_1
X_07382_ _07382_/A1 _07382_/A2 _07382_/Z VDD VDD VSS VSS gf180mcu_fd_sc_mcu7t5v0__xor2_1
X_09121_ _09946_/A1 _09121_/A2 _09121_/B1 _09121_/B2 _10642_/D VDD VDD
+ VSS VSS gf180mcu_fd_sc_mcu7t5v0__oai22_1
X_06333_ _07603_/B _06333_/A2 _10011_/D VDD VDD VSS VSS gf180mcu_fd_sc_mcu7t5v0__nor2_1
X_09052_ _09861_/A1 _09062_/A2 _09061_/A2 VDD VDD VSS VSS gf180mcu_fd_sc_mcu7t5v0__nand2_4
X_06264_ _06264_/A1 _06198_/Z _06264_/B _06479_/A2 VDD VDD VSS VSS
+ gf180mcu_fd_sc_mcu7t5v0__oai21_4
X_05215_ _10524_/Q _08975_/B2 VDD VDD VSS VSS gf180mcu_fd_sc_mcu7t5v0__clkinv_1
X_08003_ _11027_/Q _08559_/A2 _06112_/I _11035_/Q _08007_/A2 VDD VDD VSS
+ VSS gf180mcu_fd_sc_mcu7t5v0__aoi22_1
X_06195_ _09999_/Q _09998_/Q _06195_/Z VDD VDD VSS VSS gf180mcu_fd_sc_mcu7t5v0__and2_2
X_05146_ _10032_/Q _06534_/B2 VDD VDD VSS VSS gf180mcu_fd_sc_mcu7t5v0__clkinv_1
X_09954_ _09954_/D _11010_/CLK _09954_/Q VDD VDD VSS VSS gf180mcu_fd_sc_mcu7t5v0__dffq_1
X_05077_ _11072_/Q _05976_/A1 VDD VDD VSS VSS gf180mcu_fd_sc_mcu7t5v0__clkinv_1
X_09885_ _11140_/Q _09887_/A2 _09886_/B VDD VDD VSS VSS gf180mcu_fd_sc_mcu7t5v0__nand2_1
X_08905_ _06112_/I _09872_/A2 _09900_/B _08920_/A2 VDD VDD VSS VSS
+ gf180mcu_fd_sc_mcu7t5v0__aoi21_4
X_08836_ _10444_/Q _10443_/Q _10445_/Q _08836_/Z VDD VDD VSS VSS gf180mcu_fd_sc_mcu7t5v0__and3_1
X_08767_ _09896_/A1 _08769_/A2 _08769_/B1 _08767_/B2 _10392_/D VDD VDD
+ VSS VSS gf180mcu_fd_sc_mcu7t5v0__oai22_1
X_05979_ _05979_/A1 _05976_/Z _05979_/A3 _05983_/B1 VDD VDD VSS VSS
+ gf180mcu_fd_sc_mcu7t5v0__nor3_1
X_07718_ _10170_/Q _07726_/A2 _07719_/B VDD VDD VSS VSS gf180mcu_fd_sc_mcu7t5v0__nand2_1
X_08698_ _10338_/Q _08698_/A2 _08699_/A2 VDD VDD VSS VSS gf180mcu_fd_sc_mcu7t5v0__nand2_1
X_07649_ _06058_/Z _07657_/A2 _07649_/B _10130_/D VDD VDD VSS VSS
+ gf180mcu_fd_sc_mcu7t5v0__oai21_1
X_10660_ _10660_/D _10666_/CLK _10660_/Q VDD VDD VSS VSS gf180mcu_fd_sc_mcu7t5v0__dffq_1
X_09319_ _09924_/A1 _09321_/A2 _09321_/B1 _09319_/B2 _10800_/D VDD VDD
+ VSS VSS gf180mcu_fd_sc_mcu7t5v0__oai22_1
X_10591_ _10591_/D _11138_/CLK _10591_/Q VDD VDD VSS VSS gf180mcu_fd_sc_mcu7t5v0__dffq_1
X_11143_ _11143_/D _11147_/CLK _11143_/Q VDD VDD VSS VSS gf180mcu_fd_sc_mcu7t5v0__dffq_1
X_11074_ _11074_/D _11082_/CLK _11074_/Q VDD VDD VSS VSS gf180mcu_fd_sc_mcu7t5v0__dffq_1
X_10025_ _10025_/D _11181_/CLK _10025_/Q VDD VDD VSS VSS gf180mcu_fd_sc_mcu7t5v0__dffq_1
X_10927_ _10927_/D _11018_/CLK _10927_/Q VDD VDD VSS VSS gf180mcu_fd_sc_mcu7t5v0__dffq_1
X_10858_ _10858_/D _11165_/CLK _10858_/Q VDD VDD VSS VSS gf180mcu_fd_sc_mcu7t5v0__dffq_1
X_10789_ _10789_/D _11010_/CLK _10789_/Q VDD VDD VSS VSS gf180mcu_fd_sc_mcu7t5v0__dffq_1
X_05000_ _10313_/Q _08620_/A2 VDD VDD VSS VSS gf180mcu_fd_sc_mcu7t5v0__clkinv_2
X_06951_ _06952_/A1 _10000_/Q _06951_/B _06955_/A2 VDD VDD VSS VSS
+ gf180mcu_fd_sc_mcu7t5v0__oai21_1
X_09670_ _09897_/A1 _09671_/A2 _09671_/B1 _09670_/B2 _11049_/D VDD VDD
+ VSS VSS gf180mcu_fd_sc_mcu7t5v0__oai22_1
X_05902_ _09962_/Q _06093_/B2 VDD VDD VSS VSS gf180mcu_fd_sc_mcu7t5v0__clkinv_1
X_08621_ _08621_/I _08698_/A2 VDD VDD VSS VSS gf180mcu_fd_sc_mcu7t5v0__inv_2
X_06882_ _06047_/Z _06889_/A2 _06889_/B1 _06882_/B2 _10053_/D VDD VDD
+ VSS VSS gf180mcu_fd_sc_mcu7t5v0__oai22_1
X_05833_ _10442_/Q _08829_/B2 VDD VDD VSS VSS gf180mcu_fd_sc_mcu7t5v0__clkinv_1
X_08552_ _11157_/Q _08560_/B1 _09872_/A1 _11141_/Q _08554_/A2 VDD VDD
+ VSS VSS gf180mcu_fd_sc_mcu7t5v0__aoi22_1
X_05764_ _10681_/Q _09170_/B2 VDD VDD VSS VSS gf180mcu_fd_sc_mcu7t5v0__clkinv_1
X_08483_ _08588_/B _08483_/A2 _08483_/B1 _09442_/A1 _08513_/A1 VDD VDD
+ VSS VSS gf180mcu_fd_sc_mcu7t5v0__aoi22_1
X_07503_ _07503_/A1 _07601_/B _07603_/B _07503_/C _10123_/D VDD VDD VSS
+ VSS gf180mcu_fd_sc_mcu7t5v0__aoi211_1
X_05695_ _10297_/Q _08606_/B2 VDD VDD VSS VSS gf180mcu_fd_sc_mcu7t5v0__clkinv_1
X_07434_ _07434_/A1 _07365_/I _07434_/B _07468_/B1 VDD VDD VSS VSS
+ gf180mcu_fd_sc_mcu7t5v0__oai21_1
X_07365_ _07365_/I _07572_/A2 VDD VDD VSS VSS gf180mcu_fd_sc_mcu7t5v0__clkinv_1
X_09104_ _06047_/Z _09111_/A2 _09111_/B1 _09104_/B2 _10627_/D VDD VDD
+ VSS VSS gf180mcu_fd_sc_mcu7t5v0__oai22_1
X_07296_ _10106_/Q _07310_/A2 _07297_/B VDD VDD VSS VSS gf180mcu_fd_sc_mcu7t5v0__nand2_1
X_06316_ _06481_/A2 _06446_/A2 _06479_/A2 _06362_/A2 VDD VDD VSS VSS
+ gf180mcu_fd_sc_mcu7t5v0__nor3_1
X_09035_ _09920_/A1 _09041_/A2 _09041_/B1 _09035_/B2 _10572_/D VDD VDD
+ VSS VSS gf180mcu_fd_sc_mcu7t5v0__oai22_1
X_06247_ _10001_/Q _06481_/A2 _06300_/A1 VDD VDD VSS VSS gf180mcu_fd_sc_mcu7t5v0__nand2_1
X_06178_ _06178_/A1 _08675_/A2 _06178_/B _09999_/D VDD VDD VSS VSS
+ gf180mcu_fd_sc_mcu7t5v0__aoi21_1
X_05129_ _10683_/Q _09174_/B2 VDD VDD VSS VSS gf180mcu_fd_sc_mcu7t5v0__clkinv_1
X_09937_ _09937_/A1 _09937_/A2 _09946_/A2 VDD VDD VSS VSS gf180mcu_fd_sc_mcu7t5v0__nand2_4
X_09868_ _09944_/A1 _09870_/A2 _09870_/B1 _09868_/B2 _11131_/D VDD VDD
+ VSS VSS gf180mcu_fd_sc_mcu7t5v0__oai22_1
X_08819_ _09832_/A1 _08819_/A2 _08819_/B1 _08819_/B2 _10434_/D VDD VDD
+ VSS VSS gf180mcu_fd_sc_mcu7t5v0__oai22_1
X_09799_ _11093_/Q _09817_/A2 _09809_/B _09800_/B VDD VDD VSS VSS
+ gf180mcu_fd_sc_mcu7t5v0__oai21_1
X_10712_ _10712_/D _11139_/CLK _10712_/Q VDD VDD VSS VSS gf180mcu_fd_sc_mcu7t5v0__dffq_1
X_10643_ _10643_/D _10666_/CLK _10643_/Q VDD VDD VSS VSS gf180mcu_fd_sc_mcu7t5v0__dffq_1
X_10574_ _10574_/D _10666_/CLK _10574_/Q VDD VDD VSS VSS gf180mcu_fd_sc_mcu7t5v0__dffq_1
X_11126_ _11126_/D _11149_/CLK _11126_/Q VDD VDD VSS VSS gf180mcu_fd_sc_mcu7t5v0__dffq_1
X_11057_ _11057_/D _11097_/CLK _11057_/Q VDD VDD VSS VSS gf180mcu_fd_sc_mcu7t5v0__dffq_1
X_10008_ _10008_/D _10327_/CLK _10008_/Q VDD VDD VSS VSS gf180mcu_fd_sc_mcu7t5v0__dffq_2
X_05480_ _10162_/Q _07705_/B2 VDD VDD VSS VSS gf180mcu_fd_sc_mcu7t5v0__clkinv_1
Xrepeater61 rst_n _09809_/B VDD VDD VSS VSS gf180mcu_fd_sc_mcu7t5v0__buf_8
Xrepeater50 _08654_/B _08658_/B VDD VDD VSS VSS gf180mcu_fd_sc_mcu7t5v0__buf_8
X_07150_ _06420_/B _07149_/Z _07152_/B VDD VDD VSS VSS gf180mcu_fd_sc_mcu7t5v0__xor2_1
X_06101_ _09754_/B _06109_/A2 _06109_/B1 VDD VDD VSS VSS gf180mcu_fd_sc_mcu7t5v0__nand2_4
X_07081_ _10004_/Q _07181_/A2 _07135_/A1 VDD VDD VSS VSS gf180mcu_fd_sc_mcu7t5v0__nand2_1
X_06032_ _06032_/I _07921_/A1 VDD VDD VSS VSS gf180mcu_fd_sc_mcu7t5v0__inv_2
X_07983_ _10651_/Q _08582_/A2 _08584_/A2 _10635_/Q _10611_/Q _06877_/Z _07986_/A1
+ VDD VDD VSS VSS gf180mcu_fd_sc_mcu7t5v0__aoi222_1
X_09722_ _09722_/A1 _10288_/Q _09722_/B1 _09722_/B2 _09900_/B _11062_/D VDD
+ VDD VSS VSS gf180mcu_fd_sc_mcu7t5v0__aoi221_1
X_06934_ _10000_/Q _07222_/A2 _07003_/A1 VDD VDD VSS VSS gf180mcu_fd_sc_mcu7t5v0__nand2_1
X_09653_ _06058_/Z _09661_/A2 _09653_/B _11038_/D VDD VDD VSS VSS
+ gf180mcu_fd_sc_mcu7t5v0__oai21_1
X_06865_ _10007_/Q _06869_/A2 _06874_/B1 VDD VDD VSS VSS gf180mcu_fd_sc_mcu7t5v0__nor2_1
X_09584_ _06061_/Z _09587_/A2 _09587_/B1 _09584_/B2 _10999_/D VDD VDD
+ VSS VSS gf180mcu_fd_sc_mcu7t5v0__oai22_1
X_05816_ _10785_/Q _09300_/B2 VDD VDD VSS VSS gf180mcu_fd_sc_mcu7t5v0__clkinv_1
X_08604_ _06058_/Z _08608_/A2 _08608_/B1 _08604_/B2 _10295_/D VDD VDD
+ VSS VSS gf180mcu_fd_sc_mcu7t5v0__oai22_1
X_08535_ _08535_/A1 _08535_/A2 _08535_/B _08597_/A1 VDD VDD VSS VSS
+ gf180mcu_fd_sc_mcu7t5v0__oai21_1
X_06796_ _10001_/Q _06847_/A2 _06848_/B2 VDD VDD VSS VSS gf180mcu_fd_sc_mcu7t5v0__nand2_1
X_05747_ _10545_/Q _09000_/B2 VDD VDD VSS VSS gf180mcu_fd_sc_mcu7t5v0__clkinv_1
X_08466_ _08466_/A1 _08466_/A2 _08466_/A3 _08472_/A2 VDD VDD VSS VSS
+ gf180mcu_fd_sc_mcu7t5v0__nand3_2
X_05678_ _09976_/Q _06121_/B2 VDD VDD VSS VSS gf180mcu_fd_sc_mcu7t5v0__clkinv_1
X_08397_ _09662_/A2 _08397_/A2 _08397_/B1 _09412_/A2 _08429_/A1 VDD VDD
+ VSS VSS gf180mcu_fd_sc_mcu7t5v0__aoi22_1
X_07417_ _07417_/A1 _07516_/A1 _07418_/B1 VDD VDD VSS VSS gf180mcu_fd_sc_mcu7t5v0__nor2_1
X_07348_ _07381_/A1 _07417_/A1 _07594_/A1 _07350_/B VDD VDD VSS VSS
+ gf180mcu_fd_sc_mcu7t5v0__nand3_1
X_07279_ _06047_/Z _07293_/A2 _07279_/B _10098_/D VDD VDD VSS VSS
+ gf180mcu_fd_sc_mcu7t5v0__oai21_1
X_09018_ _06061_/Z _09021_/A2 _09021_/B1 _09018_/B2 _10559_/D VDD VDD
+ VSS VSS gf180mcu_fd_sc_mcu7t5v0__oai22_1
X_10290_ _10290_/D _11097_/CLK _10290_/Q VDD VDD VSS VSS gf180mcu_fd_sc_mcu7t5v0__dffq_1
X_10626_ _10626_/D _10978_/CLK _10626_/Q VDD VDD VSS VSS gf180mcu_fd_sc_mcu7t5v0__dffq_1
X_10557_ _10557_/D _11138_/CLK _10557_/Q VDD VDD VSS VSS gf180mcu_fd_sc_mcu7t5v0__dffq_1
X_10488_ _10488_/D _11164_/CLK _10488_/Q VDD VDD VSS VSS gf180mcu_fd_sc_mcu7t5v0__dffq_1
X_11109_ _11109_/D _11109_/CLK _11109_/Q VDD VDD VSS VSS gf180mcu_fd_sc_mcu7t5v0__dffq_1
X_04980_ _11089_/Q _09793_/A1 VDD VDD VSS VSS gf180mcu_fd_sc_mcu7t5v0__clkinv_1
X_06650_ _06650_/A1 _06650_/A2 _06650_/B _06688_/A1 VDD VDD VSS VSS
+ gf180mcu_fd_sc_mcu7t5v0__oai21_2
X_05601_ _10759_/Q _09268_/B2 VDD VDD VSS VSS gf180mcu_fd_sc_mcu7t5v0__clkinv_1
X_06581_ _10045_/Q _06593_/A2 _06582_/I VDD VDD VSS VSS gf180mcu_fd_sc_mcu7t5v0__nand2_1
X_05532_ _10519_/Q _08968_/B2 VDD VDD VSS VSS gf180mcu_fd_sc_mcu7t5v0__clkinv_1
X_08320_ _09178_/B2 _08585_/A2 _08581_/A2 _09168_/B2 _08321_/C VDD VDD
+ VSS VSS gf180mcu_fd_sc_mcu7t5v0__oai22_1
X_08251_ _10662_/Q _08584_/B1 _08563_/C1 _10646_/Q _08253_/A2 VDD VDD
+ VSS VSS gf180mcu_fd_sc_mcu7t5v0__aoi22_1
X_05463_ _10056_/Q _06885_/B2 VDD VDD VSS VSS gf180mcu_fd_sc_mcu7t5v0__clkinv_1
X_07202_ _10006_/Q _07200_/Z _07239_/A2 VDD VDD VSS VSS gf180mcu_fd_sc_mcu7t5v0__nor2_1
X_05394_ _10797_/Q _09316_/B2 VDD VDD VSS VSS gf180mcu_fd_sc_mcu7t5v0__clkinv_1
X_08182_ _08182_/A1 _08182_/A2 _08514_/B _08183_/I VDD VDD VSS VSS
+ gf180mcu_fd_sc_mcu7t5v0__oai21_1
X_07133_ _10005_/Q _07181_/A2 _07183_/A1 VDD VDD VSS VSS gf180mcu_fd_sc_mcu7t5v0__nand2_1
X_07064_ _07063_/C _07064_/A2 _07057_/Z _07064_/B2 _07601_/B _07065_/B VDD VDD
+ VSS VSS gf180mcu_fd_sc_mcu7t5v0__aoi221_1
X_06015_ _10318_/Q bus_addr[2] _08619_/B _06016_/I VDD VDD VSS VSS
+ gf180mcu_fd_sc_mcu7t5v0__mux2_4
X_07966_ _07966_/A1 _07966_/A2 _07966_/A3 _08013_/C1 VDD VDD VSS VSS
+ gf180mcu_fd_sc_mcu7t5v0__nand3_2
X_09705_ bus_wdata[5] _09722_/A1 _09705_/B _09706_/A2 VDD VDD VSS VSS
+ gf180mcu_fd_sc_mcu7t5v0__aoi21_1
X_06917_ _09916_/A1 _06917_/A2 _06917_/B _10076_/D VDD VDD VSS VSS
+ gf180mcu_fd_sc_mcu7t5v0__oai21_1
X_09636_ _11031_/Q _09642_/A2 _09637_/B VDD VDD VSS VSS gf180mcu_fd_sc_mcu7t5v0__nand2_1
X_07897_ _07897_/A1 _07905_/A2 _07897_/B _10268_/D VDD VDD VSS VSS
+ gf180mcu_fd_sc_mcu7t5v0__aoi21_1
X_06848_ _06848_/A1 _06855_/A1 _06798_/Z _06848_/B2 _06857_/A3 VDD VDD
+ VSS VSS gf180mcu_fd_sc_mcu7t5v0__oai22_1
X_09567_ _09916_/A1 _09567_/A2 _09567_/B _10986_/D VDD VDD VSS VSS
+ gf180mcu_fd_sc_mcu7t5v0__oai21_1
X_06779_ _10005_/Q _06847_/A2 _06781_/A2 VDD VDD VSS VSS gf180mcu_fd_sc_mcu7t5v0__nand2_1
X_09498_ _06061_/Z _09501_/A2 _09501_/B1 _09498_/B2 _10943_/D VDD VDD
+ VSS VSS gf180mcu_fd_sc_mcu7t5v0__oai22_1
X_08518_ _08518_/A1 _08518_/A2 _08519_/C VDD VDD VSS VSS gf180mcu_fd_sc_mcu7t5v0__nand2_1
X_08449_ _11017_/Q _08573_/B1 _07680_/I _10377_/Q _08449_/C _08452_/A1 VDD VDD
+ VSS VSS gf180mcu_fd_sc_mcu7t5v0__aoi221_2
X_10411_ _10411_/D _11164_/CLK _10411_/Q VDD VDD VSS VSS gf180mcu_fd_sc_mcu7t5v0__dffq_1
X_10342_ _10342_/D _11149_/CLK _10342_/Q VDD VDD VSS VSS gf180mcu_fd_sc_mcu7t5v0__dffq_1
X_10273_ _10273_/D _11052_/CLK _10273_/Q VDD VDD VSS VSS gf180mcu_fd_sc_mcu7t5v0__dffq_1
X_10609_ _10609_/D _10666_/CLK _10609_/Q VDD VDD VSS VSS gf180mcu_fd_sc_mcu7t5v0__dffq_1
X_07820_ _10236_/Q _07824_/A2 _07821_/B VDD VDD VSS VSS gf180mcu_fd_sc_mcu7t5v0__nand2_1
X_07751_ _06047_/Z _07758_/A2 _07758_/B1 _07751_/B2 _10191_/D VDD VDD
+ VSS VSS gf180mcu_fd_sc_mcu7t5v0__oai22_1
X_06702_ _10004_/Q _06590_/Z _06756_/A1 VDD VDD VSS VSS gf180mcu_fd_sc_mcu7t5v0__nand2_1
X_07682_ _07682_/A1 _08585_/B1 _09937_/A2 VDD VDD VSS VSS gf180mcu_fd_sc_mcu7t5v0__nor2_4
X_09421_ _09926_/A1 _09421_/A2 _09421_/B1 _09421_/B2 _10882_/D VDD VDD
+ VSS VSS gf180mcu_fd_sc_mcu7t5v0__oai22_1
X_06633_ _10040_/Q _06633_/A2 _06804_/A4 _06804_/A3 _06636_/A3 VDD VDD
+ VSS VSS gf180mcu_fd_sc_mcu7t5v0__aoi22_2
X_09352_ _09851_/A1 _09412_/A2 _09361_/A2 VDD VDD VSS VSS gf180mcu_fd_sc_mcu7t5v0__nand2_4
X_06564_ _10042_/Q _06578_/A2 _06872_/I0 VDD VDD VSS VSS gf180mcu_fd_sc_mcu7t5v0__nor2_1
X_08303_ _10399_/Q _08589_/B1 _08576_/B1 _10927_/Q _08591_/B1 _10991_/Q _08305_/A2
+ VDD VDD VSS VSS gf180mcu_fd_sc_mcu7t5v0__aoi222_2
X_05515_ _10439_/Q _08826_/B2 VDD VDD VSS VSS gf180mcu_fd_sc_mcu7t5v0__clkinv_1
X_09283_ _09918_/A1 _09291_/A2 _09291_/B1 VDD VDD VSS VSS gf180mcu_fd_sc_mcu7t5v0__nand2_2
X_06495_ _06492_/Z _06495_/A2 _06495_/A3 _06495_/Z VDD VDD VSS VSS
+ gf180mcu_fd_sc_mcu7t5v0__xor3_1
X_08234_ _08234_/A1 _08234_/A2 _08234_/A3 _08265_/A2 VDD VDD VSS VSS
+ gf180mcu_fd_sc_mcu7t5v0__nand3_1
X_05446_ _10678_/Q _09167_/B2 VDD VDD VSS VSS gf180mcu_fd_sc_mcu7t5v0__clkinv_1
X_08165_ _10949_/Q _08547_/A2 _08573_/B1 _11128_/Q _06125_/I _10933_/Q _08166_/A3
+ VDD VDD VSS VSS gf180mcu_fd_sc_mcu7t5v0__aoi222_4
X_05377_ _10294_/Q _08603_/B2 VDD VDD VSS VSS gf180mcu_fd_sc_mcu7t5v0__clkinv_1
X_07116_ _07019_/C _07116_/A2 _07116_/B _07601_/B _07118_/A2 VDD VDD VSS
+ VSS gf180mcu_fd_sc_mcu7t5v0__aoi211_1
X_08096_ _09412_/A2 _08096_/A2 _08096_/B1 _09523_/A2 _08097_/A3 VDD VDD
+ VSS VSS gf180mcu_fd_sc_mcu7t5v0__aoi22_1
X_07047_ _10085_/Q _07046_/Z _07067_/B VDD VDD VSS VSS gf180mcu_fd_sc_mcu7t5v0__and2_1
X_08998_ _06061_/Z _09001_/A2 _09001_/B1 _08998_/B2 _10543_/D VDD VDD
+ VSS VSS gf180mcu_fd_sc_mcu7t5v0__oai22_1
X_07949_ _10475_/Q _08528_/B1 _09834_/A2 _11110_/Q _07950_/I VDD VDD VSS
+ VSS gf180mcu_fd_sc_mcu7t5v0__aoi22_1
X_10960_ _10960_/D _10978_/CLK _10960_/Q VDD VDD VSS VSS gf180mcu_fd_sc_mcu7t5v0__dffq_1
X_10891_ _10891_/D _11109_/CLK _10891_/Q VDD VDD VSS VSS gf180mcu_fd_sc_mcu7t5v0__dffq_1
X_09619_ _06061_/Z _09625_/A2 _09619_/B _11023_/D VDD VDD VSS VSS
+ gf180mcu_fd_sc_mcu7t5v0__oai21_1
X_10325_ _10325_/D _11150_/CLK _10325_/Q VDD VDD VSS VSS gf180mcu_fd_sc_mcu7t5v0__dffq_1
X_10256_ _10256_/D _10327_/CLK _10256_/Q VDD VDD VSS VSS gf180mcu_fd_sc_mcu7t5v0__dffq_1
X_10187_ _10187_/D _10905_/CLK _10187_/Q VDD VDD VSS VSS gf180mcu_fd_sc_mcu7t5v0__dffq_1
X_05300_ _10493_/Q _08936_/B2 VDD VDD VSS VSS gf180mcu_fd_sc_mcu7t5v0__clkinv_1
X_06280_ _06280_/I _06322_/A1 VDD VDD VSS VSS gf180mcu_fd_sc_mcu7t5v0__clkinv_1
X_05231_ _10652_/Q _09135_/B2 VDD VDD VSS VSS gf180mcu_fd_sc_mcu7t5v0__clkinv_1
X_05162_ _10159_/Q _07702_/B2 VDD VDD VSS VSS gf180mcu_fd_sc_mcu7t5v0__clkinv_1
X_05093_ _10143_/Q _07671_/B2 VDD VDD VSS VSS gf180mcu_fd_sc_mcu7t5v0__clkinv_1
X_09970_ _09970_/D _11181_/CLK _09970_/Q VDD VDD VSS VSS gf180mcu_fd_sc_mcu7t5v0__dffq_1
X_08921_ _09916_/A1 _08921_/A2 _08921_/B _10482_/D VDD VDD VSS VSS
+ gf180mcu_fd_sc_mcu7t5v0__oai21_1
X_08852_ _08831_/I _08850_/Z _08852_/A3 _10450_/D VDD VDD VSS VSS
+ gf180mcu_fd_sc_mcu7t5v0__nor3_1
X_07803_ _06058_/Z _07807_/A2 _07807_/B1 _07803_/B2 _10226_/D VDD VDD
+ VSS VSS gf180mcu_fd_sc_mcu7t5v0__oai22_1
X_08783_ _09940_/A1 _08789_/A2 _08789_/B1 _08783_/B2 _10404_/D VDD VDD
+ VSS VSS gf180mcu_fd_sc_mcu7t5v0__oai22_1
X_05995_ _11053_/Q _07876_/A2 _07906_/A2 _11066_/Q _05986_/I _11084_/Q _05996_/B1
+ VDD VDD VSS VSS gf180mcu_fd_sc_mcu7t5v0__aoi222_4
X_07734_ _06058_/Z _07738_/A2 _07738_/B1 _07734_/B2 _10178_/D VDD VDD
+ VSS VSS gf180mcu_fd_sc_mcu7t5v0__oai22_1
X_07665_ _09944_/A1 _07667_/A2 _07667_/B1 _07665_/B2 _10140_/D VDD VDD
+ VSS VSS gf180mcu_fd_sc_mcu7t5v0__oai22_1
X_09404_ _06047_/Z _09411_/A2 _09411_/B1 _09404_/B2 _10867_/D VDD VDD
+ VSS VSS gf180mcu_fd_sc_mcu7t5v0__oai22_1
X_06616_ _07362_/A3 _07601_/B _07603_/B _06616_/C _10046_/D VDD VDD VSS
+ VSS gf180mcu_fd_sc_mcu7t5v0__aoi211_1
X_07596_ _10006_/Q _07629_/A2 _07598_/B2 VDD VDD VSS VSS gf180mcu_fd_sc_mcu7t5v0__nand2_1
X_09335_ _09904_/A1 _09341_/A2 _09341_/B1 _09335_/B2 _10812_/D VDD VDD
+ VSS VSS gf180mcu_fd_sc_mcu7t5v0__oai22_1
X_06547_ _06578_/A1 _08675_/A2 _06547_/B _10042_/D VDD VDD VSS VSS
+ gf180mcu_fd_sc_mcu7t5v0__aoi21_1
X_09266_ _09921_/A1 _09271_/A2 _09271_/B1 _09266_/B2 _10757_/D VDD VDD
+ VSS VSS gf180mcu_fd_sc_mcu7t5v0__oai22_1
X_06478_ _06478_/A1 _06478_/A2 _06478_/B _06496_/A1 VDD VDD VSS VSS
+ gf180mcu_fd_sc_mcu7t5v0__aoi21_1
X_08217_ _08217_/A1 _08217_/A2 _08217_/A3 _08224_/A2 VDD VDD VSS VSS
+ gf180mcu_fd_sc_mcu7t5v0__nand3_2
X_05429_ _10542_/Q _08997_/B2 VDD VDD VSS VSS gf180mcu_fd_sc_mcu7t5v0__clkinv_1
Xclkbuf_opt_1_0_clk clkbuf_1_0_0_clk/Z clkbuf_opt_1_1_clk/I VDD VDD VSS
+ VSS gf180mcu_fd_sc_mcu7t5v0__clkbuf_16
X_09197_ _06058_/Z _09201_/A2 _09201_/B1 _09197_/B2 _10702_/D VDD VDD
+ VSS VSS gf180mcu_fd_sc_mcu7t5v0__oai22_1
X_08148_ _10885_/Q _08547_/A2 _08573_/B1 _10217_/Q _08576_/B1 _10201_/Q _08150_/A2
+ VDD VDD VSS VSS gf180mcu_fd_sc_mcu7t5v0__aoi222_2
X_08079_ _11028_/Q _08559_/A2 _08589_/B1 _10128_/Q _08082_/A1 VDD VDD
+ VSS VSS gf180mcu_fd_sc_mcu7t5v0__aoi22_1
X_10110_ _10110_/D _11139_/CLK _10110_/Q VDD VDD VSS VSS gf180mcu_fd_sc_mcu7t5v0__dffq_1
X_11090_ _11090_/D _11097_/CLK _11090_/Q VDD VDD VSS VSS gf180mcu_fd_sc_mcu7t5v0__dffq_1
X_10041_ _10041_/D _11150_/CLK _10041_/Q VDD VDD VSS VSS gf180mcu_fd_sc_mcu7t5v0__dffq_2
X_10943_ _10943_/D _11018_/CLK _10943_/Q VDD VDD VSS VSS gf180mcu_fd_sc_mcu7t5v0__dffq_1
X_10874_ _10874_/D _11165_/CLK _10874_/Q VDD VDD VSS VSS gf180mcu_fd_sc_mcu7t5v0__dffq_1
X_10308_ _10308_/D _11018_/CLK _10308_/Q VDD VDD VSS VSS gf180mcu_fd_sc_mcu7t5v0__dffq_1
X_10239_ _10239_/D _10327_/CLK _10239_/Q VDD VDD VSS VSS gf180mcu_fd_sc_mcu7t5v0__dffq_1
X_05780_ _10067_/Q _06898_/B2 VDD VDD VSS VSS gf180mcu_fd_sc_mcu7t5v0__clkinv_1
X_07450_ _07451_/A1 _07451_/A2 _07451_/B _07450_/Z VDD VDD VSS VSS
+ gf180mcu_fd_sc_mcu7t5v0__and3_1
X_07381_ _07381_/A1 _07401_/A1 _07405_/A1 VDD VDD VSS VSS gf180mcu_fd_sc_mcu7t5v0__nor2_1
X_06401_ _06402_/A1 _06402_/A2 _06429_/B VDD VDD VSS VSS gf180mcu_fd_sc_mcu7t5v0__and2_1
X_09120_ _09945_/A1 _09121_/A2 _09121_/B1 _09120_/B2 _10641_/D VDD VDD
+ VSS VSS gf180mcu_fd_sc_mcu7t5v0__oai22_1
X_06332_ _10011_/Q _07601_/B _06332_/B1 _06332_/B2 _06333_/A2 VDD VDD
+ VSS VSS gf180mcu_fd_sc_mcu7t5v0__aoi22_1
X_09051_ _09926_/A1 _09051_/A2 _09051_/B1 _09051_/B2 _10586_/D VDD VDD
+ VSS VSS gf180mcu_fd_sc_mcu7t5v0__oai22_1
X_08002_ _09979_/Q _09872_/A1 _08589_/B1 _10127_/Q _08007_/A1 VDD VDD
+ VSS VSS gf180mcu_fd_sc_mcu7t5v0__aoi22_1
X_06263_ _10047_/Q _09999_/Q _09998_/Q _06264_/B VDD VDD VSS VSS gf180mcu_fd_sc_mcu7t5v0__nand3_2
X_05214_ _10516_/Q _08965_/B2 VDD VDD VSS VSS gf180mcu_fd_sc_mcu7t5v0__clkinv_1
X_06194_ _07628_/A1 _08675_/A2 _06194_/B _10007_/D VDD VDD VSS VSS
+ gf180mcu_fd_sc_mcu7t5v0__aoi21_1
X_05145_ _10053_/Q _06882_/B2 VDD VDD VSS VSS gf180mcu_fd_sc_mcu7t5v0__clkinv_1
X_09953_ _09953_/D _11010_/CLK _09953_/Q VDD VDD VSS VSS gf180mcu_fd_sc_mcu7t5v0__dffq_1
X_05076_ _11069_/Q _05978_/A2 VDD VDD VSS VSS gf180mcu_fd_sc_mcu7t5v0__clkinv_1
X_09884_ _09884_/A1 _09888_/A2 _09884_/B _11139_/D VDD VDD VSS VSS
+ gf180mcu_fd_sc_mcu7t5v0__oai21_1
X_08904_ _09645_/A2 _09900_/A2 _08921_/A2 VDD VDD VSS VSS gf180mcu_fd_sc_mcu7t5v0__nand2_2
X_08835_ _10444_/Q _10443_/Q _10445_/Q _08837_/A2 VDD VDD VSS VSS
+ gf180mcu_fd_sc_mcu7t5v0__aoi21_1
X_08766_ _06061_/Z _08769_/A2 _08769_/B1 _08766_/B2 _10391_/D VDD VDD
+ VSS VSS gf180mcu_fd_sc_mcu7t5v0__oai22_1
X_05978_ _11070_/Q _05978_/A2 _05977_/Z _05979_/A3 VDD VDD VSS VSS
+ gf180mcu_fd_sc_mcu7t5v0__nand3_1
X_07717_ _09529_/A1 _07727_/A2 _07717_/B _10169_/D VDD VDD VSS VSS
+ gf180mcu_fd_sc_mcu7t5v0__oai21_1
X_08697_ _10287_/Q _08621_/I _08699_/A1 VDD VDD VSS VSS gf180mcu_fd_sc_mcu7t5v0__nand2_1
X_07648_ _10130_/Q _07656_/A2 _07649_/B VDD VDD VSS VSS gf180mcu_fd_sc_mcu7t5v0__nand2_1
X_07579_ _07579_/A1 _07577_/Z _07579_/Z VDD VDD VSS VSS gf180mcu_fd_sc_mcu7t5v0__xor2_1
X_09318_ _06061_/Z _09321_/A2 _09321_/B1 _09318_/B2 _10799_/D VDD VDD
+ VSS VSS gf180mcu_fd_sc_mcu7t5v0__oai22_1
X_10590_ _10590_/D _10666_/CLK _10590_/Q VDD VDD VSS VSS gf180mcu_fd_sc_mcu7t5v0__dffq_1
X_09249_ _09896_/A1 _09251_/A2 _09251_/B1 _09249_/B2 _10744_/D VDD VDD
+ VSS VSS gf180mcu_fd_sc_mcu7t5v0__oai22_1
X_11142_ _11142_/D _11142_/CLK _11142_/Q VDD VDD VSS VSS gf180mcu_fd_sc_mcu7t5v0__dffq_1
X_11073_ _11073_/D _11101_/CLK _11073_/Q VDD VDD VSS VSS gf180mcu_fd_sc_mcu7t5v0__dffq_1
X_10024_ _10024_/D _11181_/CLK _10024_/Q VDD VDD VSS VSS gf180mcu_fd_sc_mcu7t5v0__dffq_1
X_10926_ _10926_/D _11018_/CLK _10926_/Q VDD VDD VSS VSS gf180mcu_fd_sc_mcu7t5v0__dffq_1
X_10857_ _10857_/D _11165_/CLK _10857_/Q VDD VDD VSS VSS gf180mcu_fd_sc_mcu7t5v0__dffq_1
X_10788_ _10788_/D _11010_/CLK _10788_/Q VDD VDD VSS VSS gf180mcu_fd_sc_mcu7t5v0__dffq_1
X_06950_ _10079_/Q _07248_/B _07206_/C VDD VDD VSS VSS gf180mcu_fd_sc_mcu7t5v0__nor2_2
X_05901_ _10206_/Q _07769_/B2 VDD VDD VSS VSS gf180mcu_fd_sc_mcu7t5v0__clkinv_1
X_06881_ _09754_/B _06889_/A2 _06889_/B1 VDD VDD VSS VSS gf180mcu_fd_sc_mcu7t5v0__nand2_2
X_05832_ _10474_/Q _08903_/B2 VDD VDD VSS VSS gf180mcu_fd_sc_mcu7t5v0__clkinv_1
X_08620_ _10314_/Q _08620_/A2 _10312_/Q _08621_/I VDD VDD VSS VSS
+ gf180mcu_fd_sc_mcu7t5v0__nor3_4
X_08551_ _10482_/Q _06112_/I _08589_/B1 _10076_/Q _08551_/C _08554_/A1 VDD VDD
+ VSS VSS gf180mcu_fd_sc_mcu7t5v0__aoi221_1
X_05763_ _10673_/Q _09160_/B2 VDD VDD VSS VSS gf180mcu_fd_sc_mcu7t5v0__clkinv_1
X_07502_ _07502_/A1 _07502_/A2 _07503_/C VDD VDD VSS VSS gf180mcu_fd_sc_mcu7t5v0__nor2_1
X_05694_ _10904_/Q _09449_/B2 VDD VDD VSS VSS gf180mcu_fd_sc_mcu7t5v0__clkinv_1
X_08482_ _08482_/A1 _08482_/A2 _08482_/A3 _08483_/B1 VDD VDD VSS VSS
+ gf180mcu_fd_sc_mcu7t5v0__nand3_1
X_07433_ _07470_/B2 _07365_/I _07473_/A2 VDD VDD VSS VSS gf180mcu_fd_sc_mcu7t5v0__nor2_1
X_09103_ _09413_/A1 _09111_/A2 _09111_/B1 VDD VDD VSS VSS gf180mcu_fd_sc_mcu7t5v0__nand2_2
X_07364_ _07471_/A1 _07471_/A2 _07471_/B _07365_/I VDD VDD VSS VSS
+ gf180mcu_fd_sc_mcu7t5v0__oai21_4
X_07295_ _09889_/A1 _09900_/A2 _09900_/B _07310_/A2 VDD VDD VSS VSS
+ gf180mcu_fd_sc_mcu7t5v0__aoi21_4
X_06315_ _10011_/Q _06294_/Z _06312_/Z _06331_/A2 VDD VDD VSS VSS
+ gf180mcu_fd_sc_mcu7t5v0__xnor3_1
X_09034_ _06047_/Z _09041_/A2 _09041_/B1 _09034_/B2 _10571_/D VDD VDD
+ VSS VSS gf180mcu_fd_sc_mcu7t5v0__oai22_1
X_06246_ _10001_/Q _06446_/A2 _06246_/B _06253_/B VDD VDD VSS VSS
+ gf180mcu_fd_sc_mcu7t5v0__oai21_1
X_06177_ _10258_/Q _08675_/A2 _08674_/B _06178_/B VDD VDD VSS VSS
+ gf180mcu_fd_sc_mcu7t5v0__oai21_1
X_05128_ _10675_/Q _09164_/B2 VDD VDD VSS VSS gf180mcu_fd_sc_mcu7t5v0__clkinv_1
X_05059_ _10005_/Q _06420_/B VDD VDD VSS VSS gf180mcu_fd_sc_mcu7t5v0__inv_3
X_09936_ _09946_/A1 _09936_/A2 _09936_/B1 _09936_/B2 _11173_/D VDD VDD
+ VSS VSS gf180mcu_fd_sc_mcu7t5v0__oai22_1
X_09867_ _06061_/Z _09870_/A2 _09870_/B1 _09867_/B2 _11130_/D VDD VDD
+ VSS VSS gf180mcu_fd_sc_mcu7t5v0__oai22_1
X_08818_ _09925_/A1 _08819_/A2 _08819_/B1 _08818_/B2 _10433_/D VDD VDD
+ VSS VSS gf180mcu_fd_sc_mcu7t5v0__oai22_1
X_09798_ _09798_/A1 _09817_/A2 _09798_/B _11091_/D VDD VDD VSS VSS
+ gf180mcu_fd_sc_mcu7t5v0__aoi21_1
X_08749_ _09832_/A1 _08749_/A2 _08749_/B1 _08749_/B2 _10378_/D VDD VDD
+ VSS VSS gf180mcu_fd_sc_mcu7t5v0__oai22_1
X_10711_ _10711_/D _11052_/CLK _10711_/Q VDD VDD VSS VSS gf180mcu_fd_sc_mcu7t5v0__dffq_1
X_10642_ _10642_/D _10666_/CLK _10642_/Q VDD VDD VSS VSS gf180mcu_fd_sc_mcu7t5v0__dffq_1
X_10573_ _10573_/D _10666_/CLK _10573_/Q VDD VDD VSS VSS gf180mcu_fd_sc_mcu7t5v0__dffq_1
X_11125_ _11125_/D _11147_/CLK _11125_/Q VDD VDD VSS VSS gf180mcu_fd_sc_mcu7t5v0__dffq_1
X_11056_ _11056_/D _11097_/CLK _11056_/Q VDD VDD VSS VSS gf180mcu_fd_sc_mcu7t5v0__dffq_1
X_10007_ _10007_/D _11039_/CLK _10007_/Q VDD VDD VSS VSS gf180mcu_fd_sc_mcu7t5v0__dffq_4
X_10909_ _10909_/D _10978_/CLK _10909_/Q VDD VDD VSS VSS gf180mcu_fd_sc_mcu7t5v0__dffq_1
Xrepeater51 _09599_/A1 _09852_/A1 VDD VDD VSS VSS gf180mcu_fd_sc_mcu7t5v0__buf_12
Xrepeater40 _09926_/A1 _09832_/A1 VDD VDD VSS VSS gf180mcu_fd_sc_mcu7t5v0__buf_12
Xrepeater62 _08674_/B _08672_/B VDD VDD VSS VSS gf180mcu_fd_sc_mcu7t5v0__buf_8
X_07080_ _10004_/Q _07222_/A2 _07181_/A2 _10003_/Q _07084_/A2 VDD VDD
+ VSS VSS gf180mcu_fd_sc_mcu7t5v0__aoi22_1
X_06100_ _09937_/A1 _09861_/A1 _06109_/A2 VDD VDD VSS VSS gf180mcu_fd_sc_mcu7t5v0__nand2_4
X_06031_ _10322_/Q bus_addr[6] _08619_/B _06032_/I VDD VDD VSS VSS
+ gf180mcu_fd_sc_mcu7t5v0__mux2_4
X_07982_ _07982_/A1 _07982_/A2 _07982_/A3 _08013_/B2 VDD VDD VSS VSS
+ gf180mcu_fd_sc_mcu7t5v0__nand3_2
X_09721_ _09721_/A1 _09721_/A2 _09721_/B _11061_/D VDD VDD VSS VSS
+ gf180mcu_fd_sc_mcu7t5v0__aoi21_1
X_06933_ _10000_/Q _07222_/A2 _06933_/Z VDD VDD VSS VSS gf180mcu_fd_sc_mcu7t5v0__and2_1
X_09652_ _11038_/Q _09660_/A2 _09653_/B VDD VDD VSS VSS gf180mcu_fd_sc_mcu7t5v0__nand2_1
X_06864_ _06864_/A1 _06864_/A2 _06871_/A1 VDD VDD VSS VSS gf180mcu_fd_sc_mcu7t5v0__nand2_1
X_09583_ _06058_/Z _09587_/A2 _09587_/B1 _09583_/B2 _10998_/D VDD VDD
+ VSS VSS gf180mcu_fd_sc_mcu7t5v0__oai22_1
X_05815_ _10777_/Q _09290_/B2 VDD VDD VSS VSS gf180mcu_fd_sc_mcu7t5v0__clkinv_1
X_06795_ _06750_/Z _06795_/A2 _06795_/B _06813_/A1 VDD VDD VSS VSS
+ gf180mcu_fd_sc_mcu7t5v0__oai21_1
X_08603_ _09941_/A1 _08608_/A2 _08608_/B1 _08603_/B2 _10294_/D VDD VDD
+ VSS VSS gf180mcu_fd_sc_mcu7t5v0__oai22_1
X_05746_ _10537_/Q _08990_/B2 VDD VDD VSS VSS gf180mcu_fd_sc_mcu7t5v0__clkinv_1
X_08534_ _08534_/A1 _08534_/A2 _08534_/B1 _08534_/B2 _08535_/A2 VDD VDD
+ VSS VSS gf180mcu_fd_sc_mcu7t5v0__oai22_1
X_08465_ _10977_/Q _08555_/A2 _08584_/A2 _10921_/Q _08466_/A3 VDD VDD
+ VSS VSS gf180mcu_fd_sc_mcu7t5v0__aoi22_1
X_05677_ _10029_/Q _06529_/B2 VDD VDD VSS VSS gf180mcu_fd_sc_mcu7t5v0__clkinv_1
X_08396_ _08396_/A1 _08396_/A2 _08396_/A3 _08397_/B1 VDD VDD VSS VSS
+ gf180mcu_fd_sc_mcu7t5v0__nand3_1
X_07416_ _07434_/A1 _07485_/A3 _07516_/A1 VDD VDD VSS VSS gf180mcu_fd_sc_mcu7t5v0__nor2_2
X_07347_ _07496_/A1 _07349_/A2 _07545_/A1 _07594_/A1 VDD VDD VSS VSS
+ gf180mcu_fd_sc_mcu7t5v0__nand3_2
X_09017_ _06058_/Z _09021_/A2 _09021_/B1 _09017_/B2 _10558_/D VDD VDD
+ VSS VSS gf180mcu_fd_sc_mcu7t5v0__oai22_1
X_07278_ _10098_/Q _07292_/A2 _07279_/B VDD VDD VSS VSS gf180mcu_fd_sc_mcu7t5v0__nand2_1
X_06229_ _06258_/A1 _06229_/A2 _07601_/B _06231_/B1 VDD VDD VSS VSS
+ gf180mcu_fd_sc_mcu7t5v0__aoi21_1
X_09919_ _06047_/Z _09926_/A2 _09926_/B1 _09919_/B2 _11158_/D VDD VDD
+ VSS VSS gf180mcu_fd_sc_mcu7t5v0__oai22_1
X_10625_ _10625_/D _10666_/CLK _10625_/Q VDD VDD VSS VSS gf180mcu_fd_sc_mcu7t5v0__dffq_1
X_10556_ _10556_/D _11138_/CLK _10556_/Q VDD VDD VSS VSS gf180mcu_fd_sc_mcu7t5v0__dffq_1
X_10487_ _10487_/D _11164_/CLK _10487_/Q VDD VDD VSS VSS gf180mcu_fd_sc_mcu7t5v0__dffq_1
X_11108_ _11108_/D _11109_/CLK _11108_/Q VDD VDD VSS VSS gf180mcu_fd_sc_mcu7t5v0__dffq_1
X_11039_ _11039_/D _11039_/CLK _11039_/Q VDD VDD VSS VSS gf180mcu_fd_sc_mcu7t5v0__dffq_1
X_05600_ _10751_/Q _09258_/B2 VDD VDD VSS VSS gf180mcu_fd_sc_mcu7t5v0__clkinv_1
X_06580_ _10000_/Q _06557_/Z _06580_/B _06834_/C _06585_/B1 VDD VDD VSS
+ VSS gf180mcu_fd_sc_mcu7t5v0__oai211_1
X_05531_ _10511_/Q _08958_/B2 VDD VDD VSS VSS gf180mcu_fd_sc_mcu7t5v0__clkinv_1
X_08250_ _10606_/Q _08563_/A2 _08584_/A2 _10638_/Q _06877_/Z _10614_/Q _08253_/A1
+ VDD VDD VSS VSS gf180mcu_fd_sc_mcu7t5v0__aoi222_2
X_05462_ _10064_/Q _06895_/B2 VDD VDD VSS VSS gf180mcu_fd_sc_mcu7t5v0__clkinv_1
X_08181_ _08181_/A1 _08181_/A2 _08181_/A3 _08181_/A4 _08182_/A2 VDD VDD
+ VSS VSS gf180mcu_fd_sc_mcu7t5v0__nand4_2
X_07201_ _10006_/Q _07200_/Z _07239_/B VDD VDD VSS VSS gf180mcu_fd_sc_mcu7t5v0__nand2_1
X_05393_ _10789_/Q _09306_/B2 VDD VDD VSS VSS gf180mcu_fd_sc_mcu7t5v0__clkinv_1
X_07132_ _10005_/Q _07222_/A2 _07227_/A1 VDD VDD VSS VSS gf180mcu_fd_sc_mcu7t5v0__nand2_1
X_07063_ _07208_/A1 _07046_/Z _07063_/B _07063_/C _07064_/B2 VDD VDD VSS
+ VSS gf180mcu_fd_sc_mcu7t5v0__aoi211_1
X_06014_ _09728_/A1 _06014_/A2 _06014_/B bus_rdata[7] VDD VDD VSS VSS
+ gf180mcu_fd_sc_mcu7t5v0__oai21_4
X_07965_ _10883_/Q _08547_/A2 _08576_/B1 _10199_/Q _07965_/C _07966_/A3 VDD
+ VDD VSS VSS gf180mcu_fd_sc_mcu7t5v0__aoi221_4
X_06916_ _10076_/Q _06916_/A2 _06917_/B VDD VDD VSS VSS gf180mcu_fd_sc_mcu7t5v0__nand2_1
X_09704_ _09678_/Z _09704_/A2 _09705_/B VDD VDD VSS VSS gf180mcu_fd_sc_mcu7t5v0__nand2_1
X_09635_ _06058_/Z _09643_/A2 _09635_/B _11030_/D VDD VDD VSS VSS
+ gf180mcu_fd_sc_mcu7t5v0__oai21_1
X_07896_ bus_wdata[2] _07905_/A2 _08654_/B _07897_/B VDD VDD VSS VSS
+ gf180mcu_fd_sc_mcu7t5v0__oai21_1
X_06847_ _10002_/Q _06847_/A2 _06858_/A1 VDD VDD VSS VSS gf180mcu_fd_sc_mcu7t5v0__nand2_1
X_09566_ _10986_/Q _09566_/A2 _09567_/B VDD VDD VSS VSS gf180mcu_fd_sc_mcu7t5v0__nand2_1
X_06778_ _06778_/A1 _06778_/A2 _06783_/A3 VDD VDD VSS VSS gf180mcu_fd_sc_mcu7t5v0__nand2_1
X_09497_ _06058_/Z _09501_/A2 _09501_/B1 _09497_/B2 _10942_/D VDD VDD
+ VSS VSS gf180mcu_fd_sc_mcu7t5v0__oai22_1
X_05729_ _10149_/Q _07677_/B2 VDD VDD VSS VSS gf180mcu_fd_sc_mcu7t5v0__clkinv_1
X_08517_ _10068_/Q _08530_/A2 _08564_/C1 _10031_/Q _08563_/C1 _11181_/Q _08518_/A2
+ VDD VDD VSS VSS gf180mcu_fd_sc_mcu7t5v0__aoi222_1
X_08448_ _08448_/I _08449_/C VDD VDD VSS VSS gf180mcu_fd_sc_mcu7t5v0__clkinv_1
X_10410_ _10410_/D _11138_/CLK _10410_/Q VDD VDD VSS VSS gf180mcu_fd_sc_mcu7t5v0__dffq_1
X_08379_ _10672_/Q _08563_/A2 _08584_/A2 _10704_/Q _08382_/A2 VDD VDD
+ VSS VSS gf180mcu_fd_sc_mcu7t5v0__aoi22_1
X_10341_ _10341_/D _11147_/CLK _10341_/Q VDD VDD VSS VSS gf180mcu_fd_sc_mcu7t5v0__dffq_1
X_10272_ _10272_/D _11052_/CLK _10272_/Q VDD VDD VSS VSS gf180mcu_fd_sc_mcu7t5v0__dffq_1
X_10608_ _10608_/D _10666_/CLK _10608_/Q VDD VDD VSS VSS gf180mcu_fd_sc_mcu7t5v0__dffq_1
X_10539_ _10539_/D _11138_/CLK _10539_/Q VDD VDD VSS VSS gf180mcu_fd_sc_mcu7t5v0__dffq_1
X_07750_ _09809_/B _07758_/A2 _07758_/B1 VDD VDD VSS VSS gf180mcu_fd_sc_mcu7t5v0__nand2_2
X_06701_ _06704_/A2 _06704_/A3 _06751_/A2 VDD VDD VSS VSS gf180mcu_fd_sc_mcu7t5v0__nand2_1
X_07681_ _07809_/A2 _08563_/C1 _07699_/A2 VDD VDD VSS VSS gf180mcu_fd_sc_mcu7t5v0__nand2_2
X_09420_ _09945_/A1 _09421_/A2 _09421_/B1 _09420_/B2 _10881_/D VDD VDD
+ VSS VSS gf180mcu_fd_sc_mcu7t5v0__oai22_1
X_06632_ _10047_/Q _06650_/A1 _06629_/Z _06647_/A2 VDD VDD VSS VSS
+ gf180mcu_fd_sc_mcu7t5v0__xnor3_1
X_09351_ _09926_/A1 _09351_/A2 _09351_/B1 _09351_/B2 _10826_/D VDD VDD
+ VSS VSS gf180mcu_fd_sc_mcu7t5v0__oai22_1
X_06563_ _10041_/Q _06579_/A3 _06578_/A2 VDD VDD VSS VSS gf180mcu_fd_sc_mcu7t5v0__nand2_1
X_08302_ _10179_/Q _08589_/A2 _08591_/A2 _10383_/Q _08305_/A1 VDD VDD
+ VSS VSS gf180mcu_fd_sc_mcu7t5v0__aoi22_1
X_05514_ _10471_/Q _08900_/B2 VDD VDD VSS VSS gf180mcu_fd_sc_mcu7t5v0__clkinv_1
X_09282_ _09502_/A1 _09332_/A2 _09291_/A2 VDD VDD VSS VSS gf180mcu_fd_sc_mcu7t5v0__nand2_4
X_08233_ _10109_/Q _08589_/A2 _08589_/B1 _10072_/Q _08234_/A3 VDD VDD
+ VSS VSS gf180mcu_fd_sc_mcu7t5v0__aoi22_1
X_06494_ _06441_/Z _06494_/A2 _06494_/B _06495_/A3 VDD VDD VSS VSS
+ gf180mcu_fd_sc_mcu7t5v0__oai21_1
X_05445_ _10670_/Q _09157_/B2 VDD VDD VSS VSS gf180mcu_fd_sc_mcu7t5v0__clkinv_1
X_08164_ _10973_/Q _08555_/A2 _06877_/Z _10957_/Q _07680_/I _10909_/Q _08166_/A2 VDD
+ VDD VSS VSS gf180mcu_fd_sc_mcu7t5v0__aoi222_2
X_05376_ _10901_/Q _09446_/B2 VDD VDD VSS VSS gf180mcu_fd_sc_mcu7t5v0__clkinv_1
X_08095_ _08095_/A1 _09062_/A2 _08095_/B1 _09142_/A2 _08097_/A2 VDD VDD
+ VSS VSS gf180mcu_fd_sc_mcu7t5v0__aoi22_1
X_07115_ _07115_/A1 _07115_/A2 _07115_/B _07115_/C _07116_/A2 VDD VDD
+ VSS VSS gf180mcu_fd_sc_mcu7t5v0__oai211_1
X_07046_ _07046_/A1 _07043_/Z _07046_/Z VDD VDD VSS VSS gf180mcu_fd_sc_mcu7t5v0__xor2_1
X_08997_ _06058_/Z _09001_/A2 _09001_/B1 _08997_/B2 _10542_/D VDD VDD
+ VSS VSS gf180mcu_fd_sc_mcu7t5v0__oai22_1
X_07948_ _07948_/A1 _07948_/A2 _07948_/A3 _08008_/A2 VDD VDD VSS VSS
+ gf180mcu_fd_sc_mcu7t5v0__nand3_1
X_07879_ bus_wdata[1] _07890_/A2 _08654_/B _07880_/B VDD VDD VSS VSS
+ gf180mcu_fd_sc_mcu7t5v0__oai21_1
X_10890_ _10890_/D _11147_/CLK _10890_/Q VDD VDD VSS VSS gf180mcu_fd_sc_mcu7t5v0__dffq_1
X_09618_ _11023_/Q _09624_/A2 _09619_/B VDD VDD VSS VSS gf180mcu_fd_sc_mcu7t5v0__nand2_1
X_09549_ _09946_/A1 _09549_/A2 _09549_/B1 _09549_/B2 _10978_/D VDD VDD
+ VSS VSS gf180mcu_fd_sc_mcu7t5v0__oai22_1
X_10324_ _10324_/D _10327_/CLK _10324_/Q VDD VDD VSS VSS gf180mcu_fd_sc_mcu7t5v0__dffq_1
X_10255_ _10255_/D _10327_/CLK _10255_/Q VDD VDD VSS VSS gf180mcu_fd_sc_mcu7t5v0__dffq_1
X_10186_ _10186_/D _10905_/CLK _10186_/Q VDD VDD VSS VSS gf180mcu_fd_sc_mcu7t5v0__dffq_1
X_05230_ _10644_/Q _09125_/B2 VDD VDD VSS VSS gf180mcu_fd_sc_mcu7t5v0__clkinv_1
X_05161_ _10183_/Q _07741_/B2 VDD VDD VSS VSS gf180mcu_fd_sc_mcu7t5v0__clkinv_1
X_05092_ _10427_/Q _08812_/B2 VDD VDD VSS VSS gf180mcu_fd_sc_mcu7t5v0__clkinv_1
X_08920_ _10482_/Q _08920_/A2 _08921_/B VDD VDD VSS VSS gf180mcu_fd_sc_mcu7t5v0__nand2_1
X_08851_ _10450_/Q _08847_/Z _08852_/A3 VDD VDD VSS VSS gf180mcu_fd_sc_mcu7t5v0__nor2_1
X_07802_ _09893_/A1 _07807_/A2 _07807_/B1 _07802_/B2 _10225_/D VDD VDD
+ VSS VSS gf180mcu_fd_sc_mcu7t5v0__oai22_1
X_05994_ _10281_/Q _07829_/C _05996_/C VDD VDD VSS VSS gf180mcu_fd_sc_mcu7t5v0__nand2_1
X_08782_ _06047_/Z _08789_/A2 _08789_/B1 _08782_/B2 _10403_/D VDD VDD
+ VSS VSS gf180mcu_fd_sc_mcu7t5v0__oai22_1
X_07733_ _09921_/A1 _07738_/A2 _07738_/B1 _07733_/B2 _10177_/D VDD VDD
+ VSS VSS gf180mcu_fd_sc_mcu7t5v0__oai22_1
X_07664_ _06061_/Z _07667_/A2 _07667_/B1 _07664_/B2 _10139_/D VDD VDD
+ VSS VSS gf180mcu_fd_sc_mcu7t5v0__oai22_1
X_09403_ _08514_/B _09411_/A2 _09411_/B1 VDD VDD VSS VSS gf180mcu_fd_sc_mcu7t5v0__nand2_2
X_06615_ _07601_/B _06615_/A2 _06616_/C VDD VDD VSS VSS gf180mcu_fd_sc_mcu7t5v0__nor2_1
X_07595_ _10006_/Q _07629_/A2 _07599_/B VDD VDD VSS VSS gf180mcu_fd_sc_mcu7t5v0__nor2_1
X_09334_ _06047_/Z _09341_/A2 _09341_/B1 _09334_/B2 _10811_/D VDD VDD
+ VSS VSS gf180mcu_fd_sc_mcu7t5v0__oai22_1
X_06546_ _10251_/Q _08675_/A2 _08674_/B _06547_/B VDD VDD VSS VSS
+ gf180mcu_fd_sc_mcu7t5v0__oai21_1
X_09265_ _09904_/A1 _09271_/A2 _09271_/B1 _09265_/B2 _10756_/D VDD VDD
+ VSS VSS gf180mcu_fd_sc_mcu7t5v0__oai22_1
X_06477_ _06477_/A1 _06477_/A2 _06477_/B _06498_/A1 VDD VDD VSS VSS
+ gf180mcu_fd_sc_mcu7t5v0__oai21_1
X_08216_ _10950_/Q _06023_/I _06125_/I _10934_/Q _08217_/A3 VDD VDD VSS
+ VSS gf180mcu_fd_sc_mcu7t5v0__aoi22_1
X_05428_ _10534_/Q _08987_/B2 VDD VDD VSS VSS gf180mcu_fd_sc_mcu7t5v0__clkinv_1
X_09196_ _09941_/A1 _09201_/A2 _09201_/B1 _09196_/B2 _10701_/D VDD VDD
+ VSS VSS gf180mcu_fd_sc_mcu7t5v0__oai22_1
X_08147_ _11144_/Q _08555_/A2 _08589_/B1 _11120_/Q _08150_/A1 VDD VDD
+ VSS VSS gf180mcu_fd_sc_mcu7t5v0__aoi22_1
X_05359_ _10026_/Q _06526_/B2 VDD VDD VSS VSS gf180mcu_fd_sc_mcu7t5v0__clkinv_1
X_08078_ _08078_/A1 _08078_/A2 _08078_/A3 _08099_/B2 VDD VDD VSS VSS
+ gf180mcu_fd_sc_mcu7t5v0__nand3_1
X_07029_ _07029_/A1 _07029_/A2 _07217_/B1 _08667_/A1 _07223_/A2 VDD VDD
+ VSS VSS gf180mcu_fd_sc_mcu7t5v0__aoi22_4
X_10040_ _10040_/D _11150_/CLK _10040_/Q VDD VDD VSS VSS gf180mcu_fd_sc_mcu7t5v0__dffq_4
X_10942_ _10942_/D _11018_/CLK _10942_/Q VDD VDD VSS VSS gf180mcu_fd_sc_mcu7t5v0__dffq_1
X_10873_ _10873_/D _11165_/CLK _10873_/Q VDD VDD VSS VSS gf180mcu_fd_sc_mcu7t5v0__dffq_1
X_10307_ _10307_/D _11018_/CLK _10307_/Q VDD VDD VSS VSS gf180mcu_fd_sc_mcu7t5v0__dffq_1
X_10238_ _10238_/D _11101_/CLK _10238_/Q VDD VDD VSS VSS gf180mcu_fd_sc_mcu7t5v0__dffq_1
X_10169_ _10169_/D _11101_/CLK _10169_/Q VDD VDD VSS VSS gf180mcu_fd_sc_mcu7t5v0__dffq_1
X_06400_ _06389_/I _06398_/Z _06402_/A2 VDD VDD VSS VSS gf180mcu_fd_sc_mcu7t5v0__xnor2_1
X_07380_ _07431_/A1 _07485_/A1 _07382_/A2 VDD VDD VSS VSS gf180mcu_fd_sc_mcu7t5v0__nor2_1
X_06331_ _06327_/B _06331_/A2 _07601_/B _06332_/B2 VDD VDD VSS VSS
+ gf180mcu_fd_sc_mcu7t5v0__aoi21_1
X_09050_ _09945_/A1 _09051_/A2 _09051_/B1 _09050_/B2 _10585_/D VDD VDD
+ VSS VSS gf180mcu_fd_sc_mcu7t5v0__oai22_1
X_06262_ _06274_/A1 _06274_/A2 _06275_/A1 VDD VDD VSS VSS gf180mcu_fd_sc_mcu7t5v0__nand2_1
X_05213_ _10508_/Q _08955_/B2 VDD VDD VSS VSS gf180mcu_fd_sc_mcu7t5v0__clkinv_1
X_08001_ _08001_/A1 _08001_/A2 _08001_/A3 _08009_/B1 VDD VDD VSS VSS
+ gf180mcu_fd_sc_mcu7t5v0__nand3_1
X_06193_ _10338_/Q _08675_/A2 _08672_/B _06194_/B VDD VDD VSS VSS
+ gf180mcu_fd_sc_mcu7t5v0__oai21_1
X_05144_ _10061_/Q _06892_/B2 VDD VDD VSS VSS gf180mcu_fd_sc_mcu7t5v0__clkinv_1
X_09952_ _09952_/D _11039_/CLK _09952_/Q VDD VDD VSS VSS gf180mcu_fd_sc_mcu7t5v0__dffq_1
X_05075_ _10301_/Q _09813_/A1 VDD VDD VSS VSS gf180mcu_fd_sc_mcu7t5v0__clkinv_1
X_08903_ _09832_/A1 _08903_/A2 _08903_/B1 _08903_/B2 _10474_/D VDD VDD
+ VSS VSS gf180mcu_fd_sc_mcu7t5v0__oai22_1
X_09883_ _11139_/Q _09887_/A2 _09884_/B VDD VDD VSS VSS gf180mcu_fd_sc_mcu7t5v0__nand2_1
X_08834_ _08831_/I _08833_/Z _10444_/D VDD VDD VSS VSS gf180mcu_fd_sc_mcu7t5v0__nor2_1
X_08765_ _06058_/Z _08769_/A2 _08769_/B1 _08765_/B2 _10390_/D VDD VDD
+ VSS VSS gf180mcu_fd_sc_mcu7t5v0__oai22_1
X_05977_ _11068_/Q _11067_/Q _05977_/Z VDD VDD VSS VSS gf180mcu_fd_sc_mcu7t5v0__and2_1
X_07716_ _10169_/Q _07726_/A2 _07717_/B VDD VDD VSS VSS gf180mcu_fd_sc_mcu7t5v0__nand2_1
X_08696_ _08696_/A1 _08696_/A2 _09900_/B _10337_/D VDD VDD VSS VSS
+ gf180mcu_fd_sc_mcu7t5v0__aoi21_1
X_07647_ _09921_/A1 _07657_/A2 _07647_/B _10129_/D VDD VDD VSS VSS
+ gf180mcu_fd_sc_mcu7t5v0__oai21_1
X_07578_ _07579_/A1 _07577_/Z _07605_/B VDD VDD VSS VSS gf180mcu_fd_sc_mcu7t5v0__and2_1
X_09317_ _06058_/Z _09321_/A2 _09321_/B1 _09317_/B2 _10798_/D VDD VDD
+ VSS VSS gf180mcu_fd_sc_mcu7t5v0__oai22_1
X_06529_ _09944_/A1 _06531_/A2 _06531_/B1 _06529_/B2 _10029_/D VDD VDD
+ VSS VSS gf180mcu_fd_sc_mcu7t5v0__oai22_1
X_09248_ _06061_/Z _09251_/A2 _09251_/B1 _09248_/B2 _10743_/D VDD VDD
+ VSS VSS gf180mcu_fd_sc_mcu7t5v0__oai22_1
X_09179_ _09884_/A1 _09181_/A2 _09181_/B1 _09179_/B2 _10688_/D VDD VDD
+ VSS VSS gf180mcu_fd_sc_mcu7t5v0__oai22_1
X_11141_ _11141_/D _11163_/CLK _11141_/Q VDD VDD VSS VSS gf180mcu_fd_sc_mcu7t5v0__dffq_1
X_11072_ _11072_/D _11082_/CLK _11072_/Q VDD VDD VSS VSS gf180mcu_fd_sc_mcu7t5v0__dffq_1
X_10023_ _10023_/D _11176_/CLK _10023_/Q VDD VDD VSS VSS gf180mcu_fd_sc_mcu7t5v0__dffq_1
X_10925_ _10925_/D _11018_/CLK _10925_/Q VDD VDD VSS VSS gf180mcu_fd_sc_mcu7t5v0__dffq_1
X_10856_ _10856_/D _11165_/CLK _10856_/Q VDD VDD VSS VSS gf180mcu_fd_sc_mcu7t5v0__dffq_1
X_10787_ _10787_/D _11164_/CLK _10787_/Q VDD VDD VSS VSS gf180mcu_fd_sc_mcu7t5v0__dffq_1
X_05900_ _10222_/Q _07797_/B2 VDD VDD VSS VSS gf180mcu_fd_sc_mcu7t5v0__clkinv_1
X_06880_ _09937_/A1 _09851_/A1 _06889_/A2 VDD VDD VSS VSS gf180mcu_fd_sc_mcu7t5v0__nand2_4
X_05831_ _10490_/Q _08931_/B2 VDD VDD VSS VSS gf180mcu_fd_sc_mcu7t5v0__clkinv_1
X_05762_ _10665_/Q _09150_/B2 VDD VDD VSS VSS gf180mcu_fd_sc_mcu7t5v0__clkinv_1
X_08550_ _08550_/I _08551_/C VDD VDD VSS VSS gf180mcu_fd_sc_mcu7t5v0__clkinv_1
X_05693_ _10140_/Q _07665_/B2 VDD VDD VSS VSS gf180mcu_fd_sc_mcu7t5v0__clkinv_1
X_07501_ _07548_/C _07501_/A2 _07636_/B _07502_/A2 VDD VDD VSS VSS
+ gf180mcu_fd_sc_mcu7t5v0__oai21_1
X_08481_ _10165_/Q _06023_/I _08563_/A2 _09961_/Q _08482_/A3 VDD VDD VSS
+ VSS gf180mcu_fd_sc_mcu7t5v0__aoi22_1
X_07432_ _07519_/A1 _07519_/A2 _07519_/B _10003_/Q _07434_/B VDD VDD VSS
+ VSS gf180mcu_fd_sc_mcu7t5v0__oai211_2
X_09102_ _09871_/A1 _09142_/A2 _09111_/A2 VDD VDD VSS VSS gf180mcu_fd_sc_mcu7t5v0__nand2_4
X_07363_ _08663_/A1 _07332_/C _07471_/B VDD VDD VSS VSS gf180mcu_fd_sc_mcu7t5v0__nand2_4
X_07294_ _08580_/A2 _09872_/A2 _07311_/A2 VDD VDD VSS VSS gf180mcu_fd_sc_mcu7t5v0__nand2_2
X_06314_ _10011_/Q _06312_/Z _06334_/B VDD VDD VSS VSS gf180mcu_fd_sc_mcu7t5v0__and2_1
X_09033_ _09413_/A1 _09041_/A2 _09041_/B1 VDD VDD VSS VSS gf180mcu_fd_sc_mcu7t5v0__nand2_2
X_06245_ _06328_/A1 _06270_/A2 _06245_/B _06246_/B VDD VDD VSS VSS
+ gf180mcu_fd_sc_mcu7t5v0__oai21_1
X_06176_ _06176_/A1 _08675_/A2 _06176_/B _09998_/D VDD VDD VSS VSS
+ gf180mcu_fd_sc_mcu7t5v0__aoi21_1
X_05127_ _10667_/Q _09154_/B2 VDD VDD VSS VSS gf180mcu_fd_sc_mcu7t5v0__clkinv_1
X_05058_ _10006_/Q _06470_/B VDD VDD VSS VSS gf180mcu_fd_sc_mcu7t5v0__clkinv_4
X_09935_ _09945_/A1 _09936_/A2 _09936_/B1 _09935_/B2 _11172_/D VDD VDD
+ VSS VSS gf180mcu_fd_sc_mcu7t5v0__oai22_1
X_09866_ _06058_/Z _09870_/A2 _09870_/B1 _09866_/B2 _11129_/D VDD VDD
+ VSS VSS gf180mcu_fd_sc_mcu7t5v0__oai22_1
X_08817_ _09896_/A1 _08819_/A2 _08819_/B1 _08817_/B2 _10432_/D VDD VDD
+ VSS VSS gf180mcu_fd_sc_mcu7t5v0__oai22_1
X_09797_ _11092_/Q _09817_/A2 _09809_/B _09798_/B VDD VDD VSS VSS
+ gf180mcu_fd_sc_mcu7t5v0__oai21_1
X_08748_ _09897_/A1 _08749_/A2 _08749_/B1 _08748_/B2 _10377_/D VDD VDD
+ VSS VSS gf180mcu_fd_sc_mcu7t5v0__oai22_1
X_08679_ _10281_/Q _08621_/I _08681_/A1 VDD VDD VSS VSS gf180mcu_fd_sc_mcu7t5v0__nand2_1
X_10710_ _10710_/D _11052_/CLK _10710_/Q VDD VDD VSS VSS gf180mcu_fd_sc_mcu7t5v0__dffq_1
X_10641_ _10641_/D _10666_/CLK _10641_/Q VDD VDD VSS VSS gf180mcu_fd_sc_mcu7t5v0__dffq_1
X_10572_ _10572_/D _11138_/CLK _10572_/Q VDD VDD VSS VSS gf180mcu_fd_sc_mcu7t5v0__dffq_1
X_11124_ _11124_/D _11142_/CLK _11124_/Q VDD VDD VSS VSS gf180mcu_fd_sc_mcu7t5v0__dffq_1
X_11055_ _11055_/D _11097_/CLK _11055_/Q VDD VDD VSS VSS gf180mcu_fd_sc_mcu7t5v0__dffq_1
X_10006_ _10006_/D _11039_/CLK _10006_/Q VDD VDD VSS VSS gf180mcu_fd_sc_mcu7t5v0__dffq_4
X_10908_ _10908_/D _10978_/CLK _10908_/Q VDD VDD VSS VSS gf180mcu_fd_sc_mcu7t5v0__dffq_1
Xrepeater52 _09599_/A1 _09890_/A1 VDD VDD VSS VSS gf180mcu_fd_sc_mcu7t5v0__buf_12
X_10839_ _10839_/D _11165_/CLK _10839_/Q VDD VDD VSS VSS gf180mcu_fd_sc_mcu7t5v0__dffq_1
Xrepeater41 _09916_/A1 _09926_/A1 VDD VDD VSS VSS gf180mcu_fd_sc_mcu7t5v0__buf_12
Xrepeater63 rst_n _08674_/B VDD VDD VSS VSS gf180mcu_fd_sc_mcu7t5v0__buf_8
Xrepeater30 _09941_/A1 _09921_/A1 VDD VDD VSS VSS gf180mcu_fd_sc_mcu7t5v0__buf_16
X_06030_ _08585_/A2 _07682_/A1 _09502_/A1 VDD VDD VSS VSS gf180mcu_fd_sc_mcu7t5v0__nor2_4
X_07981_ _10755_/Q _08559_/A2 _08589_/B1 _10763_/Q _08877_/A2 _10795_/Q _07982_/A3
+ VDD VDD VSS VSS gf180mcu_fd_sc_mcu7t5v0__aoi222_4
X_09720_ _09809_/B _09720_/A2 _09722_/B1 _09721_/B VDD VDD VSS VSS
+ gf180mcu_fd_sc_mcu7t5v0__nand3_1
X_06932_ _06967_/A1 _06967_/A2 _06967_/A3 _07222_/A2 VDD VDD VSS VSS
+ gf180mcu_fd_sc_mcu7t5v0__nor3_4
X_09651_ _09921_/A1 _09661_/A2 _09651_/B _11037_/D VDD VDD VSS VSS
+ gf180mcu_fd_sc_mcu7t5v0__oai21_1
X_06863_ _06682_/B _06862_/Z _06876_/B1 VDD VDD VSS VSS gf180mcu_fd_sc_mcu7t5v0__nand2_1
X_09582_ _09893_/A1 _09587_/A2 _09587_/B1 _09582_/B2 _10997_/D VDD VDD
+ VSS VSS gf180mcu_fd_sc_mcu7t5v0__oai22_1
X_05814_ _10769_/Q _09280_/B2 VDD VDD VSS VSS gf180mcu_fd_sc_mcu7t5v0__clkinv_1
X_08602_ _09940_/A1 _08608_/A2 _08608_/B1 _08602_/B2 _10293_/D VDD VDD
+ VSS VSS gf180mcu_fd_sc_mcu7t5v0__oai22_1
X_06794_ _06794_/A1 _06794_/A2 _06841_/A1 VDD VDD VSS VSS gf180mcu_fd_sc_mcu7t5v0__xnor2_1
X_05745_ _10529_/Q _08980_/B2 VDD VDD VSS VSS gf180mcu_fd_sc_mcu7t5v0__clkinv_1
X_08533_ _08533_/A1 _08533_/A2 _08533_/B1 _08533_/B2 _08535_/A1 VDD VDD
+ VSS VSS gf180mcu_fd_sc_mcu7t5v0__oai22_1
X_08464_ _10953_/Q _08547_/A2 _08573_/B1 _11132_/Q _06125_/I _10937_/Q _08466_/A2
+ VDD VDD VSS VSS gf180mcu_fd_sc_mcu7t5v0__aoi222_2
X_05676_ _10037_/Q _06539_/B2 VDD VDD VSS VSS gf180mcu_fd_sc_mcu7t5v0__clkinv_1
X_08395_ _10856_/Q _08591_/A2 _07255_/I _10880_/Q _08589_/B1 _10832_/Q _08396_/A3
+ VDD VDD VSS VSS gf180mcu_fd_sc_mcu7t5v0__aoi222_2
X_07415_ _07346_/Z _07451_/A2 _07415_/Z VDD VDD VSS VSS gf180mcu_fd_sc_mcu7t5v0__and2_1
X_07346_ _07496_/A1 _07349_/A2 _07545_/A1 _07346_/Z VDD VDD VSS VSS
+ gf180mcu_fd_sc_mcu7t5v0__and3_1
X_09016_ _09893_/A1 _09021_/A2 _09021_/B1 _09016_/B2 _10557_/D VDD VDD
+ VSS VSS gf180mcu_fd_sc_mcu7t5v0__oai22_1
X_07277_ _09861_/A1 _09523_/A2 _09900_/B _07292_/A2 VDD VDD VSS VSS
+ gf180mcu_fd_sc_mcu7t5v0__aoi21_4
X_06228_ _06553_/A3 _06270_/A1 _06228_/B _06229_/A2 VDD VDD VSS VSS
+ gf180mcu_fd_sc_mcu7t5v0__aoi21_1
X_06159_ _06058_/Z _06167_/A2 _06159_/B _09990_/D VDD VDD VSS VSS
+ gf180mcu_fd_sc_mcu7t5v0__oai21_1
X_09918_ _09918_/A1 _09926_/A2 _09926_/B1 VDD VDD VSS VSS gf180mcu_fd_sc_mcu7t5v0__nand2_2
X_09849_ _11117_/Q _09849_/A2 _09850_/B VDD VDD VSS VSS gf180mcu_fd_sc_mcu7t5v0__nand2_1
X_10624_ _10624_/D _10666_/CLK _10624_/Q VDD VDD VSS VSS gf180mcu_fd_sc_mcu7t5v0__dffq_1
X_10555_ _10555_/D _11138_/CLK _10555_/Q VDD VDD VSS VSS gf180mcu_fd_sc_mcu7t5v0__dffq_1
X_10486_ _10486_/D _11164_/CLK _10486_/Q VDD VDD VSS VSS gf180mcu_fd_sc_mcu7t5v0__dffq_1
X_11107_ _11107_/D _11109_/CLK _11107_/Q VDD VDD VSS VSS gf180mcu_fd_sc_mcu7t5v0__dffq_1
X_11038_ _11038_/D _11039_/CLK _11038_/Q VDD VDD VSS VSS gf180mcu_fd_sc_mcu7t5v0__dffq_1
X_05530_ _10503_/Q _08948_/B2 VDD VDD VSS VSS gf180mcu_fd_sc_mcu7t5v0__clkinv_1
X_05461_ _10194_/Q _07754_/B2 VDD VDD VSS VSS gf180mcu_fd_sc_mcu7t5v0__clkinv_1
X_05392_ _10781_/Q _09296_/B2 VDD VDD VSS VSS gf180mcu_fd_sc_mcu7t5v0__clkinv_1
X_08180_ _09917_/A2 _08180_/A2 _08180_/B1 _09142_/A2 _08181_/A4 VDD VDD
+ VSS VSS gf180mcu_fd_sc_mcu7t5v0__aoi22_1
X_07200_ _07243_/A2 _07244_/A1 _07200_/Z VDD VDD VSS VSS gf180mcu_fd_sc_mcu7t5v0__xor2_1
X_07131_ _10003_/Q _07221_/A2 _07177_/B2 VDD VDD VSS VSS gf180mcu_fd_sc_mcu7t5v0__nand2_1
X_07062_ _07207_/A1 _07231_/A1 _07062_/B1 _07062_/B2 _07062_/C _07063_/B VDD
+ VDD VSS VSS gf180mcu_fd_sc_mcu7t5v0__oai221_1
X_06013_ _11059_/Q _07876_/A2 _05986_/I _11090_/Q _06014_/A2 VDD VDD VSS
+ VSS gf180mcu_fd_sc_mcu7t5v0__aoi22_2
X_07964_ _07964_/I _07965_/C VDD VDD VSS VSS gf180mcu_fd_sc_mcu7t5v0__clkinv_1
X_09703_ _11057_/Q _09678_/Z _09809_/B _09706_/A1 VDD VDD VSS VSS
+ gf180mcu_fd_sc_mcu7t5v0__oai21_1
X_07895_ _07895_/A1 _07905_/A2 _07895_/B _10267_/D VDD VDD VSS VSS
+ gf180mcu_fd_sc_mcu7t5v0__aoi21_1
X_06915_ _09925_/A1 _06917_/A2 _06915_/B _10075_/D VDD VDD VSS VSS
+ gf180mcu_fd_sc_mcu7t5v0__oai21_1
X_09634_ _11030_/Q _09642_/A2 _09635_/B VDD VDD VSS VSS gf180mcu_fd_sc_mcu7t5v0__nand2_1
X_06846_ _10001_/Q _06867_/A2 _06857_/A2 VDD VDD VSS VSS gf180mcu_fd_sc_mcu7t5v0__nand2_1
X_09565_ _09925_/A1 _09567_/A2 _09565_/B _10985_/D VDD VDD VSS VSS
+ gf180mcu_fd_sc_mcu7t5v0__oai21_1
X_06777_ _06607_/B _06828_/A2 _06778_/A2 VDD VDD VSS VSS gf180mcu_fd_sc_mcu7t5v0__nor2_1
X_09496_ _09921_/A1 _09501_/A2 _09501_/B1 _09496_/B2 _10941_/D VDD VDD
+ VSS VSS gf180mcu_fd_sc_mcu7t5v0__oai22_1
X_05728_ _10433_/Q _08818_/B2 VDD VDD VSS VSS gf180mcu_fd_sc_mcu7t5v0__clkinv_1
X_08516_ _09970_/Q _08586_/A2 _08528_/B1 _09978_/Q _10060_/Q _06877_/Z _08518_/A1
+ VDD VDD VSS VSS gf180mcu_fd_sc_mcu7t5v0__aoi222_1
X_08447_ _10729_/Q _08580_/A2 _08576_/B1 _11001_/Q _08448_/I VDD VDD VSS
+ VSS gf180mcu_fd_sc_mcu7t5v0__aoi22_1
X_05659_ _10688_/Q _09179_/B2 VDD VDD VSS VSS gf180mcu_fd_sc_mcu7t5v0__clkinv_1
X_08378_ _10688_/Q _06023_/I _08529_/B1 _10696_/Q _08382_/A1 VDD VDD VSS
+ VSS gf180mcu_fd_sc_mcu7t5v0__aoi22_1
X_07329_ _10331_/Q _10118_/Q _10117_/Q _07333_/B VDD VDD VSS VSS gf180mcu_fd_sc_mcu7t5v0__nand3_2
X_10340_ _10340_/D _11142_/CLK _10340_/Q VDD VDD VSS VSS gf180mcu_fd_sc_mcu7t5v0__dffq_1
X_10271_ _10271_/D _11097_/CLK _10271_/Q VDD VDD VSS VSS gf180mcu_fd_sc_mcu7t5v0__dffq_1
X_10607_ _10607_/D _10666_/CLK _10607_/Q VDD VDD VSS VSS gf180mcu_fd_sc_mcu7t5v0__dffq_1
X_10538_ _10538_/D _11018_/CLK _10538_/Q VDD VDD VSS VSS gf180mcu_fd_sc_mcu7t5v0__dffq_1
X_10469_ _10469_/D _11165_/CLK _10469_/Q VDD VDD VSS VSS gf180mcu_fd_sc_mcu7t5v0__dffq_1
X_06700_ _10004_/Q _06700_/A2 _06700_/A3 _06704_/A3 VDD VDD VSS VSS
+ gf180mcu_fd_sc_mcu7t5v0__nand3_1
X_07680_ _07680_/I _08585_/B1 VDD VDD VSS VSS gf180mcu_fd_sc_mcu7t5v0__clkinv_4
X_06631_ _10047_/Q _06629_/Z _06650_/B VDD VDD VSS VSS gf180mcu_fd_sc_mcu7t5v0__nand2_1
X_09350_ _09945_/A1 _09351_/A2 _09351_/B1 _09350_/B2 _10825_/D VDD VDD
+ VSS VSS gf180mcu_fd_sc_mcu7t5v0__oai22_1
X_06562_ _10040_/Q _06570_/A2 _06872_/I1 VDD VDD VSS VSS gf180mcu_fd_sc_mcu7t5v0__nor2_4
X_09281_ _09916_/A1 _09281_/A2 _09281_/B1 _09281_/B2 _10770_/D VDD VDD
+ VSS VSS gf180mcu_fd_sc_mcu7t5v0__oai22_1
X_05513_ _10487_/Q _08928_/B2 VDD VDD VSS VSS gf180mcu_fd_sc_mcu7t5v0__clkinv_1
X_08301_ _10131_/Q _08589_/B1 _08301_/B _08348_/B1 VDD VDD VSS VSS
+ gf180mcu_fd_sc_mcu7t5v0__aoi21_1
X_08232_ _09990_/Q _08590_/A2 _09872_/A1 _11137_/Q _08234_/A2 VDD VDD
+ VSS VSS gf180mcu_fd_sc_mcu7t5v0__aoi22_1
X_06493_ _06493_/A1 _06493_/A2 _06440_/Z _06493_/B2 _06495_/A2 VDD VDD
+ VSS VSS gf180mcu_fd_sc_mcu7t5v0__oai22_1
X_05444_ _10662_/Q _09147_/B2 VDD VDD VSS VSS gf180mcu_fd_sc_mcu7t5v0__clkinv_1
X_08163_ _10917_/Q _08584_/A2 _08584_/B1 _10749_/Q _08166_/A1 VDD VDD
+ VSS VSS gf180mcu_fd_sc_mcu7t5v0__aoi22_1
X_05375_ _10137_/Q _07662_/B2 VDD VDD VSS VSS gf180mcu_fd_sc_mcu7t5v0__clkinv_1
X_08094_ _09645_/A1 _08094_/A2 _08094_/B1 _09889_/A2 _08097_/A1 VDD VDD
+ VSS VSS gf180mcu_fd_sc_mcu7t5v0__aoi22_1
X_07114_ _10004_/Q _07199_/A1 _07114_/B _07115_/B VDD VDD VSS VSS
+ gf180mcu_fd_sc_mcu7t5v0__oai21_1
X_07045_ _07045_/I _07143_/A1 VDD VDD VSS VSS gf180mcu_fd_sc_mcu7t5v0__clkinv_1
X_08996_ _09893_/A1 _09001_/A2 _09001_/B1 _08996_/B2 _10541_/D VDD VDD
+ VSS VSS gf180mcu_fd_sc_mcu7t5v0__oai22_1
X_07947_ _10143_/Q _08590_/B1 _07255_/I _11158_/Q _07947_/C _07948_/A3 VDD VDD
+ VSS VSS gf180mcu_fd_sc_mcu7t5v0__aoi221_1
X_07878_ _07878_/A1 _07890_/A2 _07878_/B _10259_/D VDD VDD VSS VSS
+ gf180mcu_fd_sc_mcu7t5v0__aoi21_1
X_09617_ _06058_/Z _09625_/A2 _09617_/B _11022_/D VDD VDD VSS VSS
+ gf180mcu_fd_sc_mcu7t5v0__oai21_1
X_06829_ _06871_/C _06864_/A2 _06834_/A2 VDD VDD VSS VSS gf180mcu_fd_sc_mcu7t5v0__nand2_1
X_09548_ _09945_/A1 _09549_/A2 _09549_/B1 _09548_/B2 _10977_/D VDD VDD
+ VSS VSS gf180mcu_fd_sc_mcu7t5v0__oai22_1
X_09479_ _09896_/A1 _09481_/A2 _09481_/B1 _09479_/B2 _10928_/D VDD VDD
+ VSS VSS gf180mcu_fd_sc_mcu7t5v0__oai22_1
X_10323_ _10323_/D _10327_/CLK _10323_/Q VDD VDD VSS VSS gf180mcu_fd_sc_mcu7t5v0__dffq_2
X_10254_ _10254_/D _11097_/CLK _10254_/Q VDD VDD VSS VSS gf180mcu_fd_sc_mcu7t5v0__dffq_1
X_10185_ _10185_/D _10905_/CLK _10185_/Q VDD VDD VSS VSS gf180mcu_fd_sc_mcu7t5v0__dffq_1
X_05160_ _09955_/Q _06086_/B2 VDD VDD VSS VSS gf180mcu_fd_sc_mcu7t5v0__clkinv_1
X_05091_ _10435_/Q _08822_/B2 VDD VDD VSS VSS gf180mcu_fd_sc_mcu7t5v0__clkinv_1
X_08850_ _10450_/Q _08847_/Z _08850_/Z VDD VDD VSS VSS gf180mcu_fd_sc_mcu7t5v0__and2_1
X_07801_ _09920_/A1 _07807_/A2 _07807_/B1 _07801_/B2 _10224_/D VDD VDD
+ VSS VSS gf180mcu_fd_sc_mcu7t5v0__oai22_1
X_08781_ _09193_/A1 _08789_/A2 _08789_/B1 VDD VDD VSS VSS gf180mcu_fd_sc_mcu7t5v0__nand2_2
X_05993_ _08619_/B _05988_/Z _05993_/B1 _09728_/A1 _05993_/C bus_rdata[0] VDD
+ VDD VSS VSS gf180mcu_fd_sc_mcu7t5v0__oai221_4
X_07732_ _09920_/A1 _07738_/A2 _07738_/B1 _07732_/B2 _10176_/D VDD VDD
+ VSS VSS gf180mcu_fd_sc_mcu7t5v0__oai22_1
X_07663_ _06058_/Z _07667_/A2 _07667_/B1 _07663_/B2 _10138_/D VDD VDD
+ VSS VSS gf180mcu_fd_sc_mcu7t5v0__oai22_1
X_09402_ _09861_/A1 _09412_/A2 _09411_/A2 VDD VDD VSS VSS gf180mcu_fd_sc_mcu7t5v0__nand2_4
X_06614_ _06682_/B _06598_/Z _06614_/B _06615_/A2 VDD VDD VSS VSS
+ gf180mcu_fd_sc_mcu7t5v0__aoi21_1
X_09333_ _09918_/A1 _09341_/A2 _09341_/B1 VDD VDD VSS VSS gf180mcu_fd_sc_mcu7t5v0__nand2_2
X_07594_ _07594_/A1 _07594_/A2 _07600_/B2 VDD VDD VSS VSS gf180mcu_fd_sc_mcu7t5v0__nor2_1
X_06545_ _06571_/A2 _08675_/A2 _06545_/B _10041_/D VDD VDD VSS VSS
+ gf180mcu_fd_sc_mcu7t5v0__aoi21_1
X_09264_ _06047_/Z _09271_/A2 _09271_/B1 _09264_/B2 _10755_/D VDD VDD
+ VSS VSS gf180mcu_fd_sc_mcu7t5v0__oai22_1
X_06476_ _06476_/A1 _06476_/A2 _06476_/B _06499_/A2 VDD VDD VSS VSS
+ gf180mcu_fd_sc_mcu7t5v0__oai21_1
X_05427_ _10526_/Q _08977_/B2 VDD VDD VSS VSS gf180mcu_fd_sc_mcu7t5v0__clkinv_1
X_08215_ _10974_/Q _08555_/A2 _08591_/A2 _10918_/Q _08584_/B1 _10750_/Q _08217_/A2
+ VDD VDD VSS VSS gf180mcu_fd_sc_mcu7t5v0__aoi222_2
X_09195_ _09940_/A1 _09201_/A2 _09201_/B1 _09195_/B2 _10700_/D VDD VDD
+ VSS VSS gf180mcu_fd_sc_mcu7t5v0__oai22_1
X_08146_ _08146_/A1 _08146_/A2 _08146_/A3 _08151_/A2 VDD VDD VSS VSS
+ gf180mcu_fd_sc_mcu7t5v0__nand3_1
X_05358_ _10034_/Q _06536_/B2 VDD VDD VSS VSS gf180mcu_fd_sc_mcu7t5v0__clkinv_1
X_05289_ _10804_/Q _09325_/B2 VDD VDD VSS VSS gf180mcu_fd_sc_mcu7t5v0__clkinv_1
X_08077_ _10708_/Q _08586_/A2 _08584_/A2 _10700_/Q _08077_/C _08078_/A3 VDD
+ VDD VSS VSS gf180mcu_fd_sc_mcu7t5v0__aoi221_1
X_07028_ _10081_/Q _10080_/Q _07217_/B1 VDD VDD VSS VSS gf180mcu_fd_sc_mcu7t5v0__nor2_4
X_08979_ _09924_/A1 _08981_/A2 _08981_/B1 _08979_/B2 _10528_/D VDD VDD
+ VSS VSS gf180mcu_fd_sc_mcu7t5v0__oai22_1
X_10941_ _10941_/D _11018_/CLK _10941_/Q VDD VDD VSS VSS gf180mcu_fd_sc_mcu7t5v0__dffq_1
X_10872_ _10872_/D _11142_/CLK _10872_/Q VDD VDD VSS VSS gf180mcu_fd_sc_mcu7t5v0__dffq_1
X_10306_ _10306_/D _11018_/CLK _10306_/Q VDD VDD VSS VSS gf180mcu_fd_sc_mcu7t5v0__dffq_1
X_10237_ _10237_/D _11101_/CLK _10237_/Q VDD VDD VSS VSS gf180mcu_fd_sc_mcu7t5v0__dffq_1
X_10168_ _10168_/D _11097_/CLK _10168_/Q VDD VDD VSS VSS gf180mcu_fd_sc_mcu7t5v0__dffq_1
X_10099_ _10099_/D _11052_/CLK _10099_/Q VDD VDD VSS VSS gf180mcu_fd_sc_mcu7t5v0__dffq_1
X_06330_ _06330_/A1 _06330_/A2 _06330_/B _06332_/B1 VDD VDD VSS VSS
+ gf180mcu_fd_sc_mcu7t5v0__oai21_1
X_06261_ _06964_/A1 _07601_/B _07603_/B _06261_/C _10009_/D VDD VDD VSS
+ VSS gf180mcu_fd_sc_mcu7t5v0__aoi211_1
X_05212_ _10500_/Q _08945_/B2 VDD VDD VSS VSS gf180mcu_fd_sc_mcu7t5v0__clkinv_1
X_08000_ _10061_/Q _08530_/A2 _08528_/B1 _09971_/Q _08001_/A3 VDD VDD
+ VSS VSS gf180mcu_fd_sc_mcu7t5v0__aoi22_1
X_06192_ _06470_/B _08675_/A2 _06192_/B _10006_/D VDD VDD VSS VSS
+ gf180mcu_fd_sc_mcu7t5v0__aoi21_1
X_05143_ _10191_/Q _07751_/B2 VDD VDD VSS VSS gf180mcu_fd_sc_mcu7t5v0__clkinv_1
X_09951_ _09951_/D _11039_/CLK _09951_/Q VDD VDD VSS VSS gf180mcu_fd_sc_mcu7t5v0__dffq_1
X_05074_ bus_addr[7] _07829_/C VDD VDD VSS VSS gf180mcu_fd_sc_mcu7t5v0__inv_3
X_08902_ _09925_/A1 _08903_/A2 _08903_/B1 _08902_/B2 _10473_/D VDD VDD
+ VSS VSS gf180mcu_fd_sc_mcu7t5v0__oai22_1
X_09882_ _06061_/Z _09888_/A2 _09882_/B _11138_/D VDD VDD VSS VSS
+ gf180mcu_fd_sc_mcu7t5v0__oai21_1
X_08833_ _08833_/A1 _10443_/Q _08833_/Z VDD VDD VSS VSS gf180mcu_fd_sc_mcu7t5v0__xor2_1
X_08764_ _09921_/A1 _08769_/A2 _08769_/B1 _08764_/B2 _10389_/D VDD VDD
+ VSS VSS gf180mcu_fd_sc_mcu7t5v0__oai22_1
X_05976_ _05976_/A1 _11071_/Q _11074_/Q _11073_/Q _05976_/Z VDD VDD VSS
+ VSS gf180mcu_fd_sc_mcu7t5v0__or4_1
X_07715_ _09940_/A1 _07727_/A2 _07715_/B _10168_/D VDD VDD VSS VSS
+ gf180mcu_fd_sc_mcu7t5v0__oai21_1
X_08695_ _10337_/Q _08698_/A2 _08696_/A2 VDD VDD VSS VSS gf180mcu_fd_sc_mcu7t5v0__nand2_1
X_07646_ _10129_/Q _07656_/A2 _07647_/B VDD VDD VSS VSS gf180mcu_fd_sc_mcu7t5v0__nand2_1
X_07577_ _07568_/Z _07576_/Z _07577_/Z VDD VDD VSS VSS gf180mcu_fd_sc_mcu7t5v0__xor2_1
X_09316_ _09921_/A1 _09321_/A2 _09321_/B1 _09316_/B2 _10797_/D VDD VDD
+ VSS VSS gf180mcu_fd_sc_mcu7t5v0__oai22_1
X_06528_ _06061_/Z _06531_/A2 _06531_/B1 _06528_/B2 _10028_/D VDD VDD
+ VSS VSS gf180mcu_fd_sc_mcu7t5v0__oai22_1
X_09247_ _06058_/Z _09251_/A2 _09251_/B1 _09247_/B2 _10742_/D VDD VDD
+ VSS VSS gf180mcu_fd_sc_mcu7t5v0__oai22_1
X_06459_ _06476_/A1 _06476_/A2 _06459_/Z VDD VDD VSS VSS gf180mcu_fd_sc_mcu7t5v0__xor2_1
X_09178_ _06061_/Z _09181_/A2 _09181_/B1 _09178_/B2 _10687_/D VDD VDD
+ VSS VSS gf180mcu_fd_sc_mcu7t5v0__oai22_1
X_08129_ _10901_/Q _08584_/A2 _08563_/C1 _10294_/Q _08564_/C1 _10137_/Q _08130_/A3
+ VDD VDD VSS VSS gf180mcu_fd_sc_mcu7t5v0__aoi222_2
X_11140_ _11140_/D _11165_/CLK _11140_/Q VDD VDD VSS VSS gf180mcu_fd_sc_mcu7t5v0__dffq_1
X_11071_ _11071_/D _11101_/CLK _11071_/Q VDD VDD VSS VSS gf180mcu_fd_sc_mcu7t5v0__dffq_1
X_10022_ _10022_/D _10905_/CLK _10022_/Q VDD VDD VSS VSS gf180mcu_fd_sc_mcu7t5v0__dffq_1
X_10924_ _10924_/D _11017_/CLK _10924_/Q VDD VDD VSS VSS gf180mcu_fd_sc_mcu7t5v0__dffq_1
X_10855_ _10855_/D _11165_/CLK _10855_/Q VDD VDD VSS VSS gf180mcu_fd_sc_mcu7t5v0__dffq_1
X_10786_ _10786_/D _11010_/CLK _10786_/Q VDD VDD VSS VSS gf180mcu_fd_sc_mcu7t5v0__dffq_1
X_05830_ _10498_/Q _08941_/B2 VDD VDD VSS VSS gf180mcu_fd_sc_mcu7t5v0__clkinv_1
X_05761_ _10657_/Q _09140_/B2 VDD VDD VSS VSS gf180mcu_fd_sc_mcu7t5v0__clkinv_1
X_07500_ _07635_/A1 _07480_/Z _07500_/B _07501_/A2 VDD VDD VSS VSS
+ gf180mcu_fd_sc_mcu7t5v0__aoi21_1
X_05692_ _10164_/Q _07707_/B2 VDD VDD VSS VSS gf180mcu_fd_sc_mcu7t5v0__clkinv_1
X_08480_ _10022_/Q _08586_/A2 _08584_/A2 _10905_/Q _08482_/A2 VDD VDD
+ VSS VSS gf180mcu_fd_sc_mcu7t5v0__aoi22_1
X_07431_ _07431_/A1 _07485_/A3 _07468_/B2 VDD VDD VSS VSS gf180mcu_fd_sc_mcu7t5v0__nor2_1
X_07362_ _10118_/Q _07557_/B2 _07362_/A3 _07362_/B _07471_/A2 VDD VDD
+ VSS VSS gf180mcu_fd_sc_mcu7t5v0__oai31_4
X_09101_ _09946_/A1 _09101_/A2 _09101_/B1 _09101_/B2 _10626_/D VDD VDD
+ VSS VSS gf180mcu_fd_sc_mcu7t5v0__oai22_1
X_06313_ _10011_/Q _06312_/Z _06313_/Z VDD VDD VSS VSS gf180mcu_fd_sc_mcu7t5v0__or2_1
X_07293_ _09946_/A1 _07293_/A2 _07293_/B _10105_/D VDD VDD VSS VSS
+ gf180mcu_fd_sc_mcu7t5v0__oai21_1
X_09032_ _09645_/A2 _09062_/A2 _09041_/A2 VDD VDD VSS VSS gf180mcu_fd_sc_mcu7t5v0__nand2_4
X_06244_ _06372_/B2 _06270_/A2 _06372_/C _06245_/B VDD VDD VSS VSS
+ gf180mcu_fd_sc_mcu7t5v0__aoi21_1
X_06175_ _10257_/Q _08675_/A2 _08674_/B _06176_/B VDD VDD VSS VSS
+ gf180mcu_fd_sc_mcu7t5v0__oai21_1
X_05126_ _10659_/Q _09144_/B2 VDD VDD VSS VSS gf180mcu_fd_sc_mcu7t5v0__clkinv_1
X_05057_ _10007_/Q _07628_/A1 VDD VDD VSS VSS gf180mcu_fd_sc_mcu7t5v0__clkinv_3
X_09934_ _09944_/A1 _09936_/A2 _09936_/B1 _09934_/B2 _11171_/D VDD VDD
+ VSS VSS gf180mcu_fd_sc_mcu7t5v0__oai22_1
X_09865_ _09893_/A1 _09870_/A2 _09870_/B1 _09865_/B2 _11128_/D VDD VDD
+ VSS VSS gf180mcu_fd_sc_mcu7t5v0__oai22_1
X_08816_ _06061_/Z _08819_/A2 _08819_/B1 _08816_/B2 _10431_/D VDD VDD
+ VSS VSS gf180mcu_fd_sc_mcu7t5v0__oai22_1
X_09796_ _10301_/Q _09796_/A2 _09817_/A2 VDD VDD VSS VSS gf180mcu_fd_sc_mcu7t5v0__nand2_4
X_08747_ _09896_/A1 _08749_/A2 _08749_/B1 _08747_/B2 _10376_/D VDD VDD
+ VSS VSS gf180mcu_fd_sc_mcu7t5v0__oai22_1
X_05959_ _10288_/Q _05954_/Z _09678_/A1 VDD VDD VSS VSS gf180mcu_fd_sc_mcu7t5v0__nand2_1
X_08678_ _08678_/A1 _08678_/A2 _09900_/B _10331_/D VDD VDD VSS VSS
+ gf180mcu_fd_sc_mcu7t5v0__aoi21_1
X_07629_ _07589_/B _07629_/A2 _07630_/A2 VDD VDD VSS VSS gf180mcu_fd_sc_mcu7t5v0__nand2_1
X_10640_ _10640_/D _10666_/CLK _10640_/Q VDD VDD VSS VSS gf180mcu_fd_sc_mcu7t5v0__dffq_1
X_10571_ _10571_/D _10666_/CLK _10571_/Q VDD VDD VSS VSS gf180mcu_fd_sc_mcu7t5v0__dffq_1
X_11123_ _11123_/D _11142_/CLK _11123_/Q VDD VDD VSS VSS gf180mcu_fd_sc_mcu7t5v0__dffq_1
X_11054_ _11054_/D _11097_/CLK _11054_/Q VDD VDD VSS VSS gf180mcu_fd_sc_mcu7t5v0__dffq_1
X_10005_ _10005_/D _11039_/CLK _10005_/Q VDD VDD VSS VSS gf180mcu_fd_sc_mcu7t5v0__dffq_4
X_10907_ _10907_/D _10978_/CLK _10907_/Q VDD VDD VSS VSS gf180mcu_fd_sc_mcu7t5v0__dffq_1
Xrepeater20 _08540_/A2 _08590_/A2 VDD VDD VSS VSS gf180mcu_fd_sc_mcu7t5v0__buf_16
Xrepeater53 _08514_/B _09599_/A1 VDD VDD VSS VSS gf180mcu_fd_sc_mcu7t5v0__buf_8
X_10838_ _10838_/D _11142_/CLK _10838_/Q VDD VDD VSS VSS gf180mcu_fd_sc_mcu7t5v0__dffq_1
Xrepeater31 _09529_/A1 _09941_/A1 VDD VDD VSS VSS gf180mcu_fd_sc_mcu7t5v0__buf_16
Xrepeater42 _09897_/A1 _09945_/A1 VDD VDD VSS VSS gf180mcu_fd_sc_mcu7t5v0__clkbuf_20
X_10769_ _10769_/D _11164_/CLK _10769_/Q VDD VDD VSS VSS gf180mcu_fd_sc_mcu7t5v0__dffq_1
X_07980_ _10771_/Q _08540_/A2 _08560_/B1 _10803_/Q _06112_/I _10787_/Q _07982_/A2
+ VDD VDD VSS VSS gf180mcu_fd_sc_mcu7t5v0__aoi222_2
X_06931_ _10323_/Q _07122_/B _10080_/Q _06967_/A3 VDD VDD VSS VSS
+ gf180mcu_fd_sc_mcu7t5v0__aoi21_4
X_09650_ _11037_/Q _09660_/A2 _09651_/B VDD VDD VSS VSS gf180mcu_fd_sc_mcu7t5v0__nand2_1
X_08601_ _06047_/Z _08608_/A2 _08608_/B1 _08601_/B2 _10292_/D VDD VDD
+ VSS VSS gf180mcu_fd_sc_mcu7t5v0__oai22_1
X_06862_ _06876_/A1 _06862_/A2 _06861_/Z _06862_/Z VDD VDD VSS VSS
+ gf180mcu_fd_sc_mcu7t5v0__xor3_1
X_09581_ _09920_/A1 _09587_/A2 _09587_/B1 _09581_/B2 _10996_/D VDD VDD
+ VSS VSS gf180mcu_fd_sc_mcu7t5v0__oai22_1
X_05813_ _10761_/Q _09270_/B2 VDD VDD VSS VSS gf180mcu_fd_sc_mcu7t5v0__clkinv_1
X_06793_ _06794_/A1 _06794_/A2 _06860_/A1 VDD VDD VSS VSS gf180mcu_fd_sc_mcu7t5v0__nor2_1
X_05744_ _10521_/Q _08970_/B2 VDD VDD VSS VSS gf180mcu_fd_sc_mcu7t5v0__clkinv_1
X_08532_ _10097_/Q _08532_/A2 _08532_/B _08533_/B1 VDD VDD VSS VSS
+ gf180mcu_fd_sc_mcu7t5v0__aoi21_1
X_08463_ _10961_/Q _06877_/Z _08584_/B1 _10753_/Q _07680_/I _10913_/Q _08466_/A1 VDD
+ VDD VSS VSS gf180mcu_fd_sc_mcu7t5v0__aoi222_2
X_07414_ _07370_/Z _07414_/A2 _07414_/B _07451_/A2 VDD VDD VSS VSS
+ gf180mcu_fd_sc_mcu7t5v0__oai21_1
X_05675_ _10058_/Q _06887_/B2 VDD VDD VSS VSS gf180mcu_fd_sc_mcu7t5v0__clkinv_1
X_08394_ _10840_/Q _08590_/A2 _08582_/A2 _10872_/Q _07680_/I _10864_/Q _08396_/A2
+ VDD VDD VSS VSS gf180mcu_fd_sc_mcu7t5v0__aoi222_1
X_07345_ _10116_/Q _10115_/Q _07367_/A2 VDD VDD VSS VSS gf180mcu_fd_sc_mcu7t5v0__nor2_1
X_07276_ _09861_/A1 _09523_/A2 _07293_/A2 VDD VDD VSS VSS gf180mcu_fd_sc_mcu7t5v0__nand2_2
X_09015_ _09920_/A1 _09021_/A2 _09021_/B1 _09015_/B2 _10556_/D VDD VDD
+ VSS VSS gf180mcu_fd_sc_mcu7t5v0__oai22_1
X_06227_ _10008_/Q _06257_/A2 _06258_/A1 VDD VDD VSS VSS gf180mcu_fd_sc_mcu7t5v0__nand2_1
X_06158_ _09990_/Q _06166_/A2 _06159_/B VDD VDD VSS VSS gf180mcu_fd_sc_mcu7t5v0__nand2_1
X_05109_ _10523_/Q _08974_/B2 VDD VDD VSS VSS gf180mcu_fd_sc_mcu7t5v0__clkinv_1
X_06089_ _06058_/Z _06093_/A2 _06093_/B1 _06089_/B2 _09958_/D VDD VDD
+ VSS VSS gf180mcu_fd_sc_mcu7t5v0__oai22_1
X_09917_ _09927_/A2 _09917_/A2 _09926_/A2 VDD VDD VSS VSS gf180mcu_fd_sc_mcu7t5v0__nand2_4
X_09848_ _09925_/A1 _09850_/A2 _09848_/B _11116_/D VDD VDD VSS VSS
+ gf180mcu_fd_sc_mcu7t5v0__oai21_1
X_09779_ _09755_/I _09778_/Z _11082_/D VDD VDD VSS VSS gf180mcu_fd_sc_mcu7t5v0__nor2_1
X_10623_ _10623_/D _10978_/CLK _10623_/Q VDD VDD VSS VSS gf180mcu_fd_sc_mcu7t5v0__dffq_1
X_10554_ _10554_/D _10978_/CLK _10554_/Q VDD VDD VSS VSS gf180mcu_fd_sc_mcu7t5v0__dffq_1
Xclkbuf_leaf_21_clk clkbuf_1_0_0_clk/Z _11097_/CLK VDD VDD VSS VSS
+ gf180mcu_fd_sc_mcu7t5v0__clkbuf_16
X_10485_ _10485_/D _11164_/CLK _10485_/Q VDD VDD VSS VSS gf180mcu_fd_sc_mcu7t5v0__dffq_1
X_11106_ _11106_/D _11109_/CLK _11106_/Q VDD VDD VSS VSS gf180mcu_fd_sc_mcu7t5v0__dffq_1
X_11037_ _11037_/D _11164_/CLK _11037_/Q VDD VDD VSS VSS gf180mcu_fd_sc_mcu7t5v0__dffq_1
X_05460_ _10998_/Q _09583_/B2 VDD VDD VSS VSS gf180mcu_fd_sc_mcu7t5v0__clkinv_1
X_05391_ _10773_/Q _09286_/B2 VDD VDD VSS VSS gf180mcu_fd_sc_mcu7t5v0__clkinv_1
Xclkbuf_leaf_12_clk clkbuf_opt_2_0_clk/Z _11109_/CLK VDD VDD VSS VSS
+ gf180mcu_fd_sc_mcu7t5v0__clkbuf_16
X_07130_ _07083_/Z _07084_/Z _07138_/A2 VDD VDD VSS VSS gf180mcu_fd_sc_mcu7t5v0__nand2_1
X_07061_ _10003_/Q _07206_/A2 _07062_/C VDD VDD VSS VSS gf180mcu_fd_sc_mcu7t5v0__nand2_1
X_06012_ _10287_/Q _07829_/C _06014_/B VDD VDD VSS VSS gf180mcu_fd_sc_mcu7t5v0__nand2_1
X_07963_ _10215_/Q _08573_/B1 _07680_/I _10223_/Q _07964_/I VDD VDD VSS
+ VSS gf180mcu_fd_sc_mcu7t5v0__aoi22_1
X_09702_ _11058_/Q _10289_/Q _09704_/A2 VDD VDD VSS VSS gf180mcu_fd_sc_mcu7t5v0__nand2_1
X_07894_ bus_wdata[1] _07905_/A2 _08654_/B _07895_/B VDD VDD VSS VSS
+ gf180mcu_fd_sc_mcu7t5v0__oai21_1
X_06914_ _10075_/Q _06916_/A2 _06915_/B VDD VDD VSS VSS gf180mcu_fd_sc_mcu7t5v0__nand2_1
X_09633_ _09921_/A1 _09643_/A2 _09633_/B _11029_/D VDD VDD VSS VSS
+ gf180mcu_fd_sc_mcu7t5v0__oai21_1
X_06845_ _10000_/Q _06869_/A2 _06857_/A1 VDD VDD VSS VSS gf180mcu_fd_sc_mcu7t5v0__nand2_1
X_09564_ _10985_/Q _09566_/A2 _09565_/B VDD VDD VSS VSS gf180mcu_fd_sc_mcu7t5v0__nand2_1
X_08515_ _08515_/I _10286_/D VDD VDD VSS VSS gf180mcu_fd_sc_mcu7t5v0__clkinv_1
X_06776_ _06776_/A1 _06776_/A2 _06776_/B _06828_/A2 VDD VDD VSS VSS
+ gf180mcu_fd_sc_mcu7t5v0__aoi21_1
X_09495_ _09920_/A1 _09501_/A2 _09501_/B1 _09495_/B2 _10940_/D VDD VDD
+ VSS VSS gf180mcu_fd_sc_mcu7t5v0__oai22_1
X_05727_ _10441_/Q _08828_/B2 VDD VDD VSS VSS gf180mcu_fd_sc_mcu7t5v0__clkinv_1
X_08446_ _08446_/A1 _08446_/A2 _08446_/A3 _08453_/A2 VDD VDD VSS VSS
+ gf180mcu_fd_sc_mcu7t5v0__nand3_1
X_05658_ _10680_/Q _09169_/B2 VDD VDD VSS VSS gf180mcu_fd_sc_mcu7t5v0__clkinv_1
X_08377_ _09861_/A2 _08377_/A2 _08377_/B1 _09442_/A1 _08388_/A3 VDD VDD
+ VSS VSS gf180mcu_fd_sc_mcu7t5v0__aoi22_1
X_05589_ _10296_/Q _08605_/B2 VDD VDD VSS VSS gf180mcu_fd_sc_mcu7t5v0__clkinv_1
X_07328_ _10118_/Q _10117_/Q _07328_/Z VDD VDD VSS VSS gf180mcu_fd_sc_mcu7t5v0__and2_1
X_07259_ _08532_/A2 _07809_/A2 _09900_/B _07274_/A2 VDD VDD VSS VSS
+ gf180mcu_fd_sc_mcu7t5v0__aoi21_4
X_10270_ _10270_/D _11052_/CLK _10270_/Q VDD VDD VSS VSS gf180mcu_fd_sc_mcu7t5v0__dffq_1
X_10606_ _10606_/D _10666_/CLK _10606_/Q VDD VDD VSS VSS gf180mcu_fd_sc_mcu7t5v0__dffq_1
X_10537_ _10537_/D _11109_/CLK _10537_/Q VDD VDD VSS VSS gf180mcu_fd_sc_mcu7t5v0__dffq_1
X_10468_ _10468_/D _11165_/CLK _10468_/Q VDD VDD VSS VSS gf180mcu_fd_sc_mcu7t5v0__dffq_1
X_10399_ _10399_/D _11018_/CLK _10399_/Q VDD VDD VSS VSS gf180mcu_fd_sc_mcu7t5v0__dffq_1
Xclkbuf_leaf_1_clk clkbuf_1_0_0_clk/Z _11176_/CLK VDD VDD VSS VSS
+ gf180mcu_fd_sc_mcu7t5v0__clkbuf_16
X_06630_ _10047_/Q _06629_/Z _06650_/A2 VDD VDD VSS VSS gf180mcu_fd_sc_mcu7t5v0__nor2_1
X_06561_ _10042_/Q _06571_/A2 _06570_/A2 VDD VDD VSS VSS gf180mcu_fd_sc_mcu7t5v0__nand2_2
X_09280_ _09925_/A1 _09281_/A2 _09281_/B1 _09280_/B2 _10769_/D VDD VDD
+ VSS VSS gf180mcu_fd_sc_mcu7t5v0__oai22_1
X_05512_ _10495_/Q _08938_/B2 VDD VDD VSS VSS gf180mcu_fd_sc_mcu7t5v0__clkinv_1
X_08300_ _08300_/A1 _08300_/A2 _08300_/A3 _08301_/B VDD VDD VSS VSS
+ gf180mcu_fd_sc_mcu7t5v0__nand3_1
X_06492_ _06492_/A1 _06492_/A2 _06491_/Z _06492_/Z VDD VDD VSS VSS
+ gf180mcu_fd_sc_mcu7t5v0__xor3_1
X_05443_ _10654_/Q _09137_/B2 VDD VDD VSS VSS gf180mcu_fd_sc_mcu7t5v0__clkinv_1
X_08231_ _11153_/Q _08444_/B1 _08877_/A2 _10462_/Q _08231_/C _08234_/A1 VDD
+ VDD VSS VSS gf180mcu_fd_sc_mcu7t5v0__aoi221_2
X_08162_ _09062_/A2 _08162_/A2 _08162_/B1 _09412_/A2 _08181_/A2 VDD VDD
+ VSS VSS gf180mcu_fd_sc_mcu7t5v0__aoi22_1
X_05374_ _10161_/Q _07704_/B2 VDD VDD VSS VSS gf180mcu_fd_sc_mcu7t5v0__clkinv_1
X_08093_ _08093_/A1 _08093_/A2 _08093_/A3 _08094_/B1 VDD VDD VSS VSS
+ gf180mcu_fd_sc_mcu7t5v0__nand3_2
X_07113_ _07207_/A1 _07113_/A2 _07113_/B _07114_/B VDD VDD VSS VSS
+ gf180mcu_fd_sc_mcu7t5v0__oai21_1
X_07044_ _07046_/A1 _07043_/Z _07045_/I VDD VDD VSS VSS gf180mcu_fd_sc_mcu7t5v0__nand2_1
X_08995_ _09920_/A1 _09001_/A2 _09001_/B1 _08995_/B2 _10540_/D VDD VDD
+ VSS VSS gf180mcu_fd_sc_mcu7t5v0__oai22_1
X_07946_ _08896_/B2 _08587_/B1 _08581_/A2 _08934_/B2 _07947_/C VDD VDD
+ VSS VSS gf180mcu_fd_sc_mcu7t5v0__oai22_1
X_07877_ bus_wdata[0] _07890_/A2 _08654_/B _07878_/B VDD VDD VSS VSS
+ gf180mcu_fd_sc_mcu7t5v0__oai21_1
X_09616_ _11022_/Q _09624_/A2 _09617_/B VDD VDD VSS VSS gf180mcu_fd_sc_mcu7t5v0__nand2_1
X_06828_ _06773_/Z _06828_/A2 _06827_/B _06834_/A1 VDD VDD VSS VSS
+ gf180mcu_fd_sc_mcu7t5v0__nor3_1
X_09547_ _09944_/A1 _09549_/A2 _09549_/B1 _09547_/B2 _10976_/D VDD VDD
+ VSS VSS gf180mcu_fd_sc_mcu7t5v0__oai22_1
X_06759_ _06750_/Z _06795_/A2 _06760_/B VDD VDD VSS VSS gf180mcu_fd_sc_mcu7t5v0__xor2_1
X_09478_ _06061_/Z _09481_/A2 _09481_/B1 _09478_/B2 _10927_/D VDD VDD
+ VSS VSS gf180mcu_fd_sc_mcu7t5v0__oai22_1
X_08429_ _08429_/A1 _08429_/A2 _08429_/A3 _08429_/A4 _08430_/A2 VDD VDD
+ VSS VSS gf180mcu_fd_sc_mcu7t5v0__nand4_2
X_10322_ _10322_/D _11052_/CLK _10322_/Q VDD VDD VSS VSS gf180mcu_fd_sc_mcu7t5v0__dffq_1
X_10253_ _10253_/D _11150_/CLK _10253_/Q VDD VDD VSS VSS gf180mcu_fd_sc_mcu7t5v0__dffq_1
X_10184_ _10184_/D _11181_/CLK _10184_/Q VDD VDD VSS VSS gf180mcu_fd_sc_mcu7t5v0__dffq_1
X_05090_ _10467_/Q _08896_/B2 VDD VDD VSS VSS gf180mcu_fd_sc_mcu7t5v0__clkinv_1
X_07800_ _06047_/Z _07807_/A2 _07807_/B1 _07800_/B2 _10223_/D VDD VDD
+ VSS VSS gf180mcu_fd_sc_mcu7t5v0__oai22_1
X_08780_ _09937_/A2 _08588_/B _08789_/A2 VDD VDD VSS VSS gf180mcu_fd_sc_mcu7t5v0__nand2_4
X_07731_ _06047_/Z _07738_/A2 _07738_/B1 _07731_/B2 _10175_/D VDD VDD
+ VSS VSS gf180mcu_fd_sc_mcu7t5v0__oai22_1
X_05992_ _11083_/Q _05986_/I _07906_/A2 _11051_/Q _05992_/C _05993_/B1 VDD VDD
+ VSS VSS gf180mcu_fd_sc_mcu7t5v0__aoi221_4
X_07662_ _09941_/A1 _07667_/A2 _07667_/B1 _07662_/B2 _10137_/D VDD VDD
+ VSS VSS gf180mcu_fd_sc_mcu7t5v0__oai22_1
X_09401_ _09926_/A1 _09401_/A2 _09401_/B1 _09401_/B2 _10866_/D VDD VDD
+ VSS VSS gf180mcu_fd_sc_mcu7t5v0__oai22_1
X_07593_ _07593_/A1 _07593_/A2 _07592_/B _07594_/A2 VDD VDD VSS VSS
+ gf180mcu_fd_sc_mcu7t5v0__nor3_1
X_06613_ _06606_/Z _06613_/A2 _06613_/B _06613_/C _06614_/B VDD VDD VSS
+ VSS gf180mcu_fd_sc_mcu7t5v0__aoi211_1
X_09332_ _09927_/A2 _09332_/A2 _09341_/A2 VDD VDD VSS VSS gf180mcu_fd_sc_mcu7t5v0__nand2_4
X_06544_ _10250_/Q _08675_/A2 _08674_/B _06545_/B VDD VDD VSS VSS
+ gf180mcu_fd_sc_mcu7t5v0__oai21_1
X_09263_ _09433_/A1 _09271_/A2 _09271_/B1 VDD VDD VSS VSS gf180mcu_fd_sc_mcu7t5v0__nand2_4
X_06475_ _06475_/A1 _06475_/A2 _07603_/B _10014_/D VDD VDD VSS VSS
+ gf180mcu_fd_sc_mcu7t5v0__aoi21_1
X_05426_ _10518_/Q _08967_/B2 VDD VDD VSS VSS gf180mcu_fd_sc_mcu7t5v0__clkinv_1
X_08214_ _10958_/Q _06877_/Z _07680_/I _10910_/Q _11129_/Q _08582_/A2 _08217_/A1 VDD
+ VDD VSS VSS gf180mcu_fd_sc_mcu7t5v0__aoi222_2
X_09194_ _06047_/Z _09201_/A2 _09201_/B1 _09194_/B2 _10699_/D VDD VDD
+ VSS VSS gf180mcu_fd_sc_mcu7t5v0__oai22_1
X_08145_ _10169_/Q _08528_/B1 _08563_/C1 _10153_/Q _08529_/B1 _10193_/Q _08146_/A3
+ VDD VDD VSS VSS gf180mcu_fd_sc_mcu7t5v0__aoi222_2
X_05357_ _10055_/Q _06884_/B2 VDD VDD VSS VSS gf180mcu_fd_sc_mcu7t5v0__clkinv_1
X_05288_ _10796_/Q _09315_/B2 VDD VDD VSS VSS gf180mcu_fd_sc_mcu7t5v0__clkinv_1
X_08076_ _09185_/B2 _08587_/B1 _08581_/A2 _09165_/B2 _08077_/C VDD VDD
+ VSS VSS gf180mcu_fd_sc_mcu7t5v0__oai22_1
X_07027_ _07070_/A1 _10011_/Q _07122_/B _07029_/A2 VDD VDD VSS VSS
+ gf180mcu_fd_sc_mcu7t5v0__oai21_2
X_08978_ _06061_/Z _08981_/A2 _08981_/B1 _08978_/B2 _10527_/D VDD VDD
+ VSS VSS gf180mcu_fd_sc_mcu7t5v0__oai22_1
X_07929_ _10555_/Q _06023_/I _08582_/A2 _10587_/Q _08584_/B1 _10595_/Q _07931_/A2
+ VDD VDD VSS VSS gf180mcu_fd_sc_mcu7t5v0__aoi222_1
X_10940_ _10940_/D _11017_/CLK _10940_/Q VDD VDD VSS VSS gf180mcu_fd_sc_mcu7t5v0__dffq_1
X_10871_ _10871_/D _11142_/CLK _10871_/Q VDD VDD VSS VSS gf180mcu_fd_sc_mcu7t5v0__dffq_1
X_10305_ _10305_/D _11018_/CLK _10305_/Q VDD VDD VSS VSS gf180mcu_fd_sc_mcu7t5v0__dffq_1
X_10236_ _10236_/D _11101_/CLK _10236_/Q VDD VDD VSS VSS gf180mcu_fd_sc_mcu7t5v0__dffq_1
X_10167_ _10167_/D _11097_/CLK _10167_/Q VDD VDD VSS VSS gf180mcu_fd_sc_mcu7t5v0__dffq_1
X_10098_ _10098_/D _11052_/CLK _10098_/Q VDD VDD VSS VSS gf180mcu_fd_sc_mcu7t5v0__dffq_1
X_06260_ _06260_/A1 _06260_/A2 _07601_/B _06261_/C VDD VDD VSS VSS
+ gf180mcu_fd_sc_mcu7t5v0__aoi21_1
X_05211_ _10356_/Q _08723_/B2 VDD VDD VSS VSS gf180mcu_fd_sc_mcu7t5v0__clkinv_1
X_06191_ _10337_/Q _08675_/A2 _08672_/B _06192_/B VDD VDD VSS VSS
+ gf180mcu_fd_sc_mcu7t5v0__oai21_1
X_05142_ _10995_/Q _09580_/B2 VDD VDD VSS VSS gf180mcu_fd_sc_mcu7t5v0__clkinv_1
X_09950_ _09950_/D _11039_/CLK _09950_/Q VDD VDD VSS VSS gf180mcu_fd_sc_mcu7t5v0__dffq_1
X_05073_ _09811_/B _09900_/B VDD VDD VSS VSS gf180mcu_fd_sc_mcu7t5v0__inv_20
X_08901_ _09896_/A1 _08903_/A2 _08903_/B1 _08901_/B2 _10472_/D VDD VDD
+ VSS VSS gf180mcu_fd_sc_mcu7t5v0__oai22_1
X_09881_ _11138_/Q _09887_/A2 _09882_/B VDD VDD VSS VSS gf180mcu_fd_sc_mcu7t5v0__nand2_1
X_08832_ _10443_/Q _08831_/I _10443_/D VDD VDD VSS VSS gf180mcu_fd_sc_mcu7t5v0__nor2_1
X_08763_ _09920_/A1 _08769_/A2 _08769_/B1 _08763_/B2 _10388_/D VDD VDD
+ VSS VSS gf180mcu_fd_sc_mcu7t5v0__oai22_1
X_05975_ _09811_/B _05975_/A2 _10303_/D VDD VDD VSS VSS gf180mcu_fd_sc_mcu7t5v0__and2_1
X_07714_ _10168_/Q _07726_/A2 _07715_/B VDD VDD VSS VSS gf180mcu_fd_sc_mcu7t5v0__nand2_1
X_08694_ _10286_/Q _08621_/I _08696_/A1 VDD VDD VSS VSS gf180mcu_fd_sc_mcu7t5v0__nand2_1
X_07645_ _09904_/A1 _07657_/A2 _07645_/B _10128_/D VDD VDD VSS VSS
+ gf180mcu_fd_sc_mcu7t5v0__oai21_1
X_07576_ _07576_/A1 _07575_/B _07576_/Z VDD VDD VSS VSS gf180mcu_fd_sc_mcu7t5v0__xor2_1
X_09315_ _09904_/A1 _09321_/A2 _09321_/B1 _09315_/B2 _10796_/D VDD VDD
+ VSS VSS gf180mcu_fd_sc_mcu7t5v0__oai22_1
X_06527_ _06058_/Z _06531_/A2 _06531_/B1 _06527_/B2 _10027_/D VDD VDD
+ VSS VSS gf180mcu_fd_sc_mcu7t5v0__oai22_1
X_09246_ _09893_/A1 _09251_/A2 _09251_/B1 _09246_/B2 _10741_/D VDD VDD
+ VSS VSS gf180mcu_fd_sc_mcu7t5v0__oai22_1
X_06458_ _10014_/Q _06456_/Z _06476_/A2 VDD VDD VSS VSS gf180mcu_fd_sc_mcu7t5v0__xnor2_1
X_05409_ _10438_/Q _08825_/B2 VDD VDD VSS VSS gf180mcu_fd_sc_mcu7t5v0__clkinv_1
X_09177_ _06058_/Z _09181_/A2 _09181_/B1 _09177_/B2 _10686_/D VDD VDD
+ VSS VSS gf180mcu_fd_sc_mcu7t5v0__oai22_1
X_06389_ _06389_/I _06399_/A1 VDD VDD VSS VSS gf180mcu_fd_sc_mcu7t5v0__clkinv_1
X_08128_ _10161_/Q _06023_/I _08586_/A2 _10018_/Q _08584_/B1 _10365_/Q _08130_/A2
+ VDD VDD VSS VSS gf180mcu_fd_sc_mcu7t5v0__aoi222_1
X_08059_ _11103_/Q _08559_/A2 _08589_/B1 _10892_/Q _08591_/B1 _10516_/Q _08062_/A1
+ VDD VDD VSS VSS gf180mcu_fd_sc_mcu7t5v0__aoi222_2
X_11070_ _11070_/D _11082_/CLK _11070_/Q VDD VDD VSS VSS gf180mcu_fd_sc_mcu7t5v0__dffq_1
X_10021_ _10021_/D _11176_/CLK _10021_/Q VDD VDD VSS VSS gf180mcu_fd_sc_mcu7t5v0__dffq_1
X_10923_ _10923_/D _11109_/CLK _10923_/Q VDD VDD VSS VSS gf180mcu_fd_sc_mcu7t5v0__dffq_1
X_10854_ _10854_/D _11165_/CLK _10854_/Q VDD VDD VSS VSS gf180mcu_fd_sc_mcu7t5v0__dffq_1
X_10785_ _10785_/D _11010_/CLK _10785_/Q VDD VDD VSS VSS gf180mcu_fd_sc_mcu7t5v0__dffq_1
X_10219_ _10219_/D _11147_/CLK _10219_/Q VDD VDD VSS VSS gf180mcu_fd_sc_mcu7t5v0__dffq_1
X_05760_ _10649_/Q _09130_/B2 VDD VDD VSS VSS gf180mcu_fd_sc_mcu7t5v0__clkinv_1
X_05691_ _10188_/Q _07746_/B2 VDD VDD VSS VSS gf180mcu_fd_sc_mcu7t5v0__clkinv_1
X_07430_ _07430_/A1 _07430_/A2 _07430_/B _07438_/A2 VDD VDD VSS VSS
+ gf180mcu_fd_sc_mcu7t5v0__aoi21_1
X_07361_ _10118_/Q _07361_/A2 _10117_/Q _07471_/A1 VDD VDD VSS VSS
+ gf180mcu_fd_sc_mcu7t5v0__aoi21_4
X_09100_ _09945_/A1 _09101_/A2 _09101_/B1 _09100_/B2 _10625_/D VDD VDD
+ VSS VSS gf180mcu_fd_sc_mcu7t5v0__oai22_1
X_06312_ _06312_/A1 _06312_/A2 _06312_/Z VDD VDD VSS VSS gf180mcu_fd_sc_mcu7t5v0__xor2_1
X_09031_ _09946_/A1 _09031_/A2 _09031_/B1 _09031_/B2 _10570_/D VDD VDD
+ VSS VSS gf180mcu_fd_sc_mcu7t5v0__oai22_1
X_07292_ _10105_/Q _07292_/A2 _07293_/B VDD VDD VSS VSS gf180mcu_fd_sc_mcu7t5v0__nand2_1
X_06243_ _10001_/Q _06446_/A2 _06270_/A2 VDD VDD VSS VSS gf180mcu_fd_sc_mcu7t5v0__nand2_2
X_06174_ _06222_/A1 _08675_/A2 _06174_/B _09997_/D VDD VDD VSS VSS
+ gf180mcu_fd_sc_mcu7t5v0__aoi21_1
X_05125_ _10651_/Q _09134_/B2 VDD VDD VSS VSS gf180mcu_fd_sc_mcu7t5v0__clkinv_1
X_05056_ _10008_/Q _06553_/A3 VDD VDD VSS VSS gf180mcu_fd_sc_mcu7t5v0__clkinv_2
X_09933_ _06061_/Z _09936_/A2 _09936_/B1 _09933_/B2 _11170_/D VDD VDD
+ VSS VSS gf180mcu_fd_sc_mcu7t5v0__oai22_1
X_09864_ _09920_/A1 _09870_/A2 _09870_/B1 _09864_/B2 _11127_/D VDD VDD
+ VSS VSS gf180mcu_fd_sc_mcu7t5v0__oai22_1
X_08815_ _06058_/Z _08819_/A2 _08819_/B1 _08815_/B2 _10430_/D VDD VDD
+ VSS VSS gf180mcu_fd_sc_mcu7t5v0__oai22_1
X_09795_ _09795_/A1 _09795_/A2 _09795_/B _11090_/D VDD VDD VSS VSS
+ gf180mcu_fd_sc_mcu7t5v0__aoi21_1
X_08746_ _06061_/Z _08749_/A2 _08749_/B1 _08746_/B2 _10375_/D VDD VDD
+ VSS VSS gf180mcu_fd_sc_mcu7t5v0__oai22_1
X_05958_ _05958_/A1 _05958_/A2 _10289_/D VDD VDD VSS VSS gf180mcu_fd_sc_mcu7t5v0__nand2_1
X_05889_ _10031_/Q _06531_/B2 VDD VDD VSS VSS gf180mcu_fd_sc_mcu7t5v0__clkinv_1
X_08677_ _10331_/Q _08698_/A2 _08678_/A2 VDD VDD VSS VSS gf180mcu_fd_sc_mcu7t5v0__nand2_1
X_07628_ _07628_/A1 _07606_/Z _07628_/Z VDD VDD VSS VSS gf180mcu_fd_sc_mcu7t5v0__xor2_1
X_07559_ _10000_/Q _07629_/A2 _07562_/A1 VDD VDD VSS VSS gf180mcu_fd_sc_mcu7t5v0__nand2_1
X_10570_ _10570_/D _10666_/CLK _10570_/Q VDD VDD VSS VSS gf180mcu_fd_sc_mcu7t5v0__dffq_1
X_09229_ _09896_/A1 _09231_/A2 _09231_/B1 _09229_/B2 _10728_/D VDD VDD
+ VSS VSS gf180mcu_fd_sc_mcu7t5v0__oai22_1
X_11122_ _11122_/D _11142_/CLK _11122_/Q VDD VDD VSS VSS gf180mcu_fd_sc_mcu7t5v0__dffq_1
X_11053_ _11053_/D _11097_/CLK _11053_/Q VDD VDD VSS VSS gf180mcu_fd_sc_mcu7t5v0__dffq_1
X_10004_ _10004_/D _10327_/CLK _10004_/Q VDD VDD VSS VSS gf180mcu_fd_sc_mcu7t5v0__dffq_4
X_10906_ _10906_/D _11176_/CLK _10906_/Q VDD VDD VSS VSS gf180mcu_fd_sc_mcu7t5v0__dffq_1
Xrepeater10 _09872_/A1 _06125_/I VDD VDD VSS VSS gf180mcu_fd_sc_mcu7t5v0__buf_16
X_10837_ _10837_/D _11142_/CLK _10837_/Q VDD VDD VSS VSS gf180mcu_fd_sc_mcu7t5v0__dffq_1
Xrepeater54 _08514_/B _09413_/A1 VDD VDD VSS VSS gf180mcu_fd_sc_mcu7t5v0__buf_8
Xrepeater21 _08560_/A2 _08540_/A2 VDD VDD VSS VSS gf180mcu_fd_sc_mcu7t5v0__buf_12
Xrepeater32 _09904_/A1 _09940_/A1 VDD VDD VSS VSS gf180mcu_fd_sc_mcu7t5v0__clkbuf_20
Xrepeater43 _09897_/A1 _09925_/A1 VDD VDD VSS VSS gf180mcu_fd_sc_mcu7t5v0__buf_16
X_10768_ _10768_/D _11164_/CLK _10768_/Q VDD VDD VSS VSS gf180mcu_fd_sc_mcu7t5v0__dffq_1
X_10699_ _10699_/D _10905_/CLK _10699_/Q VDD VDD VSS VSS gf180mcu_fd_sc_mcu7t5v0__dffq_1
X_06930_ _10119_/Q _07122_/B _06967_/A2 VDD VDD VSS VSS gf180mcu_fd_sc_mcu7t5v0__nor2_2
X_08600_ _08658_/B _08608_/A2 _08608_/B1 VDD VDD VSS VSS gf180mcu_fd_sc_mcu7t5v0__nand2_2
X_06861_ _06861_/A1 _06859_/Z _06860_/Z _06861_/Z VDD VDD VSS VSS
+ gf180mcu_fd_sc_mcu7t5v0__xor3_1
X_09580_ _06047_/Z _09587_/A2 _09587_/B1 _09580_/B2 _10995_/D VDD VDD
+ VSS VSS gf180mcu_fd_sc_mcu7t5v0__oai22_1
X_05812_ _10753_/Q _09260_/B2 VDD VDD VSS VSS gf180mcu_fd_sc_mcu7t5v0__clkinv_1
X_06792_ _06792_/A1 _06749_/Z _06792_/B _06794_/A2 VDD VDD VSS VSS
+ gf180mcu_fd_sc_mcu7t5v0__aoi21_1
X_05743_ _10513_/Q _08960_/B2 VDD VDD VSS VSS gf180mcu_fd_sc_mcu7t5v0__clkinv_1
X_08531_ _08531_/A1 _08531_/A2 _08531_/A3 _08532_/B VDD VDD VSS VSS
+ gf180mcu_fd_sc_mcu7t5v0__nand3_1
X_08462_ _09937_/A1 _08462_/A2 _08462_/B1 _09062_/A2 _08473_/A3 VDD VDD
+ VSS VSS gf180mcu_fd_sc_mcu7t5v0__aoi22_1
X_05674_ _10066_/Q _06897_/B2 VDD VDD VSS VSS gf180mcu_fd_sc_mcu7t5v0__clkinv_1
X_07413_ _07370_/Z _07414_/A2 _07414_/B _07413_/Z VDD VDD VSS VSS
+ gf180mcu_fd_sc_mcu7t5v0__or3_1
X_08393_ _10824_/Q _08580_/A2 _06125_/I _10848_/Q _08396_/A1 VDD VDD VSS
+ VSS gf180mcu_fd_sc_mcu7t5v0__aoi22_1
X_07344_ _07352_/A1 _10115_/Q _07353_/A3 _07545_/A1 VDD VDD VSS VSS
+ gf180mcu_fd_sc_mcu7t5v0__nand3_2
X_07275_ _09946_/A1 _07275_/A2 _07275_/B _10097_/D VDD VDD VSS VSS
+ gf180mcu_fd_sc_mcu7t5v0__oai21_1
X_09014_ _06047_/Z _09021_/A2 _09021_/B1 _09014_/B2 _10555_/D VDD VDD
+ VSS VSS gf180mcu_fd_sc_mcu7t5v0__oai22_1
X_06226_ _10312_/Q _08625_/A1 _07601_/B VDD VDD VSS VSS gf180mcu_fd_sc_mcu7t5v0__or2_4
X_06157_ _09921_/A1 _06167_/A2 _06157_/B _09989_/D VDD VDD VSS VSS
+ gf180mcu_fd_sc_mcu7t5v0__oai21_1
X_05108_ _10515_/Q _08964_/B2 VDD VDD VSS VSS gf180mcu_fd_sc_mcu7t5v0__clkinv_1
X_06088_ _09941_/A1 _06093_/A2 _06093_/B1 _06088_/B2 _09957_/D VDD VDD
+ VSS VSS gf180mcu_fd_sc_mcu7t5v0__oai22_1
X_09916_ _09916_/A1 _09916_/A2 _09916_/B _11157_/D VDD VDD VSS VSS
+ gf180mcu_fd_sc_mcu7t5v0__oai21_1
X_05039_ _10079_/Q _06952_/A1 VDD VDD VSS VSS gf180mcu_fd_sc_mcu7t5v0__clkinv_3
X_09847_ _11116_/Q _09849_/A2 _09848_/B VDD VDD VSS VSS gf180mcu_fd_sc_mcu7t5v0__nand2_1
X_09778_ _11082_/Q _09778_/A2 _09778_/Z VDD VDD VSS VSS gf180mcu_fd_sc_mcu7t5v0__xor2_1
X_08729_ _09832_/A1 _08729_/A2 _08729_/B1 _08729_/B2 _10362_/D VDD VDD
+ VSS VSS gf180mcu_fd_sc_mcu7t5v0__oai22_1
X_10622_ _10622_/D _10978_/CLK _10622_/Q VDD VDD VSS VSS gf180mcu_fd_sc_mcu7t5v0__dffq_1
X_10553_ _10553_/D _10978_/CLK _10553_/Q VDD VDD VSS VSS gf180mcu_fd_sc_mcu7t5v0__dffq_1
X_10484_ _10484_/D _11163_/CLK _10484_/Q VDD VDD VSS VSS gf180mcu_fd_sc_mcu7t5v0__dffq_1
X_11105_ _11105_/D _11109_/CLK _11105_/Q VDD VDD VSS VSS gf180mcu_fd_sc_mcu7t5v0__dffq_1
X_11036_ _11036_/D _11039_/CLK _11036_/Q VDD VDD VSS VSS gf180mcu_fd_sc_mcu7t5v0__dffq_1
X_05390_ _10765_/Q _09276_/B2 VDD VDD VSS VSS gf180mcu_fd_sc_mcu7t5v0__clkinv_1
X_07060_ _07247_/I1 _07231_/A1 _07206_/C _07062_/B1 VDD VDD VSS VSS
+ gf180mcu_fd_sc_mcu7t5v0__aoi21_1
X_06011_ _09728_/A1 _06011_/A2 _06011_/B bus_rdata[6] VDD VDD VSS VSS
+ gf180mcu_fd_sc_mcu7t5v0__oai21_4
X_07962_ _11142_/Q _08555_/A2 _08591_/A2 _10339_/Q _07966_/A2 VDD VDD
+ VSS VSS gf180mcu_fd_sc_mcu7t5v0__aoi22_1
X_09701_ _09678_/Z _09701_/A2 _09701_/B _11056_/D VDD VDD VSS VSS
+ gf180mcu_fd_sc_mcu7t5v0__aoi21_1
X_06913_ _09924_/A1 _06917_/A2 _06913_/B _10074_/D VDD VDD VSS VSS
+ gf180mcu_fd_sc_mcu7t5v0__oai21_1
X_07893_ _09679_/A1 _07905_/A2 _07893_/B _08654_/B _10266_/D VDD VDD VSS
+ VSS gf180mcu_fd_sc_mcu7t5v0__oai211_1
X_09632_ _11029_/Q _09642_/A2 _09633_/B VDD VDD VSS VSS gf180mcu_fd_sc_mcu7t5v0__nand2_1
X_06844_ _06844_/A1 _06844_/A2 _06869_/A2 VDD VDD VSS VSS gf180mcu_fd_sc_mcu7t5v0__nand2_2
X_09563_ _09924_/A1 _09567_/A2 _09563_/B _10984_/D VDD VDD VSS VSS
+ gf180mcu_fd_sc_mcu7t5v0__oai21_1
X_08514_ _08514_/A1 _08514_/A2 _08514_/B _08515_/I VDD VDD VSS VSS
+ gf180mcu_fd_sc_mcu7t5v0__oai21_1
X_06775_ _06776_/A1 _06776_/A2 _06776_/B _06778_/A1 VDD VDD VSS VSS
+ gf180mcu_fd_sc_mcu7t5v0__nand3_1
X_09494_ _06047_/Z _09501_/A2 _09501_/B1 _09494_/B2 _10939_/D VDD VDD
+ VSS VSS gf180mcu_fd_sc_mcu7t5v0__oai22_1
X_05726_ _10473_/Q _08902_/B2 VDD VDD VSS VSS gf180mcu_fd_sc_mcu7t5v0__clkinv_1
X_08445_ _10112_/Q _08580_/A2 _06125_/I _11140_/Q _08877_/A2 _10465_/Q _08446_/A3
+ VDD VDD VSS VSS gf180mcu_fd_sc_mcu7t5v0__aoi222_2
X_05657_ _10672_/Q _09159_/B2 VDD VDD VSS VSS gf180mcu_fd_sc_mcu7t5v0__clkinv_1
X_08376_ _08376_/A1 _08376_/A2 _08376_/A3 _08377_/B1 VDD VDD VSS VSS
+ gf180mcu_fd_sc_mcu7t5v0__nand3_1
X_05588_ _10903_/Q _09448_/B2 VDD VDD VSS VSS gf180mcu_fd_sc_mcu7t5v0__clkinv_1
X_07327_ _07557_/A1 _10117_/Q _10045_/Q _07368_/A1 VDD VDD VSS VSS
+ gf180mcu_fd_sc_mcu7t5v0__nand3_4
X_07258_ _07682_/A1 _08533_/B2 _08347_/A1 _07809_/A2 VDD VDD VSS VSS
+ gf180mcu_fd_sc_mcu7t5v0__nor3_4
X_06209_ _06222_/A1 _09996_/Q _06223_/A3 _06328_/A1 VDD VDD VSS VSS
+ gf180mcu_fd_sc_mcu7t5v0__nand3_2
X_07189_ _07170_/Z _07189_/A2 _07189_/Z VDD VDD VSS VSS gf180mcu_fd_sc_mcu7t5v0__xor2_1
X_10605_ _10605_/D _11176_/CLK _10605_/Q VDD VDD VSS VSS gf180mcu_fd_sc_mcu7t5v0__dffq_1
X_10536_ _10536_/D _11018_/CLK _10536_/Q VDD VDD VSS VSS gf180mcu_fd_sc_mcu7t5v0__dffq_1
X_10467_ _10467_/D _11165_/CLK _10467_/Q VDD VDD VSS VSS gf180mcu_fd_sc_mcu7t5v0__dffq_1
X_10398_ _10398_/D _11017_/CLK _10398_/Q VDD VDD VSS VSS gf180mcu_fd_sc_mcu7t5v0__dffq_1
X_11019_ _11019_/D _11039_/CLK _11019_/Q VDD VDD VSS VSS gf180mcu_fd_sc_mcu7t5v0__dffq_1
X_06560_ _10000_/Q _06557_/Z _06583_/A2 VDD VDD VSS VSS gf180mcu_fd_sc_mcu7t5v0__nand2_1
X_05511_ _10415_/Q _08796_/B2 VDD VDD VSS VSS gf180mcu_fd_sc_mcu7t5v0__clkinv_1
X_06491_ _06489_/Z _06490_/Z _06491_/Z VDD VDD VSS VSS gf180mcu_fd_sc_mcu7t5v0__xor2_1
X_05442_ _10646_/Q _09127_/B2 VDD VDD VSS VSS gf180mcu_fd_sc_mcu7t5v0__clkinv_1
X_08230_ _08230_/I _08231_/C VDD VDD VSS VSS gf180mcu_fd_sc_mcu7t5v0__clkinv_1
X_08161_ _08161_/A1 _08161_/A2 _08161_/A3 _08162_/B1 VDD VDD VSS VSS
+ gf180mcu_fd_sc_mcu7t5v0__nand3_1
X_05373_ _10185_/Q _07743_/B2 VDD VDD VSS VSS gf180mcu_fd_sc_mcu7t5v0__clkinv_1
X_08092_ _11143_/Q _08555_/A2 _08576_/B1 _10200_/Q _08093_/A3 VDD VDD
+ VSS VSS gf180mcu_fd_sc_mcu7t5v0__aoi22_1
X_07112_ _10004_/Q _07206_/A2 _07113_/A2 _07247_/I1 _07206_/C _07113_/B VDD
+ VDD VSS VSS gf180mcu_fd_sc_mcu7t5v0__aoi221_1
X_07043_ _07031_/I _07043_/A2 _07041_/B _07043_/Z VDD VDD VSS VSS
+ gf180mcu_fd_sc_mcu7t5v0__xor3_1
X_08994_ _06047_/Z _09001_/A2 _09001_/B1 _08994_/B2 _10539_/D VDD VDD
+ VSS VSS gf180mcu_fd_sc_mcu7t5v0__oai22_1
X_07945_ _10483_/Q _08590_/A2 _08591_/B1 _10427_/Q _07948_/A2 VDD VDD
+ VSS VSS gf180mcu_fd_sc_mcu7t5v0__aoi22_1
X_09615_ _09921_/A1 _09625_/A2 _09615_/B _11021_/D VDD VDD VSS VSS
+ gf180mcu_fd_sc_mcu7t5v0__oai21_1
X_07876_ bus_addr[2] _07876_/A2 _07906_/A3 _07890_/A2 VDD VDD VSS VSS
+ gf180mcu_fd_sc_mcu7t5v0__nand3_4
X_06827_ _06773_/Z _06828_/A2 _06827_/B _06864_/A2 VDD VDD VSS VSS
+ gf180mcu_fd_sc_mcu7t5v0__oai21_1
X_09546_ _06061_/Z _09549_/A2 _09549_/B1 _09546_/B2 _10975_/D VDD VDD
+ VSS VSS gf180mcu_fd_sc_mcu7t5v0__oai22_1
X_06758_ _06758_/A1 _06758_/A2 _06795_/A2 VDD VDD VSS VSS gf180mcu_fd_sc_mcu7t5v0__xnor2_1
X_09477_ _06058_/Z _09481_/A2 _09481_/B1 _09477_/B2 _10926_/D VDD VDD
+ VSS VSS gf180mcu_fd_sc_mcu7t5v0__oai22_1
X_05709_ _10776_/Q _09289_/B2 VDD VDD VSS VSS gf180mcu_fd_sc_mcu7t5v0__clkinv_1
X_08428_ _09568_/A2 _08428_/A2 _08428_/B1 _09062_/A2 _08429_/A4 VDD VDD
+ VSS VSS gf180mcu_fd_sc_mcu7t5v0__aoi22_1
X_06689_ _06696_/A2 _06689_/A2 _06689_/B _06714_/A1 VDD VDD VSS VSS
+ gf180mcu_fd_sc_mcu7t5v0__aoi21_2
X_08359_ _09645_/A1 _08359_/A2 _08359_/B1 _09142_/A2 _08388_/A1 VDD VDD
+ VSS VSS gf180mcu_fd_sc_mcu7t5v0__aoi22_1
X_10321_ _10321_/D _11052_/CLK _10321_/Q VDD VDD VSS VSS gf180mcu_fd_sc_mcu7t5v0__dffq_1
X_10252_ _10252_/D _11150_/CLK _10252_/Q VDD VDD VSS VSS gf180mcu_fd_sc_mcu7t5v0__dffq_1
X_10183_ _10183_/D _11181_/CLK _10183_/Q VDD VDD VSS VSS gf180mcu_fd_sc_mcu7t5v0__dffq_1
X_10519_ _10519_/D _11109_/CLK _10519_/Q VDD VDD VSS VSS gf180mcu_fd_sc_mcu7t5v0__dffq_1
X_07730_ _09918_/A1 _07738_/A2 _07738_/B1 VDD VDD VSS VSS gf180mcu_fd_sc_mcu7t5v0__nand2_2
X_05991_ bus_addr[0] _07865_/A2 _07906_/A2 VDD VDD VSS VSS gf180mcu_fd_sc_mcu7t5v0__nor2_4
X_07661_ _09940_/A1 _07667_/A2 _07667_/B1 _07661_/B2 _10136_/D VDD VDD
+ VSS VSS gf180mcu_fd_sc_mcu7t5v0__oai22_1
X_09400_ _09945_/A1 _09401_/A2 _09401_/B1 _09400_/B2 _10865_/D VDD VDD
+ VSS VSS gf180mcu_fd_sc_mcu7t5v0__oai22_1
X_07592_ _07593_/A1 _07593_/A2 _07592_/B _07625_/B VDD VDD VSS VSS
+ gf180mcu_fd_sc_mcu7t5v0__oai21_1
X_06612_ _06832_/A1 _06627_/A1 _06612_/B1 _06612_/B2 _06612_/C _06613_/C VDD
+ VDD VSS VSS gf180mcu_fd_sc_mcu7t5v0__oai221_1
X_09331_ _09916_/A1 _09331_/A2 _09331_/B1 _09331_/B2 _10810_/D VDD VDD
+ VSS VSS gf180mcu_fd_sc_mcu7t5v0__oai22_1
X_06543_ _06579_/A3 _08675_/A2 _06543_/B _10040_/D VDD VDD VSS VSS
+ gf180mcu_fd_sc_mcu7t5v0__aoi21_1
X_09262_ _09889_/A1 _09332_/A2 _09271_/A2 VDD VDD VSS VSS gf180mcu_fd_sc_mcu7t5v0__nand2_4
X_06474_ _06228_/B _06459_/Z _06474_/B _07636_/B _06475_/A2 VDD VDD VSS
+ VSS gf180mcu_fd_sc_mcu7t5v0__oai211_1
X_05425_ _10510_/Q _08957_/B2 VDD VDD VSS VSS gf180mcu_fd_sc_mcu7t5v0__clkinv_1
X_08213_ _08213_/A1 _08213_/A2 _08213_/A3 _08222_/A2 VDD VDD VSS VSS
+ gf180mcu_fd_sc_mcu7t5v0__nand3_2
X_09193_ _09193_/A1 _09201_/A2 _09201_/B1 VDD VDD VSS VSS gf180mcu_fd_sc_mcu7t5v0__nand2_2
X_05356_ _10063_/Q _06894_/B2 VDD VDD VSS VSS gf180mcu_fd_sc_mcu7t5v0__clkinv_1
X_08144_ _10209_/Q _08528_/A2 _08586_/A2 _10100_/Q _08532_/A2 _10092_/Q _08146_/A2
+ VDD VDD VSS VSS gf180mcu_fd_sc_mcu7t5v0__aoi222_2
X_05287_ _10788_/Q _09305_/B2 VDD VDD VSS VSS gf180mcu_fd_sc_mcu7t5v0__clkinv_1
X_08075_ _10684_/Q _06023_/I _08584_/B1 _10716_/Q _08078_/A2 VDD VDD VSS
+ VSS gf180mcu_fd_sc_mcu7t5v0__aoi22_1
X_07026_ _10122_/Q _07025_/Z _07029_/A1 VDD VDD VSS VSS gf180mcu_fd_sc_mcu7t5v0__nand2_1
X_08977_ _06058_/Z _08981_/A2 _08981_/B1 _08977_/B2 _10526_/D VDD VDD
+ VSS VSS gf180mcu_fd_sc_mcu7t5v0__oai22_1
X_07928_ _10539_/Q _08555_/A2 _08589_/B1 _10547_/Q _07931_/A1 VDD VDD
+ VSS VSS gf180mcu_fd_sc_mcu7t5v0__aoi22_1
X_07859_ _10251_/Q _07864_/A2 _07860_/B VDD VDD VSS VSS gf180mcu_fd_sc_mcu7t5v0__nor2_1
X_10870_ _10870_/D _11165_/CLK _10870_/Q VDD VDD VSS VSS gf180mcu_fd_sc_mcu7t5v0__dffq_1
X_09529_ _09529_/A1 _09539_/A2 _09529_/B _10965_/D VDD VDD VSS VSS
+ gf180mcu_fd_sc_mcu7t5v0__oai21_1
X_10304_ _10304_/D _11018_/CLK _10304_/Q VDD VDD VSS VSS gf180mcu_fd_sc_mcu7t5v0__dffq_1
X_10235_ _10235_/D _11101_/CLK _10235_/Q VDD VDD VSS VSS gf180mcu_fd_sc_mcu7t5v0__dffq_1
X_10166_ _10166_/D _11176_/CLK _10166_/Q VDD VDD VSS VSS gf180mcu_fd_sc_mcu7t5v0__dffq_1
X_10097_ _10097_/D _10905_/CLK _10097_/Q VDD VDD VSS VSS gf180mcu_fd_sc_mcu7t5v0__dffq_1
X_10999_ _10999_/D _11147_/CLK _10999_/Q VDD VDD VSS VSS gf180mcu_fd_sc_mcu7t5v0__dffq_1
X_05210_ _10892_/Q _09435_/B2 VDD VDD VSS VSS gf180mcu_fd_sc_mcu7t5v0__clkinv_1
X_06190_ _06420_/B _08675_/A2 _06190_/B _10005_/D VDD VDD VSS VSS
+ gf180mcu_fd_sc_mcu7t5v0__aoi21_1
X_05141_ _11011_/Q _09600_/B2 VDD VDD VSS VSS gf180mcu_fd_sc_mcu7t5v0__clkinv_1
X_05072_ bus_addr[5] _07829_/A2 VDD VDD VSS VSS gf180mcu_fd_sc_mcu7t5v0__inv_1
X_08900_ _06061_/Z _08903_/A2 _08903_/B1 _08900_/B2 _10471_/D VDD VDD
+ VSS VSS gf180mcu_fd_sc_mcu7t5v0__oai22_1
X_09880_ _06058_/Z _09888_/A2 _09880_/B _11137_/D VDD VDD VSS VSS
+ gf180mcu_fd_sc_mcu7t5v0__oai21_1
X_08831_ _08831_/I _08872_/B VDD VDD VSS VSS gf180mcu_fd_sc_mcu7t5v0__clkinv_2
X_08762_ _06047_/Z _08769_/A2 _08769_/B1 _08762_/B2 _10387_/D VDD VDD
+ VSS VSS gf180mcu_fd_sc_mcu7t5v0__oai22_1
X_05974_ _05974_/A1 _09796_/A2 _05983_/A2 _09813_/A1 _05975_/A2 VDD VDD
+ VSS VSS gf180mcu_fd_sc_mcu7t5v0__oai22_1
X_07713_ _06047_/Z _07727_/A2 _07713_/B _10167_/D VDD VDD VSS VSS
+ gf180mcu_fd_sc_mcu7t5v0__oai21_1
X_08693_ _08693_/A1 _08693_/A2 _09900_/B _10336_/D VDD VDD VSS VSS
+ gf180mcu_fd_sc_mcu7t5v0__aoi21_1
X_07644_ _10128_/Q _07656_/A2 _07645_/B VDD VDD VSS VSS gf180mcu_fd_sc_mcu7t5v0__nand2_1
X_07575_ _07569_/B _07525_/Z _07575_/B _07615_/B VDD VDD VSS VSS gf180mcu_fd_sc_mcu7t5v0__oai21_1
X_09314_ _06047_/Z _09321_/A2 _09321_/B1 _09314_/B2 _10795_/D VDD VDD
+ VSS VSS gf180mcu_fd_sc_mcu7t5v0__oai22_1
X_06526_ _09941_/A1 _06531_/A2 _06531_/B1 _06526_/B2 _10026_/D VDD VDD
+ VSS VSS gf180mcu_fd_sc_mcu7t5v0__oai22_1
X_09245_ _09920_/A1 _09251_/A2 _09251_/B1 _09245_/B2 _10740_/D VDD VDD
+ VSS VSS gf180mcu_fd_sc_mcu7t5v0__oai22_1
X_06457_ _10014_/Q _06456_/Z _06476_/B VDD VDD VSS VSS gf180mcu_fd_sc_mcu7t5v0__nand2_1
X_05408_ _10470_/Q _08899_/B2 VDD VDD VSS VSS gf180mcu_fd_sc_mcu7t5v0__clkinv_1
X_09176_ _09941_/A1 _09181_/A2 _09181_/B1 _09176_/B2 _10685_/D VDD VDD
+ VSS VSS gf180mcu_fd_sc_mcu7t5v0__oai22_1
X_06388_ _06388_/A1 _06434_/B2 _06493_/A1 _06389_/I VDD VDD VSS VSS
+ gf180mcu_fd_sc_mcu7t5v0__xor3_1
X_05339_ _10669_/Q _09156_/B2 VDD VDD VSS VSS gf180mcu_fd_sc_mcu7t5v0__clkinv_1
X_08127_ _09957_/Q _08563_/A2 _06877_/Z _10185_/Q _08130_/A1 VDD VDD VSS
+ VSS gf180mcu_fd_sc_mcu7t5v0__aoi22_1
X_08058_ _08058_/A1 _08058_/A2 _08058_/A3 _08095_/B1 VDD VDD VSS VSS
+ gf180mcu_fd_sc_mcu7t5v0__nand3_1
X_07009_ _07221_/A2 _07011_/A3 _07009_/Z VDD VDD VSS VSS gf180mcu_fd_sc_mcu7t5v0__xor2_1
X_10020_ _10020_/D _10905_/CLK _10020_/Q VDD VDD VSS VSS gf180mcu_fd_sc_mcu7t5v0__dffq_1
X_10922_ _10922_/D _10978_/CLK _10922_/Q VDD VDD VSS VSS gf180mcu_fd_sc_mcu7t5v0__dffq_1
X_10853_ _10853_/D _11165_/CLK _10853_/Q VDD VDD VSS VSS gf180mcu_fd_sc_mcu7t5v0__dffq_1
X_10784_ _10784_/D _11010_/CLK _10784_/Q VDD VDD VSS VSS gf180mcu_fd_sc_mcu7t5v0__dffq_1
X_10218_ _10218_/D _11147_/CLK _10218_/Q VDD VDD VSS VSS gf180mcu_fd_sc_mcu7t5v0__dffq_1
X_10149_ _10149_/D _11164_/CLK _10149_/Q VDD VDD VSS VSS gf180mcu_fd_sc_mcu7t5v0__dffq_1
X_05690_ _09960_/Q _06091_/B2 VDD VDD VSS VSS gf180mcu_fd_sc_mcu7t5v0__clkinv_1
X_07360_ _10332_/Q _10118_/Q _10117_/Q _07362_/B VDD VDD VSS VSS gf180mcu_fd_sc_mcu7t5v0__nand3_2
X_06311_ _06312_/A1 _06312_/A2 _06311_/Z VDD VDD VSS VSS gf180mcu_fd_sc_mcu7t5v0__and2_1
X_09030_ _09945_/A1 _09031_/A2 _09031_/B1 _09030_/B2 _10569_/D VDD VDD
+ VSS VSS gf180mcu_fd_sc_mcu7t5v0__oai22_1
X_07291_ _09537_/A1 _07293_/A2 _07291_/B _10104_/D VDD VDD VSS VSS
+ gf180mcu_fd_sc_mcu7t5v0__oai21_1
X_06242_ _10001_/Q _06276_/A1 _06239_/Z _06242_/Z VDD VDD VSS VSS
+ gf180mcu_fd_sc_mcu7t5v0__xor3_1
X_06173_ _10256_/Q _08675_/A2 rst_n _06174_/B VDD VDD VSS VSS gf180mcu_fd_sc_mcu7t5v0__oai21_1
X_05124_ _10643_/Q _09124_/B2 VDD VDD VSS VSS gf180mcu_fd_sc_mcu7t5v0__clkinv_1
X_05055_ _10009_/Q _06964_/A1 VDD VDD VSS VSS gf180mcu_fd_sc_mcu7t5v0__inv_3
X_09932_ _06058_/Z _09936_/A2 _09936_/B1 _09932_/B2 _11169_/D VDD VDD
+ VSS VSS gf180mcu_fd_sc_mcu7t5v0__oai22_1
X_09863_ _06047_/Z _09870_/A2 _09870_/B1 _09863_/B2 _11126_/D VDD VDD
+ VSS VSS gf180mcu_fd_sc_mcu7t5v0__oai22_1
X_08814_ _09921_/A1 _08819_/A2 _08819_/B1 _08814_/B2 _10429_/D VDD VDD
+ VSS VSS gf180mcu_fd_sc_mcu7t5v0__oai22_1
X_09794_ _11098_/Q _09795_/A2 _09809_/B _09795_/B VDD VDD VSS VSS
+ gf180mcu_fd_sc_mcu7t5v0__oai21_1
X_08745_ _06058_/Z _08749_/A2 _08749_/B1 _08745_/B2 _10374_/D VDD VDD
+ VSS VSS gf180mcu_fd_sc_mcu7t5v0__oai22_1
X_05957_ _09809_/B _10290_/Q _05942_/Z _05958_/A2 VDD VDD VSS VSS
+ gf180mcu_fd_sc_mcu7t5v0__nand3_1
X_08676_ _10280_/Q _08621_/I _08678_/A1 VDD VDD VSS VSS gf180mcu_fd_sc_mcu7t5v0__nand2_1
X_05888_ _10039_/Q _06541_/B2 VDD VDD VSS VSS gf180mcu_fd_sc_mcu7t5v0__clkinv_1
X_07627_ _10007_/Q _07606_/Z _07632_/S VDD VDD VSS VSS gf180mcu_fd_sc_mcu7t5v0__nand2_1
X_07558_ _08673_/A1 _07332_/C _07558_/B1 _07558_/B2 _07629_/A2 VDD VDD
+ VSS VSS gf180mcu_fd_sc_mcu7t5v0__aoi22_4
X_06509_ _06509_/A1 _06498_/Z _06504_/Z _06509_/B2 _06509_/C _06510_/A2 VDD
+ VDD VSS VSS gf180mcu_fd_sc_mcu7t5v0__oai221_1
X_07489_ _07489_/I _07542_/A1 VDD VDD VSS VSS gf180mcu_fd_sc_mcu7t5v0__clkinv_1
X_09228_ _06061_/Z _09231_/A2 _09231_/B1 _09228_/B2 _10727_/D VDD VDD
+ VSS VSS gf180mcu_fd_sc_mcu7t5v0__oai22_1
X_09159_ _09884_/A1 _09161_/A2 _09161_/B1 _09159_/B2 _10672_/D VDD VDD
+ VSS VSS gf180mcu_fd_sc_mcu7t5v0__oai22_1
X_11121_ _11121_/D _11147_/CLK _11121_/Q VDD VDD VSS VSS gf180mcu_fd_sc_mcu7t5v0__dffq_1
X_11052_ _11052_/D _11052_/CLK _11052_/Q VDD VDD VSS VSS gf180mcu_fd_sc_mcu7t5v0__dffq_1
X_10003_ _10003_/D _11150_/CLK _10003_/Q VDD VDD VSS VSS gf180mcu_fd_sc_mcu7t5v0__dffq_4
X_10905_ _10905_/D _10905_/CLK _10905_/Q VDD VDD VSS VSS gf180mcu_fd_sc_mcu7t5v0__dffq_1
X_10836_ _10836_/D _11142_/CLK _10836_/Q VDD VDD VSS VSS gf180mcu_fd_sc_mcu7t5v0__dffq_1
Xrepeater11 _09872_/A1 _08591_/C1 VDD VDD VSS VSS gf180mcu_fd_sc_mcu7t5v0__buf_12
Xrepeater33 _09904_/A1 _09920_/A1 VDD VDD VSS VSS gf180mcu_fd_sc_mcu7t5v0__buf_16
Xrepeater22 _08560_/A2 _08528_/A2 VDD VDD VSS VSS gf180mcu_fd_sc_mcu7t5v0__buf_12
Xrepeater44 _09537_/A1 _09897_/A1 VDD VDD VSS VSS gf180mcu_fd_sc_mcu7t5v0__buf_16
Xrepeater55 _09918_/A1 _09824_/A1 VDD VDD VSS VSS gf180mcu_fd_sc_mcu7t5v0__buf_8
X_10767_ _10767_/D _11164_/CLK _10767_/Q VDD VDD VSS VSS gf180mcu_fd_sc_mcu7t5v0__dffq_1
X_10698_ _10698_/D _11139_/CLK _10698_/Q VDD VDD VSS VSS gf180mcu_fd_sc_mcu7t5v0__dffq_1
X_06860_ _06860_/A1 _06860_/A2 _06860_/Z VDD VDD VSS VSS gf180mcu_fd_sc_mcu7t5v0__xor2_1
X_05811_ _11132_/Q _09869_/B2 VDD VDD VSS VSS gf180mcu_fd_sc_mcu7t5v0__clkinv_1
X_06791_ _10000_/Q _06867_/A2 _06794_/A1 VDD VDD VSS VSS gf180mcu_fd_sc_mcu7t5v0__nand2_1
X_05742_ _10505_/Q _08950_/B2 VDD VDD VSS VSS gf180mcu_fd_sc_mcu7t5v0__clkinv_1
X_08530_ _10970_/Q _08530_/A2 _06877_/Z _10238_/Q _08563_/C1 _10158_/Q _08531_/A3
+ VDD VDD VSS VSS gf180mcu_fd_sc_mcu7t5v0__aoi222_2
X_08461_ _08461_/A1 _08461_/A2 _08461_/A3 _08462_/B1 VDD VDD VSS VSS
+ gf180mcu_fd_sc_mcu7t5v0__nand3_1
X_05673_ _10196_/Q _07756_/B2 VDD VDD VSS VSS gf180mcu_fd_sc_mcu7t5v0__clkinv_1
X_07412_ _10002_/Q _07485_/A3 _07412_/A3 _07414_/B VDD VDD VSS VSS
+ gf180mcu_fd_sc_mcu7t5v0__xor3_1
X_08392_ _08392_/A1 _08392_/A2 _08392_/A3 _08397_/A2 VDD VDD VSS VSS
+ gf180mcu_fd_sc_mcu7t5v0__nand3_1
X_07343_ _10116_/Q _07352_/A2 _07632_/I0 VDD VDD VSS VSS gf180mcu_fd_sc_mcu7t5v0__nor2_2
X_07274_ _10097_/Q _07274_/A2 _07275_/B VDD VDD VSS VSS gf180mcu_fd_sc_mcu7t5v0__nand2_1
X_09013_ _09413_/A1 _09021_/A2 _09021_/B1 VDD VDD VSS VSS gf180mcu_fd_sc_mcu7t5v0__nand2_2
X_06225_ _10312_/Q _08625_/A1 _07636_/B VDD VDD VSS VSS gf180mcu_fd_sc_mcu7t5v0__nor2_4
X_06156_ _09989_/Q _06166_/A2 _06157_/B VDD VDD VSS VSS gf180mcu_fd_sc_mcu7t5v0__nand2_1
X_05107_ _10507_/Q _08954_/B2 VDD VDD VSS VSS gf180mcu_fd_sc_mcu7t5v0__clkinv_1
X_06087_ _09940_/A1 _06093_/A2 _06093_/B1 _06087_/B2 _09956_/D VDD VDD
+ VSS VSS gf180mcu_fd_sc_mcu7t5v0__oai22_1
X_09915_ _11157_/Q _09915_/A2 _09916_/B VDD VDD VSS VSS gf180mcu_fd_sc_mcu7t5v0__nand2_1
X_05038_ _10080_/Q _07070_/A1 VDD VDD VSS VSS gf180mcu_fd_sc_mcu7t5v0__clkinv_3
X_09846_ _09924_/A1 _09850_/A2 _09846_/B _11115_/D VDD VDD VSS VSS
+ gf180mcu_fd_sc_mcu7t5v0__oai21_1
X_09777_ _11081_/Q _09772_/Z _09777_/B _11081_/D VDD VDD VSS VSS gf180mcu_fd_sc_mcu7t5v0__aoi21_1
X_06989_ _07019_/C _06989_/A2 _06989_/B1 _06989_/B2 _07601_/B _06990_/C VDD
+ VDD VSS VSS gf180mcu_fd_sc_mcu7t5v0__aoi221_1
X_08728_ _09925_/A1 _08729_/A2 _08729_/B1 _08728_/B2 _10361_/D VDD VDD
+ VSS VSS gf180mcu_fd_sc_mcu7t5v0__oai22_1
X_08659_ _08659_/A1 _08659_/A2 _08659_/B _10322_/D VDD VDD VSS VSS
+ gf180mcu_fd_sc_mcu7t5v0__aoi21_1
X_10621_ _10621_/D _10978_/CLK _10621_/Q VDD VDD VSS VSS gf180mcu_fd_sc_mcu7t5v0__dffq_1
X_10552_ _10552_/D _11142_/CLK _10552_/Q VDD VDD VSS VSS gf180mcu_fd_sc_mcu7t5v0__dffq_1
X_10483_ _10483_/D _11165_/CLK _10483_/Q VDD VDD VSS VSS gf180mcu_fd_sc_mcu7t5v0__dffq_1
X_11104_ _11104_/D _11109_/CLK _11104_/Q VDD VDD VSS VSS gf180mcu_fd_sc_mcu7t5v0__dffq_1
X_11035_ _11035_/D _11164_/CLK _11035_/Q VDD VDD VSS VSS gf180mcu_fd_sc_mcu7t5v0__dffq_1
X_10819_ _10819_/D _11138_/CLK _10819_/Q VDD VDD VSS VSS gf180mcu_fd_sc_mcu7t5v0__dffq_1
X_06010_ _11058_/Q _07876_/A2 _05986_/I _11089_/Q _06011_/A2 VDD VDD VSS
+ VSS gf180mcu_fd_sc_mcu7t5v0__aoi22_2
X_07961_ _10347_/Q _06125_/I _08589_/B1 _11118_/Q _07966_/A1 VDD VDD VSS
+ VSS gf180mcu_fd_sc_mcu7t5v0__aoi22_1
X_06912_ _10074_/Q _06916_/A2 _06913_/B VDD VDD VSS VSS gf180mcu_fd_sc_mcu7t5v0__nand2_1
X_09700_ _11056_/Q _09678_/Z rst_n _09701_/B VDD VDD VSS VSS gf180mcu_fd_sc_mcu7t5v0__oai21_1
X_07892_ _10266_/Q _07905_/A2 _07893_/B VDD VDD VSS VSS gf180mcu_fd_sc_mcu7t5v0__nand2_1
X_09631_ _09904_/A1 _09643_/A2 _09631_/B _11028_/D VDD VDD VSS VSS
+ gf180mcu_fd_sc_mcu7t5v0__oai21_1
X_06843_ _10015_/Q _06843_/A2 _06843_/B1 _10126_/Q _06844_/A2 VDD VDD
+ VSS VSS gf180mcu_fd_sc_mcu7t5v0__aoi22_1
X_09562_ _10984_/Q _09566_/A2 _09563_/B VDD VDD VSS VSS gf180mcu_fd_sc_mcu7t5v0__nand2_1
X_06774_ _06420_/B _06772_/Z _06776_/B VDD VDD VSS VSS gf180mcu_fd_sc_mcu7t5v0__xor2_1
X_05725_ _10489_/Q _08930_/B2 VDD VDD VSS VSS gf180mcu_fd_sc_mcu7t5v0__clkinv_1
X_08513_ _08513_/A1 _08513_/A2 _08513_/A3 _08513_/A4 _08514_/A2 VDD VDD
+ VSS VSS gf180mcu_fd_sc_mcu7t5v0__nand4_1
X_09493_ _09824_/A1 _09501_/A2 _09501_/B1 VDD VDD VSS VSS gf180mcu_fd_sc_mcu7t5v0__nand2_4
X_05656_ _10664_/Q _09149_/B2 VDD VDD VSS VSS gf180mcu_fd_sc_mcu7t5v0__clkinv_1
X_08444_ _09993_/Q _08560_/A2 _08444_/B1 _11156_/Q _07255_/I _11116_/Q _08446_/A2
+ VDD VDD VSS VSS gf180mcu_fd_sc_mcu7t5v0__aoi222_2
X_08375_ _09960_/Q _08563_/A2 _08564_/C1 _10140_/Q _08563_/C1 _10297_/Q _08376_/A3
+ VDD VDD VSS VSS gf180mcu_fd_sc_mcu7t5v0__aoi222_1
X_05587_ _10139_/Q _07664_/B2 VDD VDD VSS VSS gf180mcu_fd_sc_mcu7t5v0__clkinv_1
X_07326_ _10118_/Q _07557_/B2 _07326_/A3 _07519_/A1 VDD VDD VSS VSS
+ gf180mcu_fd_sc_mcu7t5v0__nor3_4
X_07257_ _09523_/A2 _09927_/A2 _07275_/A2 VDD VDD VSS VSS gf180mcu_fd_sc_mcu7t5v0__nand2_2
X_06208_ _09997_/Q _06222_/A2 _06505_/A1 VDD VDD VSS VSS gf180mcu_fd_sc_mcu7t5v0__nor2_2
X_07188_ _07170_/Z _07189_/A2 _07215_/B VDD VDD VSS VSS gf180mcu_fd_sc_mcu7t5v0__or2_1
X_06139_ _09984_/Q _06143_/A2 _06140_/B VDD VDD VSS VSS gf180mcu_fd_sc_mcu7t5v0__nand2_1
X_09829_ _06061_/Z _09832_/A2 _09832_/B1 _09829_/B2 _11106_/D VDD VDD
+ VSS VSS gf180mcu_fd_sc_mcu7t5v0__oai22_1
X_10604_ _10604_/D _10666_/CLK _10604_/Q VDD VDD VSS VSS gf180mcu_fd_sc_mcu7t5v0__dffq_1
X_10535_ _10535_/D _11109_/CLK _10535_/Q VDD VDD VSS VSS gf180mcu_fd_sc_mcu7t5v0__dffq_1
X_10466_ _10466_/D _11139_/CLK _10466_/Q VDD VDD VSS VSS gf180mcu_fd_sc_mcu7t5v0__dffq_1
X_10397_ _10397_/D _11018_/CLK _10397_/Q VDD VDD VSS VSS gf180mcu_fd_sc_mcu7t5v0__dffq_1
X_11018_ _11018_/D _11018_/CLK _11018_/Q VDD VDD VSS VSS gf180mcu_fd_sc_mcu7t5v0__dffq_1
X_05510_ _10878_/Q _09417_/B2 VDD VDD VSS VSS gf180mcu_fd_sc_mcu7t5v0__clkinv_1
X_06490_ _06490_/A1 _06490_/A2 _06490_/A3 _06490_/Z VDD VDD VSS VSS
+ gf180mcu_fd_sc_mcu7t5v0__xor3_1
X_05441_ _10638_/Q _09117_/B2 VDD VDD VSS VSS gf180mcu_fd_sc_mcu7t5v0__clkinv_1
X_08160_ _10869_/Q _08582_/A2 _07680_/I _10861_/Q _08160_/C _08161_/A3 VDD VDD
+ VSS VSS gf180mcu_fd_sc_mcu7t5v0__aoi221_1
X_05372_ _09957_/Q _06088_/B2 VDD VDD VSS VSS gf180mcu_fd_sc_mcu7t5v0__clkinv_1
X_07111_ _10004_/Q _07199_/A1 _07113_/A2 VDD VDD VSS VSS gf180mcu_fd_sc_mcu7t5v0__nand2_1
X_08091_ _10216_/Q _08573_/B1 _06125_/I _10348_/Q _08093_/A2 VDD VDD VSS
+ VSS gf180mcu_fd_sc_mcu7t5v0__aoi22_1
X_07042_ _06998_/Z _07001_/Z _07041_/B _07068_/A2 VDD VDD VSS VSS
+ gf180mcu_fd_sc_mcu7t5v0__nand3_1
X_08993_ _09890_/A1 _09001_/A2 _09001_/B1 VDD VDD VSS VSS gf180mcu_fd_sc_mcu7t5v0__nand2_2
X_07944_ _10411_/Q _08559_/A2 _06112_/I _10435_/Q _07948_/A1 VDD VDD VSS
+ VSS gf180mcu_fd_sc_mcu7t5v0__aoi22_1
X_07875_ rst_n _07874_/Z _10258_/D VDD VDD VSS VSS gf180mcu_fd_sc_mcu7t5v0__and2_1
X_09614_ _11021_/Q _09624_/A2 _09615_/B VDD VDD VSS VSS gf180mcu_fd_sc_mcu7t5v0__nand2_1
X_06826_ _10006_/Q _06824_/Z _06827_/B VDD VDD VSS VSS gf180mcu_fd_sc_mcu7t5v0__xor2_1
X_09545_ _06058_/Z _09549_/A2 _09549_/B1 _09545_/B2 _10974_/D VDD VDD
+ VSS VSS gf180mcu_fd_sc_mcu7t5v0__oai22_1
X_06757_ _06758_/A1 _06758_/A2 _06795_/B VDD VDD VSS VSS gf180mcu_fd_sc_mcu7t5v0__or2_1
X_09476_ _09921_/A1 _09481_/A2 _09481_/B1 _09476_/B2 _10925_/D VDD VDD
+ VSS VSS gf180mcu_fd_sc_mcu7t5v0__oai22_1
X_05708_ _10768_/Q _09279_/B2 VDD VDD VSS VSS gf180mcu_fd_sc_mcu7t5v0__clkinv_1
X_06688_ _06688_/A1 _06671_/Z _06688_/B _06739_/A1 VDD VDD VSS VSS
+ gf180mcu_fd_sc_mcu7t5v0__aoi21_2
X_05639_ _10528_/Q _08979_/B2 VDD VDD VSS VSS gf180mcu_fd_sc_mcu7t5v0__clkinv_1
X_08427_ _08427_/A1 _08427_/A2 _08427_/A3 _08428_/B1 VDD VDD VSS VSS
+ gf180mcu_fd_sc_mcu7t5v0__nand3_1
X_08358_ _08358_/A1 _08358_/A2 _08358_/A3 _08359_/B1 VDD VDD VSS VSS
+ gf180mcu_fd_sc_mcu7t5v0__nand3_2
X_08289_ _10487_/Q _08540_/A2 _08560_/B1 _10147_/Q _07255_/I _11162_/Q _08291_/A2
+ VDD VDD VSS VSS gf180mcu_fd_sc_mcu7t5v0__aoi222_4
X_07309_ _09897_/A1 _07311_/A2 _07309_/B _10112_/D VDD VDD VSS VSS
+ gf180mcu_fd_sc_mcu7t5v0__oai21_1
X_10320_ _10320_/D _11052_/CLK _10320_/Q VDD VDD VSS VSS gf180mcu_fd_sc_mcu7t5v0__dffq_1
X_10251_ _10251_/D _11150_/CLK _10251_/Q VDD VDD VSS VSS gf180mcu_fd_sc_mcu7t5v0__dffq_1
X_10182_ _10182_/D _11017_/CLK _10182_/Q VDD VDD VSS VSS gf180mcu_fd_sc_mcu7t5v0__dffq_1
X_10518_ _10518_/D _11018_/CLK _10518_/Q VDD VDD VSS VSS gf180mcu_fd_sc_mcu7t5v0__dffq_1
X_10449_ _10449_/D _11101_/CLK _10449_/Q VDD VDD VSS VSS gf180mcu_fd_sc_mcu7t5v0__dffq_1
X_05990_ _11052_/Q _07876_/A2 _05992_/C VDD VDD VSS VSS gf180mcu_fd_sc_mcu7t5v0__and2_1
X_07660_ _06047_/Z _07667_/A2 _07667_/B1 _07660_/B2 _10135_/D VDD VDD
+ VSS VSS gf180mcu_fd_sc_mcu7t5v0__oai22_1
X_07591_ _06470_/B _07625_/A2 _07592_/B VDD VDD VSS VSS gf180mcu_fd_sc_mcu7t5v0__xor2_1
X_06611_ _10001_/Q _06873_/A2 _06682_/B _06612_/C VDD VDD VSS VSS
+ gf180mcu_fd_sc_mcu7t5v0__aoi21_1
X_09330_ _09925_/A1 _09331_/A2 _09331_/B1 _09330_/B2 _10809_/D VDD VDD
+ VSS VSS gf180mcu_fd_sc_mcu7t5v0__oai22_1
X_06542_ _10249_/Q _08675_/A2 _08674_/B _06543_/B VDD VDD VSS VSS
+ gf180mcu_fd_sc_mcu7t5v0__oai21_1
X_09261_ _09946_/A1 _09261_/A2 _09261_/B1 _09261_/B2 _10754_/D VDD VDD
+ VSS VSS gf180mcu_fd_sc_mcu7t5v0__oai22_1
X_08212_ _11030_/Q _08589_/A2 _06112_/I _11038_/Q _09872_/A1 _09982_/Q _08213_/A3
+ VDD VDD VSS VSS gf180mcu_fd_sc_mcu7t5v0__aoi222_2
X_06473_ _06228_/B _06473_/A2 _06473_/A3 _06473_/A4 _06474_/B VDD VDD
+ VSS VSS gf180mcu_fd_sc_mcu7t5v0__nand4_1
X_05424_ _10502_/Q _08947_/B2 VDD VDD VSS VSS gf180mcu_fd_sc_mcu7t5v0__clkinv_1
X_09192_ _09645_/A2 _08588_/B _09201_/A2 VDD VDD VSS VSS gf180mcu_fd_sc_mcu7t5v0__nand2_4
X_05355_ _10193_/Q _07753_/B2 VDD VDD VSS VSS gf180mcu_fd_sc_mcu7t5v0__clkinv_1
X_08143_ _10965_/Q _08530_/A2 _06877_/Z _10233_/Q _08146_/A1 VDD VDD VSS
+ VSS gf180mcu_fd_sc_mcu7t5v0__aoi22_1
X_08074_ _10668_/Q _08563_/A2 _08476_/C1 _10404_/Q _08078_/A1 VDD VDD
+ VSS VSS gf180mcu_fd_sc_mcu7t5v0__aoi22_1
X_05286_ _10780_/Q _09295_/B2 VDD VDD VSS VSS gf180mcu_fd_sc_mcu7t5v0__clkinv_1
X_07025_ _10081_/Q _10080_/Q _07025_/Z VDD VDD VSS VSS gf180mcu_fd_sc_mcu7t5v0__and2_1
X_08976_ _09921_/A1 _08981_/A2 _08981_/B1 _08976_/B2 _10525_/D VDD VDD
+ VSS VSS gf180mcu_fd_sc_mcu7t5v0__oai22_1
X_07927_ _07927_/A1 _07927_/A2 _07927_/A3 _07936_/C2 VDD VDD VSS VSS
+ gf180mcu_fd_sc_mcu7t5v0__nand3_1
X_07858_ _07858_/A1 _07864_/A2 _07858_/B _09900_/B _10250_/D VDD VDD VSS
+ VSS gf180mcu_fd_sc_mcu7t5v0__aoi211_1
X_07789_ _09852_/A1 _07797_/A2 _07797_/B1 VDD VDD VSS VSS gf180mcu_fd_sc_mcu7t5v0__nand2_2
X_06809_ _06811_/A2 _06811_/A3 _06853_/B VDD VDD VSS VSS gf180mcu_fd_sc_mcu7t5v0__nor2_1
X_09528_ _10965_/Q _09538_/A2 _09529_/B VDD VDD VSS VSS gf180mcu_fd_sc_mcu7t5v0__nand2_1
X_09459_ _09944_/A1 _09461_/A2 _09461_/B1 _09459_/B2 _10912_/D VDD VDD
+ VSS VSS gf180mcu_fd_sc_mcu7t5v0__oai22_1
X_10303_ _10303_/D _11101_/CLK _10303_/Q VDD VDD VSS VSS gf180mcu_fd_sc_mcu7t5v0__dffq_2
X_10234_ _10234_/D _11101_/CLK _10234_/Q VDD VDD VSS VSS gf180mcu_fd_sc_mcu7t5v0__dffq_1
X_10165_ _10165_/D _10905_/CLK _10165_/Q VDD VDD VSS VSS gf180mcu_fd_sc_mcu7t5v0__dffq_1
X_10096_ _10096_/D _10905_/CLK _10096_/Q VDD VDD VSS VSS gf180mcu_fd_sc_mcu7t5v0__dffq_1
X_10998_ _10998_/D _11147_/CLK _10998_/Q VDD VDD VSS VSS gf180mcu_fd_sc_mcu7t5v0__dffq_1
X_05140_ _10371_/Q _08742_/B2 VDD VDD VSS VSS gf180mcu_fd_sc_mcu7t5v0__clkinv_1
X_05071_ bus_addr[1] _07865_/A2 VDD VDD VSS VSS gf180mcu_fd_sc_mcu7t5v0__clkinv_2
X_08830_ _10289_/Q _10291_/Q _10290_/Q _08830_/B _08831_/I VDD VDD VSS
+ VSS gf180mcu_fd_sc_mcu7t5v0__oai31_4
X_08761_ _09824_/A1 _08769_/A2 _08769_/B1 VDD VDD VSS VSS gf180mcu_fd_sc_mcu7t5v0__nand2_2
X_05973_ _09796_/A2 _05972_/Z _05983_/A2 VDD VDD VSS VSS gf180mcu_fd_sc_mcu7t5v0__nand2_1
X_07712_ _10167_/Q _07726_/A2 _07713_/B VDD VDD VSS VSS gf180mcu_fd_sc_mcu7t5v0__nand2_1
X_08692_ _10336_/Q _08698_/A2 _08693_/A2 VDD VDD VSS VSS gf180mcu_fd_sc_mcu7t5v0__nand2_1
X_07643_ _06047_/Z _07657_/A2 _07643_/B _10127_/D VDD VDD VSS VSS
+ gf180mcu_fd_sc_mcu7t5v0__oai21_1
X_09313_ _09433_/A1 _09321_/A2 _09321_/B1 VDD VDD VSS VSS gf180mcu_fd_sc_mcu7t5v0__nand2_4
X_07574_ _07573_/B _07617_/B2 _07574_/A3 _07575_/B VDD VDD VSS VSS
+ gf180mcu_fd_sc_mcu7t5v0__xor3_1
X_06525_ _09940_/A1 _06531_/A2 _06531_/B1 _06525_/B2 _10025_/D VDD VDD
+ VSS VSS gf180mcu_fd_sc_mcu7t5v0__oai22_1
X_09244_ _06047_/Z _09251_/A2 _09251_/B1 _09244_/B2 _10739_/D VDD VDD
+ VSS VSS gf180mcu_fd_sc_mcu7t5v0__oai22_1
X_06456_ _06477_/A1 _06477_/A2 _06477_/B _06456_/Z VDD VDD VSS VSS
+ gf180mcu_fd_sc_mcu7t5v0__xor3_1
X_05407_ _10486_/Q _08927_/B2 VDD VDD VSS VSS gf180mcu_fd_sc_mcu7t5v0__clkinv_1
X_09175_ _09940_/A1 _09181_/A2 _09181_/B1 _09175_/B2 _10684_/D VDD VDD
+ VSS VSS gf180mcu_fd_sc_mcu7t5v0__oai22_1
X_06387_ _06388_/A1 _06493_/A1 _06387_/Z VDD VDD VSS VSS gf180mcu_fd_sc_mcu7t5v0__and2_1
X_08126_ _08126_/A1 _08126_/A2 _08126_/A3 _08131_/A2 VDD VDD VSS VSS
+ gf180mcu_fd_sc_mcu7t5v0__nand3_1
X_05338_ _10661_/Q _09146_/B2 VDD VDD VSS VSS gf180mcu_fd_sc_mcu7t5v0__clkinv_1
X_08057_ _10620_/Q _06023_/I _08582_/A2 _10652_/Q _08564_/C1 _10628_/Q _08058_/A3
+ VDD VDD VSS VSS gf180mcu_fd_sc_mcu7t5v0__aoi222_2
X_05269_ _10136_/Q _07661_/B2 VDD VDD VSS VSS gf180mcu_fd_sc_mcu7t5v0__clkinv_1
X_07008_ _07222_/A2 _07181_/A2 _07199_/B _07011_/A3 VDD VDD VSS VSS
+ gf180mcu_fd_sc_mcu7t5v0__oai21_1
X_08959_ _09924_/A1 _08961_/A2 _08961_/B1 _08959_/B2 _10512_/D VDD VDD
+ VSS VSS gf180mcu_fd_sc_mcu7t5v0__oai22_1
X_10921_ _10921_/D _11149_/CLK _10921_/Q VDD VDD VSS VSS gf180mcu_fd_sc_mcu7t5v0__dffq_1
X_10852_ _10852_/D _11165_/CLK _10852_/Q VDD VDD VSS VSS gf180mcu_fd_sc_mcu7t5v0__dffq_1
X_10783_ _10783_/D _11010_/CLK _10783_/Q VDD VDD VSS VSS gf180mcu_fd_sc_mcu7t5v0__dffq_1
X_10217_ _10217_/D _11149_/CLK _10217_/Q VDD VDD VSS VSS gf180mcu_fd_sc_mcu7t5v0__dffq_1
X_10148_ _10148_/D _11164_/CLK _10148_/Q VDD VDD VSS VSS gf180mcu_fd_sc_mcu7t5v0__dffq_1
X_10079_ _10079_/D _11039_/CLK _10079_/Q VDD VDD VSS VSS gf180mcu_fd_sc_mcu7t5v0__dffq_2
X_06310_ _06342_/A1 _06310_/A2 _06310_/A3 _06312_/A2 VDD VDD VSS VSS
+ gf180mcu_fd_sc_mcu7t5v0__xnor3_1
X_07290_ _10104_/Q _07292_/A2 _07291_/B VDD VDD VSS VSS gf180mcu_fd_sc_mcu7t5v0__nand2_1
X_06241_ _10001_/Q _06239_/Z _06276_/A2 VDD VDD VSS VSS gf180mcu_fd_sc_mcu7t5v0__nor2_1
X_06172_ _06204_/A2 _08675_/A2 _06172_/B _09996_/D VDD VDD VSS VSS
+ gf180mcu_fd_sc_mcu7t5v0__aoi21_1
X_05123_ _10635_/Q _09114_/B2 VDD VDD VSS VSS gf180mcu_fd_sc_mcu7t5v0__clkinv_1
X_05054_ _10010_/Q _06994_/A1 VDD VDD VSS VSS gf180mcu_fd_sc_mcu7t5v0__clkinv_3
X_09931_ _09941_/A1 _09936_/A2 _09936_/B1 _09931_/B2 _11168_/D VDD VDD
+ VSS VSS gf180mcu_fd_sc_mcu7t5v0__oai22_1
X_09862_ _09890_/A1 _09870_/A2 _09870_/B1 VDD VDD VSS VSS gf180mcu_fd_sc_mcu7t5v0__nand2_2
X_08813_ _09920_/A1 _08819_/A2 _08819_/B1 _08813_/B2 _10428_/D VDD VDD
+ VSS VSS gf180mcu_fd_sc_mcu7t5v0__oai22_1
X_09793_ _09793_/A1 _09795_/A2 _09793_/B _11089_/D VDD VDD VSS VSS
+ gf180mcu_fd_sc_mcu7t5v0__aoi21_1
X_08744_ _09893_/A1 _08749_/A2 _08749_/B1 _08744_/B2 _10373_/D VDD VDD
+ VSS VSS gf180mcu_fd_sc_mcu7t5v0__oai22_1
X_05956_ _09809_/B _10289_/Q _05956_/A3 _05958_/A1 VDD VDD VSS VSS
+ gf180mcu_fd_sc_mcu7t5v0__nand3_1
X_05887_ _10060_/Q _06889_/B2 VDD VDD VSS VSS gf180mcu_fd_sc_mcu7t5v0__clkinv_1
X_08675_ _08675_/A1 _08675_/A2 _08675_/B _10330_/D VDD VDD VSS VSS
+ gf180mcu_fd_sc_mcu7t5v0__aoi21_1
X_07626_ _10007_/Q _07606_/Z _07634_/A1 VDD VDD VSS VSS gf180mcu_fd_sc_mcu7t5v0__nor2_1
X_07557_ _07557_/A1 _10051_/Q _07556_/Z _07557_/B2 _07558_/B2 VDD VDD
+ VSS VSS gf180mcu_fd_sc_mcu7t5v0__aoi22_2
X_06508_ _06372_/C _06508_/A2 _06508_/A3 _06508_/B1 _10007_/Q _06509_/C VDD
+ VDD VSS VSS gf180mcu_fd_sc_mcu7t5v0__oai32_1
X_07488_ _10004_/Q _07487_/Z _07489_/I VDD VDD VSS VSS gf180mcu_fd_sc_mcu7t5v0__and2_1
X_09227_ _06058_/Z _09231_/A2 _09231_/B1 _09227_/B2 _10726_/D VDD VDD
+ VSS VSS gf180mcu_fd_sc_mcu7t5v0__oai22_1
X_06439_ _10003_/Q _06439_/A2 _06493_/A2 VDD VDD VSS VSS gf180mcu_fd_sc_mcu7t5v0__nand2_1
X_09158_ _06061_/Z _09161_/A2 _09161_/B1 _09158_/B2 _10671_/D VDD VDD
+ VSS VSS gf180mcu_fd_sc_mcu7t5v0__oai22_1
X_08109_ _10781_/Q _09872_/A1 _07255_/I _10813_/Q _08112_/A2 VDD VDD VSS
+ VSS gf180mcu_fd_sc_mcu7t5v0__aoi22_1
X_09089_ _09944_/A1 _09091_/A2 _09091_/B1 _09089_/B2 _10616_/D VDD VDD
+ VSS VSS gf180mcu_fd_sc_mcu7t5v0__oai22_1
X_11120_ _11120_/D _11142_/CLK _11120_/Q VDD VDD VSS VSS gf180mcu_fd_sc_mcu7t5v0__dffq_1
X_11051_ _11051_/D _11097_/CLK _11051_/Q VDD VDD VSS VSS gf180mcu_fd_sc_mcu7t5v0__dffq_1
X_10002_ _10002_/D _11150_/CLK _10002_/Q VDD VDD VSS VSS gf180mcu_fd_sc_mcu7t5v0__dffq_4
X_10904_ _10904_/D _11176_/CLK _10904_/Q VDD VDD VSS VSS gf180mcu_fd_sc_mcu7t5v0__dffq_1
X_10835_ _10835_/D _11142_/CLK _10835_/Q VDD VDD VSS VSS gf180mcu_fd_sc_mcu7t5v0__dffq_1
Xrepeater34 _08563_/A2 _08555_/A2 VDD VDD VSS VSS gf180mcu_fd_sc_mcu7t5v0__buf_12
Xrepeater45 _09884_/A1 _09944_/A1 VDD VDD VSS VSS gf180mcu_fd_sc_mcu7t5v0__buf_16
Xrepeater12 _08529_/B1 _09872_/A1 VDD VDD VSS VSS gf180mcu_fd_sc_mcu7t5v0__buf_16
Xrepeater23 _06877_/Z _08589_/B1 VDD VDD VSS VSS gf180mcu_fd_sc_mcu7t5v0__buf_20
X_10766_ _10766_/D _11164_/CLK _10766_/Q VDD VDD VSS VSS gf180mcu_fd_sc_mcu7t5v0__dffq_1
Xrepeater56 _09918_/A1 _09433_/A1 VDD VDD VSS VSS gf180mcu_fd_sc_mcu7t5v0__buf_8
X_10697_ _10697_/D _11139_/CLK _10697_/Q VDD VDD VSS VSS gf180mcu_fd_sc_mcu7t5v0__dffq_1
X_05810_ _10913_/Q _09460_/B2 VDD VDD VSS VSS gf180mcu_fd_sc_mcu7t5v0__clkinv_1
X_06790_ _06790_/A1 _06790_/A2 _06867_/A2 VDD VDD VSS VSS gf180mcu_fd_sc_mcu7t5v0__nand2_2
X_05741_ _10361_/Q _08728_/B2 VDD VDD VSS VSS gf180mcu_fd_sc_mcu7t5v0__clkinv_1
X_05672_ _11000_/Q _09585_/B2 VDD VDD VSS VSS gf180mcu_fd_sc_mcu7t5v0__clkinv_1
X_08460_ _10577_/Q _08584_/A2 _08563_/C1 _10585_/Q _08564_/C1 _10569_/Q _08461_/A3
+ VDD VDD VSS VSS gf180mcu_fd_sc_mcu7t5v0__aoi222_1
X_08391_ _10728_/Q _08580_/A2 _06125_/I _11048_/Q _07680_/I _10376_/Q _08392_/A3 VDD
+ VDD VSS VSS gf180mcu_fd_sc_mcu7t5v0__aoi222_2
X_07411_ _10002_/Q _07410_/Z _07451_/A1 VDD VDD VSS VSS gf180mcu_fd_sc_mcu7t5v0__nand2_1
Xclkbuf_leaf_15_clk clkbuf_1_1_0_clk/Z _11163_/CLK VDD VDD VSS VSS
+ gf180mcu_fd_sc_mcu7t5v0__clkbuf_16
X_07342_ _10115_/Q _07353_/A3 _07352_/A2 VDD VDD VSS VSS gf180mcu_fd_sc_mcu7t5v0__nand2_2
X_07273_ _09945_/A1 _07275_/A2 _07273_/B _10096_/D VDD VDD VSS VSS
+ gf180mcu_fd_sc_mcu7t5v0__oai21_1
X_09012_ _09502_/A1 _09062_/A2 _09021_/A2 VDD VDD VSS VSS gf180mcu_fd_sc_mcu7t5v0__nand2_4
X_06224_ _10000_/Q _06481_/A2 _06224_/B _06228_/B _06231_/B2 VDD VDD VSS
+ VSS gf180mcu_fd_sc_mcu7t5v0__oai211_1
X_06155_ _09904_/A1 _06167_/A2 _06155_/B _09988_/D VDD VDD VSS VSS
+ gf180mcu_fd_sc_mcu7t5v0__oai21_1
X_05106_ _10499_/Q _08944_/B2 VDD VDD VSS VSS gf180mcu_fd_sc_mcu7t5v0__clkinv_1
X_06086_ _06047_/Z _06093_/A2 _06093_/B1 _06086_/B2 _09955_/D VDD VDD
+ VSS VSS gf180mcu_fd_sc_mcu7t5v0__oai22_1
X_05037_ _10081_/Q _07122_/B VDD VDD VSS VSS gf180mcu_fd_sc_mcu7t5v0__clkinv_4
X_09914_ _09925_/A1 _09916_/A2 _09914_/B _11156_/D VDD VDD VSS VSS
+ gf180mcu_fd_sc_mcu7t5v0__oai21_1
X_09845_ _11115_/Q _09849_/A2 _09846_/B VDD VDD VSS VSS gf180mcu_fd_sc_mcu7t5v0__nand2_1
X_09776_ _11081_/Q _09772_/Z _09776_/B _09777_/B VDD VDD VSS VSS gf180mcu_fd_sc_mcu7t5v0__oai21_1
X_06988_ _07019_/C _06988_/A2 _06989_/B2 VDD VDD VSS VSS gf180mcu_fd_sc_mcu7t5v0__nor2_1
X_08727_ _09924_/A1 _08729_/A2 _08729_/B1 _08727_/B2 _10360_/D VDD VDD
+ VSS VSS gf180mcu_fd_sc_mcu7t5v0__oai22_1
X_05939_ _08833_/A1 _10443_/Q _10446_/Q _05939_/A4 _05942_/A2 VDD VDD
+ VSS VSS gf180mcu_fd_sc_mcu7t5v0__nor4_1
X_08658_ _10322_/Q _08659_/A1 _08658_/B _08659_/B VDD VDD VSS VSS
+ gf180mcu_fd_sc_mcu7t5v0__oai21_1
X_07609_ _10007_/Q _07609_/A2 _07613_/A2 VDD VDD VSS VSS gf180mcu_fd_sc_mcu7t5v0__nand2_1
X_08589_ _10418_/Q _08589_/A2 _08589_/B1 _10498_/Q _08592_/A1 VDD VDD
+ VSS VSS gf180mcu_fd_sc_mcu7t5v0__aoi22_1
X_10620_ _10620_/D _10978_/CLK _10620_/Q VDD VDD VSS VSS gf180mcu_fd_sc_mcu7t5v0__dffq_1
X_10551_ _10551_/D _11138_/CLK _10551_/Q VDD VDD VSS VSS gf180mcu_fd_sc_mcu7t5v0__dffq_1
X_10482_ _10482_/D _11139_/CLK _10482_/Q VDD VDD VSS VSS gf180mcu_fd_sc_mcu7t5v0__dffq_1
X_11103_ _11103_/D _11109_/CLK _11103_/Q VDD VDD VSS VSS gf180mcu_fd_sc_mcu7t5v0__dffq_1
X_11034_ _11034_/D _11164_/CLK _11034_/Q VDD VDD VSS VSS gf180mcu_fd_sc_mcu7t5v0__dffq_1
X_10818_ _10818_/D _11010_/CLK _10818_/Q VDD VDD VSS VSS gf180mcu_fd_sc_mcu7t5v0__dffq_1
X_10749_ _10749_/D _10978_/CLK _10749_/Q VDD VDD VSS VSS gf180mcu_fd_sc_mcu7t5v0__dffq_1
X_07960_ _07960_/A1 _07960_/A2 _07960_/A3 _08009_/A2 VDD VDD VSS VSS
+ gf180mcu_fd_sc_mcu7t5v0__nand3_1
Xclkbuf_leaf_4_clk clkbuf_1_0_0_clk/Z _10666_/CLK VDD VDD VSS VSS
+ gf180mcu_fd_sc_mcu7t5v0__clkbuf_16
X_06911_ _06061_/Z _06917_/A2 _06911_/B _10073_/D VDD VDD VSS VSS
+ gf180mcu_fd_sc_mcu7t5v0__oai21_1
X_07891_ bus_addr[2] _05986_/I _07906_/A3 _07905_/A2 VDD VDD VSS VSS
+ gf180mcu_fd_sc_mcu7t5v0__nand3_4
X_09630_ _11028_/Q _09642_/A2 _09631_/B VDD VDD VSS VSS gf180mcu_fd_sc_mcu7t5v0__nand2_1
X_06842_ _10338_/Q _06651_/Z _06844_/A1 VDD VDD VSS VSS gf180mcu_fd_sc_mcu7t5v0__nand2_1
X_09561_ _06061_/Z _09567_/A2 _09561_/B _10983_/D VDD VDD VSS VSS
+ gf180mcu_fd_sc_mcu7t5v0__oai21_1
X_06773_ _10005_/Q _06772_/Z _06773_/Z VDD VDD VSS VSS gf180mcu_fd_sc_mcu7t5v0__and2_1
X_05724_ _10497_/Q _08940_/B2 VDD VDD VSS VSS gf180mcu_fd_sc_mcu7t5v0__clkinv_1
X_08512_ _09332_/A2 _08512_/A2 _08512_/B1 _09823_/A2 _08513_/A4 VDD VDD
+ VSS VSS gf180mcu_fd_sc_mcu7t5v0__aoi22_2
X_09492_ _09900_/A1 _09568_/A2 _09501_/A2 VDD VDD VSS VSS gf180mcu_fd_sc_mcu7t5v0__nand2_4
X_05655_ _10656_/Q _09139_/B2 VDD VDD VSS VSS gf180mcu_fd_sc_mcu7t5v0__clkinv_1
X_08443_ _10481_/Q _08528_/B1 _08589_/B1 _10075_/Q _08446_/A1 VDD VDD
+ VSS VSS gf180mcu_fd_sc_mcu7t5v0__aoi22_1
X_08374_ _10164_/Q _06023_/I _08586_/A2 _10021_/Q _08584_/B1 _10368_/Q _08376_/A2
+ VDD VDD VSS VSS gf180mcu_fd_sc_mcu7t5v0__aoi222_1
X_05586_ _10163_/Q _07706_/B2 VDD VDD VSS VSS gf180mcu_fd_sc_mcu7t5v0__clkinv_1
X_07325_ _07352_/A1 _10000_/Q _07325_/B _07354_/B2 VDD VDD VSS VSS
+ gf180mcu_fd_sc_mcu7t5v0__oai21_1
X_07256_ _07682_/A1 _08581_/B1 _09927_/A2 VDD VDD VSS VSS gf180mcu_fd_sc_mcu7t5v0__nor2_4
X_06207_ _09996_/Q _06223_/A3 _06222_/A2 VDD VDD VSS VSS gf180mcu_fd_sc_mcu7t5v0__nand2_2
X_07187_ _07215_/A1 _07215_/A2 _07189_/A2 VDD VDD VSS VSS gf180mcu_fd_sc_mcu7t5v0__xnor2_1
X_06138_ _06061_/Z _06144_/A2 _06138_/B _09983_/D VDD VDD VSS VSS
+ gf180mcu_fd_sc_mcu7t5v0__oai21_1
X_06069_ _10125_/Q cgra_status[0] _06069_/B _09537_/A1 VDD VDD VSS VSS
+ gf180mcu_fd_sc_mcu7t5v0__aoi21_4
X_09828_ _06058_/Z _09832_/A2 _09832_/B1 _09828_/B2 _11105_/D VDD VDD
+ VSS VSS gf180mcu_fd_sc_mcu7t5v0__oai22_1
X_09759_ _09757_/Z _09759_/A2 _11075_/D VDD VDD VSS VSS gf180mcu_fd_sc_mcu7t5v0__nor2_1
X_10603_ _10603_/D _10666_/CLK _10603_/Q VDD VDD VSS VSS gf180mcu_fd_sc_mcu7t5v0__dffq_1
X_10534_ _10534_/D _11018_/CLK _10534_/Q VDD VDD VSS VSS gf180mcu_fd_sc_mcu7t5v0__dffq_1
X_10465_ _10465_/D _11138_/CLK _10465_/Q VDD VDD VSS VSS gf180mcu_fd_sc_mcu7t5v0__dffq_1
X_10396_ _10396_/D _11018_/CLK _10396_/Q VDD VDD VSS VSS gf180mcu_fd_sc_mcu7t5v0__dffq_1
X_11017_ _11017_/D _11017_/CLK _11017_/Q VDD VDD VSS VSS gf180mcu_fd_sc_mcu7t5v0__dffq_1
X_05440_ _10630_/Q _09107_/B2 VDD VDD VSS VSS gf180mcu_fd_sc_mcu7t5v0__clkinv_1
X_05371_ _10201_/Q _07764_/B2 VDD VDD VSS VSS gf180mcu_fd_sc_mcu7t5v0__clkinv_1
X_07110_ _07246_/A1 _07152_/A2 _07115_/A2 VDD VDD VSS VSS gf180mcu_fd_sc_mcu7t5v0__nand2_1
X_08090_ _10884_/Q _08547_/A2 _07680_/I _10224_/Q _08090_/C _08093_/A1 VDD VDD
+ VSS VSS gf180mcu_fd_sc_mcu7t5v0__aoi221_2
X_07041_ _06998_/Z _07001_/Z _07041_/B _07068_/B VDD VDD VSS VSS gf180mcu_fd_sc_mcu7t5v0__aoi21_1
X_08992_ _09889_/A1 _09062_/A2 _09001_/A2 VDD VDD VSS VSS gf180mcu_fd_sc_mcu7t5v0__nand2_4
X_07943_ _07943_/A1 _07943_/A2 _07943_/A3 _08012_/A2 VDD VDD VSS VSS
+ gf180mcu_fd_sc_mcu7t5v0__nand3_4
X_07874_ bus_wdata[4] _10258_/Q _07874_/S _07874_/Z VDD VDD VSS VSS
+ gf180mcu_fd_sc_mcu7t5v0__mux2_1
X_09613_ _09904_/A1 _09625_/A2 _09613_/B _11020_/D VDD VDD VSS VSS
+ gf180mcu_fd_sc_mcu7t5v0__oai21_1
X_06825_ _10006_/Q _06824_/Z _06864_/A1 VDD VDD VSS VSS gf180mcu_fd_sc_mcu7t5v0__nand2_1
X_09544_ _09893_/A1 _09549_/A2 _09549_/B1 _09544_/B2 _10973_/D VDD VDD
+ VSS VSS gf180mcu_fd_sc_mcu7t5v0__oai22_1
X_06756_ _06756_/A1 _06752_/Z _06849_/A1 _06758_/A2 VDD VDD VSS VSS
+ gf180mcu_fd_sc_mcu7t5v0__xnor3_1
X_09475_ _09920_/A1 _09481_/A2 _09481_/B1 _09475_/B2 _10924_/D VDD VDD
+ VSS VSS gf180mcu_fd_sc_mcu7t5v0__oai22_1
X_05707_ _10760_/Q _09269_/B2 VDD VDD VSS VSS gf180mcu_fd_sc_mcu7t5v0__clkinv_1
X_06687_ _06687_/A1 _06687_/A2 _07603_/B _10048_/D VDD VDD VSS VSS
+ gf180mcu_fd_sc_mcu7t5v0__aoi21_1
X_05638_ _10520_/Q _08969_/B2 VDD VDD VSS VSS gf180mcu_fd_sc_mcu7t5v0__clkinv_1
X_08426_ _10544_/Q _08555_/A2 _07680_/I _10584_/Q _08426_/C _08427_/A3 VDD VDD
+ VSS VSS gf180mcu_fd_sc_mcu7t5v0__aoi221_1
X_08357_ _10640_/Q _08584_/A2 _08584_/B1 _10664_/Q _08358_/A3 VDD VDD
+ VSS VSS gf180mcu_fd_sc_mcu7t5v0__aoi22_1
X_05569_ _10057_/Q _06886_/B2 VDD VDD VSS VSS gf180mcu_fd_sc_mcu7t5v0__clkinv_1
X_08288_ _10439_/Q _06112_/I _08589_/B1 _10495_/Q _08291_/A1 VDD VDD VSS
+ VSS gf180mcu_fd_sc_mcu7t5v0__aoi22_1
X_07308_ _10112_/Q _07310_/A2 _07309_/B VDD VDD VSS VSS gf180mcu_fd_sc_mcu7t5v0__nand2_1
X_07239_ _07239_/A1 _07239_/A2 _07239_/B _07245_/A1 VDD VDD VSS VSS
+ gf180mcu_fd_sc_mcu7t5v0__oai21_1
X_10250_ _10250_/D _11150_/CLK _10250_/Q VDD VDD VSS VSS gf180mcu_fd_sc_mcu7t5v0__dffq_1
X_10181_ _10181_/D _11017_/CLK _10181_/Q VDD VDD VSS VSS gf180mcu_fd_sc_mcu7t5v0__dffq_1
X_10517_ _10517_/D _11109_/CLK _10517_/Q VDD VDD VSS VSS gf180mcu_fd_sc_mcu7t5v0__dffq_1
X_10448_ _10448_/D _11101_/CLK _10448_/Q VDD VDD VSS VSS gf180mcu_fd_sc_mcu7t5v0__dffq_1
X_10379_ _10379_/D _11109_/CLK _10379_/Q VDD VDD VSS VSS gf180mcu_fd_sc_mcu7t5v0__dffq_1
X_07590_ _07629_/A2 _07630_/A1 _07625_/A2 VDD VDD VSS VSS gf180mcu_fd_sc_mcu7t5v0__xnor2_1
X_06610_ _06872_/I1 _06627_/A1 _06873_/B _06612_/B2 VDD VDD VSS VSS
+ gf180mcu_fd_sc_mcu7t5v0__aoi21_1
X_06541_ _09946_/A1 _06541_/A2 _06541_/B1 _06541_/B2 _10039_/D VDD VDD
+ VSS VSS gf180mcu_fd_sc_mcu7t5v0__oai22_1
X_09260_ _09945_/A1 _09261_/A2 _09261_/B1 _09260_/B2 _10753_/D VDD VDD
+ VSS VSS gf180mcu_fd_sc_mcu7t5v0__oai22_1
X_06472_ _06372_/C _06472_/A2 _06472_/A3 _06502_/A1 _10006_/Q _06473_/A4 VDD
+ VDD VSS VSS gf180mcu_fd_sc_mcu7t5v0__oai32_1
X_05423_ _10358_/Q _08725_/B2 VDD VDD VSS VSS gf180mcu_fd_sc_mcu7t5v0__clkinv_1
X_08211_ _09950_/Q _08560_/A2 _08560_/B1 _11006_/Q _07255_/I _10982_/Q _08213_/A2
+ VDD VDD VSS VSS gf180mcu_fd_sc_mcu7t5v0__aoi222_4
X_09191_ _09946_/A1 _09191_/A2 _09191_/B1 _09191_/B2 _10698_/D VDD VDD
+ VSS VSS gf180mcu_fd_sc_mcu7t5v0__oai22_1
X_05354_ _10997_/Q _09582_/B2 VDD VDD VSS VSS gf180mcu_fd_sc_mcu7t5v0__clkinv_1
X_08142_ _08142_/A1 _08142_/A2 _08142_/A3 _08142_/A4 _08182_/A1 VDD VDD
+ VSS VSS gf180mcu_fd_sc_mcu7t5v0__nand4_1
X_05285_ _10772_/Q _09285_/B2 VDD VDD VSS VSS gf180mcu_fd_sc_mcu7t5v0__clkinv_1
X_08073_ _08534_/B2 _08329_/B _08588_/B VDD VDD VSS VSS gf180mcu_fd_sc_mcu7t5v0__nor2_4
X_07024_ _07024_/A1 _07024_/A2 _07024_/B _07067_/A1 VDD VDD VSS VSS
+ gf180mcu_fd_sc_mcu7t5v0__oai21_1
X_08975_ _09904_/A1 _08981_/A2 _08981_/B1 _08975_/B2 _10524_/D VDD VDD
+ VSS VSS gf180mcu_fd_sc_mcu7t5v0__oai22_1
X_07926_ _10667_/Q _08580_/A2 _08529_/B1 _10691_/Q _07926_/C _07927_/A3 VDD
+ VDD VSS VSS gf180mcu_fd_sc_mcu7t5v0__aoi221_2
X_07857_ _10250_/Q _07864_/A2 _07858_/B VDD VDD VSS VSS gf180mcu_fd_sc_mcu7t5v0__nor2_1
X_07788_ _09900_/A1 _09889_/A2 _07797_/A2 VDD VDD VSS VSS gf180mcu_fd_sc_mcu7t5v0__nand2_4
X_06808_ _06808_/A1 _06849_/B _06811_/A3 VDD VDD VSS VSS gf180mcu_fd_sc_mcu7t5v0__nand2_1
X_09527_ _09940_/A1 _09539_/A2 _09527_/B _10964_/D VDD VDD VSS VSS
+ gf180mcu_fd_sc_mcu7t5v0__oai21_1
X_06739_ _06739_/A1 _06718_/Z _06739_/B _06786_/A1 VDD VDD VSS VSS
+ gf180mcu_fd_sc_mcu7t5v0__oai21_1
X_09458_ _06061_/Z _09461_/A2 _09461_/B1 _09458_/B2 _10911_/D VDD VDD
+ VSS VSS gf180mcu_fd_sc_mcu7t5v0__oai22_1
X_09389_ _09896_/A1 _09391_/A2 _09391_/B1 _09389_/B2 _10856_/D VDD VDD
+ VSS VSS gf180mcu_fd_sc_mcu7t5v0__oai22_1
X_08409_ _09992_/Q _08560_/A2 _08413_/A1 VDD VDD VSS VSS gf180mcu_fd_sc_mcu7t5v0__nand2_1
X_10302_ _10302_/D _11101_/CLK _10302_/Q VDD VDD VSS VSS gf180mcu_fd_sc_mcu7t5v0__dffq_1
X_10233_ _10233_/D _11101_/CLK _10233_/Q VDD VDD VSS VSS gf180mcu_fd_sc_mcu7t5v0__dffq_1
X_10164_ _10164_/D _10905_/CLK _10164_/Q VDD VDD VSS VSS gf180mcu_fd_sc_mcu7t5v0__dffq_1
X_10095_ _10095_/D _11052_/CLK _10095_/Q VDD VDD VSS VSS gf180mcu_fd_sc_mcu7t5v0__dffq_1
X_10997_ _10997_/D _11147_/CLK _10997_/Q VDD VDD VSS VSS gf180mcu_fd_sc_mcu7t5v0__dffq_1
X_05070_ bus_addr[0] _07865_/A1 VDD VDD VSS VSS gf180mcu_fd_sc_mcu7t5v0__inv_1
X_08760_ _09871_/A1 _09568_/A2 _08769_/A2 VDD VDD VSS VSS gf180mcu_fd_sc_mcu7t5v0__nand2_4
X_05972_ _11101_/Q _11100_/Q _11099_/Q _05972_/Z VDD VDD VSS VSS gf180mcu_fd_sc_mcu7t5v0__and3_1
X_07711_ _08528_/B1 _07809_/A2 _09900_/B _07726_/A2 VDD VDD VSS VSS
+ gf180mcu_fd_sc_mcu7t5v0__aoi21_4
X_08691_ _10285_/Q _08621_/I _08693_/A1 VDD VDD VSS VSS gf180mcu_fd_sc_mcu7t5v0__nand2_1
X_07642_ _10127_/Q _07656_/A2 _07643_/B VDD VDD VSS VSS gf180mcu_fd_sc_mcu7t5v0__nand2_1
X_09312_ _09937_/A2 _09332_/A2 _09321_/A2 VDD VDD VSS VSS gf180mcu_fd_sc_mcu7t5v0__nand2_4
X_07573_ _10006_/Q _07609_/A2 _07573_/B _07617_/B1 VDD VDD VSS VSS
+ gf180mcu_fd_sc_mcu7t5v0__aoi21_1
X_06524_ _06047_/Z _06531_/A2 _06531_/B1 _06524_/B2 _10024_/D VDD VDD
+ VSS VSS gf180mcu_fd_sc_mcu7t5v0__oai22_1
X_09243_ _09852_/A1 _09251_/A2 _09251_/B1 VDD VDD VSS VSS gf180mcu_fd_sc_mcu7t5v0__nand2_2
X_06455_ _06455_/A1 _06455_/A2 _06477_/B VDD VDD VSS VSS gf180mcu_fd_sc_mcu7t5v0__xor2_1
X_05406_ _10494_/Q _08937_/B2 VDD VDD VSS VSS gf180mcu_fd_sc_mcu7t5v0__clkinv_1
X_09174_ _06047_/Z _09181_/A2 _09181_/B1 _09174_/B2 _10683_/D VDD VDD
+ VSS VSS gf180mcu_fd_sc_mcu7t5v0__oai22_1
X_06386_ _10002_/Q _06439_/A2 _06441_/A2 VDD VDD VSS VSS gf180mcu_fd_sc_mcu7t5v0__nand2_1
X_05337_ _10653_/Q _09136_/B2 VDD VDD VSS VSS gf180mcu_fd_sc_mcu7t5v0__clkinv_1
X_08125_ _10063_/Q _08530_/A2 _08528_/B1 _09973_/Q _08126_/A3 VDD VDD
+ VSS VSS gf180mcu_fd_sc_mcu7t5v0__aoi22_1
X_08056_ _10604_/Q _08563_/A2 _06877_/Z _10612_/Q _08563_/C1 _10644_/Q _08058_/A2
+ VDD VDD VSS VSS gf180mcu_fd_sc_mcu7t5v0__aoi222_2
X_05268_ _10160_/Q _07703_/B2 VDD VDD VSS VSS gf180mcu_fd_sc_mcu7t5v0__clkinv_1
X_05199_ _10144_/Q _07672_/B2 VDD VDD VSS VSS gf180mcu_fd_sc_mcu7t5v0__clkinv_1
X_07007_ _10084_/Q _07024_/A1 _07020_/A2 _07007_/Z VDD VDD VSS VSS
+ gf180mcu_fd_sc_mcu7t5v0__xor3_1
X_08958_ _06061_/Z _08961_/A2 _08961_/B1 _08958_/B2 _10511_/D VDD VDD
+ VSS VSS gf180mcu_fd_sc_mcu7t5v0__oai22_1
X_08889_ _09884_/A1 _08893_/A2 _08889_/B _10464_/D VDD VDD VSS VSS
+ gf180mcu_fd_sc_mcu7t5v0__oai21_1
X_07909_ bus_wdata[1] _07920_/A2 _08654_/B _07910_/B VDD VDD VSS VSS
+ gf180mcu_fd_sc_mcu7t5v0__oai21_1
X_10920_ _10920_/D _10978_/CLK _10920_/Q VDD VDD VSS VSS gf180mcu_fd_sc_mcu7t5v0__dffq_1
X_10851_ _10851_/D _11142_/CLK _10851_/Q VDD VDD VSS VSS gf180mcu_fd_sc_mcu7t5v0__dffq_1
X_10782_ _10782_/D _11010_/CLK _10782_/Q VDD VDD VSS VSS gf180mcu_fd_sc_mcu7t5v0__dffq_1
X_10216_ _10216_/D _11147_/CLK _10216_/Q VDD VDD VSS VSS gf180mcu_fd_sc_mcu7t5v0__dffq_1
X_10147_ _10147_/D _11164_/CLK _10147_/Q VDD VDD VSS VSS gf180mcu_fd_sc_mcu7t5v0__dffq_1
X_10078_ _10078_/D _11039_/CLK _10078_/Q VDD VDD VSS VSS gf180mcu_fd_sc_mcu7t5v0__dffq_2
Xclkbuf_0_clk clk clkbuf_0_clk/Z VDD VDD VSS VSS gf180mcu_fd_sc_mcu7t5v0__clkbuf_16
X_06240_ _10001_/Q _06239_/Z _06276_/B VDD VDD VSS VSS gf180mcu_fd_sc_mcu7t5v0__nand2_1
X_06171_ _10255_/Q _08675_/A2 rst_n _06172_/B VDD VDD VSS VSS gf180mcu_fd_sc_mcu7t5v0__oai21_1
X_05122_ _10627_/Q _09104_/B2 VDD VDD VSS VSS gf180mcu_fd_sc_mcu7t5v0__clkinv_1
X_05053_ _10012_/Q _06377_/A1 VDD VDD VSS VSS gf180mcu_fd_sc_mcu7t5v0__clkinv_1
X_09930_ _09940_/A1 _09936_/A2 _09936_/B1 _09930_/B2 _11167_/D VDD VDD
+ VSS VSS gf180mcu_fd_sc_mcu7t5v0__oai22_1
X_09861_ _09861_/A1 _09861_/A2 _09870_/A2 VDD VDD VSS VSS gf180mcu_fd_sc_mcu7t5v0__nand2_4
X_08812_ _06047_/Z _08819_/A2 _08819_/B1 _08812_/B2 _10427_/D VDD VDD
+ VSS VSS gf180mcu_fd_sc_mcu7t5v0__oai22_1
X_09792_ _11097_/Q _09795_/A2 _09809_/B _09793_/B VDD VDD VSS VSS
+ gf180mcu_fd_sc_mcu7t5v0__oai21_1
X_08743_ _09920_/A1 _08749_/A2 _08749_/B1 _08743_/B2 _10372_/D VDD VDD
+ VSS VSS gf180mcu_fd_sc_mcu7t5v0__oai22_1
X_05955_ _09900_/B _09724_/A2 _05954_/Z _05955_/B _10290_/D VDD VDD VSS
+ VSS gf180mcu_fd_sc_mcu7t5v0__oai31_1
X_05886_ _10068_/Q _06899_/B2 VDD VDD VSS VSS gf180mcu_fd_sc_mcu7t5v0__clkinv_1
X_08674_ _10287_/Q _08675_/A2 _08674_/B _08675_/B VDD VDD VSS VSS
+ gf180mcu_fd_sc_mcu7t5v0__oai21_1
X_07625_ _06470_/B _07625_/A2 _07625_/B _07631_/A1 VDD VDD VSS VSS
+ gf180mcu_fd_sc_mcu7t5v0__oai21_1
X_07556_ _07557_/A1 _10088_/Q _07556_/Z VDD VDD VSS VSS gf180mcu_fd_sc_mcu7t5v0__or2_1
X_06507_ _10007_/Q _06508_/B1 _06507_/B _06508_/A3 VDD VDD VSS VSS
+ gf180mcu_fd_sc_mcu7t5v0__aoi21_1
X_09226_ _09893_/A1 _09231_/A2 _09231_/B1 _09226_/B2 _10725_/D VDD VDD
+ VSS VSS gf180mcu_fd_sc_mcu7t5v0__oai22_1
X_07487_ _07463_/Z _07487_/A2 _07487_/Z VDD VDD VSS VSS gf180mcu_fd_sc_mcu7t5v0__xor2_1
X_06438_ _10001_/Q _06483_/A2 _06493_/B2 VDD VDD VSS VSS gf180mcu_fd_sc_mcu7t5v0__nand2_1
X_09157_ _06058_/Z _09161_/A2 _09161_/B1 _09157_/B2 _10670_/D VDD VDD
+ VSS VSS gf180mcu_fd_sc_mcu7t5v0__oai22_1
X_06369_ _06509_/B2 _06417_/A2 _06374_/B2 VDD VDD VSS VSS gf180mcu_fd_sc_mcu7t5v0__nor2_1
X_08108_ _10805_/Q _08560_/B1 _08877_/A2 _10797_/Q _08112_/A1 VDD VDD
+ VSS VSS gf180mcu_fd_sc_mcu7t5v0__aoi22_1
X_09088_ _06061_/Z _09091_/A2 _09091_/B1 _09088_/B2 _10615_/D VDD VDD
+ VSS VSS gf180mcu_fd_sc_mcu7t5v0__oai22_1
X_08039_ _10820_/Q _08580_/A2 _07680_/I _10860_/Q _08039_/C _08040_/A3 VDD VDD
+ VSS VSS gf180mcu_fd_sc_mcu7t5v0__aoi221_2
X_11050_ _11050_/D _11142_/CLK _11050_/Q VDD VDD VSS VSS gf180mcu_fd_sc_mcu7t5v0__dffq_1
X_10001_ _10001_/D _11150_/CLK _10001_/Q VDD VDD VSS VSS gf180mcu_fd_sc_mcu7t5v0__dffq_4
X_10903_ _10903_/D _10905_/CLK _10903_/Q VDD VDD VSS VSS gf180mcu_fd_sc_mcu7t5v0__dffq_1
X_10834_ _10834_/D _11165_/CLK _10834_/Q VDD VDD VSS VSS gf180mcu_fd_sc_mcu7t5v0__dffq_1
Xrepeater35 _08589_/A2 _08559_/A2 VDD VDD VSS VSS gf180mcu_fd_sc_mcu7t5v0__clkbuf_12
Xrepeater24 _08586_/A2 _08582_/A2 VDD VDD VSS VSS gf180mcu_fd_sc_mcu7t5v0__buf_16
Xrepeater13 _06112_/I _08591_/A2 VDD VDD VSS VSS gf180mcu_fd_sc_mcu7t5v0__buf_16
X_10765_ _10765_/D _11164_/CLK _10765_/Q VDD VDD VSS VSS gf180mcu_fd_sc_mcu7t5v0__dffq_1
Xrepeater46 _09924_/A1 _09896_/A1 VDD VDD VSS VSS gf180mcu_fd_sc_mcu7t5v0__buf_12
Xrepeater57 _08514_/B _09918_/A1 VDD VDD VSS VSS gf180mcu_fd_sc_mcu7t5v0__buf_8
X_10696_ _10696_/D _11139_/CLK _10696_/Q VDD VDD VSS VSS gf180mcu_fd_sc_mcu7t5v0__dffq_1
X_11179_ _11179_/D _11181_/CLK _11179_/Q VDD VDD VSS VSS gf180mcu_fd_sc_mcu7t5v0__dffq_1
X_05740_ _10897_/Q _09440_/B2 VDD VDD VSS VSS gf180mcu_fd_sc_mcu7t5v0__clkinv_1
X_05671_ _11016_/Q _09605_/B2 VDD VDD VSS VSS gf180mcu_fd_sc_mcu7t5v0__clkinv_1
X_08390_ _10744_/Q _08590_/A2 _08573_/B1 _11016_/Q _08576_/B1 _11000_/Q _08392_/A2
+ VDD VDD VSS VSS gf180mcu_fd_sc_mcu7t5v0__aoi222_4
X_07410_ _07485_/A3 _07412_/A3 _07410_/Z VDD VDD VSS VSS gf180mcu_fd_sc_mcu7t5v0__xor2_1
X_07341_ _10116_/Q _07341_/A2 _07353_/A3 _07417_/A1 VDD VDD VSS VSS
+ gf180mcu_fd_sc_mcu7t5v0__nand3_1
X_07272_ _10096_/Q _07274_/A2 _07273_/B VDD VDD VSS VSS gf180mcu_fd_sc_mcu7t5v0__nand2_1
X_09011_ _09926_/A1 _09011_/A2 _09011_/B1 _09011_/B2 _10554_/D VDD VDD
+ VSS VSS gf180mcu_fd_sc_mcu7t5v0__oai22_1
X_06223_ _09997_/Q _09996_/Q _06223_/A3 _06228_/B VDD VDD VSS VSS
+ gf180mcu_fd_sc_mcu7t5v0__nand3_2
X_06154_ _09988_/Q _06166_/A2 _06155_/B VDD VDD VSS VSS gf180mcu_fd_sc_mcu7t5v0__nand2_1
X_05105_ _10355_/Q _08722_/B2 VDD VDD VSS VSS gf180mcu_fd_sc_mcu7t5v0__clkinv_1
X_06085_ _09193_/A1 _06093_/A2 _06093_/B1 VDD VDD VSS VSS gf180mcu_fd_sc_mcu7t5v0__nand2_4
X_09913_ _11156_/Q _09915_/A2 _09914_/B VDD VDD VSS VSS gf180mcu_fd_sc_mcu7t5v0__nand2_1
X_05036_ _10082_/Q _07333_/A2 VDD VDD VSS VSS gf180mcu_fd_sc_mcu7t5v0__clkinv_3
X_09844_ _06061_/Z _09850_/A2 _09844_/B _11114_/D VDD VDD VSS VSS
+ gf180mcu_fd_sc_mcu7t5v0__oai21_1
X_09775_ _11081_/Q _09772_/Z _09778_/A2 VDD VDD VSS VSS gf180mcu_fd_sc_mcu7t5v0__nand2_1
X_06987_ _06991_/A1 _06985_/Z _06989_/B1 VDD VDD VSS VSS gf180mcu_fd_sc_mcu7t5v0__nand2_1
X_08726_ _06061_/Z _08729_/A2 _08729_/B1 _08726_/B2 _10359_/D VDD VDD
+ VSS VSS gf180mcu_fd_sc_mcu7t5v0__oai22_1
X_05938_ _10448_/Q _10450_/Q _05938_/A3 _05942_/A1 VDD VDD VSS VSS
+ gf180mcu_fd_sc_mcu7t5v0__nor3_1
X_08657_ _10272_/Q _08657_/A2 _08657_/B1 _10265_/Q _08657_/C _08659_/A2 VDD
+ VDD VSS VSS gf180mcu_fd_sc_mcu7t5v0__aoi221_1
X_05869_ _10674_/Q _09161_/B2 VDD VDD VSS VSS gf180mcu_fd_sc_mcu7t5v0__clkinv_1
X_07608_ _10001_/Q _07629_/A2 _07619_/A2 VDD VDD VSS VSS gf180mcu_fd_sc_mcu7t5v0__nand2_1
X_08588_ _08588_/A1 _08588_/A2 _08588_/B _08594_/A1 VDD VDD VSS VSS
+ gf180mcu_fd_sc_mcu7t5v0__oai21_1
X_07539_ _06420_/B _07540_/A2 _07593_/A1 VDD VDD VSS VSS gf180mcu_fd_sc_mcu7t5v0__nor2_1
X_10550_ _10550_/D _10978_/CLK _10550_/Q VDD VDD VSS VSS gf180mcu_fd_sc_mcu7t5v0__dffq_1
X_09209_ _09884_/A1 _09211_/A2 _09211_/B1 _09209_/B2 _10712_/D VDD VDD
+ VSS VSS gf180mcu_fd_sc_mcu7t5v0__oai22_1
X_10481_ _10481_/D _11139_/CLK _10481_/Q VDD VDD VSS VSS gf180mcu_fd_sc_mcu7t5v0__dffq_1
X_11102_ _11102_/D _11109_/CLK _11102_/Q VDD VDD VSS VSS gf180mcu_fd_sc_mcu7t5v0__dffq_1
X_11033_ _11033_/D _11164_/CLK _11033_/Q VDD VDD VSS VSS gf180mcu_fd_sc_mcu7t5v0__dffq_1
X_10817_ _10817_/D _11010_/CLK _10817_/Q VDD VDD VSS VSS gf180mcu_fd_sc_mcu7t5v0__dffq_1
X_10748_ _10748_/D _10978_/CLK _10748_/Q VDD VDD VSS VSS gf180mcu_fd_sc_mcu7t5v0__dffq_1
X_10679_ _10679_/D _11138_/CLK _10679_/Q VDD VDD VSS VSS gf180mcu_fd_sc_mcu7t5v0__dffq_1
X_06910_ _10073_/Q _06916_/A2 _06911_/B VDD VDD VSS VSS gf180mcu_fd_sc_mcu7t5v0__nand2_1
X_07890_ _07890_/A1 _07890_/A2 _07890_/B _10265_/D VDD VDD VSS VSS
+ gf180mcu_fd_sc_mcu7t5v0__aoi21_1
X_06841_ _06841_/A1 _06841_/A2 _06841_/B _06859_/A1 VDD VDD VSS VSS
+ gf180mcu_fd_sc_mcu7t5v0__oai21_1
X_09560_ _10983_/Q _09566_/A2 _09561_/B VDD VDD VSS VSS gf180mcu_fd_sc_mcu7t5v0__nand2_1
X_06772_ _06847_/A2 _06772_/A2 _06772_/Z VDD VDD VSS VSS gf180mcu_fd_sc_mcu7t5v0__xor2_1
X_09491_ _09926_/A1 _09491_/A2 _09491_/B1 _09491_/B2 _10938_/D VDD VDD
+ VSS VSS gf180mcu_fd_sc_mcu7t5v0__oai22_1
X_08511_ _08511_/A1 _08511_/A2 _08511_/A3 _08512_/B1 VDD VDD VSS VSS
+ gf180mcu_fd_sc_mcu7t5v0__nand3_2
X_05723_ _10417_/Q _08798_/B2 VDD VDD VSS VSS gf180mcu_fd_sc_mcu7t5v0__clkinv_1
X_08442_ _09568_/A2 _08442_/A2 _08442_/B1 _09889_/A2 _08473_/A1 VDD VDD
+ VSS VSS gf180mcu_fd_sc_mcu7t5v0__aoi22_2
X_05654_ _10648_/Q _09129_/B2 VDD VDD VSS VSS gf180mcu_fd_sc_mcu7t5v0__clkinv_1
X_05585_ _10187_/Q _07745_/B2 VDD VDD VSS VSS gf180mcu_fd_sc_mcu7t5v0__clkinv_1
X_08373_ _10904_/Q _08584_/A2 _06877_/Z _10188_/Q _08376_/A1 VDD VDD VSS
+ VSS gf180mcu_fd_sc_mcu7t5v0__aoi22_1
X_07324_ _10116_/Q _07496_/A1 _07633_/C VDD VDD VSS VSS gf180mcu_fd_sc_mcu7t5v0__nor2_2
X_07255_ _07255_/I _08581_/B1 VDD VDD VSS VSS gf180mcu_fd_sc_mcu7t5v0__inv_1
X_06206_ _06223_/A3 _06216_/A2 _06507_/B VDD VDD VSS VSS gf180mcu_fd_sc_mcu7t5v0__nand2_1
X_07186_ _07186_/A1 _07186_/A2 _07215_/A2 VDD VDD VSS VSS gf180mcu_fd_sc_mcu7t5v0__xnor2_1
X_06137_ _09983_/Q _06143_/A2 _06138_/B VDD VDD VSS VSS gf180mcu_fd_sc_mcu7t5v0__nand2_1
X_06068_ bus_wdata[6] _08619_/B _06069_/B VDD VDD VSS VSS gf180mcu_fd_sc_mcu7t5v0__and2_1
X_05019_ _10264_/Q _07888_/A1 VDD VDD VSS VSS gf180mcu_fd_sc_mcu7t5v0__clkinv_1
X_09827_ _09921_/A1 _09832_/A2 _09832_/B1 _09827_/B2 _11104_/D VDD VDD
+ VSS VSS gf180mcu_fd_sc_mcu7t5v0__oai22_1
X_09758_ _11075_/Q _09753_/Z _09776_/B _09759_/A2 VDD VDD VSS VSS
+ gf180mcu_fd_sc_mcu7t5v0__oai21_1
X_08709_ _09926_/A1 _08709_/A2 _08709_/B1 _08709_/B2 _10346_/D VDD VDD
+ VSS VSS gf180mcu_fd_sc_mcu7t5v0__oai22_1
X_09689_ _11054_/Q _09678_/Z rst_n _09692_/A1 VDD VDD VSS VSS gf180mcu_fd_sc_mcu7t5v0__oai21_1
X_10602_ _10602_/D _11138_/CLK _10602_/Q VDD VDD VSS VSS gf180mcu_fd_sc_mcu7t5v0__dffq_1
X_10533_ _10533_/D _11109_/CLK _10533_/Q VDD VDD VSS VSS gf180mcu_fd_sc_mcu7t5v0__dffq_1
X_10464_ _10464_/D _11139_/CLK _10464_/Q VDD VDD VSS VSS gf180mcu_fd_sc_mcu7t5v0__dffq_1
X_10395_ _10395_/D _11018_/CLK _10395_/Q VDD VDD VSS VSS gf180mcu_fd_sc_mcu7t5v0__dffq_1
X_11016_ _11016_/D _11018_/CLK _11016_/Q VDD VDD VSS VSS gf180mcu_fd_sc_mcu7t5v0__dffq_1
X_05370_ _10217_/Q _07792_/B2 VDD VDD VSS VSS gf180mcu_fd_sc_mcu7t5v0__clkinv_1
X_07040_ _07040_/A1 _07078_/A1 _07040_/A3 _07041_/B VDD VDD VSS VSS
+ gf180mcu_fd_sc_mcu7t5v0__xor3_1
X_08991_ _09832_/A1 _08991_/A2 _08991_/B1 _08991_/B2 _10538_/D VDD VDD
+ VSS VSS gf180mcu_fd_sc_mcu7t5v0__oai22_1
X_07942_ _10507_/Q _06112_/I _08576_/B1 _10531_/Q _07942_/C _07943_/A3 VDD VDD
+ VSS VSS gf180mcu_fd_sc_mcu7t5v0__aoi221_4
X_07873_ _08674_/B _07872_/Z _10257_/D VDD VDD VSS VSS gf180mcu_fd_sc_mcu7t5v0__and2_1
X_09612_ _11020_/Q _09624_/A2 _09613_/B VDD VDD VSS VSS gf180mcu_fd_sc_mcu7t5v0__nand2_1
X_06824_ _06867_/A2 _06868_/A1 _06824_/Z VDD VDD VSS VSS gf180mcu_fd_sc_mcu7t5v0__xor2_1
X_09543_ _09940_/A1 _09549_/A2 _09549_/B1 _09543_/B2 _10972_/D VDD VDD
+ VSS VSS gf180mcu_fd_sc_mcu7t5v0__oai22_1
X_06755_ _06756_/A1 _06849_/A1 _06801_/A2 VDD VDD VSS VSS gf180mcu_fd_sc_mcu7t5v0__nand2_1
X_09474_ _06047_/Z _09481_/A2 _09481_/B1 _09474_/B2 _10923_/D VDD VDD
+ VSS VSS gf180mcu_fd_sc_mcu7t5v0__oai22_1
X_05706_ _10752_/Q _09259_/B2 VDD VDD VSS VSS gf180mcu_fd_sc_mcu7t5v0__clkinv_1
X_06686_ _06834_/C _06672_/Z _06686_/B _07636_/B _06687_/A2 VDD VDD VSS
+ VSS gf180mcu_fd_sc_mcu7t5v0__oai211_1
X_05637_ _10512_/Q _08959_/B2 VDD VDD VSS VSS gf180mcu_fd_sc_mcu7t5v0__clkinv_1
X_08425_ _09019_/B2 _08585_/A2 _08581_/A2 _09009_/B2 _08426_/C VDD VDD
+ VSS VSS gf180mcu_fd_sc_mcu7t5v0__oai22_1
X_08356_ _10624_/Q _06023_/I _08582_/A2 _10656_/Q _08564_/C1 _10632_/Q _08358_/A2
+ VDD VDD VSS VSS gf180mcu_fd_sc_mcu7t5v0__aoi222_4
X_07307_ _09924_/A1 _07311_/A2 _07307_/B _10111_/D VDD VDD VSS VSS
+ gf180mcu_fd_sc_mcu7t5v0__oai21_1
X_05568_ _10065_/Q _06896_/B2 VDD VDD VSS VSS gf180mcu_fd_sc_mcu7t5v0__clkinv_1
X_08287_ _08287_/A1 _08287_/A2 _08287_/A3 _08343_/B1 VDD VDD VSS VSS
+ gf180mcu_fd_sc_mcu7t5v0__nand3_2
X_05499_ _10790_/Q _09307_/B2 VDD VDD VSS VSS gf180mcu_fd_sc_mcu7t5v0__clkinv_1
X_07238_ _07019_/C _07237_/Z _07238_/Z VDD VDD VSS VSS gf180mcu_fd_sc_mcu7t5v0__or2_1
X_07169_ _10000_/Q _07243_/A2 _07170_/A2 _07235_/A1 VDD VDD VSS VSS
+ gf180mcu_fd_sc_mcu7t5v0__nand3_1
X_10180_ _10180_/D _11017_/CLK _10180_/Q VDD VDD VSS VSS gf180mcu_fd_sc_mcu7t5v0__dffq_1
X_10516_ _10516_/D _11109_/CLK _10516_/Q VDD VDD VSS VSS gf180mcu_fd_sc_mcu7t5v0__dffq_1
X_10447_ _10447_/D _11101_/CLK _10447_/Q VDD VDD VSS VSS gf180mcu_fd_sc_mcu7t5v0__dffq_1
X_10378_ _10378_/D _11142_/CLK _10378_/Q VDD VDD VSS VSS gf180mcu_fd_sc_mcu7t5v0__dffq_1
X_06540_ _09945_/A1 _06541_/A2 _06541_/B1 _06540_/B2 _10038_/D VDD VDD
+ VSS VSS gf180mcu_fd_sc_mcu7t5v0__oai22_1
X_06471_ _10006_/Q _06502_/A1 _06507_/B _06472_/A3 VDD VDD VSS VSS
+ gf180mcu_fd_sc_mcu7t5v0__aoi21_1
X_05422_ _10894_/Q _09437_/B2 VDD VDD VSS VSS gf180mcu_fd_sc_mcu7t5v0__clkinv_1
X_08210_ _10130_/Q _08589_/B1 _08877_/A2 _11022_/Q _08213_/A1 VDD VDD
+ VSS VSS gf180mcu_fd_sc_mcu7t5v0__aoi22_1
X_09190_ _09537_/A1 _09191_/A2 _09191_/B1 _09190_/B2 _10697_/D VDD VDD
+ VSS VSS gf180mcu_fd_sc_mcu7t5v0__oai22_1
X_05353_ _11013_/Q _09602_/B2 VDD VDD VSS VSS gf180mcu_fd_sc_mcu7t5v0__clkinv_1
X_08141_ _09662_/A2 _08141_/A2 _08141_/B1 _09823_/A2 _08142_/A4 VDD VDD
+ VSS VSS gf180mcu_fd_sc_mcu7t5v0__aoi22_1
X_05284_ _10764_/Q _09275_/B2 VDD VDD VSS VSS gf180mcu_fd_sc_mcu7t5v0__clkinv_1
X_08072_ _08072_/A1 _08072_/A2 _08072_/A3 _08096_/B1 VDD VDD VSS VSS
+ gf180mcu_fd_sc_mcu7t5v0__nand3_2
X_07023_ _07603_/B _07023_/A2 _10084_/D VDD VDD VSS VSS gf180mcu_fd_sc_mcu7t5v0__nor2_1
X_08974_ _06047_/Z _08981_/A2 _08981_/B1 _08974_/B2 _10523_/D VDD VDD
+ VSS VSS gf180mcu_fd_sc_mcu7t5v0__oai22_1
X_07925_ _07925_/I _07926_/C VDD VDD VSS VSS gf180mcu_fd_sc_mcu7t5v0__clkinv_1
X_07856_ _09679_/A1 _07864_/A2 _07856_/B _09900_/B _10249_/D VDD VDD VSS
+ VSS gf180mcu_fd_sc_mcu7t5v0__aoi211_1
X_04999_ _10314_/Q _06168_/A1 VDD VDD VSS VSS gf180mcu_fd_sc_mcu7t5v0__clkinv_1
X_07787_ _09946_/A1 _07787_/A2 _07787_/B _10214_/D VDD VDD VSS VSS
+ gf180mcu_fd_sc_mcu7t5v0__oai21_1
X_06807_ _06806_/B _06807_/A2 _06807_/A3 _06849_/B VDD VDD VSS VSS
+ gf180mcu_fd_sc_mcu7t5v0__or3_1
X_09526_ _10964_/Q _09538_/A2 _09527_/B VDD VDD VSS VSS gf180mcu_fd_sc_mcu7t5v0__nand2_1
X_06738_ _10050_/Q _07601_/B _06785_/A1 VDD VDD VSS VSS gf180mcu_fd_sc_mcu7t5v0__nand2_1
X_09457_ _06058_/Z _09461_/A2 _09461_/B1 _09457_/B2 _10910_/D VDD VDD
+ VSS VSS gf180mcu_fd_sc_mcu7t5v0__oai22_1
X_08408_ _09332_/A2 _08408_/A2 _08408_/B1 _09889_/A2 _08429_/A2 VDD VDD
+ VSS VSS gf180mcu_fd_sc_mcu7t5v0__aoi22_1
X_06669_ _06669_/A1 _06667_/Z _06669_/Z VDD VDD VSS VSS gf180mcu_fd_sc_mcu7t5v0__xor2_1
X_09388_ _06061_/Z _09391_/A2 _09391_/B1 _09388_/B2 _10855_/D VDD VDD
+ VSS VSS gf180mcu_fd_sc_mcu7t5v0__oai22_1
X_08339_ _10343_/Q _08591_/A2 _08589_/B1 _11122_/Q _08342_/A1 VDD VDD
+ VSS VSS gf180mcu_fd_sc_mcu7t5v0__aoi22_1
X_10301_ _10301_/D _11101_/CLK _10301_/Q VDD VDD VSS VSS gf180mcu_fd_sc_mcu7t5v0__dffq_2
X_10232_ _10232_/D _11101_/CLK _10232_/Q VDD VDD VSS VSS gf180mcu_fd_sc_mcu7t5v0__dffq_1
X_10163_ _10163_/D _11176_/CLK _10163_/Q VDD VDD VSS VSS gf180mcu_fd_sc_mcu7t5v0__dffq_1
X_10094_ _10094_/D _10905_/CLK _10094_/Q VDD VDD VSS VSS gf180mcu_fd_sc_mcu7t5v0__dffq_1
X_10996_ _10996_/D _11147_/CLK _10996_/Q VDD VDD VSS VSS gf180mcu_fd_sc_mcu7t5v0__dffq_1
X_05971_ _09811_/B _09795_/A2 _05971_/A3 _10300_/D VDD VDD VSS VSS
+ gf180mcu_fd_sc_mcu7t5v0__nand3_1
X_07710_ _08528_/B1 _07809_/A2 _07727_/A2 VDD VDD VSS VSS gf180mcu_fd_sc_mcu7t5v0__nand2_2
X_08690_ _08690_/A1 _08690_/A2 _09900_/B _10335_/D VDD VDD VSS VSS
+ gf180mcu_fd_sc_mcu7t5v0__aoi21_1
X_07641_ _09645_/A1 _09851_/A1 _09900_/B _07656_/A2 VDD VDD VSS VSS
+ gf180mcu_fd_sc_mcu7t5v0__aoi21_4
X_07572_ _10006_/Q _07572_/A2 _07617_/A2 VDD VDD VSS VSS gf180mcu_fd_sc_mcu7t5v0__nand2_1
X_09311_ _09916_/A1 _09311_/A2 _09311_/B1 _09311_/B2 _10794_/D VDD VDD
+ VSS VSS gf180mcu_fd_sc_mcu7t5v0__oai22_1
X_06523_ _09754_/B _06531_/A2 _06531_/B1 VDD VDD VSS VSS gf180mcu_fd_sc_mcu7t5v0__nand2_2
X_09242_ _09502_/A1 _09662_/A2 _09251_/A2 VDD VDD VSS VSS gf180mcu_fd_sc_mcu7t5v0__nand2_4
X_06454_ _06455_/A1 _06455_/A2 _06497_/A2 VDD VDD VSS VSS gf180mcu_fd_sc_mcu7t5v0__nor2_1
X_05405_ _10414_/Q _08795_/B2 VDD VDD VSS VSS gf180mcu_fd_sc_mcu7t5v0__clkinv_1
X_09173_ _09193_/A1 _09181_/A2 _09181_/B1 VDD VDD VSS VSS gf180mcu_fd_sc_mcu7t5v0__nand2_2
X_06385_ _10002_/Q _06484_/A2 _06493_/A1 VDD VDD VSS VSS gf180mcu_fd_sc_mcu7t5v0__nand2_1
X_05336_ _10645_/Q _09126_/B2 VDD VDD VSS VSS gf180mcu_fd_sc_mcu7t5v0__clkinv_1
X_08124_ _10034_/Q _08528_/A2 _08586_/A2 _09965_/Q _08564_/C1 _10026_/Q _08126_/A2
+ VDD VDD VSS VSS gf180mcu_fd_sc_mcu7t5v0__aoi222_1
X_08055_ _10636_/Q _08584_/A2 _08584_/B1 _10660_/Q _08058_/A1 VDD VDD
+ VSS VSS gf180mcu_fd_sc_mcu7t5v0__aoi22_1
X_05267_ _10184_/Q _07742_/B2 VDD VDD VSS VSS gf180mcu_fd_sc_mcu7t5v0__clkinv_1
X_05198_ _10428_/Q _08813_/B2 VDD VDD VSS VSS gf180mcu_fd_sc_mcu7t5v0__clkinv_1
X_07006_ _10084_/Q _07020_/A2 _07024_/B VDD VDD VSS VSS gf180mcu_fd_sc_mcu7t5v0__nand2_1
X_08957_ _06058_/Z _08961_/A2 _08961_/B1 _08957_/B2 _10510_/D VDD VDD
+ VSS VSS gf180mcu_fd_sc_mcu7t5v0__oai22_1
X_08888_ _10464_/Q _08892_/A2 _08889_/B VDD VDD VSS VSS gf180mcu_fd_sc_mcu7t5v0__nand2_1
X_07908_ _08632_/A1 _07920_/A2 _07908_/B _10273_/D VDD VDD VSS VSS
+ gf180mcu_fd_sc_mcu7t5v0__aoi21_1
X_07839_ _10242_/Q _07842_/A2 _07840_/B VDD VDD VSS VSS gf180mcu_fd_sc_mcu7t5v0__nor2_1
X_10850_ _10850_/D _11165_/CLK _10850_/Q VDD VDD VSS VSS gf180mcu_fd_sc_mcu7t5v0__dffq_1
X_09509_ _09944_/A1 _09511_/A2 _09511_/B1 _09509_/B2 _10952_/D VDD VDD
+ VSS VSS gf180mcu_fd_sc_mcu7t5v0__oai22_1
X_10781_ _10781_/D _11010_/CLK _10781_/Q VDD VDD VSS VSS gf180mcu_fd_sc_mcu7t5v0__dffq_1
X_10215_ _10215_/D _11149_/CLK _10215_/Q VDD VDD VSS VSS gf180mcu_fd_sc_mcu7t5v0__dffq_1
X_10146_ _10146_/D _11164_/CLK _10146_/Q VDD VDD VSS VSS gf180mcu_fd_sc_mcu7t5v0__dffq_1
X_10077_ _10077_/D _11039_/CLK _10077_/Q VDD VDD VSS VSS gf180mcu_fd_sc_mcu7t5v0__dffq_2
X_10979_ _10979_/D _11039_/CLK _10979_/Q VDD VDD VSS VSS gf180mcu_fd_sc_mcu7t5v0__dffq_1
X_06170_ _06223_/A3 _08675_/A2 _06170_/B _09995_/D VDD VDD VSS VSS
+ gf180mcu_fd_sc_mcu7t5v0__aoi21_1
X_05121_ _10619_/Q _09094_/B2 VDD VDD VSS VSS gf180mcu_fd_sc_mcu7t5v0__clkinv_1
X_05052_ _10013_/Q _07124_/A1 VDD VDD VSS VSS gf180mcu_fd_sc_mcu7t5v0__clkinv_2
X_09860_ _09926_/A1 _09860_/A2 _09860_/B1 _09860_/B2 _11125_/D VDD VDD
+ VSS VSS gf180mcu_fd_sc_mcu7t5v0__oai22_1
X_08811_ _09599_/A1 _08819_/A2 _08819_/B1 VDD VDD VSS VSS gf180mcu_fd_sc_mcu7t5v0__nand2_2
X_09791_ _09791_/A1 _09795_/A2 _09791_/B _11088_/D VDD VDD VSS VSS
+ gf180mcu_fd_sc_mcu7t5v0__aoi21_1
X_08742_ _06047_/Z _08749_/A2 _08749_/B1 _08742_/B2 _10371_/D VDD VDD
+ VSS VSS gf180mcu_fd_sc_mcu7t5v0__oai22_1
X_05954_ _11051_/Q _09728_/A1 _08626_/A2 _05954_/Z VDD VDD VSS VSS
+ gf180mcu_fd_sc_mcu7t5v0__or3_1
X_08673_ _08673_/A1 _08675_/A2 _08673_/B _10329_/D VDD VDD VSS VSS
+ gf180mcu_fd_sc_mcu7t5v0__aoi21_1
X_07624_ _10126_/Q _07624_/A2 _07635_/A2 _07637_/A2 VDD VDD VSS VSS
+ gf180mcu_fd_sc_mcu7t5v0__xnor3_1
X_05885_ _10198_/Q _07758_/B2 VDD VDD VSS VSS gf180mcu_fd_sc_mcu7t5v0__clkinv_1
X_07555_ _10337_/Q _07328_/Z _07558_/B1 VDD VDD VSS VSS gf180mcu_fd_sc_mcu7t5v0__nand2_1
X_06506_ _07628_/A1 _06506_/A2 _06508_/A2 VDD VDD VSS VSS gf180mcu_fd_sc_mcu7t5v0__nor2_1
X_07486_ _07589_/B _07589_/A2 _07487_/A2 VDD VDD VSS VSS gf180mcu_fd_sc_mcu7t5v0__nand2_1
X_09225_ _09920_/A1 _09231_/A2 _09231_/B1 _09225_/B2 _10724_/D VDD VDD
+ VSS VSS gf180mcu_fd_sc_mcu7t5v0__oai22_1
X_06437_ _06389_/I _06437_/A2 _06437_/B _06452_/A1 VDD VDD VSS VSS
+ gf180mcu_fd_sc_mcu7t5v0__oai21_1
X_06368_ _06368_/A1 _06368_/A2 _06368_/B _06417_/A2 VDD VDD VSS VSS
+ gf180mcu_fd_sc_mcu7t5v0__aoi21_1
X_09156_ _09941_/A1 _09161_/A2 _09161_/B1 _09156_/B2 _10669_/D VDD VDD
+ VSS VSS gf180mcu_fd_sc_mcu7t5v0__oai22_1
X_05319_ _10509_/Q _08956_/B2 VDD VDD VSS VSS gf180mcu_fd_sc_mcu7t5v0__clkinv_1
X_09087_ _06058_/Z _09091_/A2 _09091_/B1 _09087_/B2 _10614_/D VDD VDD
+ VSS VSS gf180mcu_fd_sc_mcu7t5v0__oai22_1
X_08107_ _08107_/A1 _08107_/A2 _08107_/A3 _08113_/A2 VDD VDD VSS VSS
+ gf180mcu_fd_sc_mcu7t5v0__nand3_1
X_06299_ _10000_/Q _06484_/A2 _06342_/A1 VDD VDD VSS VSS gf180mcu_fd_sc_mcu7t5v0__nand2_1
X_08038_ _09365_/B2 _08585_/A2 _08581_/A2 _09355_/B2 _08039_/C VDD VDD
+ VSS VSS gf180mcu_fd_sc_mcu7t5v0__oai22_1
X_10000_ _10000_/D _11150_/CLK _10000_/Q VDD VDD VSS VSS gf180mcu_fd_sc_mcu7t5v0__dffq_4
X_09989_ _09989_/D _11163_/CLK _09989_/Q VDD VDD VSS VSS gf180mcu_fd_sc_mcu7t5v0__dffq_1
X_10902_ _10902_/D _11176_/CLK _10902_/Q VDD VDD VSS VSS gf180mcu_fd_sc_mcu7t5v0__dffq_1
X_10833_ _10833_/D _11165_/CLK _10833_/Q VDD VDD VSS VSS gf180mcu_fd_sc_mcu7t5v0__dffq_1
Xrepeater25 _08590_/B1 _08573_/B1 VDD VDD VSS VSS gf180mcu_fd_sc_mcu7t5v0__buf_16
X_10764_ _10764_/D _11010_/CLK _10764_/Q VDD VDD VSS VSS gf180mcu_fd_sc_mcu7t5v0__dffq_1
Xrepeater36 _08580_/A2 _08589_/A2 VDD VDD VSS VSS gf180mcu_fd_sc_mcu7t5v0__buf_8
Xrepeater14 _08584_/A2 _06112_/I VDD VDD VSS VSS gf180mcu_fd_sc_mcu7t5v0__buf_16
Xrepeater58 _09193_/A1 _08514_/B VDD VDD VSS VSS gf180mcu_fd_sc_mcu7t5v0__buf_12
Xrepeater47 _09884_/A1 _09924_/A1 VDD VDD VSS VSS gf180mcu_fd_sc_mcu7t5v0__buf_12
X_10695_ _10695_/D _11139_/CLK _10695_/Q VDD VDD VSS VSS gf180mcu_fd_sc_mcu7t5v0__dffq_1
X_11178_ _11178_/D _11181_/CLK _11178_/Q VDD VDD VSS VSS gf180mcu_fd_sc_mcu7t5v0__dffq_1
X_10129_ _10129_/D _11164_/CLK _10129_/Q VDD VDD VSS VSS gf180mcu_fd_sc_mcu7t5v0__dffq_1
X_05670_ _10376_/Q _08747_/B2 VDD VDD VSS VSS gf180mcu_fd_sc_mcu7t5v0__clkinv_1
X_07340_ _10114_/Q _07349_/A2 _07632_/I1 VDD VDD VSS VSS gf180mcu_fd_sc_mcu7t5v0__nor2_2
X_09010_ _09945_/A1 _09011_/A2 _09011_/B1 _09010_/B2 _10553_/D VDD VDD
+ VSS VSS gf180mcu_fd_sc_mcu7t5v0__oai22_1
X_07271_ _09884_/A1 _07275_/A2 _07271_/B _10095_/D VDD VDD VSS VSS
+ gf180mcu_fd_sc_mcu7t5v0__oai21_1
X_06222_ _06222_/A1 _06222_/A2 _06327_/B VDD VDD VSS VSS gf180mcu_fd_sc_mcu7t5v0__nor2_4
X_06153_ _06047_/Z _06167_/A2 _06153_/B _09987_/D VDD VDD VSS VSS
+ gf180mcu_fd_sc_mcu7t5v0__oai21_1
X_05104_ _10891_/Q _09434_/B2 VDD VDD VSS VSS gf180mcu_fd_sc_mcu7t5v0__clkinv_1
X_06084_ _09442_/A1 _09889_/A1 _06093_/A2 VDD VDD VSS VSS gf180mcu_fd_sc_mcu7t5v0__nand2_4
X_09912_ _09924_/A1 _09916_/A2 _09912_/B _11155_/D VDD VDD VSS VSS
+ gf180mcu_fd_sc_mcu7t5v0__oai21_1
X_05035_ _10083_/Q _07361_/A2 VDD VDD VSS VSS gf180mcu_fd_sc_mcu7t5v0__clkinv_3
X_09843_ _11114_/Q _09849_/A2 _09844_/B VDD VDD VSS VSS gf180mcu_fd_sc_mcu7t5v0__nand2_1
X_09774_ _09772_/Z _09774_/A2 _11080_/D VDD VDD VSS VSS gf180mcu_fd_sc_mcu7t5v0__nor2_1
X_06986_ _06991_/A1 _06985_/Z _06988_/A2 VDD VDD VSS VSS gf180mcu_fd_sc_mcu7t5v0__nor2_1
X_08725_ _06058_/Z _08729_/A2 _08729_/B1 _08725_/B2 _10358_/D VDD VDD
+ VSS VSS gf180mcu_fd_sc_mcu7t5v0__oai22_1
X_05937_ _10447_/Q _10449_/Q _05938_/A3 VDD VDD VSS VSS gf180mcu_fd_sc_mcu7t5v0__nand2_1
X_05868_ _10666_/Q _09151_/B2 VDD VDD VSS VSS gf180mcu_fd_sc_mcu7t5v0__clkinv_1
X_08656_ _08656_/A1 _07601_/B _08657_/C VDD VDD VSS VSS gf180mcu_fd_sc_mcu7t5v0__nor2_1
X_07607_ _10000_/Q _07606_/Z _07619_/A1 VDD VDD VSS VSS gf180mcu_fd_sc_mcu7t5v0__nand2_1
X_08587_ _09161_/B2 _08587_/A2 _08587_/B1 _09191_/B2 _08587_/C _08588_/A2 VDD
+ VDD VSS VSS gf180mcu_fd_sc_mcu7t5v0__oai221_2
X_07538_ _07508_/Z _07538_/A2 _07540_/A2 VDD VDD VSS VSS gf180mcu_fd_sc_mcu7t5v0__xnor2_1
X_05799_ _10141_/Q _07666_/B2 VDD VDD VSS VSS gf180mcu_fd_sc_mcu7t5v0__clkinv_1
X_07469_ _07470_/A1 _07485_/A1 _07522_/A1 VDD VDD VSS VSS gf180mcu_fd_sc_mcu7t5v0__nor2_1
X_10480_ _10480_/D _11139_/CLK _10480_/Q VDD VDD VSS VSS gf180mcu_fd_sc_mcu7t5v0__dffq_1
X_09208_ _06061_/Z _09211_/A2 _09211_/B1 _09208_/B2 _10711_/D VDD VDD
+ VSS VSS gf180mcu_fd_sc_mcu7t5v0__oai22_1
X_09139_ _09944_/A1 _09141_/A2 _09141_/B1 _09139_/B2 _10656_/D VDD VDD
+ VSS VSS gf180mcu_fd_sc_mcu7t5v0__oai22_1
X_11101_ _11101_/D _11101_/CLK _11101_/Q VDD VDD VSS VSS gf180mcu_fd_sc_mcu7t5v0__dffq_1
X_11032_ _11032_/D _11039_/CLK _11032_/Q VDD VDD VSS VSS gf180mcu_fd_sc_mcu7t5v0__dffq_1
X_10816_ _10816_/D _11010_/CLK _10816_/Q VDD VDD VSS VSS gf180mcu_fd_sc_mcu7t5v0__dffq_1
X_10747_ _10747_/D _10978_/CLK _10747_/Q VDD VDD VSS VSS gf180mcu_fd_sc_mcu7t5v0__dffq_1
X_10678_ _10678_/D _11138_/CLK _10678_/Q VDD VDD VSS VSS gf180mcu_fd_sc_mcu7t5v0__dffq_1
X_06840_ _06840_/A1 _06840_/A2 _06861_/A1 VDD VDD VSS VSS gf180mcu_fd_sc_mcu7t5v0__nand2_1
X_06771_ _06823_/B _06823_/A1 _06771_/B _06772_/A2 VDD VDD VSS VSS
+ gf180mcu_fd_sc_mcu7t5v0__aoi21_1
X_09490_ _09945_/A1 _09491_/A2 _09491_/B1 _09490_/B2 _10937_/D VDD VDD
+ VSS VSS gf180mcu_fd_sc_mcu7t5v0__oai22_1
X_08510_ _11108_/Q _08559_/A2 _08576_/B1 _10537_/Q _08511_/A3 VDD VDD
+ VSS VSS gf180mcu_fd_sc_mcu7t5v0__aoi22_1
X_05722_ _10880_/Q _09419_/B2 VDD VDD VSS VSS gf180mcu_fd_sc_mcu7t5v0__clkinv_1
X_08441_ _08441_/A1 _08441_/A2 _08441_/A3 _08442_/B1 VDD VDD VSS VSS
+ gf180mcu_fd_sc_mcu7t5v0__nand3_1
X_05653_ _10640_/Q _09119_/B2 VDD VDD VSS VSS gf180mcu_fd_sc_mcu7t5v0__clkinv_1
X_08372_ _08372_/A1 _08372_/A2 _08372_/A3 _08377_/A2 VDD VDD VSS VSS
+ gf180mcu_fd_sc_mcu7t5v0__nand3_1
X_05584_ _09959_/Q _06090_/B2 VDD VDD VSS VSS gf180mcu_fd_sc_mcu7t5v0__clkinv_1
X_07323_ _10115_/Q _10114_/Q _07496_/A1 VDD VDD VSS VSS gf180mcu_fd_sc_mcu7t5v0__nand2_2
X_07254_ _07679_/A1 _07254_/A2 _09834_/A2 VDD VDD VSS VSS gf180mcu_fd_sc_mcu7t5v0__nor2_4
X_06205_ _09995_/Q _06215_/A2 _06372_/B2 VDD VDD VSS VSS gf180mcu_fd_sc_mcu7t5v0__nor2_2
X_07185_ _07186_/A1 _07186_/A2 _07232_/B VDD VDD VSS VSS gf180mcu_fd_sc_mcu7t5v0__nand2_1
X_06136_ _06058_/Z _06144_/A2 _06136_/B _09982_/D VDD VDD VSS VSS
+ gf180mcu_fd_sc_mcu7t5v0__oai21_1
X_06067_ _09953_/Q _06071_/A2 _06070_/B VDD VDD VSS VSS gf180mcu_fd_sc_mcu7t5v0__nand2_1
X_05018_ _10265_/Q _07890_/A1 VDD VDD VSS VSS gf180mcu_fd_sc_mcu7t5v0__clkinv_1
X_09826_ _09904_/A1 _09832_/A2 _09832_/B1 _09826_/B2 _11103_/D VDD VDD
+ VSS VSS gf180mcu_fd_sc_mcu7t5v0__oai22_1
X_09757_ _11075_/Q _09753_/Z _09757_/Z VDD VDD VSS VSS gf180mcu_fd_sc_mcu7t5v0__and2_1
X_06969_ _07431_/A1 _06968_/Z _07013_/A1 VDD VDD VSS VSS gf180mcu_fd_sc_mcu7t5v0__nor2_1
X_08708_ _09897_/A1 _08709_/A2 _08709_/B1 _08708_/B2 _10345_/D VDD VDD
+ VSS VSS gf180mcu_fd_sc_mcu7t5v0__oai22_1
X_09688_ _11055_/Q _10289_/Q _09690_/A2 VDD VDD VSS VSS gf180mcu_fd_sc_mcu7t5v0__nand2_1
X_08639_ _08659_/A1 _08639_/A2 _08639_/B _10317_/D VDD VDD VSS VSS
+ gf180mcu_fd_sc_mcu7t5v0__aoi21_1
X_10601_ _10601_/D _11138_/CLK _10601_/Q VDD VDD VSS VSS gf180mcu_fd_sc_mcu7t5v0__dffq_1
X_10532_ _10532_/D _11109_/CLK _10532_/Q VDD VDD VSS VSS gf180mcu_fd_sc_mcu7t5v0__dffq_1
X_10463_ _10463_/D _11139_/CLK _10463_/Q VDD VDD VSS VSS gf180mcu_fd_sc_mcu7t5v0__dffq_1
X_10394_ _10394_/D _11018_/CLK _10394_/Q VDD VDD VSS VSS gf180mcu_fd_sc_mcu7t5v0__dffq_1
X_11015_ _11015_/D _11017_/CLK _11015_/Q VDD VDD VSS VSS gf180mcu_fd_sc_mcu7t5v0__dffq_1
X_08990_ _09925_/A1 _08991_/A2 _08991_/B1 _08990_/B2 _10537_/D VDD VDD
+ VSS VSS gf180mcu_fd_sc_mcu7t5v0__oai22_1
X_07941_ _08722_/B2 _08585_/A2 _08581_/A2 _09434_/B2 _07942_/C VDD VDD
+ VSS VSS gf180mcu_fd_sc_mcu7t5v0__oai22_2
X_07872_ bus_wdata[3] _10257_/Q _07874_/S _07872_/Z VDD VDD VSS VSS
+ gf180mcu_fd_sc_mcu7t5v0__mux2_1
X_09611_ _06047_/Z _09625_/A2 _09611_/B _11019_/D VDD VDD VSS VSS
+ gf180mcu_fd_sc_mcu7t5v0__oai21_1
X_06823_ _06823_/A1 _06771_/B _06847_/A2 _06823_/B _06868_/A1 VDD VDD
+ VSS VSS gf180mcu_fd_sc_mcu7t5v0__oai31_1
X_09542_ _06047_/Z _09549_/A2 _09549_/B1 _09542_/B2 _10971_/D VDD VDD
+ VSS VSS gf180mcu_fd_sc_mcu7t5v0__oai22_1
X_06754_ _06756_/A1 _06849_/A1 _06801_/B VDD VDD VSS VSS gf180mcu_fd_sc_mcu7t5v0__nor2_1
X_05705_ _11131_/Q _09868_/B2 VDD VDD VSS VSS gf180mcu_fd_sc_mcu7t5v0__clkinv_1
X_09473_ _09824_/A1 _09481_/A2 _09481_/B1 VDD VDD VSS VSS gf180mcu_fd_sc_mcu7t5v0__nand2_4
X_06685_ _06607_/B _06728_/A2 _06678_/Z _06685_/B _06686_/B VDD VDD VSS
+ VSS gf180mcu_fd_sc_mcu7t5v0__oai31_1
X_05636_ _10504_/Q _08949_/B2 VDD VDD VSS VSS gf180mcu_fd_sc_mcu7t5v0__clkinv_1
X_08424_ _10576_/Q _08584_/A2 _08564_/C1 _10568_/Q _08427_/A2 VDD VDD
+ VSS VSS gf180mcu_fd_sc_mcu7t5v0__aoi22_1
X_08355_ _10608_/Q _08563_/A2 _06877_/Z _10616_/Q _08563_/C1 _10648_/Q _08358_/A1
+ VDD VDD VSS VSS gf180mcu_fd_sc_mcu7t5v0__aoi222_2
X_05567_ _10195_/Q _07755_/B2 VDD VDD VSS VSS gf180mcu_fd_sc_mcu7t5v0__clkinv_1
X_07306_ _10111_/Q _07310_/A2 _07307_/B VDD VDD VSS VSS gf180mcu_fd_sc_mcu7t5v0__nand2_1
X_08286_ _10975_/Q _08555_/A2 _08584_/B1 _10751_/Q _07680_/I _10911_/Q _08287_/A3
+ VDD VDD VSS VSS gf180mcu_fd_sc_mcu7t5v0__aoi222_2
X_05498_ _10782_/Q _09297_/B2 VDD VDD VSS VSS gf180mcu_fd_sc_mcu7t5v0__clkinv_1
X_07237_ _10089_/Q _07237_/A2 _07250_/A2 _07237_/Z VDD VDD VSS VSS
+ gf180mcu_fd_sc_mcu7t5v0__xor3_1
X_07168_ _07168_/A1 _07231_/A2 _07168_/B1 _07168_/B2 _07170_/A2 VDD VDD
+ VSS VSS gf180mcu_fd_sc_mcu7t5v0__oai22_1
X_06119_ _06058_/Z _06123_/A2 _06123_/B1 _06119_/B2 _09974_/D VDD VDD
+ VSS VSS gf180mcu_fd_sc_mcu7t5v0__oai22_1
X_07099_ _10086_/Q _07097_/Z _07120_/B VDD VDD VSS VSS gf180mcu_fd_sc_mcu7t5v0__nand2_1
X_09809_ _11098_/Q _09817_/A2 _09809_/B _09810_/B VDD VDD VSS VSS
+ gf180mcu_fd_sc_mcu7t5v0__oai21_1
X_10515_ _10515_/D _11018_/CLK _10515_/Q VDD VDD VSS VSS gf180mcu_fd_sc_mcu7t5v0__dffq_1
X_10446_ _10446_/D _11101_/CLK _10446_/Q VDD VDD VSS VSS gf180mcu_fd_sc_mcu7t5v0__dffq_1
X_10377_ _10377_/D _11147_/CLK _10377_/Q VDD VDD VSS VSS gf180mcu_fd_sc_mcu7t5v0__dffq_1
X_06470_ _06470_/A1 _06470_/A2 _06470_/B _06472_/A2 VDD VDD VSS VSS
+ gf180mcu_fd_sc_mcu7t5v0__aoi21_1
X_05421_ _11105_/Q _09828_/B2 VDD VDD VSS VSS gf180mcu_fd_sc_mcu7t5v0__clkinv_1
X_08140_ _08724_/B2 _08585_/A2 _08140_/B _08141_/B1 VDD VDD VSS VSS
+ gf180mcu_fd_sc_mcu7t5v0__oai21_1
X_05352_ _10373_/Q _08744_/B2 VDD VDD VSS VSS gf180mcu_fd_sc_mcu7t5v0__clkinv_1
X_05283_ _10756_/Q _09265_/B2 VDD VDD VSS VSS gf180mcu_fd_sc_mcu7t5v0__clkinv_1
X_08071_ _10099_/Q _08586_/A2 _08528_/B1 _10168_/Q _08071_/C _08072_/A3 VDD
+ VDD VSS VSS gf180mcu_fd_sc_mcu7t5v0__aoi221_2
X_07022_ _10084_/Q _07601_/B _07022_/B _07023_/A2 VDD VDD VSS VSS
+ gf180mcu_fd_sc_mcu7t5v0__aoi21_1
X_08973_ _09824_/A1 _08981_/A2 _08981_/B1 VDD VDD VSS VSS gf180mcu_fd_sc_mcu7t5v0__nand2_2
X_07924_ _10675_/Q _06877_/Z _08532_/A2 _10715_/Q _07925_/I VDD VDD VSS
+ VSS gf180mcu_fd_sc_mcu7t5v0__aoi22_1
X_07855_ _10249_/Q _07864_/A2 _07856_/B VDD VDD VSS VSS gf180mcu_fd_sc_mcu7t5v0__nor2_1
X_04998_ cgra_status[1] _05996_/A1 VDD VDD VSS VSS gf180mcu_fd_sc_mcu7t5v0__clkinv_1
X_07786_ _10214_/Q _07786_/A2 _07787_/B VDD VDD VSS VSS gf180mcu_fd_sc_mcu7t5v0__nand2_1
X_06806_ _06807_/A2 _06807_/A3 _06806_/B _06808_/A1 VDD VDD VSS VSS
+ gf180mcu_fd_sc_mcu7t5v0__oai21_1
X_09525_ _06047_/Z _09539_/A2 _09525_/B _10963_/D VDD VDD VSS VSS
+ gf180mcu_fd_sc_mcu7t5v0__oai21_1
X_06737_ _06737_/A1 _07601_/B _06737_/B1 _06737_/B2 _07603_/B _10049_/D VDD
+ VDD VSS VSS gf180mcu_fd_sc_mcu7t5v0__aoi221_1
X_09456_ _09893_/A1 _09461_/A2 _09461_/B1 _09456_/B2 _10909_/D VDD VDD
+ VSS VSS gf180mcu_fd_sc_mcu7t5v0__oai22_1
X_06668_ _06669_/A1 _06667_/Z _06716_/A1 VDD VDD VSS VSS gf180mcu_fd_sc_mcu7t5v0__nand2_1
X_08407_ _08407_/A1 _08407_/A2 _08407_/A3 _08408_/B1 VDD VDD VSS VSS
+ gf180mcu_fd_sc_mcu7t5v0__nand3_1
X_05619_ _10488_/Q _08929_/B2 VDD VDD VSS VSS gf180mcu_fd_sc_mcu7t5v0__clkinv_1
X_09387_ _06058_/Z _09391_/A2 _09391_/B1 _09387_/B2 _10854_/D VDD VDD
+ VSS VSS gf180mcu_fd_sc_mcu7t5v0__oai22_1
X_06599_ _10000_/Q _06804_/A3 _06607_/A1 VDD VDD VSS VSS gf180mcu_fd_sc_mcu7t5v0__nor2_1
X_08338_ _09959_/Q _08563_/A2 _08584_/B1 _10367_/Q _08338_/C _08344_/B1 VDD
+ VDD VSS VSS gf180mcu_fd_sc_mcu7t5v0__aoi221_2
X_08269_ _09062_/A2 _08269_/A2 _08269_/B1 _08588_/B _08269_/C _08270_/A2 VDD
+ VDD VSS VSS gf180mcu_fd_sc_mcu7t5v0__aoi221_2
X_10300_ _10300_/D _11101_/CLK _10300_/Q VDD VDD VSS VSS gf180mcu_fd_sc_mcu7t5v0__dffq_1
X_10231_ _10231_/D _11101_/CLK _10231_/Q VDD VDD VSS VSS gf180mcu_fd_sc_mcu7t5v0__dffq_1
X_10162_ _10162_/D _10905_/CLK _10162_/Q VDD VDD VSS VSS gf180mcu_fd_sc_mcu7t5v0__dffq_1
X_10093_ _10093_/D _10905_/CLK _10093_/Q VDD VDD VSS VSS gf180mcu_fd_sc_mcu7t5v0__dffq_1
X_10995_ _10995_/D _11147_/CLK _10995_/Q VDD VDD VSS VSS gf180mcu_fd_sc_mcu7t5v0__dffq_1
X_10429_ _10429_/D _11017_/CLK _10429_/Q VDD VDD VSS VSS gf180mcu_fd_sc_mcu7t5v0__dffq_1
X_05970_ _11064_/Q _10300_/Q _05971_/A3 VDD VDD VSS VSS gf180mcu_fd_sc_mcu7t5v0__nand2_1
X_07640_ _09645_/A1 _09851_/A1 _07657_/A2 VDD VDD VSS VSS gf180mcu_fd_sc_mcu7t5v0__nand2_2
X_07571_ _10006_/Q _07609_/A2 _07574_/A3 VDD VDD VSS VSS gf180mcu_fd_sc_mcu7t5v0__nand2_1
X_09310_ _09925_/A1 _09311_/A2 _09311_/B1 _09310_/B2 _10793_/D VDD VDD
+ VSS VSS gf180mcu_fd_sc_mcu7t5v0__oai22_1
X_06522_ _09937_/A1 _09871_/A1 _06531_/A2 VDD VDD VSS VSS gf180mcu_fd_sc_mcu7t5v0__nand2_4
X_09241_ _09832_/A1 _09241_/A2 _09241_/B1 _09241_/B2 _10738_/D VDD VDD
+ VSS VSS gf180mcu_fd_sc_mcu7t5v0__oai22_1
X_06453_ _06478_/A1 _06478_/A2 _06455_/A2 VDD VDD VSS VSS gf180mcu_fd_sc_mcu7t5v0__xnor2_1
X_05404_ _10877_/Q _09416_/B2 VDD VDD VSS VSS gf180mcu_fd_sc_mcu7t5v0__clkinv_1
X_09172_ _09502_/A1 _08588_/B _09181_/A2 VDD VDD VSS VSS gf180mcu_fd_sc_mcu7t5v0__nand2_4
X_06384_ _10000_/Q _06483_/A2 _06434_/B2 VDD VDD VSS VSS gf180mcu_fd_sc_mcu7t5v0__nand2_1
X_05335_ _10637_/Q _09116_/B2 VDD VDD VSS VSS gf180mcu_fd_sc_mcu7t5v0__clkinv_1
X_08123_ _10055_/Q _06877_/Z _08532_/A2 _11168_/Q _08563_/C1 _11176_/Q _08126_/A1
+ VDD VDD VSS VSS gf180mcu_fd_sc_mcu7t5v0__aoi222_2
X_08054_ _08054_/A1 _08054_/A2 _08054_/A3 _08098_/B1 VDD VDD VSS VSS
+ gf180mcu_fd_sc_mcu7t5v0__nand3_2
X_05266_ _09956_/Q _06087_/B2 VDD VDD VSS VSS gf180mcu_fd_sc_mcu7t5v0__clkinv_1
X_07005_ _10084_/Q _07020_/A2 _07024_/A2 VDD VDD VSS VSS gf180mcu_fd_sc_mcu7t5v0__nor2_1
X_05197_ _10436_/Q _08823_/B2 VDD VDD VSS VSS gf180mcu_fd_sc_mcu7t5v0__clkinv_1
X_08956_ _09921_/A1 _08961_/A2 _08961_/B1 _08956_/B2 _10509_/D VDD VDD
+ VSS VSS gf180mcu_fd_sc_mcu7t5v0__oai22_1
X_08887_ _06061_/Z _08893_/A2 _08887_/B _10463_/D VDD VDD VSS VSS
+ gf180mcu_fd_sc_mcu7t5v0__oai21_1
X_07907_ bus_wdata[0] _07920_/A2 _08654_/B _07908_/B VDD VDD VSS VSS
+ gf180mcu_fd_sc_mcu7t5v0__oai21_1
X_07838_ _07860_/A1 _07842_/A2 _07838_/B _09900_/B _10241_/D VDD VDD VSS
+ VSS gf180mcu_fd_sc_mcu7t5v0__aoi211_1
X_07769_ _09926_/A1 _07769_/A2 _07769_/B1 _07769_/B2 _10206_/D VDD VDD
+ VSS VSS gf180mcu_fd_sc_mcu7t5v0__oai22_1
X_09508_ _06061_/Z _09511_/A2 _09511_/B1 _09508_/B2 _10951_/D VDD VDD
+ VSS VSS gf180mcu_fd_sc_mcu7t5v0__oai22_1
X_10780_ _10780_/D _11010_/CLK _10780_/Q VDD VDD VSS VSS gf180mcu_fd_sc_mcu7t5v0__dffq_1
X_09439_ _09924_/A1 _09441_/A2 _09441_/B1 _09439_/B2 _10896_/D VDD VDD
+ VSS VSS gf180mcu_fd_sc_mcu7t5v0__oai22_1
X_10214_ _10214_/D _11052_/CLK _10214_/Q VDD VDD VSS VSS gf180mcu_fd_sc_mcu7t5v0__dffq_1
X_10145_ _10145_/D _11163_/CLK _10145_/Q VDD VDD VSS VSS gf180mcu_fd_sc_mcu7t5v0__dffq_1
X_10076_ _10076_/D _11139_/CLK _10076_/Q VDD VDD VSS VSS gf180mcu_fd_sc_mcu7t5v0__dffq_1
X_10978_ _10978_/D _10978_/CLK _10978_/Q VDD VDD VSS VSS gf180mcu_fd_sc_mcu7t5v0__dffq_1
X_05120_ _10611_/Q _09084_/B2 VDD VDD VSS VSS gf180mcu_fd_sc_mcu7t5v0__clkinv_1
X_05051_ _10015_/Q _06511_/A1 VDD VDD VSS VSS gf180mcu_fd_sc_mcu7t5v0__clkinv_1
X_08810_ _09917_/A2 _09937_/A2 _08819_/A2 VDD VDD VSS VSS gf180mcu_fd_sc_mcu7t5v0__nand2_4
X_09790_ _11096_/Q _09795_/A2 _09811_/B _09791_/B VDD VDD VSS VSS
+ gf180mcu_fd_sc_mcu7t5v0__oai21_1
X_08741_ _09852_/A1 _08749_/A2 _08749_/B1 VDD VDD VSS VSS gf180mcu_fd_sc_mcu7t5v0__nand2_2
X_05953_ bus_we _07876_/A2 _08626_/A2 VDD VDD VSS VSS gf180mcu_fd_sc_mcu7t5v0__nand2_1
X_05884_ _11002_/Q _09587_/B2 VDD VDD VSS VSS gf180mcu_fd_sc_mcu7t5v0__clkinv_1
X_08672_ _10286_/Q _08675_/A2 _08672_/B _08673_/B VDD VDD VSS VSS
+ gf180mcu_fd_sc_mcu7t5v0__oai21_1
X_07623_ _07623_/A1 _07622_/Z _07635_/A2 VDD VDD VSS VSS gf180mcu_fd_sc_mcu7t5v0__xnor2_1
Xclkbuf_leaf_18_clk clkbuf_1_1_0_clk/Z _11150_/CLK VDD VDD VSS VSS
+ gf180mcu_fd_sc_mcu7t5v0__clkbuf_16
X_07554_ _07554_/A1 _07530_/Z _07554_/B _07582_/A1 VDD VDD VSS VSS
+ gf180mcu_fd_sc_mcu7t5v0__aoi21_1
X_06505_ _06505_/A1 _06508_/B1 _06505_/B _06506_/A2 VDD VDD VSS VSS
+ gf180mcu_fd_sc_mcu7t5v0__aoi21_1
X_07485_ _07485_/A1 _07365_/I _07485_/A3 _07485_/A4 _07589_/A2 VDD VDD
+ VSS VSS gf180mcu_fd_sc_mcu7t5v0__nand4_2
X_09224_ _06047_/Z _09231_/A2 _09231_/B1 _09224_/B2 _10723_/D VDD VDD
+ VSS VSS gf180mcu_fd_sc_mcu7t5v0__oai22_1
X_06436_ _06436_/A1 _06436_/A2 _06478_/A1 VDD VDD VSS VSS gf180mcu_fd_sc_mcu7t5v0__xnor2_1
X_09155_ _09940_/A1 _09161_/A2 _09161_/B1 _09155_/B2 _10668_/D VDD VDD
+ VSS VSS gf180mcu_fd_sc_mcu7t5v0__oai22_1
X_06367_ _06368_/A1 _06368_/A2 _06368_/B _06374_/B1 VDD VDD VSS VSS
+ gf180mcu_fd_sc_mcu7t5v0__nand3_1
X_05318_ _10501_/Q _08946_/B2 VDD VDD VSS VSS gf180mcu_fd_sc_mcu7t5v0__clkinv_1
X_08106_ _10108_/Q _08580_/A2 _08591_/A2 _10477_/Q _09872_/A1 _11136_/Q _08107_/A3
+ VDD VDD VSS VSS gf180mcu_fd_sc_mcu7t5v0__aoi222_1
X_09086_ _09941_/A1 _09091_/A2 _09091_/B1 _09086_/B2 _10613_/D VDD VDD
+ VSS VSS gf180mcu_fd_sc_mcu7t5v0__oai22_1
X_06298_ _06298_/A1 _06298_/A2 _06484_/A2 VDD VDD VSS VSS gf180mcu_fd_sc_mcu7t5v0__nand2_2
X_08037_ _10852_/Q _08584_/A2 _06125_/I _10844_/Q _08040_/A2 VDD VDD VSS
+ VSS gf180mcu_fd_sc_mcu7t5v0__aoi22_1
X_05249_ _10192_/Q _07752_/B2 VDD VDD VSS VSS gf180mcu_fd_sc_mcu7t5v0__clkinv_1
X_09988_ _09988_/D _11163_/CLK _09988_/Q VDD VDD VSS VSS gf180mcu_fd_sc_mcu7t5v0__dffq_1
X_08939_ _09896_/A1 _08941_/A2 _08941_/B1 _08939_/B2 _10496_/D VDD VDD
+ VSS VSS gf180mcu_fd_sc_mcu7t5v0__oai22_1
X_10901_ _10901_/D _11176_/CLK _10901_/Q VDD VDD VSS VSS gf180mcu_fd_sc_mcu7t5v0__dffq_1
X_10832_ _10832_/D _11165_/CLK _10832_/Q VDD VDD VSS VSS gf180mcu_fd_sc_mcu7t5v0__dffq_1
X_10763_ _10763_/D _11010_/CLK _10763_/Q VDD VDD VSS VSS gf180mcu_fd_sc_mcu7t5v0__dffq_1
Xrepeater26 _08560_/B1 _08590_/B1 VDD VDD VSS VSS gf180mcu_fd_sc_mcu7t5v0__buf_16
Xrepeater15 _08528_/B1 _08584_/A2 VDD VDD VSS VSS gf180mcu_fd_sc_mcu7t5v0__buf_16
Xrepeater48 _09811_/B _09754_/B VDD VDD VSS VSS gf180mcu_fd_sc_mcu7t5v0__buf_8
Xrepeater59 _08654_/B _09193_/A1 VDD VDD VSS VSS gf180mcu_fd_sc_mcu7t5v0__buf_8
Xrepeater37 _08580_/A2 _08563_/A2 VDD VDD VSS VSS gf180mcu_fd_sc_mcu7t5v0__buf_12
X_10694_ _10694_/D _11139_/CLK _10694_/Q VDD VDD VSS VSS gf180mcu_fd_sc_mcu7t5v0__dffq_1
X_11177_ _11177_/D _11181_/CLK _11177_/Q VDD VDD VSS VSS gf180mcu_fd_sc_mcu7t5v0__dffq_1
X_10128_ _10128_/D _11164_/CLK _10128_/Q VDD VDD VSS VSS gf180mcu_fd_sc_mcu7t5v0__dffq_1
X_10059_ _10059_/D _11181_/CLK _10059_/Q VDD VDD VSS VSS gf180mcu_fd_sc_mcu7t5v0__dffq_1
X_07270_ _10095_/Q _07274_/A2 _07271_/B VDD VDD VSS VSS gf180mcu_fd_sc_mcu7t5v0__nand2_1
X_06221_ _06221_/A1 _06221_/A2 _06221_/B _06224_/B VDD VDD VSS VSS
+ gf180mcu_fd_sc_mcu7t5v0__oai21_1
X_06152_ _09987_/Q _06166_/A2 _06153_/B VDD VDD VSS VSS gf180mcu_fd_sc_mcu7t5v0__nand2_1
X_05103_ _11102_/Q _09825_/B2 VDD VDD VSS VSS gf180mcu_fd_sc_mcu7t5v0__clkinv_1
X_06083_ _07682_/A1 _08587_/A2 _09889_/A1 VDD VDD VSS VSS gf180mcu_fd_sc_mcu7t5v0__nor2_4
Xclkbuf_leaf_7_clk clkbuf_1_0_0_clk/Z _11147_/CLK VDD VDD VSS VSS
+ gf180mcu_fd_sc_mcu7t5v0__clkbuf_16
X_05034_ _10084_/Q _06264_/A1 VDD VDD VSS VSS gf180mcu_fd_sc_mcu7t5v0__clkinv_1
X_09911_ _11155_/Q _09915_/A2 _09912_/B VDD VDD VSS VSS gf180mcu_fd_sc_mcu7t5v0__nand2_1
X_09842_ _06058_/Z _09850_/A2 _09842_/B _11113_/D VDD VDD VSS VSS
+ gf180mcu_fd_sc_mcu7t5v0__oai21_1
X_09773_ _11080_/Q _09769_/Z _09776_/B _09774_/A2 VDD VDD VSS VSS
+ gf180mcu_fd_sc_mcu7t5v0__oai21_1
X_08724_ _09921_/A1 _08729_/A2 _08729_/B1 _08724_/B2 _10357_/D VDD VDD
+ VSS VSS gf180mcu_fd_sc_mcu7t5v0__oai22_1
X_06985_ _07361_/A2 _06979_/Z _06985_/Z VDD VDD VSS VSS gf180mcu_fd_sc_mcu7t5v0__xor2_1
X_05936_ _08619_/B cgra_status[0] VDD VDD VSS VSS gf180mcu_fd_sc_mcu7t5v0__inv_12
X_05867_ _10658_/Q _09141_/B2 VDD VDD VSS VSS gf180mcu_fd_sc_mcu7t5v0__clkinv_1
X_08655_ _08659_/A1 _08655_/A2 _08655_/B _10321_/D VDD VDD VSS VSS
+ gf180mcu_fd_sc_mcu7t5v0__aoi21_1
X_07606_ _10330_/Q _10089_/Q _10052_/Q _10338_/Q _10118_/Q _10117_/Q _07606_/Z VDD
+ VDD VSS VSS gf180mcu_fd_sc_mcu7t5v0__mux4_4
X_08586_ _10714_/Q _08586_/A2 _06877_/Z _10682_/Q _08587_/C VDD VDD VSS
+ VSS gf180mcu_fd_sc_mcu7t5v0__aoi22_1
X_07537_ _07463_/Z _07589_/A2 _07589_/B _07538_/A2 VDD VDD VSS VSS
+ gf180mcu_fd_sc_mcu7t5v0__oai21_1
X_05798_ _10165_/Q _07708_/B2 VDD VDD VSS VSS gf180mcu_fd_sc_mcu7t5v0__clkinv_1
X_07468_ _07468_/A1 _07473_/A2 _07468_/B1 _07468_/B2 _07507_/B2 VDD VDD
+ VSS VSS gf180mcu_fd_sc_mcu7t5v0__aoi22_2
X_07399_ _07401_/A1 _07401_/A2 _07430_/B VDD VDD VSS VSS gf180mcu_fd_sc_mcu7t5v0__nor2_1
X_06419_ _06505_/A1 _06483_/A2 _06420_/A2 VDD VDD VSS VSS gf180mcu_fd_sc_mcu7t5v0__nand2_1
X_09207_ _06058_/Z _09211_/A2 _09211_/B1 _09207_/B2 _10710_/D VDD VDD
+ VSS VSS gf180mcu_fd_sc_mcu7t5v0__oai22_1
X_09138_ _06061_/Z _09141_/A2 _09141_/B1 _09138_/B2 _10655_/D VDD VDD
+ VSS VSS gf180mcu_fd_sc_mcu7t5v0__oai22_1
X_09069_ _09944_/A1 _09071_/A2 _09071_/B1 _09069_/B2 _10600_/D VDD VDD
+ VSS VSS gf180mcu_fd_sc_mcu7t5v0__oai22_1
X_11100_ _11100_/D _11101_/CLK _11100_/Q VDD VDD VSS VSS gf180mcu_fd_sc_mcu7t5v0__dffq_1
X_11031_ _11031_/D _11164_/CLK _11031_/Q VDD VDD VSS VSS gf180mcu_fd_sc_mcu7t5v0__dffq_1
X_10815_ _10815_/D _11010_/CLK _10815_/Q VDD VDD VSS VSS gf180mcu_fd_sc_mcu7t5v0__dffq_1
X_10746_ _10746_/D _11018_/CLK _10746_/Q VDD VDD VSS VSS gf180mcu_fd_sc_mcu7t5v0__dffq_1
X_10677_ _10677_/D _11139_/CLK _10677_/Q VDD VDD VSS VSS gf180mcu_fd_sc_mcu7t5v0__dffq_1
X_06770_ _06835_/A1 _06766_/Z _06783_/A2 VDD VDD VSS VSS gf180mcu_fd_sc_mcu7t5v0__nand2_1
X_05721_ _10872_/Q _09409_/B2 VDD VDD VSS VSS gf180mcu_fd_sc_mcu7t5v0__clkinv_1
X_08440_ _10345_/Q _08591_/A2 _06125_/I _10353_/Q _08440_/C _08441_/A3 VDD VDD
+ VSS VSS gf180mcu_fd_sc_mcu7t5v0__aoi221_1
X_05652_ _10632_/Q _09109_/B2 VDD VDD VSS VSS gf180mcu_fd_sc_mcu7t5v0__clkinv_1
X_05583_ _10203_/Q _07766_/B2 VDD VDD VSS VSS gf180mcu_fd_sc_mcu7t5v0__clkinv_1
X_08371_ _10952_/Q _06023_/I _08573_/B1 _11131_/Q _06125_/I _10936_/Q _08372_/A3 VDD
+ VDD VSS VSS gf180mcu_fd_sc_mcu7t5v0__aoi222_2
X_07322_ _07341_/A2 _07353_/A3 _07325_/B VDD VDD VSS VSS gf180mcu_fd_sc_mcu7t5v0__nor2_1
X_07253_ _08533_/B2 _08347_/A1 _09523_/A2 VDD VDD VSS VSS gf180mcu_fd_sc_mcu7t5v0__nor2_4
X_06204_ _09997_/Q _06204_/A2 _06215_/A2 VDD VDD VSS VSS gf180mcu_fd_sc_mcu7t5v0__nand2_2
X_07184_ _07178_/I _07183_/Z _07186_/A2 VDD VDD VSS VSS gf180mcu_fd_sc_mcu7t5v0__xnor2_1
X_06135_ _09982_/Q _06143_/A2 _06136_/B VDD VDD VSS VSS gf180mcu_fd_sc_mcu7t5v0__nand2_1
X_06066_ _06074_/A1 _09924_/A1 _06066_/B _09952_/D VDD VDD VSS VSS
+ gf180mcu_fd_sc_mcu7t5v0__oai21_1
X_05017_ _10267_/Q _07895_/A1 VDD VDD VSS VSS gf180mcu_fd_sc_mcu7t5v0__clkinv_1
X_09825_ _06047_/Z _09832_/A2 _09832_/B1 _09825_/B2 _11102_/D VDD VDD
+ VSS VSS gf180mcu_fd_sc_mcu7t5v0__oai22_1
X_09756_ _09756_/A1 _09753_/Z _09755_/I _11074_/D VDD VDD VSS VSS
+ gf180mcu_fd_sc_mcu7t5v0__nor3_1
X_06968_ _07181_/A2 _06970_/A3 _06968_/Z VDD VDD VSS VSS gf180mcu_fd_sc_mcu7t5v0__xor2_1
X_08707_ _09896_/A1 _08709_/A2 _08709_/B1 _08707_/B2 _10344_/D VDD VDD
+ VSS VSS gf180mcu_fd_sc_mcu7t5v0__oai22_1
X_05919_ _10762_/Q _09271_/B2 VDD VDD VSS VSS gf180mcu_fd_sc_mcu7t5v0__clkinv_1
X_09687_ _09687_/A1 _09687_/A2 _11053_/D VDD VDD VSS VSS gf180mcu_fd_sc_mcu7t5v0__nor2_1
X_08638_ _10317_/Q _08659_/A1 _08654_/B _08639_/B VDD VDD VSS VSS
+ gf180mcu_fd_sc_mcu7t5v0__oai21_1
X_06899_ _09946_/A1 _06899_/A2 _06899_/B1 _06899_/B2 _10068_/D VDD VDD
+ VSS VSS gf180mcu_fd_sc_mcu7t5v0__oai22_1
X_08569_ _10311_/Q _08590_/A2 _08590_/B1 _10946_/Q _08591_/C1 _10394_/Q _08570_/A3
+ VDD VDD VSS VSS gf180mcu_fd_sc_mcu7t5v0__aoi222_2
X_10600_ _10600_/D _11138_/CLK _10600_/Q VDD VDD VSS VSS gf180mcu_fd_sc_mcu7t5v0__dffq_1
X_10531_ _10531_/D _11109_/CLK _10531_/Q VDD VDD VSS VSS gf180mcu_fd_sc_mcu7t5v0__dffq_1
X_10462_ _10462_/D _11163_/CLK _10462_/Q VDD VDD VSS VSS gf180mcu_fd_sc_mcu7t5v0__dffq_1
X_10393_ _10393_/D _11018_/CLK _10393_/Q VDD VDD VSS VSS gf180mcu_fd_sc_mcu7t5v0__dffq_1
X_11014_ _11014_/D _11017_/CLK _11014_/Q VDD VDD VSS VSS gf180mcu_fd_sc_mcu7t5v0__dffq_1
X_10729_ _10729_/D _11147_/CLK _10729_/Q VDD VDD VSS VSS gf180mcu_fd_sc_mcu7t5v0__dffq_1
X_07940_ _11102_/Q _08559_/A2 _08591_/C1 _10499_/Q _07943_/A2 VDD VDD
+ VSS VSS gf180mcu_fd_sc_mcu7t5v0__aoi22_2
X_07871_ _08674_/B _07870_/Z _10256_/D VDD VDD VSS VSS gf180mcu_fd_sc_mcu7t5v0__and2_1
X_09610_ _11019_/Q _09624_/A2 _09611_/B VDD VDD VSS VSS gf180mcu_fd_sc_mcu7t5v0__nand2_1
X_06822_ _10051_/Q _06839_/A1 _06835_/A2 _06822_/Z VDD VDD VSS VSS
+ gf180mcu_fd_sc_mcu7t5v0__xor3_1
X_09541_ _09890_/A1 _09549_/A2 _09549_/B1 VDD VDD VSS VSS gf180mcu_fd_sc_mcu7t5v0__nand2_2
X_06753_ _10005_/Q _06557_/Z _06849_/A1 VDD VDD VSS VSS gf180mcu_fd_sc_mcu7t5v0__nand2_1
X_05704_ _10912_/Q _09459_/B2 VDD VDD VSS VSS gf180mcu_fd_sc_mcu7t5v0__clkinv_1
X_09472_ _09927_/A2 _09568_/A2 _09481_/A2 VDD VDD VSS VSS gf180mcu_fd_sc_mcu7t5v0__nand2_4
X_06684_ _06835_/A1 _06669_/Z _06684_/B _06685_/B VDD VDD VSS VSS
+ gf180mcu_fd_sc_mcu7t5v0__aoi21_1
X_05635_ _10360_/Q _08727_/B2 VDD VDD VSS VSS gf180mcu_fd_sc_mcu7t5v0__clkinv_1
X_08423_ _10592_/Q _08582_/A2 _08584_/B1 _10600_/Q _08427_/A1 VDD VDD
+ VSS VSS gf180mcu_fd_sc_mcu7t5v0__aoi22_1
X_05566_ _10999_/Q _09584_/B2 VDD VDD VSS VSS gf180mcu_fd_sc_mcu7t5v0__clkinv_1
X_08354_ _08354_/A1 _08354_/A2 _08354_/A3 _08359_/A2 VDD VDD VSS VSS
+ gf180mcu_fd_sc_mcu7t5v0__nand3_2
X_07305_ _06061_/Z _07311_/A2 _07305_/B _10110_/D VDD VDD VSS VSS
+ gf180mcu_fd_sc_mcu7t5v0__oai21_1
X_08285_ _10919_/Q _08584_/A2 _06125_/I _10935_/Q _10959_/Q _06877_/Z _08287_/A2 VDD
+ VDD VSS VSS gf180mcu_fd_sc_mcu7t5v0__aoi222_2
X_05497_ _10774_/Q _09287_/B2 VDD VDD VSS VSS gf180mcu_fd_sc_mcu7t5v0__clkinv_1
X_07236_ _07236_/A1 _07234_/Z _07235_/Z _07250_/A2 VDD VDD VSS VSS
+ gf180mcu_fd_sc_mcu7t5v0__xnor3_1
X_07167_ _10000_/Q _07243_/A2 _07170_/A1 VDD VDD VSS VSS gf180mcu_fd_sc_mcu7t5v0__nand2_1
X_06118_ _09529_/A1 _06123_/A2 _06123_/B1 _06118_/B2 _09973_/D VDD VDD
+ VSS VSS gf180mcu_fd_sc_mcu7t5v0__oai22_1
X_07098_ _10086_/Q _07097_/Z _07120_/A2 VDD VDD VSS VSS gf180mcu_fd_sc_mcu7t5v0__nor2_1
X_06049_ _09948_/Q _06071_/A2 _06052_/B VDD VDD VSS VSS gf180mcu_fd_sc_mcu7t5v0__nand2_1
X_09808_ _09808_/A1 _09817_/A2 _09808_/B _11096_/D VDD VDD VSS VSS
+ gf180mcu_fd_sc_mcu7t5v0__aoi21_1
X_09739_ _05980_/Z _09743_/A2 _09748_/A2 VDD VDD VSS VSS gf180mcu_fd_sc_mcu7t5v0__nand2_1
X_10514_ _10514_/D _11109_/CLK _10514_/Q VDD VDD VSS VSS gf180mcu_fd_sc_mcu7t5v0__dffq_1
X_10445_ _10445_/D _11101_/CLK _10445_/Q VDD VDD VSS VSS gf180mcu_fd_sc_mcu7t5v0__dffq_1
X_10376_ _10376_/D _11147_/CLK _10376_/Q VDD VDD VSS VSS gf180mcu_fd_sc_mcu7t5v0__dffq_1
X_05420_ _10926_/Q _09477_/B2 VDD VDD VSS VSS gf180mcu_fd_sc_mcu7t5v0__clkinv_1
X_05351_ _10421_/Q _08804_/B2 VDD VDD VSS VSS gf180mcu_fd_sc_mcu7t5v0__clkinv_1
X_05282_ _10748_/Q _09255_/B2 VDD VDD VSS VSS gf180mcu_fd_sc_mcu7t5v0__clkinv_1
X_08070_ _08070_/I _08071_/C VDD VDD VSS VSS gf180mcu_fd_sc_mcu7t5v0__clkinv_1
X_07021_ _07063_/C _07007_/Z _07021_/B1 _07021_/B2 _07601_/B _07022_/B VDD VDD
+ VSS VSS gf180mcu_fd_sc_mcu7t5v0__aoi221_1
X_08972_ _09900_/A1 _09823_/A2 _08981_/A2 VDD VDD VSS VSS gf180mcu_fd_sc_mcu7t5v0__nand2_4
X_07923_ _10707_/Q _08582_/A2 _08476_/C1 _10403_/Q _07927_/A2 VDD VDD
+ VSS VSS gf180mcu_fd_sc_mcu7t5v0__aoi22_1
X_07854_ bus_addr[0] _07865_/A2 bus_addr[2] _07831_/I _07864_/A2 VDD VDD
+ VSS VSS gf180mcu_fd_sc_mcu7t5v0__nor4_4
X_06805_ _10006_/Q _06557_/Z _06590_/Z _10005_/Q _06807_/A3 VDD VDD VSS
+ VSS gf180mcu_fd_sc_mcu7t5v0__aoi22_1
X_04997_ _10323_/Q _08661_/A1 VDD VDD VSS VSS gf180mcu_fd_sc_mcu7t5v0__inv_1
X_07785_ _09537_/A1 _07787_/A2 _07785_/B _10213_/D VDD VDD VSS VSS
+ gf180mcu_fd_sc_mcu7t5v0__oai21_1
X_09524_ _10963_/Q _09538_/A2 _09525_/B VDD VDD VSS VSS gf180mcu_fd_sc_mcu7t5v0__nand2_1
X_06736_ _06834_/C _06736_/A2 _07601_/B _06737_/B2 VDD VDD VSS VSS
+ gf180mcu_fd_sc_mcu7t5v0__aoi21_1
X_09455_ _09940_/A1 _09461_/A2 _09461_/B1 _09455_/B2 _10908_/D VDD VDD
+ VSS VSS gf180mcu_fd_sc_mcu7t5v0__oai22_1
X_06667_ _06696_/A2 _06667_/A2 _06667_/A3 _06667_/Z VDD VDD VSS VSS
+ gf180mcu_fd_sc_mcu7t5v0__xor3_1
X_08406_ _10220_/Q _08573_/B1 _08576_/B1 _10204_/Q _08406_/C _08407_/A3 VDD
+ VDD VSS VSS gf180mcu_fd_sc_mcu7t5v0__aoi221_1
X_05618_ _10496_/Q _08939_/B2 VDD VDD VSS VSS gf180mcu_fd_sc_mcu7t5v0__clkinv_1
X_09386_ _09893_/A1 _09391_/A2 _09391_/B1 _09386_/B2 _10853_/D VDD VDD
+ VSS VSS gf180mcu_fd_sc_mcu7t5v0__oai22_1
X_06598_ _07362_/A3 _06582_/I _06608_/A2 _06598_/Z VDD VDD VSS VSS
+ gf180mcu_fd_sc_mcu7t5v0__xor3_1
X_05549_ _10655_/Q _09138_/B2 VDD VDD VSS VSS gf180mcu_fd_sc_mcu7t5v0__clkinv_1
X_08337_ _08337_/A1 _08337_/A2 _08338_/C VDD VDD VSS VSS gf180mcu_fd_sc_mcu7t5v0__nand2_1
X_08268_ _08347_/A1 _08268_/A2 _08268_/B1 _08268_/B2 _08269_/C VDD VDD
+ VSS VSS gf180mcu_fd_sc_mcu7t5v0__oai22_1
X_07219_ _10000_/Q _07241_/A2 _07230_/A1 VDD VDD VSS VSS gf180mcu_fd_sc_mcu7t5v0__nand2_1
X_10230_ _10230_/D _11149_/CLK _10230_/Q VDD VDD VSS VSS gf180mcu_fd_sc_mcu7t5v0__dffq_1
X_08199_ _10886_/Q _08547_/A2 _08589_/B1 _11121_/Q _08201_/A2 VDD VDD
+ VSS VSS gf180mcu_fd_sc_mcu7t5v0__aoi22_1
X_10161_ _10161_/D _10905_/CLK _10161_/Q VDD VDD VSS VSS gf180mcu_fd_sc_mcu7t5v0__dffq_1
X_10092_ _10092_/D _11052_/CLK _10092_/Q VDD VDD VSS VSS gf180mcu_fd_sc_mcu7t5v0__dffq_1
X_10994_ _10994_/D _11018_/CLK _10994_/Q VDD VDD VSS VSS gf180mcu_fd_sc_mcu7t5v0__dffq_1
X_10428_ _10428_/D _11165_/CLK _10428_/Q VDD VDD VSS VSS gf180mcu_fd_sc_mcu7t5v0__dffq_1
X_10359_ _10359_/D _11109_/CLK _10359_/Q VDD VDD VSS VSS gf180mcu_fd_sc_mcu7t5v0__dffq_1
X_07570_ _10004_/Q _07393_/I _07617_/B2 VDD VDD VSS VSS gf180mcu_fd_sc_mcu7t5v0__nand2_1
X_06521_ _09946_/A1 _06521_/A2 _06521_/B1 _06521_/B2 _10023_/D VDD VDD
+ VSS VSS gf180mcu_fd_sc_mcu7t5v0__oai22_1
X_09240_ _09897_/A1 _09241_/A2 _09241_/B1 _09240_/B2 _10737_/D VDD VDD
+ VSS VSS gf180mcu_fd_sc_mcu7t5v0__oai22_1
X_06452_ _06452_/A1 _06451_/B _06478_/A2 VDD VDD VSS VSS gf180mcu_fd_sc_mcu7t5v0__xnor2_1
X_05403_ _10869_/Q _09406_/B2 VDD VDD VSS VSS gf180mcu_fd_sc_mcu7t5v0__clkinv_1
X_06383_ _06383_/A1 _06383_/A2 _06483_/A2 VDD VDD VSS VSS gf180mcu_fd_sc_mcu7t5v0__nand2_4
X_09171_ _09946_/A1 _09171_/A2 _09171_/B1 _09171_/B2 _10682_/D VDD VDD
+ VSS VSS gf180mcu_fd_sc_mcu7t5v0__oai22_1
X_05334_ _10629_/Q _09106_/B2 VDD VDD VSS VSS gf180mcu_fd_sc_mcu7t5v0__clkinv_1
X_08122_ _09568_/A2 _08122_/A2 _08122_/B1 _09645_/A1 _08142_/A2 VDD VDD
+ VSS VSS gf180mcu_fd_sc_mcu7t5v0__aoi22_1
X_08053_ _10948_/Q _08547_/A2 _08573_/B1 _11127_/Q _06125_/I _10932_/Q _08054_/A3
+ VDD VDD VSS VSS gf180mcu_fd_sc_mcu7t5v0__aoi222_4
X_05265_ _10200_/Q _07763_/B2 VDD VDD VSS VSS gf180mcu_fd_sc_mcu7t5v0__clkinv_1
X_07004_ _07004_/A1 _07004_/A2 _07020_/A2 VDD VDD VSS VSS gf180mcu_fd_sc_mcu7t5v0__xnor2_1
X_05196_ _10468_/Q _08897_/B2 VDD VDD VSS VSS gf180mcu_fd_sc_mcu7t5v0__clkinv_1
X_08955_ _09904_/A1 _08961_/A2 _08961_/B1 _08955_/B2 _10508_/D VDD VDD
+ VSS VSS gf180mcu_fd_sc_mcu7t5v0__oai22_1
X_07906_ bus_addr[2] _07906_/A2 _07906_/A3 _07920_/A2 VDD VDD VSS VSS
+ gf180mcu_fd_sc_mcu7t5v0__nand3_4
X_08886_ _10463_/Q _08892_/A2 _08887_/B VDD VDD VSS VSS gf180mcu_fd_sc_mcu7t5v0__nand2_1
X_07837_ _10241_/Q _07842_/A2 _07838_/B VDD VDD VSS VSS gf180mcu_fd_sc_mcu7t5v0__nor2_1
X_07768_ _09897_/A1 _07769_/A2 _07769_/B1 _07768_/B2 _10205_/D VDD VDD
+ VSS VSS gf180mcu_fd_sc_mcu7t5v0__oai22_1
X_09507_ _06058_/Z _09511_/A2 _09511_/B1 _09507_/B2 _10950_/D VDD VDD
+ VSS VSS gf180mcu_fd_sc_mcu7t5v0__oai22_1
X_06719_ _06739_/A1 _06718_/Z _06834_/C _06720_/B VDD VDD VSS VSS
+ gf180mcu_fd_sc_mcu7t5v0__aoi21_1
X_07699_ _09946_/A1 _07699_/A2 _07699_/B _10158_/D VDD VDD VSS VSS
+ gf180mcu_fd_sc_mcu7t5v0__oai21_1
X_09438_ _06061_/Z _09441_/A2 _09441_/B1 _09438_/B2 _10895_/D VDD VDD
+ VSS VSS gf180mcu_fd_sc_mcu7t5v0__oai22_1
X_09369_ _09896_/A1 _09371_/A2 _09371_/B1 _09369_/B2 _10840_/D VDD VDD
+ VSS VSS gf180mcu_fd_sc_mcu7t5v0__oai22_1
X_10213_ _10213_/D _11052_/CLK _10213_/Q VDD VDD VSS VSS gf180mcu_fd_sc_mcu7t5v0__dffq_1
X_10144_ _10144_/D _11165_/CLK _10144_/Q VDD VDD VSS VSS gf180mcu_fd_sc_mcu7t5v0__dffq_1
X_10075_ _10075_/D _11139_/CLK _10075_/Q VDD VDD VSS VSS gf180mcu_fd_sc_mcu7t5v0__dffq_1
X_10977_ _10977_/D _11149_/CLK _10977_/Q VDD VDD VSS VSS gf180mcu_fd_sc_mcu7t5v0__dffq_1
X_05050_ _10040_/Q _06579_/A3 VDD VDD VSS VSS gf180mcu_fd_sc_mcu7t5v0__clkinv_3
X_08740_ _09937_/A2 _09662_/A2 _08749_/A2 VDD VDD VSS VSS gf180mcu_fd_sc_mcu7t5v0__nand2_4
X_05952_ bus_addr[0] bus_addr[1] _07876_/A2 VDD VDD VSS VSS gf180mcu_fd_sc_mcu7t5v0__nor2_4
X_05883_ _11018_/Q _09607_/B2 VDD VDD VSS VSS gf180mcu_fd_sc_mcu7t5v0__clkinv_1
X_08671_ _08671_/A1 _08675_/A2 _08671_/B _10328_/D VDD VDD VSS VSS
+ gf180mcu_fd_sc_mcu7t5v0__aoi21_1
X_07622_ _07622_/A1 _07622_/A2 _07621_/Z _07622_/Z VDD VDD VSS VSS
+ gf180mcu_fd_sc_mcu7t5v0__xor3_1
X_07553_ _07553_/A1 _07553_/A2 _07553_/B _07604_/A1 VDD VDD VSS VSS
+ gf180mcu_fd_sc_mcu7t5v0__oai21_1
X_07484_ _07602_/A1 _07483_/Z _07502_/A1 VDD VDD VSS VSS gf180mcu_fd_sc_mcu7t5v0__nor2_1
X_06504_ _06504_/A1 _06503_/Z _06504_/Z VDD VDD VSS VSS gf180mcu_fd_sc_mcu7t5v0__xor2_1
X_09223_ _09852_/A1 _09231_/A2 _09231_/B1 VDD VDD VSS VSS gf180mcu_fd_sc_mcu7t5v0__nand2_2
X_06435_ _10000_/Q _06502_/A1 _06436_/A2 _06497_/A1 VDD VDD VSS VSS
+ gf180mcu_fd_sc_mcu7t5v0__nand3_1
X_09154_ _06047_/Z _09161_/A2 _09161_/B1 _09154_/B2 _10667_/D VDD VDD
+ VSS VSS gf180mcu_fd_sc_mcu7t5v0__oai22_1
X_08105_ _09989_/Q _08560_/A2 _08444_/B1 _11152_/Q _07255_/I _11112_/Q _08107_/A2
+ VDD VDD VSS VSS gf180mcu_fd_sc_mcu7t5v0__aoi222_2
X_06366_ _07470_/A1 _06363_/Z _06368_/B VDD VDD VSS VSS gf180mcu_fd_sc_mcu7t5v0__xor2_1
X_05317_ _10357_/Q _08724_/B2 VDD VDD VSS VSS gf180mcu_fd_sc_mcu7t5v0__clkinv_1
X_09085_ _09940_/A1 _09091_/A2 _09091_/B1 _09085_/B2 _10612_/D VDD VDD
+ VSS VSS gf180mcu_fd_sc_mcu7t5v0__oai22_1
X_06297_ _06298_/A1 _06298_/A2 _06297_/Z VDD VDD VSS VSS gf180mcu_fd_sc_mcu7t5v0__and2_1
X_05248_ _10996_/Q _09581_/B2 VDD VDD VSS VSS gf180mcu_fd_sc_mcu7t5v0__clkinv_1
X_08036_ _10868_/Q _08582_/A2 _08584_/B1 _10876_/Q _08040_/A1 VDD VDD
+ VSS VSS gf180mcu_fd_sc_mcu7t5v0__aoi22_1
X_05179_ _10771_/Q _09284_/B2 VDD VDD VSS VSS gf180mcu_fd_sc_mcu7t5v0__clkinv_1
X_09987_ _09987_/D _11163_/CLK _09987_/Q VDD VDD VSS VSS gf180mcu_fd_sc_mcu7t5v0__dffq_1
X_08938_ _06061_/Z _08941_/A2 _08941_/B1 _08938_/B2 _10495_/D VDD VDD
+ VSS VSS gf180mcu_fd_sc_mcu7t5v0__oai22_1
X_08869_ _10456_/Q _08865_/Z _08872_/B _08870_/A2 VDD VDD VSS VSS
+ gf180mcu_fd_sc_mcu7t5v0__oai21_1
X_10900_ _10900_/D _10905_/CLK _10900_/Q VDD VDD VSS VSS gf180mcu_fd_sc_mcu7t5v0__dffq_1
X_10831_ _10831_/D _11165_/CLK _10831_/Q VDD VDD VSS VSS gf180mcu_fd_sc_mcu7t5v0__dffq_1
X_10762_ _10762_/D _11010_/CLK _10762_/Q VDD VDD VSS VSS gf180mcu_fd_sc_mcu7t5v0__dffq_1
Xrepeater16 _09861_/A1 _09900_/A1 VDD VDD VSS VSS gf180mcu_fd_sc_mcu7t5v0__buf_16
Xrepeater27 _08444_/B1 _08560_/B1 VDD VDD VSS VSS gf180mcu_fd_sc_mcu7t5v0__buf_16
Xrepeater49 _09809_/B _09811_/B VDD VDD VSS VSS gf180mcu_fd_sc_mcu7t5v0__buf_8
Xrepeater38 _08530_/A2 _08580_/A2 VDD VDD VSS VSS gf180mcu_fd_sc_mcu7t5v0__buf_12
X_10693_ _10693_/D _11139_/CLK _10693_/Q VDD VDD VSS VSS gf180mcu_fd_sc_mcu7t5v0__dffq_1
X_11176_ _11176_/D _11176_/CLK _11176_/Q VDD VDD VSS VSS gf180mcu_fd_sc_mcu7t5v0__dffq_1
X_10127_ _10127_/D _11164_/CLK _10127_/Q VDD VDD VSS VSS gf180mcu_fd_sc_mcu7t5v0__dffq_1
X_10058_ _10058_/D _11181_/CLK _10058_/Q VDD VDD VSS VSS gf180mcu_fd_sc_mcu7t5v0__dffq_1
X_06220_ _10000_/Q _06505_/B _06372_/C _06221_/B VDD VDD VSS VSS gf180mcu_fd_sc_mcu7t5v0__aoi21_1
X_06151_ _08540_/A2 _09872_/A2 _09900_/B _06166_/A2 VDD VDD VSS VSS
+ gf180mcu_fd_sc_mcu7t5v0__aoi21_4
X_05102_ _10923_/Q _09474_/B2 VDD VDD VSS VSS gf180mcu_fd_sc_mcu7t5v0__clkinv_1
X_06082_ _07679_/A1 _06878_/A2 _08587_/A2 VDD VDD VSS VSS gf180mcu_fd_sc_mcu7t5v0__nand2_4
X_09910_ _06061_/Z _09916_/A2 _09910_/B _11154_/D VDD VDD VSS VSS
+ gf180mcu_fd_sc_mcu7t5v0__oai21_1
X_05033_ _10089_/Q _07252_/A1 VDD VDD VSS VSS gf180mcu_fd_sc_mcu7t5v0__clkinv_1
X_09841_ _11113_/Q _09849_/A2 _09842_/B VDD VDD VSS VSS gf180mcu_fd_sc_mcu7t5v0__nand2_1
X_09772_ _11080_/Q _09769_/Z _09772_/Z VDD VDD VSS VSS gf180mcu_fd_sc_mcu7t5v0__and2_1
X_06984_ _07361_/A2 _06979_/Z _06991_/B VDD VDD VSS VSS gf180mcu_fd_sc_mcu7t5v0__nor2_1
X_08723_ _09904_/A1 _08729_/A2 _08729_/B1 _08723_/B2 _10356_/D VDD VDD
+ VSS VSS gf180mcu_fd_sc_mcu7t5v0__oai22_1
X_05935_ _10314_/Q _10313_/Q _10312_/Q _08619_/B VDD VDD VSS VSS gf180mcu_fd_sc_mcu7t5v0__nor3_4
X_05866_ _10650_/Q _09131_/B2 VDD VDD VSS VSS gf180mcu_fd_sc_mcu7t5v0__clkinv_1
X_08654_ _10321_/Q _08659_/A1 _08654_/B _08655_/B VDD VDD VSS VSS
+ gf180mcu_fd_sc_mcu7t5v0__oai21_1
X_08585_ _09181_/B2 _08585_/A2 _08585_/B1 _08789_/B2 _08585_/C _08588_/A1 VDD
+ VDD VSS VSS gf180mcu_fd_sc_mcu7t5v0__oai221_1
X_07605_ _07605_/A1 _07579_/Z _07605_/B _07621_/A1 VDD VDD VSS VSS
+ gf180mcu_fd_sc_mcu7t5v0__aoi21_1
X_05797_ _10189_/Q _08478_/A1 VDD VDD VSS VSS gf180mcu_fd_sc_mcu7t5v0__clkinv_1
X_07536_ _10124_/Q _07506_/I _07533_/Z _07536_/Z VDD VDD VSS VSS gf180mcu_fd_sc_mcu7t5v0__xor3_1
X_07467_ _07554_/A1 _07507_/A2 _07467_/Z VDD VDD VSS VSS gf180mcu_fd_sc_mcu7t5v0__or2_1
X_09206_ _09941_/A1 _09211_/A2 _09211_/B1 _09206_/B2 _10709_/D VDD VDD
+ VSS VSS gf180mcu_fd_sc_mcu7t5v0__oai22_1
X_06418_ _06212_/Z _06466_/A2 _06423_/A2 VDD VDD VSS VSS gf180mcu_fd_sc_mcu7t5v0__nand2_1
X_07398_ _07434_/A1 _07365_/I _07435_/A1 VDD VDD VSS VSS gf180mcu_fd_sc_mcu7t5v0__nor2_1
X_09137_ _06058_/Z _09141_/A2 _09141_/B1 _09137_/B2 _10654_/D VDD VDD
+ VSS VSS gf180mcu_fd_sc_mcu7t5v0__oai22_1
X_06349_ _06286_/I _06349_/A2 _06442_/A1 _06350_/B VDD VDD VSS VSS
+ gf180mcu_fd_sc_mcu7t5v0__xor3_1
X_09068_ _06061_/Z _09071_/A2 _09071_/B1 _09068_/B2 _10599_/D VDD VDD
+ VSS VSS gf180mcu_fd_sc_mcu7t5v0__oai22_1
X_08019_ _10468_/Q _08591_/C1 _08591_/B1 _10428_/Q _08589_/B1 _10492_/Q _08020_/A3
+ VDD VDD VSS VSS gf180mcu_fd_sc_mcu7t5v0__aoi222_1
X_11030_ _11030_/D _11039_/CLK _11030_/Q VDD VDD VSS VSS gf180mcu_fd_sc_mcu7t5v0__dffq_1
X_10814_ _10814_/D _11164_/CLK _10814_/Q VDD VDD VSS VSS gf180mcu_fd_sc_mcu7t5v0__dffq_1
X_10745_ _10745_/D _11017_/CLK _10745_/Q VDD VDD VSS VSS gf180mcu_fd_sc_mcu7t5v0__dffq_1
X_10676_ _10676_/D _11139_/CLK _10676_/Q VDD VDD VSS VSS gf180mcu_fd_sc_mcu7t5v0__dffq_1
X_11159_ _11159_/D _11165_/CLK _11159_/Q VDD VDD VSS VSS gf180mcu_fd_sc_mcu7t5v0__dffq_1
X_05720_ _10864_/Q _09399_/B2 VDD VDD VSS VSS gf180mcu_fd_sc_mcu7t5v0__clkinv_1
X_05651_ _10624_/Q _09099_/B2 VDD VDD VSS VSS gf180mcu_fd_sc_mcu7t5v0__clkinv_1
X_08370_ _10976_/Q _08555_/A2 _06877_/Z _10960_/Q _07680_/I _10912_/Q _08372_/A2 VDD
+ VDD VSS VSS gf180mcu_fd_sc_mcu7t5v0__aoi222_1
X_05582_ _10219_/Q _07794_/B2 VDD VDD VSS VSS gf180mcu_fd_sc_mcu7t5v0__clkinv_1
X_07321_ _07557_/A1 _08675_/A2 _07321_/B _10118_/D VDD VDD VSS VSS
+ gf180mcu_fd_sc_mcu7t5v0__aoi21_1
X_07252_ _07252_/A1 _07601_/B _07238_/Z _07252_/B2 _07603_/B _10089_/D VDD VDD
+ VSS VSS gf180mcu_fd_sc_mcu7t5v0__aoi221_1
X_06203_ _06222_/A1 _09996_/Q _06216_/A2 VDD VDD VSS VSS gf180mcu_fd_sc_mcu7t5v0__nor2_1
X_07183_ _07183_/A1 _07227_/B2 _07183_/A3 _07183_/Z VDD VDD VSS VSS
+ gf180mcu_fd_sc_mcu7t5v0__xor3_1
X_06134_ _09921_/A1 _06144_/A2 _06134_/B _09981_/D VDD VDD VSS VSS
+ gf180mcu_fd_sc_mcu7t5v0__oai21_1
X_06065_ _10124_/Q cgra_status[0] _06065_/B _09884_/A1 VDD VDD VSS VSS
+ gf180mcu_fd_sc_mcu7t5v0__aoi21_4
X_05016_ _10268_/Q _07897_/A1 VDD VDD VSS VSS gf180mcu_fd_sc_mcu7t5v0__clkinv_1
X_09824_ _09824_/A1 _09832_/A2 _09832_/B1 VDD VDD VSS VSS gf180mcu_fd_sc_mcu7t5v0__nand2_4
X_09755_ _09755_/I _09776_/B VDD VDD VSS VSS gf180mcu_fd_sc_mcu7t5v0__clkinv_2
X_06967_ _06967_/A1 _06967_/A2 _06967_/A3 _06965_/Z _06970_/A3 VDD VDD
+ VSS VSS gf180mcu_fd_sc_mcu7t5v0__nor4_4
X_05918_ _10754_/Q _09261_/B2 VDD VDD VSS VSS gf180mcu_fd_sc_mcu7t5v0__clkinv_1
X_08706_ _06061_/Z _08709_/A2 _08709_/B1 _08706_/B2 _10343_/D VDD VDD
+ VSS VSS gf180mcu_fd_sc_mcu7t5v0__oai22_1
X_09686_ bus_wdata[1] _09722_/A1 _09686_/B _09687_/A2 VDD VDD VSS VSS
+ gf180mcu_fd_sc_mcu7t5v0__aoi21_1
X_06898_ _09537_/A1 _06899_/A2 _06899_/B1 _06898_/B2 _10067_/D VDD VDD
+ VSS VSS gf180mcu_fd_sc_mcu7t5v0__oai22_1
X_05849_ _10514_/Q _08961_/B2 VDD VDD VSS VSS gf180mcu_fd_sc_mcu7t5v0__clkinv_1
X_08637_ _10267_/Q _08657_/A2 _08657_/B1 _10260_/Q _08637_/C _08639_/A2 VDD
+ VDD VSS VSS gf180mcu_fd_sc_mcu7t5v0__aoi221_1
X_08568_ _10182_/Q _08589_/A2 _08589_/B1 _10402_/Q _08591_/B1 _10994_/Q _08570_/A2
+ VDD VDD VSS VSS gf180mcu_fd_sc_mcu7t5v0__aoi222_1
X_08499_ _10609_/Q _08563_/A2 _08584_/A2 _10641_/Q _08502_/A1 VDD VDD
+ VSS VSS gf180mcu_fd_sc_mcu7t5v0__aoi22_1
X_07519_ _07519_/A1 _07519_/A2 _07519_/B _10005_/Q _07617_/A1 VDD VDD
+ VSS VSS gf180mcu_fd_sc_mcu7t5v0__oai211_4
X_10530_ _10530_/D _11109_/CLK _10530_/Q VDD VDD VSS VSS gf180mcu_fd_sc_mcu7t5v0__dffq_1
X_10461_ _10461_/D _11139_/CLK _10461_/Q VDD VDD VSS VSS gf180mcu_fd_sc_mcu7t5v0__dffq_1
X_10392_ _10392_/D _11018_/CLK _10392_/Q VDD VDD VSS VSS gf180mcu_fd_sc_mcu7t5v0__dffq_1
X_11013_ _11013_/D _11142_/CLK _11013_/Q VDD VDD VSS VSS gf180mcu_fd_sc_mcu7t5v0__dffq_1
X_10728_ _10728_/D _11147_/CLK _10728_/Q VDD VDD VSS VSS gf180mcu_fd_sc_mcu7t5v0__dffq_1
X_10659_ _10659_/D _10666_/CLK _10659_/Q VDD VDD VSS VSS gf180mcu_fd_sc_mcu7t5v0__dffq_1
X_07870_ bus_wdata[2] _10256_/Q _07874_/S _07870_/Z VDD VDD VSS VSS
+ gf180mcu_fd_sc_mcu7t5v0__mux2_1
X_06821_ _10051_/Q _06835_/A2 _06839_/A2 VDD VDD VSS VSS gf180mcu_fd_sc_mcu7t5v0__nor2_1
X_09540_ _09889_/A1 _09861_/A2 _09549_/A2 VDD VDD VSS VSS gf180mcu_fd_sc_mcu7t5v0__nand2_4
X_06752_ _10003_/Q _06850_/A2 _06752_/Z VDD VDD VSS VSS gf180mcu_fd_sc_mcu7t5v0__and2_1
X_09471_ _09946_/A1 _09471_/A2 _09471_/B1 _09471_/B2 _10922_/D VDD VDD
+ VSS VSS gf180mcu_fd_sc_mcu7t5v0__oai22_1
X_05703_ _10920_/Q _09469_/B2 VDD VDD VSS VSS gf180mcu_fd_sc_mcu7t5v0__clkinv_1
X_08422_ _08422_/A1 _08422_/A2 _08422_/A3 _08428_/A2 VDD VDD VSS VSS
+ gf180mcu_fd_sc_mcu7t5v0__nand3_2
X_06683_ _06832_/A1 _06799_/A1 _06683_/B1 _06683_/B2 _06683_/C _06684_/B VDD
+ VDD VSS VSS gf180mcu_fd_sc_mcu7t5v0__oai221_1
X_05634_ _10896_/Q _09439_/B2 VDD VDD VSS VSS gf180mcu_fd_sc_mcu7t5v0__clkinv_1
X_05565_ _11015_/Q _09604_/B2 VDD VDD VSS VSS gf180mcu_fd_sc_mcu7t5v0__clkinv_1
X_08353_ _11040_/Q _06112_/I _09872_/A1 _09984_/Q _10132_/Q _08589_/B1 _08354_/A3
+ VDD VDD VSS VSS gf180mcu_fd_sc_mcu7t5v0__aoi222_2
X_08284_ _10951_/Q _06023_/I _08573_/B1 _11130_/Q _08287_/A1 VDD VDD VSS
+ VSS gf180mcu_fd_sc_mcu7t5v0__aoi22_1
X_07304_ _10110_/Q _07310_/A2 _07305_/B VDD VDD VSS VSS gf180mcu_fd_sc_mcu7t5v0__nand2_1
X_05496_ _10766_/Q _09277_/B2 VDD VDD VSS VSS gf180mcu_fd_sc_mcu7t5v0__clkinv_1
X_07235_ _07235_/A1 _07235_/A2 _07235_/Z VDD VDD VSS VSS gf180mcu_fd_sc_mcu7t5v0__xor2_1
X_07166_ _07204_/A2 _07204_/A3 _07243_/A2 VDD VDD VSS VSS gf180mcu_fd_sc_mcu7t5v0__nand2_2
X_06117_ _09940_/A1 _06123_/A2 _06123_/B1 _06117_/B2 _09972_/D VDD VDD
+ VSS VSS gf180mcu_fd_sc_mcu7t5v0__oai22_1
X_07097_ _07045_/I _07095_/Z _07097_/Z VDD VDD VSS VSS gf180mcu_fd_sc_mcu7t5v0__xor2_1
X_06048_ _06074_/A1 _06047_/Z _06048_/B _09947_/D VDD VDD VSS VSS
+ gf180mcu_fd_sc_mcu7t5v0__oai21_1
X_09807_ _11097_/Q _09817_/A2 _09811_/B _09808_/B VDD VDD VSS VSS
+ gf180mcu_fd_sc_mcu7t5v0__oai21_1
X_07999_ _10032_/Q _08528_/A2 _08586_/A2 _09963_/Q _08564_/C1 _10024_/Q _08001_/A2
+ VDD VDD VSS VSS gf180mcu_fd_sc_mcu7t5v0__aoi222_1
X_09738_ _11069_/Q _05977_/Z _05980_/Z _09731_/Z _09738_/C _11069_/D VDD VDD
+ VSS VSS gf180mcu_fd_sc_mcu7t5v0__aoi221_1
X_09669_ _09896_/A1 _09671_/A2 _09671_/B1 _09669_/B2 _11048_/D VDD VDD
+ VSS VSS gf180mcu_fd_sc_mcu7t5v0__oai22_1
X_10513_ _10513_/D _11109_/CLK _10513_/Q VDD VDD VSS VSS gf180mcu_fd_sc_mcu7t5v0__dffq_1
X_10444_ _10444_/D _11101_/CLK _10444_/Q VDD VDD VSS VSS gf180mcu_fd_sc_mcu7t5v0__dffq_1
X_10375_ _10375_/D _11147_/CLK _10375_/Q VDD VDD VSS VSS gf180mcu_fd_sc_mcu7t5v0__dffq_1
X_05350_ _11045_/Q _09666_/B2 VDD VDD VSS VSS gf180mcu_fd_sc_mcu7t5v0__clkinv_1
X_05281_ _11127_/Q _09864_/B2 VDD VDD VSS VSS gf180mcu_fd_sc_mcu7t5v0__clkinv_1
X_07020_ _07208_/A1 _07020_/A2 _07055_/A2 _07020_/B2 _07020_/C _07021_/B2 VDD
+ VDD VSS VSS gf180mcu_fd_sc_mcu7t5v0__aoi221_1
X_08971_ _09832_/A1 _08971_/A2 _08971_/B1 _08971_/B2 _10522_/D VDD VDD
+ VSS VSS gf180mcu_fd_sc_mcu7t5v0__oai22_1
X_07922_ _10683_/Q _06023_/I _08584_/A2 _10699_/Q _07927_/A1 VDD VDD VSS
+ VSS gf180mcu_fd_sc_mcu7t5v0__aoi22_1
X_07853_ _09698_/A1 _07853_/A2 _07853_/B _09900_/B _10248_/D VDD VDD VSS
+ VSS gf180mcu_fd_sc_mcu7t5v0__aoi211_1
X_06804_ _06470_/B _06420_/B _06804_/A3 _06804_/A4 _06807_/A2 VDD VDD
+ VSS VSS gf180mcu_fd_sc_mcu7t5v0__nor4_2
X_04996_ _10324_/Q _08663_/A1 VDD VDD VSS VSS gf180mcu_fd_sc_mcu7t5v0__inv_1
X_07784_ _10213_/Q _07786_/A2 _07785_/B VDD VDD VSS VSS gf180mcu_fd_sc_mcu7t5v0__nand2_1
X_09523_ _09889_/A1 _09523_/A2 _09900_/B _09538_/A2 VDD VDD VSS VSS
+ gf180mcu_fd_sc_mcu7t5v0__aoi21_4
X_06735_ _06735_/A1 _06735_/A2 _06735_/B1 _06735_/B2 _06735_/C _06736_/A2 VDD
+ VDD VSS VSS gf180mcu_fd_sc_mcu7t5v0__oai221_1
X_09454_ _06047_/Z _09461_/A2 _09461_/B1 _09454_/B2 _10907_/D VDD VDD
+ VSS VSS gf180mcu_fd_sc_mcu7t5v0__oai22_1
X_06666_ _06667_/A2 _06667_/A3 _06689_/A2 VDD VDD VSS VSS gf180mcu_fd_sc_mcu7t5v0__nand2_1
X_08405_ _09858_/B2 _08581_/A2 _08585_/B1 _08405_/B2 _08406_/C VDD VDD
+ VSS VSS gf180mcu_fd_sc_mcu7t5v0__oai22_1
X_05617_ _10416_/Q _08797_/B2 VDD VDD VSS VSS gf180mcu_fd_sc_mcu7t5v0__clkinv_1
X_09385_ _09920_/A1 _09391_/A2 _09391_/B1 _09385_/B2 _10852_/D VDD VDD
+ VSS VSS gf180mcu_fd_sc_mcu7t5v0__oai22_1
X_06597_ _07362_/A3 _06608_/A2 _06618_/A2 VDD VDD VSS VSS gf180mcu_fd_sc_mcu7t5v0__nand2_1
X_08336_ _10020_/Q _08586_/A2 _08584_/A2 _10903_/Q _10187_/Q _06877_/Z _08337_/A2
+ VDD VDD VSS VSS gf180mcu_fd_sc_mcu7t5v0__aoi222_2
X_05548_ _10647_/Q _09128_/B2 VDD VDD VSS VSS gf180mcu_fd_sc_mcu7t5v0__clkinv_1
X_08267_ _09823_/A2 _08267_/A2 _08267_/B1 _09917_/A2 _08267_/C _08270_/A1 VDD
+ VDD VSS VSS gf180mcu_fd_sc_mcu7t5v0__aoi221_2
X_05479_ _10186_/Q _07744_/B2 VDD VDD VSS VSS gf180mcu_fd_sc_mcu7t5v0__clkinv_1
X_08198_ _10218_/Q _08573_/B1 _08576_/B1 _10202_/Q _08201_/A1 VDD VDD
+ VSS VSS gf180mcu_fd_sc_mcu7t5v0__aoi22_1
X_07218_ _07240_/A2 _07240_/A3 _07241_/A2 VDD VDD VSS VSS gf180mcu_fd_sc_mcu7t5v0__nand2_1
X_07149_ _07226_/A2 _07149_/A2 _07149_/Z VDD VDD VSS VSS gf180mcu_fd_sc_mcu7t5v0__xor2_1
X_10160_ _10160_/D _11176_/CLK _10160_/Q VDD VDD VSS VSS gf180mcu_fd_sc_mcu7t5v0__dffq_1
X_10091_ _10091_/D _11052_/CLK _10091_/Q VDD VDD VSS VSS gf180mcu_fd_sc_mcu7t5v0__dffq_1
X_10993_ _10993_/D _11017_/CLK _10993_/Q VDD VDD VSS VSS gf180mcu_fd_sc_mcu7t5v0__dffq_1
X_10427_ _10427_/D _11165_/CLK _10427_/Q VDD VDD VSS VSS gf180mcu_fd_sc_mcu7t5v0__dffq_1
X_10358_ _10358_/D _11109_/CLK _10358_/Q VDD VDD VSS VSS gf180mcu_fd_sc_mcu7t5v0__dffq_1
X_10289_ _10289_/D _11097_/CLK _10289_/Q VDD VDD VSS VSS gf180mcu_fd_sc_mcu7t5v0__dffq_4
X_06520_ _09945_/A1 _06521_/A2 _06521_/B1 _06520_/B2 _10022_/D VDD VDD
+ VSS VSS gf180mcu_fd_sc_mcu7t5v0__oai22_1
X_06451_ _06437_/B _06451_/A2 _06451_/B _06478_/B VDD VDD VSS VSS
+ gf180mcu_fd_sc_mcu7t5v0__aoi21_1
X_05402_ _10861_/Q _09396_/B2 VDD VDD VSS VSS gf180mcu_fd_sc_mcu7t5v0__clkinv_1
X_06382_ _10087_/Q _06431_/A2 _06383_/A2 VDD VDD VSS VSS gf180mcu_fd_sc_mcu7t5v0__nand2_1
X_09170_ _09897_/A1 _09171_/A2 _09171_/B1 _09170_/B2 _10681_/D VDD VDD
+ VSS VSS gf180mcu_fd_sc_mcu7t5v0__oai22_1
X_05333_ _10621_/Q _09096_/B2 VDD VDD VSS VSS gf180mcu_fd_sc_mcu7t5v0__clkinv_1
X_08121_ _08121_/A1 _08121_/A2 _08121_/A3 _08122_/B1 VDD VDD VSS VSS
+ gf180mcu_fd_sc_mcu7t5v0__nand3_1
X_05264_ _10216_/Q _07791_/B2 VDD VDD VSS VSS gf180mcu_fd_sc_mcu7t5v0__clkinv_1
X_08052_ _10916_/Q _08591_/A2 _08584_/B1 _10748_/Q _08054_/A2 VDD VDD
+ VSS VSS gf180mcu_fd_sc_mcu7t5v0__aoi22_1
X_07003_ _07003_/A1 _07003_/A2 _07004_/A2 _07046_/A1 VDD VDD VSS VSS
+ gf180mcu_fd_sc_mcu7t5v0__nor3_2
X_05195_ _10484_/Q _08925_/B2 VDD VDD VSS VSS gf180mcu_fd_sc_mcu7t5v0__clkinv_1
X_08954_ _06047_/Z _08961_/A2 _08961_/B1 _08954_/B2 _10507_/D VDD VDD
+ VSS VSS gf180mcu_fd_sc_mcu7t5v0__oai22_1
X_07905_ _07905_/A1 _07905_/A2 _07905_/B _10272_/D VDD VDD VSS VSS
+ gf180mcu_fd_sc_mcu7t5v0__aoi21_1
X_08885_ _06058_/Z _08893_/A2 _08885_/B _10462_/D VDD VDD VSS VSS
+ gf180mcu_fd_sc_mcu7t5v0__oai21_1
X_07836_ _07858_/A1 _07842_/A2 _07836_/B _09900_/B _10240_/D VDD VDD VSS
+ VSS gf180mcu_fd_sc_mcu7t5v0__aoi211_1
X_07767_ _09896_/A1 _07769_/A2 _07769_/B1 _07767_/B2 _10204_/D VDD VDD
+ VSS VSS gf180mcu_fd_sc_mcu7t5v0__oai22_1
X_04979_ _11090_/Q _09795_/A1 VDD VDD VSS VSS gf180mcu_fd_sc_mcu7t5v0__clkinv_1
X_09506_ _09893_/A1 _09511_/A2 _09511_/B1 _09506_/B2 _10949_/D VDD VDD
+ VSS VSS gf180mcu_fd_sc_mcu7t5v0__oai22_1
X_06718_ _06737_/A1 _06716_/Z _06718_/Z VDD VDD VSS VSS gf180mcu_fd_sc_mcu7t5v0__xor2_1
X_07698_ _10158_/Q _07698_/A2 _07699_/B VDD VDD VSS VSS gf180mcu_fd_sc_mcu7t5v0__nand2_1
X_09437_ _06058_/Z _09441_/A2 _09441_/B1 _09437_/B2 _10894_/D VDD VDD
+ VSS VSS gf180mcu_fd_sc_mcu7t5v0__oai22_1
X_06649_ _10048_/Q _07601_/B _06687_/A1 VDD VDD VSS VSS gf180mcu_fd_sc_mcu7t5v0__nand2_1
X_09368_ _06061_/Z _09371_/A2 _09371_/B1 _09368_/B2 _10839_/D VDD VDD
+ VSS VSS gf180mcu_fd_sc_mcu7t5v0__oai22_1
X_09299_ _09924_/A1 _09301_/A2 _09301_/B1 _09299_/B2 _10784_/D VDD VDD
+ VSS VSS gf180mcu_fd_sc_mcu7t5v0__oai22_1
X_08319_ _10695_/Q _08529_/B1 _08476_/C1 _10407_/Q _08322_/A2 VDD VDD
+ VSS VSS gf180mcu_fd_sc_mcu7t5v0__aoi22_1
X_10212_ _10212_/D _11052_/CLK _10212_/Q VDD VDD VSS VSS gf180mcu_fd_sc_mcu7t5v0__dffq_1
X_10143_ _10143_/D _11165_/CLK _10143_/Q VDD VDD VSS VSS gf180mcu_fd_sc_mcu7t5v0__dffq_1
X_10074_ _10074_/D _11163_/CLK _10074_/Q VDD VDD VSS VSS gf180mcu_fd_sc_mcu7t5v0__dffq_1
X_10976_ _10976_/D _10978_/CLK _10976_/Q VDD VDD VSS VSS gf180mcu_fd_sc_mcu7t5v0__dffq_1
X_05951_ _07829_/A2 _05987_/A2 _05987_/A3 _09728_/A1 VDD VDD VSS VSS
+ gf180mcu_fd_sc_mcu7t5v0__nand3_4
X_05882_ _10378_/Q _08749_/B2 VDD VDD VSS VSS gf180mcu_fd_sc_mcu7t5v0__clkinv_1
X_08670_ _10285_/Q _08675_/A2 _08674_/B _08671_/B VDD VDD VSS VSS
+ gf180mcu_fd_sc_mcu7t5v0__oai21_1
X_07621_ _07621_/A1 _07621_/A2 _07620_/Z _07621_/Z VDD VDD VSS VSS
+ gf180mcu_fd_sc_mcu7t5v0__xor3_1
X_07552_ _10125_/Q _07601_/B _07603_/A1 VDD VDD VSS VSS gf180mcu_fd_sc_mcu7t5v0__nand2_1
X_06503_ _10007_/Q _06508_/B1 _06503_/A3 _06503_/Z VDD VDD VSS VSS
+ gf180mcu_fd_sc_mcu7t5v0__xor3_1
X_07483_ _10123_/Q _07505_/A1 _07480_/Z _07483_/Z VDD VDD VSS VSS
+ gf180mcu_fd_sc_mcu7t5v0__xor3_1
X_09222_ _09889_/A1 _09662_/A2 _09231_/A2 VDD VDD VSS VSS gf180mcu_fd_sc_mcu7t5v0__nand2_4
X_06434_ _06434_/A1 _06441_/A2 _06387_/Z _06434_/B2 _06436_/A2 VDD VDD
+ VSS VSS gf180mcu_fd_sc_mcu7t5v0__oai22_1
X_09153_ _09193_/A1 _09161_/A2 _09161_/B1 VDD VDD VSS VSS gf180mcu_fd_sc_mcu7t5v0__nand2_2
X_06365_ _06365_/I _06417_/A1 VDD VDD VSS VSS gf180mcu_fd_sc_mcu7t5v0__clkinv_1
X_05316_ _10893_/Q _09436_/B2 VDD VDD VSS VSS gf180mcu_fd_sc_mcu7t5v0__clkinv_1
X_08104_ _10071_/Q _08589_/B1 _08877_/A2 _10461_/Q _08107_/A1 VDD VDD
+ VSS VSS gf180mcu_fd_sc_mcu7t5v0__aoi22_1
X_09084_ _06047_/Z _09091_/A2 _09091_/B1 _09084_/B2 _10611_/D VDD VDD
+ VSS VSS gf180mcu_fd_sc_mcu7t5v0__oai22_1
X_06296_ _10085_/Q _06431_/A2 _06298_/A2 VDD VDD VSS VSS gf180mcu_fd_sc_mcu7t5v0__nand2_1
X_08035_ _08035_/A1 _08035_/A2 _08035_/A3 _08099_/A2 VDD VDD VSS VSS
+ gf180mcu_fd_sc_mcu7t5v0__nand3_2
X_05247_ _11012_/Q _09601_/B2 VDD VDD VSS VSS gf180mcu_fd_sc_mcu7t5v0__clkinv_1
X_05178_ _10763_/Q _09274_/B2 VDD VDD VSS VSS gf180mcu_fd_sc_mcu7t5v0__clkinv_1
X_09986_ _09986_/D _11163_/CLK _09986_/Q VDD VDD VSS VSS gf180mcu_fd_sc_mcu7t5v0__dffq_1
X_08937_ _06058_/Z _08941_/A2 _08941_/B1 _08937_/B2 _10494_/D VDD VDD
+ VSS VSS gf180mcu_fd_sc_mcu7t5v0__oai22_1
X_08868_ _10456_/Q _08865_/Z _08868_/Z VDD VDD VSS VSS gf180mcu_fd_sc_mcu7t5v0__and2_1
X_07819_ _06061_/Z _07825_/A2 _07819_/B _10235_/D VDD VDD VSS VSS
+ gf180mcu_fd_sc_mcu7t5v0__oai21_1
X_08799_ _09832_/A1 _08799_/A2 _08799_/B1 _08799_/B2 _10418_/D VDD VDD
+ VSS VSS gf180mcu_fd_sc_mcu7t5v0__oai22_1
X_10830_ _10830_/D _11165_/CLK _10830_/Q VDD VDD VSS VSS gf180mcu_fd_sc_mcu7t5v0__dffq_1
X_10761_ _10761_/D _11010_/CLK _10761_/Q VDD VDD VSS VSS gf180mcu_fd_sc_mcu7t5v0__dffq_1
Xrepeater17 _06099_/ZN _09861_/A1 VDD VDD VSS VSS gf180mcu_fd_sc_mcu7t5v0__buf_12
Xrepeater39 _09916_/A1 _09946_/A1 VDD VDD VSS VSS gf180mcu_fd_sc_mcu7t5v0__clkbuf_20
X_10692_ _10692_/D _11139_/CLK _10692_/Q VDD VDD VSS VSS gf180mcu_fd_sc_mcu7t5v0__dffq_1
Xrepeater28 _08444_/B1 _08586_/A2 VDD VDD VSS VSS gf180mcu_fd_sc_mcu7t5v0__buf_12
X_11175_ _11175_/D _11176_/CLK _11175_/Q VDD VDD VSS VSS gf180mcu_fd_sc_mcu7t5v0__dffq_1
X_10126_ _10126_/D _10327_/CLK _10126_/Q VDD VDD VSS VSS gf180mcu_fd_sc_mcu7t5v0__dffq_2
X_10057_ _10057_/D _11181_/CLK _10057_/Q VDD VDD VSS VSS gf180mcu_fd_sc_mcu7t5v0__dffq_1
X_10959_ _10959_/D _11149_/CLK _10959_/Q VDD VDD VSS VSS gf180mcu_fd_sc_mcu7t5v0__dffq_1
X_06150_ _07682_/A1 _08534_/B2 _08102_/A1 _09872_/A2 VDD VDD VSS VSS
+ gf180mcu_fd_sc_mcu7t5v0__nor3_4
X_05101_ _10939_/Q _09494_/B2 VDD VDD VSS VSS gf180mcu_fd_sc_mcu7t5v0__clkinv_1
X_06081_ _06016_/I _06017_/Z _06021_/Z _08530_/A2 VDD VDD VSS VSS
+ gf180mcu_fd_sc_mcu7t5v0__nor3_4
X_05032_ _10114_/Q _07353_/A3 VDD VDD VSS VSS gf180mcu_fd_sc_mcu7t5v0__inv_3
X_09840_ _09941_/A1 _09850_/A2 _09840_/B _11112_/D VDD VDD VSS VSS
+ gf180mcu_fd_sc_mcu7t5v0__oai21_1
X_09771_ _09769_/Z _09771_/A2 _11079_/D VDD VDD VSS VSS gf180mcu_fd_sc_mcu7t5v0__nor2_1
X_06983_ _07207_/A1 _07003_/A2 _06983_/B _06983_/C _06989_/A2 VDD VDD
+ VSS VSS gf180mcu_fd_sc_mcu7t5v0__oai211_1
X_08722_ _06047_/Z _08729_/A2 _08729_/B1 _08722_/B2 _10355_/D VDD VDD
+ VSS VSS gf180mcu_fd_sc_mcu7t5v0__oai22_1
X_05934_ _10882_/Q _09421_/B2 VDD VDD VSS VSS gf180mcu_fd_sc_mcu7t5v0__clkinv_1
X_05865_ _10642_/Q _09121_/B2 VDD VDD VSS VSS gf180mcu_fd_sc_mcu7t5v0__clkinv_1
X_08653_ _10271_/Q _08657_/A2 _08657_/B1 _10264_/Q _08653_/C _08655_/A2 VDD
+ VDD VSS VSS gf180mcu_fd_sc_mcu7t5v0__aoi221_1
X_08584_ _10706_/Q _08584_/A2 _08584_/B1 _10722_/Q _08585_/C VDD VDD VSS
+ VSS gf180mcu_fd_sc_mcu7t5v0__aoi22_1
X_05796_ _09961_/Q _06092_/B2 VDD VDD VSS VSS gf180mcu_fd_sc_mcu7t5v0__clkinv_1
X_07604_ _07604_/A1 _07587_/Z _07604_/B _07624_/A2 VDD VDD VSS VSS
+ gf180mcu_fd_sc_mcu7t5v0__aoi21_1
X_07535_ _10124_/Q _07533_/Z _07553_/B VDD VDD VSS VSS gf180mcu_fd_sc_mcu7t5v0__nand2_1
X_07466_ _10001_/Q _07428_/I _07463_/Z _10000_/Q _07507_/A2 VDD VDD VSS
+ VSS gf180mcu_fd_sc_mcu7t5v0__aoi22_1
X_06417_ _06417_/A1 _06417_/A2 _06417_/B _06466_/A2 VDD VDD VSS VSS
+ gf180mcu_fd_sc_mcu7t5v0__oai21_1
X_09205_ _09940_/A1 _09211_/A2 _09211_/B1 _09205_/B2 _10708_/D VDD VDD
+ VSS VSS gf180mcu_fd_sc_mcu7t5v0__oai22_1
X_07397_ _07519_/A1 _07519_/A2 _07519_/B _10002_/Q _07401_/A2 VDD VDD
+ VSS VSS gf180mcu_fd_sc_mcu7t5v0__oai211_2
X_09136_ _09893_/A1 _09141_/A2 _09141_/B1 _09136_/B2 _10653_/D VDD VDD
+ VSS VSS gf180mcu_fd_sc_mcu7t5v0__oai22_1
X_06348_ _10004_/Q _06446_/A2 _06395_/A1 VDD VDD VSS VSS gf180mcu_fd_sc_mcu7t5v0__nand2_1
X_09067_ _06058_/Z _09071_/A2 _09071_/B1 _09067_/B2 _10598_/D VDD VDD
+ VSS VSS gf180mcu_fd_sc_mcu7t5v0__oai22_1
X_06279_ _10002_/Q _06278_/Z _06280_/I VDD VDD VSS VSS gf180mcu_fd_sc_mcu7t5v0__nand2_1
X_08018_ _10484_/Q _08590_/A2 _08560_/B1 _10144_/Q _07255_/I _11159_/Q _08020_/A2
+ VDD VDD VSS VSS gf180mcu_fd_sc_mcu7t5v0__aoi222_2
X_09969_ _09969_/D _11181_/CLK _09969_/Q VDD VDD VSS VSS gf180mcu_fd_sc_mcu7t5v0__dffq_1
X_10813_ _10813_/D _11010_/CLK _10813_/Q VDD VDD VSS VSS gf180mcu_fd_sc_mcu7t5v0__dffq_1
X_10744_ _10744_/D _11018_/CLK _10744_/Q VDD VDD VSS VSS gf180mcu_fd_sc_mcu7t5v0__dffq_1
X_10675_ _10675_/D _11139_/CLK _10675_/Q VDD VDD VSS VSS gf180mcu_fd_sc_mcu7t5v0__dffq_1
X_11158_ _11158_/D _11165_/CLK _11158_/Q VDD VDD VSS VSS gf180mcu_fd_sc_mcu7t5v0__dffq_1
X_10109_ _10109_/D _11163_/CLK _10109_/Q VDD VDD VSS VSS gf180mcu_fd_sc_mcu7t5v0__dffq_1
X_11089_ _11089_/D _11097_/CLK _11089_/Q VDD VDD VSS VSS gf180mcu_fd_sc_mcu7t5v0__dffq_1
X_05650_ _10616_/Q _09089_/B2 VDD VDD VSS VSS gf180mcu_fd_sc_mcu7t5v0__clkinv_1
X_05581_ _10227_/Q _07804_/B2 VDD VDD VSS VSS gf180mcu_fd_sc_mcu7t5v0__clkinv_1
X_07320_ _10243_/Q _08675_/A2 _08674_/B _07321_/B VDD VDD VSS VSS
+ gf180mcu_fd_sc_mcu7t5v0__oai21_1
X_07251_ _07019_/C _07251_/A2 _07601_/B _07252_/B2 VDD VDD VSS VSS
+ gf180mcu_fd_sc_mcu7t5v0__aoi21_1
X_06202_ _10000_/Q _06481_/A2 _06270_/A1 VDD VDD VSS VSS gf180mcu_fd_sc_mcu7t5v0__nand2_1
X_07182_ _07183_/A1 _07183_/A3 _07182_/Z VDD VDD VSS VSS gf180mcu_fd_sc_mcu7t5v0__and2_1
X_06133_ _09981_/Q _06143_/A2 _06134_/B VDD VDD VSS VSS gf180mcu_fd_sc_mcu7t5v0__nand2_1
X_06064_ bus_wdata[5] _08619_/B _06065_/B VDD VDD VSS VSS gf180mcu_fd_sc_mcu7t5v0__and2_1
X_05015_ _10269_/Q _07899_/A1 VDD VDD VSS VSS gf180mcu_fd_sc_mcu7t5v0__clkinv_1
X_09823_ _09889_/A1 _09823_/A2 _09832_/A2 VDD VDD VSS VSS gf180mcu_fd_sc_mcu7t5v0__nand2_4
X_09754_ _10301_/Q _10303_/Q _10302_/Q _09754_/B _09755_/I VDD VDD VSS
+ VSS gf180mcu_fd_sc_mcu7t5v0__oai31_2
X_06966_ _10077_/Q _06966_/A2 _07199_/B VDD VDD VSS VSS gf180mcu_fd_sc_mcu7t5v0__nand2_2
X_05917_ _11133_/Q _09870_/B2 VDD VDD VSS VSS gf180mcu_fd_sc_mcu7t5v0__clkinv_1
X_08705_ _06058_/Z _08709_/A2 _08709_/B1 _08705_/B2 _10342_/D VDD VDD
+ VSS VSS gf180mcu_fd_sc_mcu7t5v0__oai22_1
X_09685_ _09678_/Z _09685_/A2 _09686_/B VDD VDD VSS VSS gf180mcu_fd_sc_mcu7t5v0__nand2_1
X_06897_ _09944_/A1 _06899_/A2 _06899_/B1 _06897_/B2 _10066_/D VDD VDD
+ VSS VSS gf180mcu_fd_sc_mcu7t5v0__oai22_1
X_05848_ _10506_/Q _08951_/B2 VDD VDD VSS VSS gf180mcu_fd_sc_mcu7t5v0__clkinv_1
X_08636_ _08636_/A1 _07601_/B _08637_/C VDD VDD VSS VSS gf180mcu_fd_sc_mcu7t5v0__nor2_1
X_08567_ _10386_/Q _08591_/A2 _08576_/B1 _10930_/Q _08570_/A1 VDD VDD
+ VSS VSS gf180mcu_fd_sc_mcu7t5v0__aoi22_1
X_05779_ _10197_/Q _07757_/B2 VDD VDD VSS VSS gf180mcu_fd_sc_mcu7t5v0__clkinv_1
X_07518_ _07518_/I _07524_/B VDD VDD VSS VSS gf180mcu_fd_sc_mcu7t5v0__clkinv_1
X_08498_ _08498_/A1 _08498_/A2 _08498_/A3 _08503_/A2 VDD VDD VSS VSS
+ gf180mcu_fd_sc_mcu7t5v0__nand3_1
X_07449_ _07470_/B2 _07428_/I _07449_/A3 _07451_/B VDD VDD VSS VSS
+ gf180mcu_fd_sc_mcu7t5v0__xor3_1
X_10460_ _10460_/D _11163_/CLK _10460_/Q VDD VDD VSS VSS gf180mcu_fd_sc_mcu7t5v0__dffq_1
X_09119_ _09944_/A1 _09121_/A2 _09121_/B1 _09119_/B2 _10640_/D VDD VDD
+ VSS VSS gf180mcu_fd_sc_mcu7t5v0__oai22_1
X_10391_ _10391_/D _11018_/CLK _10391_/Q VDD VDD VSS VSS gf180mcu_fd_sc_mcu7t5v0__dffq_1
X_11012_ _11012_/D _11017_/CLK _11012_/Q VDD VDD VSS VSS gf180mcu_fd_sc_mcu7t5v0__dffq_1
X_10727_ _10727_/D _11147_/CLK _10727_/Q VDD VDD VSS VSS gf180mcu_fd_sc_mcu7t5v0__dffq_1
X_10658_ _10658_/D _10978_/CLK _10658_/Q VDD VDD VSS VSS gf180mcu_fd_sc_mcu7t5v0__dffq_1
X_10589_ _10589_/D _10666_/CLK _10589_/Q VDD VDD VSS VSS gf180mcu_fd_sc_mcu7t5v0__dffq_1
X_06820_ _10051_/Q _06835_/A2 _06839_/B VDD VDD VSS VSS gf180mcu_fd_sc_mcu7t5v0__nand2_1
X_06751_ _06641_/Z _06751_/A2 _06751_/B _06758_/A1 VDD VDD VSS VSS
+ gf180mcu_fd_sc_mcu7t5v0__aoi21_1
X_05702_ _10936_/Q _09489_/B2 VDD VDD VSS VSS gf180mcu_fd_sc_mcu7t5v0__clkinv_1
X_09470_ _09945_/A1 _09471_/A2 _09471_/B1 _09470_/B2 _10921_/D VDD VDD
+ VSS VSS gf180mcu_fd_sc_mcu7t5v0__oai22_1
X_06682_ _10003_/Q _06873_/A2 _06682_/B _06683_/C VDD VDD VSS VSS
+ gf180mcu_fd_sc_mcu7t5v0__aoi21_1
X_08421_ _10180_/Q _08589_/A2 _08591_/A2 _10384_/Q _08422_/A3 VDD VDD
+ VSS VSS gf180mcu_fd_sc_mcu7t5v0__aoi22_1
X_05633_ _11107_/Q _09830_/B2 VDD VDD VSS VSS gf180mcu_fd_sc_mcu7t5v0__clkinv_1
X_05564_ _10375_/Q _08746_/B2 VDD VDD VSS VSS gf180mcu_fd_sc_mcu7t5v0__clkinv_1
X_08352_ _09952_/Q _08560_/A2 _08560_/B1 _11008_/Q _07255_/I _10984_/Q _08354_/A2
+ VDD VDD VSS VSS gf180mcu_fd_sc_mcu7t5v0__aoi222_4
X_05495_ _10758_/Q _09267_/B2 VDD VDD VSS VSS gf180mcu_fd_sc_mcu7t5v0__clkinv_1
X_07303_ _06058_/Z _07311_/A2 _07303_/B _10109_/D VDD VDD VSS VSS
+ gf180mcu_fd_sc_mcu7t5v0__oai21_1
X_08283_ _08283_/A1 _08283_/A2 _08283_/A3 _08343_/A2 VDD VDD VSS VSS
+ gf180mcu_fd_sc_mcu7t5v0__nand3_1
X_07234_ _07234_/A1 _07230_/Z _07233_/Z _07234_/Z VDD VDD VSS VSS
+ gf180mcu_fd_sc_mcu7t5v0__xor3_1
X_07165_ _10125_/Q _07025_/Z _07217_/B1 _10329_/Q _07204_/A3 VDD VDD VSS
+ VSS gf180mcu_fd_sc_mcu7t5v0__aoi22_2
X_06116_ _06047_/Z _06123_/A2 _06123_/B1 _06116_/B2 _09971_/D VDD VDD
+ VSS VSS gf180mcu_fd_sc_mcu7t5v0__oai22_1
X_07096_ _07045_/I _07095_/Z _07144_/A2 VDD VDD VSS VSS gf180mcu_fd_sc_mcu7t5v0__nor2_1
X_06047_ _09679_/A1 _07358_/A1 cgra_status[0] _06047_/Z VDD VDD VSS
+ VSS gf180mcu_fd_sc_mcu7t5v0__mux2_4
X_09806_ _09806_/A1 _09817_/A2 _09806_/B _11095_/D VDD VDD VSS VSS
+ gf180mcu_fd_sc_mcu7t5v0__aoi21_1
X_07998_ _10053_/Q _06877_/Z _08532_/A2 _11166_/Q _08563_/C1 _11174_/Q _08001_/A1
+ VDD VDD VSS VSS gf180mcu_fd_sc_mcu7t5v0__aoi222_2
X_09737_ _11069_/Q _05977_/Z _09754_/B _09738_/C VDD VDD VSS VSS gf180mcu_fd_sc_mcu7t5v0__oai21_1
X_06949_ _06952_/A1 _07248_/B _07206_/A2 VDD VDD VSS VSS gf180mcu_fd_sc_mcu7t5v0__nor2_2
X_09668_ _06061_/Z _09671_/A2 _09671_/B1 _09668_/B2 _11047_/D VDD VDD
+ VSS VSS gf180mcu_fd_sc_mcu7t5v0__oai22_1
X_09599_ _09599_/A1 _09607_/A2 _09607_/B1 VDD VDD VSS VSS gf180mcu_fd_sc_mcu7t5v0__nand2_2
X_08619_ _08626_/A2 _08626_/A3 _08619_/B _08622_/A2 VDD VDD VSS VSS
+ gf180mcu_fd_sc_mcu7t5v0__oai21_1
X_10512_ _10512_/D _11109_/CLK _10512_/Q VDD VDD VSS VSS gf180mcu_fd_sc_mcu7t5v0__dffq_1
X_10443_ _10443_/D _11101_/CLK _10443_/Q VDD VDD VSS VSS gf180mcu_fd_sc_mcu7t5v0__dffq_1
X_10374_ _10374_/D _11147_/CLK _10374_/Q VDD VDD VSS VSS gf180mcu_fd_sc_mcu7t5v0__dffq_1
X_05280_ _10908_/Q _09455_/B2 VDD VDD VSS VSS gf180mcu_fd_sc_mcu7t5v0__clkinv_1
X_08970_ _09925_/A1 _08971_/A2 _08971_/B1 _08970_/B2 _10521_/D VDD VDD
+ VSS VSS gf180mcu_fd_sc_mcu7t5v0__oai22_1
X_07921_ _07921_/A1 _06034_/I _08329_/B VDD VDD VSS VSS gf180mcu_fd_sc_mcu7t5v0__nand2_4
X_07852_ _10248_/Q _07853_/A2 _07853_/B VDD VDD VSS VSS gf180mcu_fd_sc_mcu7t5v0__nor2_1
X_06803_ _10006_/Q _06590_/Z _06852_/A1 VDD VDD VSS VSS gf180mcu_fd_sc_mcu7t5v0__nand2_1
X_04995_ _10325_/Q _08665_/A1 VDD VDD VSS VSS gf180mcu_fd_sc_mcu7t5v0__clkinv_1
X_09522_ _09889_/A1 _09523_/A2 _09539_/A2 VDD VDD VSS VSS gf180mcu_fd_sc_mcu7t5v0__nand2_2
X_07783_ _09884_/A1 _07787_/A2 _07783_/B _10212_/D VDD VDD VSS VSS
+ gf180mcu_fd_sc_mcu7t5v0__oai21_1
X_06734_ _10004_/Q _06734_/A2 _06734_/B1 _06872_/I1 _06873_/B _06735_/B2 VDD
+ VDD VSS VSS gf180mcu_fd_sc_mcu7t5v0__aoi221_1
X_09453_ _09890_/A1 _09461_/A2 _09461_/B1 VDD VDD VSS VSS gf180mcu_fd_sc_mcu7t5v0__nand2_2
X_06665_ _06667_/A2 _06667_/A3 _06689_/B VDD VDD VSS VSS gf180mcu_fd_sc_mcu7t5v0__nor2_1
X_08404_ _11147_/Q _08555_/A2 _08591_/A2 _10344_/Q _08407_/A2 VDD VDD
+ VSS VSS gf180mcu_fd_sc_mcu7t5v0__aoi22_1
X_09384_ _06047_/Z _09391_/A2 _09391_/B1 _09384_/B2 _10851_/D VDD VDD
+ VSS VSS gf180mcu_fd_sc_mcu7t5v0__oai22_1
X_05616_ _10879_/Q _09418_/B2 VDD VDD VSS VSS gf180mcu_fd_sc_mcu7t5v0__clkinv_1
X_06596_ _07362_/A3 _06608_/A2 _06618_/B VDD VDD VSS VSS gf180mcu_fd_sc_mcu7t5v0__nor2_1
X_08335_ _10163_/Q _06023_/I _08564_/C1 _10139_/Q _08563_/C1 _10296_/Q _08337_/A1
+ VDD VDD VSS VSS gf180mcu_fd_sc_mcu7t5v0__aoi222_2
X_05547_ _10639_/Q _09118_/B2 VDD VDD VSS VSS gf180mcu_fd_sc_mcu7t5v0__clkinv_1
X_08266_ _08266_/A1 _08266_/A2 _08267_/C VDD VDD VSS VSS gf180mcu_fd_sc_mcu7t5v0__nand2_1
X_05478_ _09958_/Q _06089_/B2 VDD VDD VSS VSS gf180mcu_fd_sc_mcu7t5v0__clkinv_1
X_08197_ _08533_/B2 _08197_/A2 _08204_/B VDD VDD VSS VSS gf180mcu_fd_sc_mcu7t5v0__nor2_1
X_07217_ _10126_/Q _07025_/Z _07217_/B1 _10330_/Q _07240_/A3 VDD VDD VSS
+ VSS gf180mcu_fd_sc_mcu7t5v0__aoi22_1
X_07148_ _07199_/B _07199_/A1 _07148_/B _07149_/A2 VDD VDD VSS VSS
+ gf180mcu_fd_sc_mcu7t5v0__aoi21_1
X_07079_ _10004_/Q _07222_/A2 _07177_/A1 VDD VDD VSS VSS gf180mcu_fd_sc_mcu7t5v0__nand2_1
X_10090_ _10090_/D _10905_/CLK _10090_/Q VDD VDD VSS VSS gf180mcu_fd_sc_mcu7t5v0__dffq_1
X_10992_ _10992_/D _11017_/CLK _10992_/Q VDD VDD VSS VSS gf180mcu_fd_sc_mcu7t5v0__dffq_1
X_10426_ _10426_/D _11017_/CLK _10426_/Q VDD VDD VSS VSS gf180mcu_fd_sc_mcu7t5v0__dffq_1
X_10357_ _10357_/D _11010_/CLK _10357_/Q VDD VDD VSS VSS gf180mcu_fd_sc_mcu7t5v0__dffq_1
X_10288_ _10288_/D _11097_/CLK _10288_/Q VDD VDD VSS VSS gf180mcu_fd_sc_mcu7t5v0__dffq_1
X_06450_ _06441_/Z _06450_/A2 _06447_/Z _06451_/B VDD VDD VSS VSS
+ gf180mcu_fd_sc_mcu7t5v0__xor3_1
X_05401_ _10853_/Q _09386_/B2 VDD VDD VSS VSS gf180mcu_fd_sc_mcu7t5v0__clkinv_1
X_06381_ _10050_/Q _06195_/Z _06383_/A1 VDD VDD VSS VSS gf180mcu_fd_sc_mcu7t5v0__nand2_1
X_08120_ _11037_/Q _06112_/I _09872_/A1 _09981_/Q _10129_/Q _08589_/B1 _08121_/A3
+ VDD VDD VSS VSS gf180mcu_fd_sc_mcu7t5v0__aoi222_1
X_05332_ _10613_/Q _09086_/B2 VDD VDD VSS VSS gf180mcu_fd_sc_mcu7t5v0__clkinv_1
X_05263_ _10224_/Q _07801_/B2 VDD VDD VSS VSS gf180mcu_fd_sc_mcu7t5v0__clkinv_1
X_08051_ _10972_/Q _08555_/A2 _06877_/Z _10956_/Q _07680_/I _10908_/Q _08054_/A1 VDD
+ VDD VSS VSS gf180mcu_fd_sc_mcu7t5v0__aoi222_2
X_07002_ _07002_/A1 _07001_/Z _07004_/A2 VDD VDD VSS VSS gf180mcu_fd_sc_mcu7t5v0__nand2_1
X_05194_ _10492_/Q _08935_/B2 VDD VDD VSS VSS gf180mcu_fd_sc_mcu7t5v0__clkinv_1
X_08953_ _09433_/A1 _08961_/A2 _08961_/B1 VDD VDD VSS VSS gf180mcu_fd_sc_mcu7t5v0__nand2_4
X_07904_ bus_wdata[6] _07905_/A2 rst_n _07905_/B VDD VDD VSS VSS gf180mcu_fd_sc_mcu7t5v0__oai21_1
X_08884_ _10462_/Q _08892_/A2 _08885_/B VDD VDD VSS VSS gf180mcu_fd_sc_mcu7t5v0__nand2_1
X_07835_ _10240_/Q _07842_/A2 _07836_/B VDD VDD VSS VSS gf180mcu_fd_sc_mcu7t5v0__nor2_1
X_07766_ _06061_/Z _07769_/A2 _07769_/B1 _07766_/B2 _10203_/D VDD VDD
+ VSS VSS gf180mcu_fd_sc_mcu7t5v0__oai22_1
X_04978_ _11091_/Q _09798_/A1 VDD VDD VSS VSS gf180mcu_fd_sc_mcu7t5v0__clkinv_1
X_09505_ _09920_/A1 _09511_/A2 _09511_/B1 _09505_/B2 _10948_/D VDD VDD
+ VSS VSS gf180mcu_fd_sc_mcu7t5v0__oai22_1
X_06717_ _10049_/Q _06716_/Z _06739_/B VDD VDD VSS VSS gf180mcu_fd_sc_mcu7t5v0__nand2_1
X_09436_ _09921_/A1 _09441_/A2 _09441_/B1 _09436_/B2 _10893_/D VDD VDD
+ VSS VSS gf180mcu_fd_sc_mcu7t5v0__oai22_1
X_07697_ _09945_/A1 _07699_/A2 _07697_/B _10157_/D VDD VDD VSS VSS
+ gf180mcu_fd_sc_mcu7t5v0__oai21_1
X_06648_ _06648_/A1 _06648_/A2 _07603_/B _10047_/D VDD VDD VSS VSS
+ gf180mcu_fd_sc_mcu7t5v0__aoi21_1
X_09367_ _06058_/Z _09371_/A2 _09371_/B1 _09367_/B2 _10838_/D VDD VDD
+ VSS VSS gf180mcu_fd_sc_mcu7t5v0__oai22_1
X_06579_ _10042_/Q _10041_/Q _06579_/A3 _06834_/C VDD VDD VSS VSS
+ gf180mcu_fd_sc_mcu7t5v0__nand3_4
X_09298_ _06061_/Z _09301_/A2 _09301_/B1 _09298_/B2 _10783_/D VDD VDD
+ VSS VSS gf180mcu_fd_sc_mcu7t5v0__oai22_1
X_08318_ _10711_/Q _08586_/A2 _08532_/A2 _10719_/Q _08322_/A1 VDD VDD
+ VSS VSS gf180mcu_fd_sc_mcu7t5v0__aoi22_1
X_08249_ _08249_/A1 _08249_/A2 _08249_/A3 _08254_/A2 VDD VDD VSS VSS
+ gf180mcu_fd_sc_mcu7t5v0__nand3_1
X_10211_ _10211_/D _11052_/CLK _10211_/Q VDD VDD VSS VSS gf180mcu_fd_sc_mcu7t5v0__dffq_1
X_10142_ _10142_/D _11176_/CLK _10142_/Q VDD VDD VSS VSS gf180mcu_fd_sc_mcu7t5v0__dffq_1
X_10073_ _10073_/D _11139_/CLK _10073_/Q VDD VDD VSS VSS gf180mcu_fd_sc_mcu7t5v0__dffq_1
X_10975_ _10975_/D _10978_/CLK _10975_/Q VDD VDD VSS VSS gf180mcu_fd_sc_mcu7t5v0__dffq_1
X_10409_ _10409_/D _11139_/CLK _10409_/Q VDD VDD VSS VSS gf180mcu_fd_sc_mcu7t5v0__dffq_1
X_05950_ bus_addr[6] _07829_/C _05987_/A3 VDD VDD VSS VSS gf180mcu_fd_sc_mcu7t5v0__nor2_2
X_05881_ _10426_/Q _08809_/B2 VDD VDD VSS VSS gf180mcu_fd_sc_mcu7t5v0__clkinv_1
X_07620_ _07613_/Z _07618_/Z _07619_/Z _07620_/Z VDD VDD VSS VSS gf180mcu_fd_sc_mcu7t5v0__xor3_1
X_07551_ _07551_/A1 _07551_/A2 _07603_/B _10124_/D VDD VDD VSS VSS
+ gf180mcu_fd_sc_mcu7t5v0__aoi21_1
X_06502_ _06502_/A1 _06502_/A2 _06502_/B _06503_/A3 VDD VDD VSS VSS
+ gf180mcu_fd_sc_mcu7t5v0__oai21_1
X_07482_ _10123_/Q _07480_/Z _07505_/B VDD VDD VSS VSS gf180mcu_fd_sc_mcu7t5v0__nand2_1
X_09221_ _09946_/A1 _09221_/A2 _09221_/B1 _09221_/B2 _10722_/D VDD VDD
+ VSS VSS gf180mcu_fd_sc_mcu7t5v0__oai22_1
X_06433_ _10000_/Q _06502_/A1 _06436_/A1 VDD VDD VSS VSS gf180mcu_fd_sc_mcu7t5v0__nand2_1
X_06364_ _10004_/Q _06363_/Z _06365_/I VDD VDD VSS VSS gf180mcu_fd_sc_mcu7t5v0__nand2_1
X_09152_ _09889_/A1 _08588_/B _09161_/A2 VDD VDD VSS VSS gf180mcu_fd_sc_mcu7t5v0__nand2_4
X_05315_ _11104_/Q _09827_/B2 VDD VDD VSS VSS gf180mcu_fd_sc_mcu7t5v0__clkinv_1
X_08103_ _08654_/B _08103_/A2 _10281_/D VDD VDD VSS VSS gf180mcu_fd_sc_mcu7t5v0__and2_1
X_09083_ _08658_/B _09091_/A2 _09091_/B1 VDD VDD VSS VSS gf180mcu_fd_sc_mcu7t5v0__nand2_2
X_06295_ _10048_/Q _06195_/Z _06298_/A1 VDD VDD VSS VSS gf180mcu_fd_sc_mcu7t5v0__nand2_1
X_05246_ _10372_/Q _08743_/B2 VDD VDD VSS VSS gf180mcu_fd_sc_mcu7t5v0__clkinv_1
X_08034_ _10724_/Q _08580_/A2 _06125_/I _11044_/Q _07680_/I _10372_/Q _08035_/A3 VDD
+ VDD VSS VSS gf180mcu_fd_sc_mcu7t5v0__aoi222_2
X_05177_ _10755_/Q _09264_/B2 VDD VDD VSS VSS gf180mcu_fd_sc_mcu7t5v0__clkinv_1
X_09985_ _09985_/D _11164_/CLK _09985_/Q VDD VDD VSS VSS gf180mcu_fd_sc_mcu7t5v0__dffq_1
X_08936_ _09921_/A1 _08941_/A2 _08941_/B1 _08936_/B2 _10493_/D VDD VDD
+ VSS VSS gf180mcu_fd_sc_mcu7t5v0__oai22_1
X_08867_ _08865_/Z _08867_/A2 _10455_/D VDD VDD VSS VSS gf180mcu_fd_sc_mcu7t5v0__nor2_1
X_07818_ _10235_/Q _07824_/A2 _07819_/B VDD VDD VSS VSS gf180mcu_fd_sc_mcu7t5v0__nand2_1
X_08798_ _09925_/A1 _08799_/A2 _08799_/B1 _08798_/B2 _10417_/D VDD VDD
+ VSS VSS gf180mcu_fd_sc_mcu7t5v0__oai22_1
X_07749_ _08529_/B1 _07809_/A2 _07758_/A2 VDD VDD VSS VSS gf180mcu_fd_sc_mcu7t5v0__nand2_4
X_10760_ _10760_/D _11010_/CLK _10760_/Q VDD VDD VSS VSS gf180mcu_fd_sc_mcu7t5v0__dffq_1
Xrepeater18 _08528_/A2 _06023_/I VDD VDD VSS VSS gf180mcu_fd_sc_mcu7t5v0__buf_16
X_09419_ _09896_/A1 _09421_/A2 _09421_/B1 _09419_/B2 _10880_/D VDD VDD
+ VSS VSS gf180mcu_fd_sc_mcu7t5v0__oai22_1
Xrepeater29 _09921_/A1 _09893_/A1 VDD VDD VSS VSS gf180mcu_fd_sc_mcu7t5v0__buf_16
X_10691_ _10691_/D _11139_/CLK _10691_/Q VDD VDD VSS VSS gf180mcu_fd_sc_mcu7t5v0__dffq_1
X_11174_ _11174_/D _11181_/CLK _11174_/Q VDD VDD VSS VSS gf180mcu_fd_sc_mcu7t5v0__dffq_1
X_10125_ _10125_/D _10327_/CLK _10125_/Q VDD VDD VSS VSS gf180mcu_fd_sc_mcu7t5v0__dffq_4
X_10056_ _10056_/D _11181_/CLK _10056_/Q VDD VDD VSS VSS gf180mcu_fd_sc_mcu7t5v0__dffq_1
X_10958_ _10958_/D _11149_/CLK _10958_/Q VDD VDD VSS VSS gf180mcu_fd_sc_mcu7t5v0__dffq_1
X_10889_ _10889_/D _11147_/CLK _10889_/Q VDD VDD VSS VSS gf180mcu_fd_sc_mcu7t5v0__dffq_1
X_05100_ _10987_/Q _09570_/B2 VDD VDD VSS VSS gf180mcu_fd_sc_mcu7t5v0__clkinv_1
X_06080_ _06016_/I _06017_/Z _06878_/A2 VDD VDD VSS VSS gf180mcu_fd_sc_mcu7t5v0__nor2_4
X_05031_ _10115_/Q _07341_/A2 VDD VDD VSS VSS gf180mcu_fd_sc_mcu7t5v0__inv_1
X_09770_ _11079_/Q _09766_/Z _09776_/B _09771_/A2 VDD VDD VSS VSS
+ gf180mcu_fd_sc_mcu7t5v0__oai21_1
X_06982_ _07246_/A1 _06972_/Z _06982_/B _06983_/C VDD VDD VSS VSS
+ gf180mcu_fd_sc_mcu7t5v0__aoi21_1
X_08721_ _09433_/A1 _08729_/A2 _08729_/B1 VDD VDD VSS VSS gf180mcu_fd_sc_mcu7t5v0__nand2_4
X_05933_ _10874_/Q _09411_/B2 VDD VDD VSS VSS gf180mcu_fd_sc_mcu7t5v0__clkinv_1
X_08652_ _08652_/A1 _07601_/B _08653_/C VDD VDD VSS VSS gf180mcu_fd_sc_mcu7t5v0__nor2_1
X_05864_ _10634_/Q _09111_/B2 VDD VDD VSS VSS gf180mcu_fd_sc_mcu7t5v0__clkinv_1
X_07603_ _07603_/A1 _07603_/A2 _07603_/B _10125_/D VDD VDD VSS VSS
+ gf180mcu_fd_sc_mcu7t5v0__aoi21_1
X_05795_ _10205_/Q _07768_/B2 VDD VDD VSS VSS gf180mcu_fd_sc_mcu7t5v0__clkinv_1
X_08583_ _08583_/A1 _08583_/A2 _08583_/A3 _08596_/B1 VDD VDD VSS VSS
+ gf180mcu_fd_sc_mcu7t5v0__nand3_1
X_07534_ _10124_/Q _07533_/Z _07553_/A2 VDD VDD VSS VSS gf180mcu_fd_sc_mcu7t5v0__nor2_1
X_07465_ _07465_/A1 _07513_/A1 _07554_/A1 VDD VDD VSS VSS gf180mcu_fd_sc_mcu7t5v0__nor2_2
X_06416_ _06417_/A1 _06417_/A2 _06417_/B _06423_/A1 VDD VDD VSS VSS
+ gf180mcu_fd_sc_mcu7t5v0__nor3_1
X_09204_ _06047_/Z _09211_/A2 _09211_/B1 _09204_/B2 _10707_/D VDD VDD
+ VSS VSS gf180mcu_fd_sc_mcu7t5v0__oai22_1
X_07396_ _07434_/A1 _07485_/A1 _07468_/A1 VDD VDD VSS VSS gf180mcu_fd_sc_mcu7t5v0__nor2_1
X_09135_ _09940_/A1 _09141_/A2 _09141_/B1 _09135_/B2 _10652_/D VDD VDD
+ VSS VSS gf180mcu_fd_sc_mcu7t5v0__oai22_1
X_06347_ _10004_/Q _06481_/A2 _06446_/A2 _10003_/Q _06390_/A2 VDD VDD
+ VSS VSS gf180mcu_fd_sc_mcu7t5v0__aoi22_1
X_09066_ _09941_/A1 _09071_/A2 _09071_/B1 _09066_/B2 _10597_/D VDD VDD
+ VSS VSS gf180mcu_fd_sc_mcu7t5v0__oai22_1
X_06278_ _06479_/A2 _06278_/A2 _06278_/Z VDD VDD VSS VSS gf180mcu_fd_sc_mcu7t5v0__xor2_1
X_08017_ _10412_/Q _08559_/A2 _06112_/I _10436_/Q _08020_/A1 VDD VDD VSS
+ VSS gf180mcu_fd_sc_mcu7t5v0__aoi22_1
X_05229_ _10636_/Q _09115_/B2 VDD VDD VSS VSS gf180mcu_fd_sc_mcu7t5v0__clkinv_1
X_09968_ _09968_/D _11181_/CLK _09968_/Q VDD VDD VSS VSS gf180mcu_fd_sc_mcu7t5v0__dffq_1
X_08919_ _09925_/A1 _08921_/A2 _08919_/B _10481_/D VDD VDD VSS VSS
+ gf180mcu_fd_sc_mcu7t5v0__oai21_1
X_09899_ _09900_/A1 _09900_/A2 _09916_/A2 VDD VDD VSS VSS gf180mcu_fd_sc_mcu7t5v0__nand2_2
X_10812_ _10812_/D _11164_/CLK _10812_/Q VDD VDD VSS VSS gf180mcu_fd_sc_mcu7t5v0__dffq_1
X_10743_ _10743_/D _11017_/CLK _10743_/Q VDD VDD VSS VSS gf180mcu_fd_sc_mcu7t5v0__dffq_1
X_10674_ _10674_/D _11139_/CLK _10674_/Q VDD VDD VSS VSS gf180mcu_fd_sc_mcu7t5v0__dffq_1
X_11157_ _11157_/D _11163_/CLK _11157_/Q VDD VDD VSS VSS gf180mcu_fd_sc_mcu7t5v0__dffq_1
X_10108_ _10108_/D _11139_/CLK _10108_/Q VDD VDD VSS VSS gf180mcu_fd_sc_mcu7t5v0__dffq_1
X_11088_ _11088_/D _11101_/CLK _11088_/Q VDD VDD VSS VSS gf180mcu_fd_sc_mcu7t5v0__dffq_1
X_10039_ _10039_/D _11181_/CLK _10039_/Q VDD VDD VSS VSS gf180mcu_fd_sc_mcu7t5v0__dffq_1
X_05580_ _10343_/Q _08706_/B2 VDD VDD VSS VSS gf180mcu_fd_sc_mcu7t5v0__clkinv_1
X_07250_ _07250_/A1 _07250_/A2 _07250_/B _07250_/C _07251_/A2 VDD VDD
+ VSS VSS gf180mcu_fd_sc_mcu7t5v0__oai211_1
X_06201_ _07379_/A1 _06444_/A2 _06257_/A2 VDD VDD VSS VSS gf180mcu_fd_sc_mcu7t5v0__nor2_1
X_07181_ _10006_/Q _07181_/A2 _07227_/A2 VDD VDD VSS VSS gf180mcu_fd_sc_mcu7t5v0__nand2_1
X_06132_ _09904_/A1 _06144_/A2 _06132_/B _09980_/D VDD VDD VSS VSS
+ gf180mcu_fd_sc_mcu7t5v0__oai21_1
X_06063_ _09952_/Q _06071_/A2 _06066_/B VDD VDD VSS VSS gf180mcu_fd_sc_mcu7t5v0__nand2_1
X_05014_ _10270_/Q _07901_/A1 VDD VDD VSS VSS gf180mcu_fd_sc_mcu7t5v0__clkinv_1
X_09822_ _09822_/A1 _09822_/A2 _11101_/D VDD VDD VSS VSS gf180mcu_fd_sc_mcu7t5v0__nor2_1
X_09753_ _11074_/Q _09749_/Z _09753_/Z VDD VDD VSS VSS gf180mcu_fd_sc_mcu7t5v0__and2_1
X_08704_ _09893_/A1 _08709_/A2 _08709_/B1 _08704_/B2 _10341_/D VDD VDD
+ VSS VSS gf180mcu_fd_sc_mcu7t5v0__oai22_1
X_06965_ _10077_/Q _06966_/A2 _06965_/Z VDD VDD VSS VSS gf180mcu_fd_sc_mcu7t5v0__and2_1
X_05916_ _10914_/Q _09461_/B2 VDD VDD VSS VSS gf180mcu_fd_sc_mcu7t5v0__clkinv_1
X_09684_ _11053_/Q _09678_/Z rst_n _09687_/A1 VDD VDD VSS VSS gf180mcu_fd_sc_mcu7t5v0__oai21_1
X_06896_ _06061_/Z _06899_/A2 _06899_/B1 _06896_/B2 _10065_/D VDD VDD
+ VSS VSS gf180mcu_fd_sc_mcu7t5v0__oai22_1
X_05847_ _10362_/Q _08729_/B2 VDD VDD VSS VSS gf180mcu_fd_sc_mcu7t5v0__clkinv_1
X_08635_ _08659_/A1 _08635_/A2 _08635_/B _10316_/D VDD VDD VSS VSS
+ gf180mcu_fd_sc_mcu7t5v0__aoi21_1
X_08566_ _08566_/A1 _08566_/A2 _08566_/A3 _08571_/B1 VDD VDD VSS VSS
+ gf180mcu_fd_sc_mcu7t5v0__nand3_1
X_05778_ _11001_/Q _09586_/B2 VDD VDD VSS VSS gf180mcu_fd_sc_mcu7t5v0__clkinv_1
X_07517_ _10003_/Q _07393_/I _07518_/I VDD VDD VSS VSS gf180mcu_fd_sc_mcu7t5v0__nand2_1
X_08497_ _10969_/Q _08530_/A2 _06877_/Z _10237_/Q _08498_/A3 VDD VDD VSS
+ VSS gf180mcu_fd_sc_mcu7t5v0__aoi22_1
X_07448_ _07470_/B2 _07447_/Z _07492_/A1 VDD VDD VSS VSS gf180mcu_fd_sc_mcu7t5v0__nor2_1
X_07379_ _07379_/A1 _07365_/I _07382_/A1 VDD VDD VSS VSS gf180mcu_fd_sc_mcu7t5v0__nor2_1
X_09118_ _06061_/Z _09121_/A2 _09121_/B1 _09118_/B2 _10639_/D VDD VDD
+ VSS VSS gf180mcu_fd_sc_mcu7t5v0__oai22_1
X_10390_ _10390_/D _11018_/CLK _10390_/Q VDD VDD VSS VSS gf180mcu_fd_sc_mcu7t5v0__dffq_1
X_09049_ _09944_/A1 _09051_/A2 _09051_/B1 _09049_/B2 _10584_/D VDD VDD
+ VSS VSS gf180mcu_fd_sc_mcu7t5v0__oai22_1
X_11011_ _11011_/D _11017_/CLK _11011_/Q VDD VDD VSS VSS gf180mcu_fd_sc_mcu7t5v0__dffq_1
X_10726_ _10726_/D _11147_/CLK _10726_/Q VDD VDD VSS VSS gf180mcu_fd_sc_mcu7t5v0__dffq_1
X_10657_ _10657_/D _10978_/CLK _10657_/Q VDD VDD VSS VSS gf180mcu_fd_sc_mcu7t5v0__dffq_1
X_10588_ _10588_/D _11138_/CLK _10588_/Q VDD VDD VSS VSS gf180mcu_fd_sc_mcu7t5v0__dffq_1
X_06750_ _06745_/I _06749_/Z _06750_/Z VDD VDD VSS VSS gf180mcu_fd_sc_mcu7t5v0__xor2_1
X_05701_ _10952_/Q _09509_/B2 VDD VDD VSS VSS gf180mcu_fd_sc_mcu7t5v0__clkinv_1
X_06681_ _06872_/I1 _06799_/A1 _06873_/B _06683_/B1 VDD VDD VSS VSS
+ gf180mcu_fd_sc_mcu7t5v0__aoi21_1
X_08420_ _10309_/Q _08590_/A2 _08590_/B1 _10944_/Q _08591_/C1 _10392_/Q _08422_/A2
+ VDD VDD VSS VSS gf180mcu_fd_sc_mcu7t5v0__aoi222_4
X_05632_ _10928_/Q _09479_/B2 VDD VDD VSS VSS gf180mcu_fd_sc_mcu7t5v0__clkinv_1
X_05563_ _10423_/Q _08806_/B2 VDD VDD VSS VSS gf180mcu_fd_sc_mcu7t5v0__clkinv_1
X_08351_ _11032_/Q _08589_/A2 _08877_/A2 _11024_/Q _08354_/A1 VDD VDD
+ VSS VSS gf180mcu_fd_sc_mcu7t5v0__aoi22_1
X_05494_ _10750_/Q _09257_/B2 VDD VDD VSS VSS gf180mcu_fd_sc_mcu7t5v0__clkinv_1
X_07302_ _10109_/Q _07310_/A2 _07303_/B VDD VDD VSS VSS gf180mcu_fd_sc_mcu7t5v0__nand2_1
X_08282_ _10479_/Q _08591_/A2 _08877_/A2 _10463_/Q _09872_/A1 _11138_/Q _08283_/A3
+ VDD VDD VSS VSS gf180mcu_fd_sc_mcu7t5v0__aoi222_1
X_07233_ _07233_/A1 _07233_/A2 _07233_/Z VDD VDD VSS VSS gf180mcu_fd_sc_mcu7t5v0__xor2_1
X_07164_ _10014_/Q _07216_/A2 _07204_/A2 VDD VDD VSS VSS gf180mcu_fd_sc_mcu7t5v0__nand2_1
X_06115_ _09754_/B _06123_/A2 _06123_/B1 VDD VDD VSS VSS gf180mcu_fd_sc_mcu7t5v0__nand2_2
X_07095_ _07095_/A1 _07091_/I _07095_/Z VDD VDD VSS VSS gf180mcu_fd_sc_mcu7t5v0__xor2_1
X_06046_ _09947_/Q _06071_/A2 _06048_/B VDD VDD VSS VSS gf180mcu_fd_sc_mcu7t5v0__nand2_1
X_07997_ _07997_/A1 _07997_/A2 _07997_/A3 _08010_/A2 VDD VDD VSS VSS
+ gf180mcu_fd_sc_mcu7t5v0__nand3_2
X_09805_ _11096_/Q _09817_/A2 _09811_/B _09806_/B VDD VDD VSS VSS
+ gf180mcu_fd_sc_mcu7t5v0__oai21_1
X_09736_ _05977_/Z _09751_/A1 _09736_/A3 _11068_/D VDD VDD VSS VSS
+ gf180mcu_fd_sc_mcu7t5v0__nor3_1
X_06948_ _06933_/Z _07247_/I1 _07246_/A1 _06948_/B _06955_/A1 VDD VDD
+ VSS VSS gf180mcu_fd_sc_mcu7t5v0__oai31_1
X_09667_ _06058_/Z _09671_/A2 _09671_/B1 _09667_/B2 _11046_/D VDD VDD
+ VSS VSS gf180mcu_fd_sc_mcu7t5v0__oai22_1
X_08618_ _09832_/A1 _08618_/A2 _08618_/B1 _08618_/B2 _10311_/D VDD VDD
+ VSS VSS gf180mcu_fd_sc_mcu7t5v0__oai22_1
X_06879_ _07682_/A1 _08581_/A2 _09851_/A1 VDD VDD VSS VSS gf180mcu_fd_sc_mcu7t5v0__nor2_4
X_09598_ _09900_/A1 _09662_/A2 _09607_/A2 VDD VDD VSS VSS gf180mcu_fd_sc_mcu7t5v0__nand2_4
X_08549_ _09994_/Q _08560_/A2 _08589_/A2 _10113_/Q _08550_/I VDD VDD VSS
+ VSS gf180mcu_fd_sc_mcu7t5v0__aoi22_1
X_10511_ _10511_/D _11109_/CLK _10511_/Q VDD VDD VSS VSS gf180mcu_fd_sc_mcu7t5v0__dffq_1
X_10442_ _10442_/D _11164_/CLK _10442_/Q VDD VDD VSS VSS gf180mcu_fd_sc_mcu7t5v0__dffq_1
X_10373_ _10373_/D _11142_/CLK _10373_/Q VDD VDD VSS VSS gf180mcu_fd_sc_mcu7t5v0__dffq_1
X_10709_ _10709_/D _10905_/CLK _10709_/Q VDD VDD VSS VSS gf180mcu_fd_sc_mcu7t5v0__dffq_1
X_07920_ _08656_/A1 _07920_/A2 _07920_/B _10279_/D VDD VDD VSS VSS
+ gf180mcu_fd_sc_mcu7t5v0__aoi21_1
X_07851_ _07862_/A1 _07853_/A2 _07851_/B _09900_/B _10247_/D VDD VDD VSS
+ VSS gf180mcu_fd_sc_mcu7t5v0__aoi211_1
X_07782_ _10212_/Q _07786_/A2 _07783_/B VDD VDD VSS VSS gf180mcu_fd_sc_mcu7t5v0__nand2_1
X_06802_ _10004_/Q _06850_/A2 _06806_/B VDD VDD VSS VSS gf180mcu_fd_sc_mcu7t5v0__nand2_1
X_09521_ _09946_/A1 _09521_/A2 _09521_/B1 _09521_/B2 _10962_/D VDD VDD
+ VSS VSS gf180mcu_fd_sc_mcu7t5v0__oai22_1
X_04994_ _10326_/Q _08667_/A1 VDD VDD VSS VSS gf180mcu_fd_sc_mcu7t5v0__inv_1
X_06733_ _10004_/Q _06823_/A1 _06734_/B1 VDD VDD VSS VSS gf180mcu_fd_sc_mcu7t5v0__nand2_1
X_09452_ _09937_/A2 _09861_/A2 _09461_/A2 VDD VDD VSS VSS gf180mcu_fd_sc_mcu7t5v0__nand2_4
X_06664_ _06664_/A1 _06659_/Z _06664_/A3 _06667_/A3 VDD VDD VSS VSS
+ gf180mcu_fd_sc_mcu7t5v0__xnor3_1
X_08403_ _10888_/Q _08547_/A2 _06125_/I _10352_/Q _08407_/A1 VDD VDD VSS
+ VSS gf180mcu_fd_sc_mcu7t5v0__aoi22_1
X_05615_ _10871_/Q _09408_/B2 VDD VDD VSS VSS gf180mcu_fd_sc_mcu7t5v0__clkinv_1
X_09383_ _08514_/B _09391_/A2 _09391_/B1 VDD VDD VSS VSS gf180mcu_fd_sc_mcu7t5v0__nand2_4
X_06595_ _06629_/A1 _06595_/A2 _06608_/A2 VDD VDD VSS VSS gf180mcu_fd_sc_mcu7t5v0__nand2_1
X_05546_ _10631_/Q _09108_/B2 VDD VDD VSS VSS gf180mcu_fd_sc_mcu7t5v0__clkinv_1
X_08334_ _10094_/Q _08532_/A2 _08334_/B _08344_/A2 VDD VDD VSS VSS
+ gf180mcu_fd_sc_mcu7t5v0__aoi21_1
X_05477_ _10202_/Q _07765_/B2 VDD VDD VSS VSS gf180mcu_fd_sc_mcu7t5v0__clkinv_1
X_08265_ _09900_/A2 _08265_/A2 _08265_/B1 _09568_/A2 _08266_/A2 VDD VDD
+ VSS VSS gf180mcu_fd_sc_mcu7t5v0__aoi22_1
X_07216_ _10015_/Q _07216_/A2 _07240_/A2 VDD VDD VSS VSS gf180mcu_fd_sc_mcu7t5v0__nand2_1
X_08196_ _10093_/Q _08532_/A2 _08196_/B _08197_/A2 VDD VDD VSS VSS
+ gf180mcu_fd_sc_mcu7t5v0__aoi21_1
X_07147_ _10087_/Q _07162_/A1 _07144_/Z _07147_/Z VDD VDD VSS VSS
+ gf180mcu_fd_sc_mcu7t5v0__xor3_1
X_07078_ _07078_/A1 _07078_/A2 _07078_/B _07090_/A2 VDD VDD VSS VSS
+ gf180mcu_fd_sc_mcu7t5v0__oai21_1
X_06029_ _08674_/B _06029_/A2 _07682_/A1 VDD VDD VSS VSS gf180mcu_fd_sc_mcu7t5v0__nand2_4
X_10991_ _10991_/D _11018_/CLK _10991_/Q VDD VDD VSS VSS gf180mcu_fd_sc_mcu7t5v0__dffq_1
X_09719_ _11061_/Q _09718_/B _09722_/B1 VDD VDD VSS VSS gf180mcu_fd_sc_mcu7t5v0__nand2_1
X_10425_ _10425_/D _11142_/CLK _10425_/Q VDD VDD VSS VSS gf180mcu_fd_sc_mcu7t5v0__dffq_1
X_10356_ _10356_/D _11109_/CLK _10356_/Q VDD VDD VSS VSS gf180mcu_fd_sc_mcu7t5v0__dffq_1
X_10287_ _10287_/D _11139_/CLK _10287_/Q VDD VDD VSS VSS gf180mcu_fd_sc_mcu7t5v0__dffq_1
X_05400_ _10845_/Q _09376_/B2 VDD VDD VSS VSS gf180mcu_fd_sc_mcu7t5v0__clkinv_1
X_06380_ _06429_/A1 _06380_/A2 _06380_/A3 _06380_/B _06402_/A1 VDD VDD
+ VSS VSS gf180mcu_fd_sc_mcu7t5v0__oai31_1
X_05331_ _10605_/Q _09076_/B2 VDD VDD VSS VSS gf180mcu_fd_sc_mcu7t5v0__clkinv_1
X_05262_ _10340_/Q _08703_/B2 VDD VDD VSS VSS gf180mcu_fd_sc_mcu7t5v0__clkinv_1
X_08050_ _09285_/B2 _08585_/A2 _08050_/B _08098_/A2 VDD VDD VSS VSS
+ gf180mcu_fd_sc_mcu7t5v0__oai21_2
X_07001_ _07000_/B _06997_/Z _07001_/A3 _07001_/Z VDD VDD VSS VSS
+ gf180mcu_fd_sc_mcu7t5v0__or3_1
X_05193_ _10412_/Q _08793_/B2 VDD VDD VSS VSS gf180mcu_fd_sc_mcu7t5v0__clkinv_1
X_08952_ _09645_/A2 _09823_/A2 _08961_/A2 VDD VDD VSS VSS gf180mcu_fd_sc_mcu7t5v0__nand2_4
X_08883_ _09941_/A1 _08893_/A2 _08883_/B _10461_/D VDD VDD VSS VSS
+ gf180mcu_fd_sc_mcu7t5v0__oai21_1
X_07903_ _07903_/A1 _07905_/A2 _07903_/B _10271_/D VDD VDD VSS VSS
+ gf180mcu_fd_sc_mcu7t5v0__aoi21_1
X_07834_ _09679_/A1 _07842_/A2 _07834_/B _09900_/B _10239_/D VDD VDD VSS
+ VSS gf180mcu_fd_sc_mcu7t5v0__aoi211_1
X_07765_ _06058_/Z _07769_/A2 _07769_/B1 _07765_/B2 _10202_/D VDD VDD
+ VSS VSS gf180mcu_fd_sc_mcu7t5v0__oai22_1
X_04977_ _11092_/Q _09800_/A1 VDD VDD VSS VSS gf180mcu_fd_sc_mcu7t5v0__clkinv_1
X_09504_ _06047_/Z _09511_/A2 _09511_/B1 _09504_/B2 _10947_/D VDD VDD
+ VSS VSS gf180mcu_fd_sc_mcu7t5v0__oai22_1
X_06716_ _06716_/A1 _06714_/Z _06716_/Z VDD VDD VSS VSS gf180mcu_fd_sc_mcu7t5v0__xor2_1
X_07696_ _10157_/Q _07698_/A2 _07697_/B VDD VDD VSS VSS gf180mcu_fd_sc_mcu7t5v0__nand2_1
X_09435_ _09904_/A1 _09441_/A2 _09441_/B1 _09435_/B2 _10892_/D VDD VDD
+ VSS VSS gf180mcu_fd_sc_mcu7t5v0__oai22_1
X_06647_ _06834_/C _06647_/A2 _06647_/B _07636_/B _06648_/A2 VDD VDD VSS
+ VSS gf180mcu_fd_sc_mcu7t5v0__oai211_1
X_09366_ _09893_/A1 _09371_/A2 _09371_/B1 _09366_/B2 _10837_/D VDD VDD
+ VSS VSS gf180mcu_fd_sc_mcu7t5v0__oai22_1
X_06578_ _06578_/A1 _06578_/A2 _06682_/B VDD VDD VSS VSS gf180mcu_fd_sc_mcu7t5v0__nor2_2
X_05529_ _10359_/Q _08726_/B2 VDD VDD VSS VSS gf180mcu_fd_sc_mcu7t5v0__clkinv_1
X_08317_ _08317_/A1 _08317_/A2 _08317_/A3 _08327_/A2 VDD VDD VSS VSS
+ gf180mcu_fd_sc_mcu7t5v0__nand3_2
X_09297_ _06058_/Z _09301_/A2 _09301_/B1 _09297_/B2 _10782_/D VDD VDD
+ VSS VSS gf180mcu_fd_sc_mcu7t5v0__oai22_1
X_08248_ _10726_/Q _08580_/A2 _08576_/B1 _10998_/Q _08249_/A3 VDD VDD
+ VSS VSS gf180mcu_fd_sc_mcu7t5v0__aoi22_1
X_08179_ _08179_/A1 _08179_/A2 _08179_/A3 _08180_/B1 VDD VDD VSS VSS
+ gf180mcu_fd_sc_mcu7t5v0__nand3_1
X_10210_ _10210_/D _11052_/CLK _10210_/Q VDD VDD VSS VSS gf180mcu_fd_sc_mcu7t5v0__dffq_1
X_10141_ _10141_/D _11176_/CLK _10141_/Q VDD VDD VSS VSS gf180mcu_fd_sc_mcu7t5v0__dffq_1
X_10072_ _10072_/D _11163_/CLK _10072_/Q VDD VDD VSS VSS gf180mcu_fd_sc_mcu7t5v0__dffq_1
X_10974_ _10974_/D _10978_/CLK _10974_/Q VDD VDD VSS VSS gf180mcu_fd_sc_mcu7t5v0__dffq_1
X_10408_ _10408_/D _11138_/CLK _10408_/Q VDD VDD VSS VSS gf180mcu_fd_sc_mcu7t5v0__dffq_1
X_10339_ _10339_/D _11147_/CLK _10339_/Q VDD VDD VSS VSS gf180mcu_fd_sc_mcu7t5v0__dffq_1
X_05880_ _11050_/Q _09671_/B2 VDD VDD VSS VSS gf180mcu_fd_sc_mcu7t5v0__clkinv_1
X_07550_ _07602_/A1 _07536_/Z _07550_/B _07551_/A2 VDD VDD VSS VSS
+ gf180mcu_fd_sc_mcu7t5v0__oai21_1
X_06501_ _10006_/Q _06501_/A2 _06501_/B _06504_/A1 VDD VDD VSS VSS
+ gf180mcu_fd_sc_mcu7t5v0__aoi21_1
X_07481_ _10123_/Q _07480_/Z _07505_/A2 VDD VDD VSS VSS gf180mcu_fd_sc_mcu7t5v0__nor2_1
X_09220_ _09945_/A1 _09221_/A2 _09221_/B1 _09220_/B2 _10721_/D VDD VDD
+ VSS VSS gf180mcu_fd_sc_mcu7t5v0__oai22_1
X_06432_ _06432_/A1 _06432_/A2 _06502_/A1 VDD VDD VSS VSS gf180mcu_fd_sc_mcu7t5v0__nand2_4
X_09151_ _09946_/A1 _09151_/A2 _09151_/B1 _09151_/B2 _10666_/D VDD VDD
+ VSS VSS gf180mcu_fd_sc_mcu7t5v0__oai22_1
X_06363_ _06338_/Z _06412_/B _06363_/Z VDD VDD VSS VSS gf180mcu_fd_sc_mcu7t5v0__xor2_1
X_05314_ _10925_/Q _09476_/B2 VDD VDD VSS VSS gf180mcu_fd_sc_mcu7t5v0__clkinv_1
X_08102_ _08102_/A1 _08102_/A2 _08102_/B _08103_/A2 VDD VDD VSS VSS
+ gf180mcu_fd_sc_mcu7t5v0__oai21_1
X_09082_ _09851_/A1 _09142_/A2 _09091_/A2 VDD VDD VSS VSS gf180mcu_fd_sc_mcu7t5v0__nand2_4
X_08033_ _10740_/Q _08590_/A2 _08573_/B1 _11012_/Q _08576_/B1 _10996_/Q _08035_/A2
+ VDD VDD VSS VSS gf180mcu_fd_sc_mcu7t5v0__aoi222_4
X_06294_ _06294_/A1 _06294_/A2 _06294_/Z VDD VDD VSS VSS gf180mcu_fd_sc_mcu7t5v0__or2_1
X_05245_ _10420_/Q _08803_/B2 VDD VDD VSS VSS gf180mcu_fd_sc_mcu7t5v0__clkinv_1
X_05176_ _10747_/Q _09254_/B2 VDD VDD VSS VSS gf180mcu_fd_sc_mcu7t5v0__clkinv_1
X_09984_ _09984_/D _11163_/CLK _09984_/Q VDD VDD VSS VSS gf180mcu_fd_sc_mcu7t5v0__dffq_1
X_08935_ _09920_/A1 _08941_/A2 _08941_/B1 _08935_/B2 _10492_/D VDD VDD
+ VSS VSS gf180mcu_fd_sc_mcu7t5v0__oai22_1
X_08866_ _10455_/Q _08862_/Z _08872_/B _08867_/A2 VDD VDD VSS VSS
+ gf180mcu_fd_sc_mcu7t5v0__oai21_1
X_08797_ _09924_/A1 _08799_/A2 _08799_/B1 _08797_/B2 _10416_/D VDD VDD
+ VSS VSS gf180mcu_fd_sc_mcu7t5v0__oai22_1
X_07817_ _06058_/Z _07825_/A2 _07817_/B _10234_/D VDD VDD VSS VSS
+ gf180mcu_fd_sc_mcu7t5v0__oai21_1
X_07748_ _09946_/A1 _07748_/A2 _07748_/B1 _07748_/B2 _10190_/D VDD VDD
+ VSS VSS gf180mcu_fd_sc_mcu7t5v0__oai22_1
X_07679_ _07679_/A1 _06110_/Z _08476_/C1 VDD VDD VSS VSS gf180mcu_fd_sc_mcu7t5v0__nor2_4
Xrepeater19 _08590_/A2 _08547_/A2 VDD VDD VSS VSS gf180mcu_fd_sc_mcu7t5v0__buf_12
X_09418_ _06061_/Z _09421_/A2 _09421_/B1 _09418_/B2 _10879_/D VDD VDD
+ VSS VSS gf180mcu_fd_sc_mcu7t5v0__oai22_1
X_10690_ _10690_/D _11138_/CLK _10690_/Q VDD VDD VSS VSS gf180mcu_fd_sc_mcu7t5v0__dffq_1
X_09349_ _09896_/A1 _09351_/A2 _09351_/B1 _09349_/B2 _10824_/D VDD VDD
+ VSS VSS gf180mcu_fd_sc_mcu7t5v0__oai22_1
X_11173_ _11173_/D _11176_/CLK _11173_/Q VDD VDD VSS VSS gf180mcu_fd_sc_mcu7t5v0__dffq_1
X_10124_ _10124_/D _10327_/CLK _10124_/Q VDD VDD VSS VSS gf180mcu_fd_sc_mcu7t5v0__dffq_2
X_10055_ _10055_/D _11176_/CLK _10055_/Q VDD VDD VSS VSS gf180mcu_fd_sc_mcu7t5v0__dffq_1
X_10957_ _10957_/D _10978_/CLK _10957_/Q VDD VDD VSS VSS gf180mcu_fd_sc_mcu7t5v0__dffq_1
X_10888_ _10888_/D _11147_/CLK _10888_/Q VDD VDD VSS VSS gf180mcu_fd_sc_mcu7t5v0__dffq_1
X_05030_ _10116_/Q _07352_/A1 VDD VDD VSS VSS gf180mcu_fd_sc_mcu7t5v0__inv_2
X_06981_ _06981_/A1 _06981_/A2 _06979_/Z _07250_/A1 _06982_/B VDD VDD
+ VSS VSS gf180mcu_fd_sc_mcu7t5v0__oai22_1
X_08720_ _09502_/A1 _09823_/A2 _08729_/A2 VDD VDD VSS VSS gf180mcu_fd_sc_mcu7t5v0__nand2_4
X_05932_ _10866_/Q _09401_/B2 VDD VDD VSS VSS gf180mcu_fd_sc_mcu7t5v0__clkinv_1
X_05863_ _10626_/Q _09101_/B2 VDD VDD VSS VSS gf180mcu_fd_sc_mcu7t5v0__clkinv_1
X_08651_ _08659_/A1 _08651_/A2 _08651_/B _10320_/D VDD VDD VSS VSS
+ gf180mcu_fd_sc_mcu7t5v0__aoi21_1
X_07602_ _07602_/A1 _07588_/Z _07602_/B _07603_/A2 VDD VDD VSS VSS
+ gf180mcu_fd_sc_mcu7t5v0__oai21_1
X_05794_ _10221_/Q _07796_/B2 VDD VDD VSS VSS gf180mcu_fd_sc_mcu7t5v0__clkinv_1
X_08582_ _10874_/Q _08582_/A2 _07680_/I _10866_/Q _08582_/C _08583_/A3 VDD VDD
+ VSS VSS gf180mcu_fd_sc_mcu7t5v0__aoi221_1
X_07533_ _07533_/A1 _07532_/Z _07533_/Z VDD VDD VSS VSS gf180mcu_fd_sc_mcu7t5v0__xor2_1
X_07464_ _10001_/Q _07463_/Z _07513_/A1 VDD VDD VSS VSS gf180mcu_fd_sc_mcu7t5v0__nand2_1
X_06415_ _10005_/Q _06413_/Z _06417_/B VDD VDD VSS VSS gf180mcu_fd_sc_mcu7t5v0__xor2_1
X_09203_ _08658_/B _09211_/A2 _09211_/B1 VDD VDD VSS VSS gf180mcu_fd_sc_mcu7t5v0__nand2_2
X_09134_ _06047_/Z _09141_/A2 _09141_/B1 _09134_/B2 _10651_/D VDD VDD
+ VSS VSS gf180mcu_fd_sc_mcu7t5v0__oai22_1
X_07395_ _07395_/I _07430_/A1 VDD VDD VSS VSS gf180mcu_fd_sc_mcu7t5v0__clkinv_1
X_06346_ _10004_/Q _06481_/A2 _06442_/A1 VDD VDD VSS VSS gf180mcu_fd_sc_mcu7t5v0__nand2_1
X_09065_ _09940_/A1 _09071_/A2 _09071_/B1 _09065_/B2 _10596_/D VDD VDD
+ VSS VSS gf180mcu_fd_sc_mcu7t5v0__oai22_1
X_06277_ _06481_/A2 _06446_/A2 _06502_/B _06278_/A2 VDD VDD VSS VSS
+ gf180mcu_fd_sc_mcu7t5v0__oai21_1
X_05228_ _10628_/Q _09105_/B2 VDD VDD VSS VSS gf180mcu_fd_sc_mcu7t5v0__clkinv_1
X_08016_ _07937_/Z _08016_/A2 _09900_/B _10280_/D VDD VDD VSS VSS
+ gf180mcu_fd_sc_mcu7t5v0__aoi21_1
X_05159_ _10199_/Q _07762_/B2 VDD VDD VSS VSS gf180mcu_fd_sc_mcu7t5v0__clkinv_1
X_09967_ _09967_/D _11181_/CLK _09967_/Q VDD VDD VSS VSS gf180mcu_fd_sc_mcu7t5v0__dffq_1
X_08918_ _10481_/Q _08920_/A2 _08919_/B VDD VDD VSS VSS gf180mcu_fd_sc_mcu7t5v0__nand2_1
X_09898_ _09926_/A1 _09898_/A2 _09898_/B1 _09898_/B2 _11149_/D VDD VDD
+ VSS VSS gf180mcu_fd_sc_mcu7t5v0__oai22_1
X_08849_ _08831_/I _08847_/Z _08849_/A3 _10449_/D VDD VDD VSS VSS
+ gf180mcu_fd_sc_mcu7t5v0__nor3_1
X_10811_ _10811_/D _11164_/CLK _10811_/Q VDD VDD VSS VSS gf180mcu_fd_sc_mcu7t5v0__dffq_1
X_10742_ _10742_/D _11017_/CLK _10742_/Q VDD VDD VSS VSS gf180mcu_fd_sc_mcu7t5v0__dffq_1
X_10673_ _10673_/D _11139_/CLK _10673_/Q VDD VDD VSS VSS gf180mcu_fd_sc_mcu7t5v0__dffq_1
X_11156_ _11156_/D _11163_/CLK _11156_/Q VDD VDD VSS VSS gf180mcu_fd_sc_mcu7t5v0__dffq_1
X_10107_ _10107_/D _11163_/CLK _10107_/Q VDD VDD VSS VSS gf180mcu_fd_sc_mcu7t5v0__dffq_1
X_11087_ _11087_/D _11097_/CLK _11087_/Q VDD VDD VSS VSS gf180mcu_fd_sc_mcu7t5v0__dffq_1
X_10038_ _10038_/D _11181_/CLK _10038_/Q VDD VDD VSS VSS gf180mcu_fd_sc_mcu7t5v0__dffq_1
X_06200_ _07333_/A2 _06198_/Z _06200_/B _06481_/A2 VDD VDD VSS VSS
+ gf180mcu_fd_sc_mcu7t5v0__oai21_4
X_07180_ _10006_/Q _07222_/A2 _07183_/A3 VDD VDD VSS VSS gf180mcu_fd_sc_mcu7t5v0__nand2_1
X_06131_ _09980_/Q _06143_/A2 _06132_/B VDD VDD VSS VSS gf180mcu_fd_sc_mcu7t5v0__nand2_1
X_06062_ _06074_/A1 _06061_/Z _06062_/B _09951_/D VDD VDD VSS VSS
+ gf180mcu_fd_sc_mcu7t5v0__oai21_1
X_05013_ _10271_/Q _07903_/A1 VDD VDD VSS VSS gf180mcu_fd_sc_mcu7t5v0__clkinv_1
X_09821_ _11100_/Q _09817_/B _11101_/Q _09822_/A2 VDD VDD VSS VSS
+ gf180mcu_fd_sc_mcu7t5v0__aoi21_1
X_09752_ _11074_/Q _09749_/Z _09756_/A1 VDD VDD VSS VSS gf180mcu_fd_sc_mcu7t5v0__nor2_1
X_08703_ _09920_/A1 _08709_/A2 _08709_/B1 _08703_/B2 _10340_/D VDD VDD
+ VSS VSS gf180mcu_fd_sc_mcu7t5v0__oai22_1
X_06964_ _06964_/A1 _07216_/A2 _06964_/B1 _06964_/B2 _07181_/A2 VDD VDD
+ VSS VSS gf180mcu_fd_sc_mcu7t5v0__aoi22_4
X_05915_ _10922_/Q _09471_/B2 VDD VDD VSS VSS gf180mcu_fd_sc_mcu7t5v0__clkinv_1
X_09683_ _11054_/Q _10289_/Q _09685_/A2 VDD VDD VSS VSS gf180mcu_fd_sc_mcu7t5v0__nand2_1
X_06895_ _06058_/Z _06899_/A2 _06899_/B1 _06895_/B2 _10064_/D VDD VDD
+ VSS VSS gf180mcu_fd_sc_mcu7t5v0__oai22_1
X_05846_ _10898_/Q _09441_/B2 VDD VDD VSS VSS gf180mcu_fd_sc_mcu7t5v0__clkinv_1
X_08634_ _10316_/Q _08659_/A1 _08654_/B _08635_/B VDD VDD VSS VSS
+ gf180mcu_fd_sc_mcu7t5v0__oai21_1
X_05777_ _11017_/Q _09606_/B2 VDD VDD VSS VSS gf180mcu_fd_sc_mcu7t5v0__clkinv_1
X_08565_ _10642_/Q _08584_/A2 _08584_/B1 _10666_/Q _08566_/A3 VDD VDD
+ VSS VSS gf180mcu_fd_sc_mcu7t5v0__aoi22_1
X_07516_ _07516_/A1 _07516_/A2 _07516_/B _07564_/A1 VDD VDD VSS VSS
+ gf180mcu_fd_sc_mcu7t5v0__aoi21_2
X_08496_ _10104_/Q _08586_/A2 _08528_/B1 _10173_/Q _08498_/A2 VDD VDD
+ VSS VSS gf180mcu_fd_sc_mcu7t5v0__aoi22_1
X_07447_ _07485_/A4 _07449_/A3 _07447_/Z VDD VDD VSS VSS gf180mcu_fd_sc_mcu7t5v0__xor2_1
X_07378_ _10001_/Q _07572_/A2 _07378_/B _07384_/A1 VDD VDD VSS VSS
+ gf180mcu_fd_sc_mcu7t5v0__oai21_1
X_09117_ _06058_/Z _09121_/A2 _09121_/B1 _09117_/B2 _10638_/D VDD VDD
+ VSS VSS gf180mcu_fd_sc_mcu7t5v0__oai22_1
X_06329_ _06460_/A1 _06312_/Z _06329_/B _06330_/B VDD VDD VSS VSS
+ gf180mcu_fd_sc_mcu7t5v0__aoi21_1
X_09048_ _06061_/Z _09051_/A2 _09051_/B1 _09048_/B2 _10583_/D VDD VDD
+ VSS VSS gf180mcu_fd_sc_mcu7t5v0__oai22_1
X_11010_ _11010_/D _11010_/CLK _11010_/Q VDD VDD VSS VSS gf180mcu_fd_sc_mcu7t5v0__dffq_1
X_10725_ _10725_/D _11147_/CLK _10725_/Q VDD VDD VSS VSS gf180mcu_fd_sc_mcu7t5v0__dffq_1
X_10656_ _10656_/D _10666_/CLK _10656_/Q VDD VDD VSS VSS gf180mcu_fd_sc_mcu7t5v0__dffq_1
X_10587_ _10587_/D _11138_/CLK _10587_/Q VDD VDD VSS VSS gf180mcu_fd_sc_mcu7t5v0__dffq_1
X_11139_ _11139_/D _11139_/CLK _11139_/Q VDD VDD VSS VSS gf180mcu_fd_sc_mcu7t5v0__dffq_1
X_05700_ _10960_/Q _09519_/B2 VDD VDD VSS VSS gf180mcu_fd_sc_mcu7t5v0__clkinv_1
X_06680_ _10003_/Q _06854_/A2 _06799_/A1 VDD VDD VSS VSS gf180mcu_fd_sc_mcu7t5v0__nand2_1
X_05631_ _10944_/Q _09499_/B2 VDD VDD VSS VSS gf180mcu_fd_sc_mcu7t5v0__clkinv_1
X_08350_ _08350_/A1 _08350_/A2 _09900_/B _10284_/D VDD VDD VSS VSS
+ gf180mcu_fd_sc_mcu7t5v0__aoi21_1
X_05562_ _11047_/Q _09668_/B2 VDD VDD VSS VSS gf180mcu_fd_sc_mcu7t5v0__clkinv_1
X_07301_ _09941_/A1 _07311_/A2 _07301_/B _10108_/D VDD VDD VSS VSS
+ gf180mcu_fd_sc_mcu7t5v0__oai21_1
X_05493_ _11129_/Q _09866_/B2 VDD VDD VSS VSS gf180mcu_fd_sc_mcu7t5v0__clkinv_1
X_08281_ _09991_/Q _08560_/A2 _08444_/B1 _11154_/Q _07255_/I _11114_/Q _08283_/A2
+ VDD VDD VSS VSS gf180mcu_fd_sc_mcu7t5v0__aoi222_2
X_07232_ _07232_/A1 _07183_/Z _07232_/B _07233_/A2 VDD VDD VSS VSS
+ gf180mcu_fd_sc_mcu7t5v0__oai21_1
X_07163_ _07163_/A1 _07140_/Z _07163_/B _07191_/A1 VDD VDD VSS VSS
+ gf180mcu_fd_sc_mcu7t5v0__oai21_1
X_06114_ _09937_/A1 _09645_/A2 _06123_/A2 VDD VDD VSS VSS gf180mcu_fd_sc_mcu7t5v0__nand2_4
X_07094_ _07095_/A1 _07094_/A2 _07143_/A3 VDD VDD VSS VSS gf180mcu_fd_sc_mcu7t5v0__nand2_1
X_06045_ _09502_/A1 _09645_/A1 _09900_/B _06071_/A2 VDD VDD VSS VSS
+ gf180mcu_fd_sc_mcu7t5v0__aoi21_4
X_09804_ _09804_/A1 _09817_/A2 _09804_/B _11094_/D VDD VDD VSS VSS
+ gf180mcu_fd_sc_mcu7t5v0__aoi21_1
X_07996_ _10304_/Q _08590_/A2 _08590_/B1 _10939_/Q _08591_/C1 _10387_/Q _07997_/A3
+ VDD VDD VSS VSS gf180mcu_fd_sc_mcu7t5v0__aoi222_2
X_09735_ _11068_/Q _11067_/Q _09736_/A3 VDD VDD VSS VSS gf180mcu_fd_sc_mcu7t5v0__nor2_1
X_06947_ _06933_/Z _07207_/A1 _07250_/A1 _06948_/B VDD VDD VSS VSS
+ gf180mcu_fd_sc_mcu7t5v0__nand3_1
X_09666_ _09893_/A1 _09671_/A2 _09671_/B1 _09666_/B2 _11045_/D VDD VDD
+ VSS VSS gf180mcu_fd_sc_mcu7t5v0__oai22_1
X_08617_ _09897_/A1 _08618_/A2 _08618_/B1 _08617_/B2 _10310_/D VDD VDD
+ VSS VSS gf180mcu_fd_sc_mcu7t5v0__oai22_1
X_06878_ _06021_/Z _06878_/A2 _08581_/A2 VDD VDD VSS VSS gf180mcu_fd_sc_mcu7t5v0__nand2_4
X_05829_ _10418_/Q _08799_/B2 VDD VDD VSS VSS gf180mcu_fd_sc_mcu7t5v0__clkinv_1
X_09597_ _09916_/A1 _09597_/A2 _09597_/B1 _09597_/B2 _11010_/D VDD VDD
+ VSS VSS gf180mcu_fd_sc_mcu7t5v0__oai22_1
X_08548_ _08548_/A1 _08548_/A2 _08548_/A3 _08596_/A2 VDD VDD VSS VSS
+ gf180mcu_fd_sc_mcu7t5v0__nand3_2
X_08479_ _10141_/Q _08564_/C1 _08584_/B1 _10369_/Q _08479_/C _08482_/A1 VDD
+ VDD VSS VSS gf180mcu_fd_sc_mcu7t5v0__aoi221_1
X_10510_ _10510_/D _11109_/CLK _10510_/Q VDD VDD VSS VSS gf180mcu_fd_sc_mcu7t5v0__dffq_1
X_10441_ _10441_/D _11164_/CLK _10441_/Q VDD VDD VSS VSS gf180mcu_fd_sc_mcu7t5v0__dffq_1
X_10372_ _10372_/D _11147_/CLK _10372_/Q VDD VDD VSS VSS gf180mcu_fd_sc_mcu7t5v0__dffq_1
X_10708_ _10708_/D _11139_/CLK _10708_/Q VDD VDD VSS VSS gf180mcu_fd_sc_mcu7t5v0__dffq_1
X_10639_ _10639_/D _10666_/CLK _10639_/Q VDD VDD VSS VSS gf180mcu_fd_sc_mcu7t5v0__dffq_1
X_07850_ _10247_/Q _07853_/A2 _07851_/B VDD VDD VSS VSS gf180mcu_fd_sc_mcu7t5v0__nor2_1
X_04993_ _10327_/Q _08669_/A1 VDD VDD VSS VSS gf180mcu_fd_sc_mcu7t5v0__inv_1
X_07781_ _06061_/Z _07787_/A2 _07781_/B _10211_/D VDD VDD VSS VSS
+ gf180mcu_fd_sc_mcu7t5v0__oai21_1
X_06801_ _06752_/Z _06801_/A2 _06801_/B _06811_/A2 VDD VDD VSS VSS
+ gf180mcu_fd_sc_mcu7t5v0__aoi21_2
X_09520_ _09945_/A1 _09521_/A2 _09521_/B1 _09520_/B2 _10961_/D VDD VDD
+ VSS VSS gf180mcu_fd_sc_mcu7t5v0__oai22_1
X_06732_ _06732_/A1 _06732_/A2 _06734_/A2 VDD VDD VSS VSS gf180mcu_fd_sc_mcu7t5v0__nand2_1
X_09451_ _09946_/A1 _09451_/A2 _09451_/B1 _09451_/B2 _10906_/D VDD VDD
+ VSS VSS gf180mcu_fd_sc_mcu7t5v0__oai22_1
X_06663_ _06664_/A1 _06664_/A3 _06699_/A2 VDD VDD VSS VSS gf180mcu_fd_sc_mcu7t5v0__nand2_1
X_08402_ _08402_/A1 _08402_/A2 _08402_/A3 _08408_/A2 VDD VDD VSS VSS
+ gf180mcu_fd_sc_mcu7t5v0__nand3_2
X_05614_ _10863_/Q _09398_/B2 VDD VDD VSS VSS gf180mcu_fd_sc_mcu7t5v0__clkinv_1
X_09382_ _09645_/A2 _09412_/A2 _09391_/A2 VDD VDD VSS VSS gf180mcu_fd_sc_mcu7t5v0__nand2_4
X_06594_ _07431_/A1 _06804_/A3 _06804_/A4 _07379_/A1 _06595_/A2 VDD VDD
+ VSS VSS gf180mcu_fd_sc_mcu7t5v0__oai22_1
X_05545_ _10623_/Q _09098_/B2 VDD VDD VSS VSS gf180mcu_fd_sc_mcu7t5v0__clkinv_1
X_08333_ _08333_/A1 _08333_/A2 _08333_/A3 _08334_/B VDD VDD VSS VSS
+ gf180mcu_fd_sc_mcu7t5v0__nand3_1
X_08264_ _08264_/A1 _08264_/A2 _08264_/A3 _08267_/B1 VDD VDD VSS VSS
+ gf180mcu_fd_sc_mcu7t5v0__nand3_1
X_05476_ _10218_/Q _07793_/B2 VDD VDD VSS VSS gf180mcu_fd_sc_mcu7t5v0__clkinv_1
X_08195_ _08195_/A1 _08195_/A2 _08195_/A3 _08196_/B VDD VDD VSS VSS
+ gf180mcu_fd_sc_mcu7t5v0__nand3_1
X_07215_ _07215_/A1 _07215_/A2 _07215_/B _07234_/A1 VDD VDD VSS VSS
+ gf180mcu_fd_sc_mcu7t5v0__oai21_1
X_07146_ _10087_/Q _07144_/Z _07162_/B VDD VDD VSS VSS gf180mcu_fd_sc_mcu7t5v0__and2_1
X_07077_ _07077_/I _07121_/A1 VDD VDD VSS VSS gf180mcu_fd_sc_mcu7t5v0__clkinv_1
X_06028_ _08628_/A1 _06028_/A2 _06029_/A2 VDD VDD VSS VSS gf180mcu_fd_sc_mcu7t5v0__nand2_2
X_07979_ _10779_/Q _09872_/A1 _07255_/I _10811_/Q _07982_/A1 VDD VDD VSS
+ VSS gf180mcu_fd_sc_mcu7t5v0__aoi22_1
X_09718_ _09718_/A1 _09718_/A2 _09718_/B _09900_/B _11060_/D VDD VDD VSS
+ VSS gf180mcu_fd_sc_mcu7t5v0__aoi211_1
X_10990_ _10990_/D _11017_/CLK _10990_/Q VDD VDD VSS VSS gf180mcu_fd_sc_mcu7t5v0__dffq_1
X_09649_ _09904_/A1 _09661_/A2 _09649_/B _11036_/D VDD VDD VSS VSS
+ gf180mcu_fd_sc_mcu7t5v0__oai21_1
X_10424_ _10424_/D _11142_/CLK _10424_/Q VDD VDD VSS VSS gf180mcu_fd_sc_mcu7t5v0__dffq_1
X_10355_ _10355_/D _11109_/CLK _10355_/Q VDD VDD VSS VSS gf180mcu_fd_sc_mcu7t5v0__dffq_1
X_10286_ _10286_/D _11052_/CLK _10286_/Q VDD VDD VSS VSS gf180mcu_fd_sc_mcu7t5v0__dffq_1
X_05330_ _10597_/Q _09066_/B2 VDD VDD VSS VSS gf180mcu_fd_sc_mcu7t5v0__clkinv_1
X_05261_ _10348_/Q _08713_/B2 VDD VDD VSS VSS gf180mcu_fd_sc_mcu7t5v0__clkinv_1
X_05192_ _10875_/Q _09414_/B2 VDD VDD VSS VSS gf180mcu_fd_sc_mcu7t5v0__clkinv_1
X_07000_ _06997_/Z _07001_/A3 _07000_/B _07002_/A1 VDD VDD VSS VSS
+ gf180mcu_fd_sc_mcu7t5v0__oai21_1
X_08951_ _09832_/A1 _08951_/A2 _08951_/B1 _08951_/B2 _10506_/D VDD VDD
+ VSS VSS gf180mcu_fd_sc_mcu7t5v0__oai22_1
X_08882_ _10461_/Q _08892_/A2 _08883_/B VDD VDD VSS VSS gf180mcu_fd_sc_mcu7t5v0__nand2_1
X_07902_ bus_wdata[5] _07905_/A2 rst_n _07903_/B VDD VDD VSS VSS gf180mcu_fd_sc_mcu7t5v0__oai21_1
X_07833_ _10239_/Q _07842_/A2 _07834_/B VDD VDD VSS VSS gf180mcu_fd_sc_mcu7t5v0__nor2_1
X_07764_ _09893_/A1 _07769_/A2 _07769_/B1 _07764_/B2 _10201_/D VDD VDD
+ VSS VSS gf180mcu_fd_sc_mcu7t5v0__oai22_1
X_04976_ _11093_/Q _09802_/A1 VDD VDD VSS VSS gf180mcu_fd_sc_mcu7t5v0__clkinv_1
X_09503_ _09852_/A1 _09511_/A2 _09511_/B1 VDD VDD VSS VSS gf180mcu_fd_sc_mcu7t5v0__nand2_2
X_06715_ _06716_/A1 _06714_/Z _06766_/A1 VDD VDD VSS VSS gf180mcu_fd_sc_mcu7t5v0__nor2_1
X_07695_ _09944_/A1 _07699_/A2 _07695_/B _10156_/D VDD VDD VSS VSS
+ gf180mcu_fd_sc_mcu7t5v0__oai21_1
X_09434_ _06047_/Z _09441_/A2 _09441_/B1 _09434_/B2 _10891_/D VDD VDD
+ VSS VSS gf180mcu_fd_sc_mcu7t5v0__oai22_1
X_06646_ _06834_/C _06646_/A2 _06646_/A3 _06647_/B VDD VDD VSS VSS
+ gf180mcu_fd_sc_mcu7t5v0__nand3_1
X_09365_ _09920_/A1 _09371_/A2 _09371_/B1 _09365_/B2 _10836_/D VDD VDD
+ VSS VSS gf180mcu_fd_sc_mcu7t5v0__oai22_1
X_06577_ _06577_/A1 _06577_/A2 _06580_/B VDD VDD VSS VSS gf180mcu_fd_sc_mcu7t5v0__nand2_1
X_08316_ _10743_/Q _08590_/A2 _08590_/B1 _11015_/Q _08589_/B1 _10735_/Q _08317_/A3
+ VDD VDD VSS VSS gf180mcu_fd_sc_mcu7t5v0__aoi222_4
X_05528_ _10895_/Q _09438_/B2 VDD VDD VSS VSS gf180mcu_fd_sc_mcu7t5v0__clkinv_1
X_09296_ _09921_/A1 _09301_/A2 _09301_/B1 _09296_/B2 _10781_/D VDD VDD
+ VSS VSS gf180mcu_fd_sc_mcu7t5v0__oai22_1
X_05459_ _11014_/Q _09603_/B2 VDD VDD VSS VSS gf180mcu_fd_sc_mcu7t5v0__clkinv_1
X_08247_ _11014_/Q _08573_/B1 _06125_/I _11046_/Q _08249_/A2 VDD VDD VSS
+ VSS gf180mcu_fd_sc_mcu7t5v0__aoi22_1
X_08178_ _10621_/Q _06023_/I _08582_/A2 _10653_/Q _08564_/C1 _10629_/Q _08179_/A3
+ VDD VDD VSS VSS gf180mcu_fd_sc_mcu7t5v0__aoi222_2
X_07129_ _07168_/B2 _07168_/B1 _07129_/Z VDD VDD VSS VSS gf180mcu_fd_sc_mcu7t5v0__xor2_1
X_10140_ _10140_/D _11176_/CLK _10140_/Q VDD VDD VSS VSS gf180mcu_fd_sc_mcu7t5v0__dffq_1
X_10071_ _10071_/D _11139_/CLK _10071_/Q VDD VDD VSS VSS gf180mcu_fd_sc_mcu7t5v0__dffq_1
X_10973_ _10973_/D _10978_/CLK _10973_/Q VDD VDD VSS VSS gf180mcu_fd_sc_mcu7t5v0__dffq_1
X_10407_ _10407_/D _11139_/CLK _10407_/Q VDD VDD VSS VSS gf180mcu_fd_sc_mcu7t5v0__dffq_1
X_10338_ _10338_/D _11150_/CLK _10338_/Q VDD VDD VSS VSS gf180mcu_fd_sc_mcu7t5v0__dffq_1
X_10269_ _10269_/D _11052_/CLK _10269_/Q VDD VDD VSS VSS gf180mcu_fd_sc_mcu7t5v0__dffq_1
X_07480_ _07439_/Z _07480_/A2 _07475_/Z _07480_/Z VDD VDD VSS VSS
+ gf180mcu_fd_sc_mcu7t5v0__xor3_1
X_06500_ _06327_/B _06499_/Z _06511_/B1 VDD VDD VSS VSS gf180mcu_fd_sc_mcu7t5v0__nand2_1
X_06431_ _10088_/Q _06431_/A2 _06432_/A2 VDD VDD VSS VSS gf180mcu_fd_sc_mcu7t5v0__nand2_1
X_09150_ _09945_/A1 _09151_/A2 _09151_/B1 _09150_/B2 _10665_/D VDD VDD
+ VSS VSS gf180mcu_fd_sc_mcu7t5v0__oai22_1
X_06362_ _06297_/Z _06362_/A2 _06362_/B _06412_/B VDD VDD VSS VSS
+ gf180mcu_fd_sc_mcu7t5v0__aoi21_1
X_05313_ _10941_/Q _09496_/B2 VDD VDD VSS VSS gf180mcu_fd_sc_mcu7t5v0__clkinv_1
X_08101_ _09823_/A2 _08101_/A2 _08101_/B _08101_/C _08102_/B VDD VDD VSS
+ VSS gf180mcu_fd_sc_mcu7t5v0__aoi211_1
X_09081_ _09946_/A1 _09081_/A2 _09081_/B1 _09081_/B2 _10610_/D VDD VDD
+ VSS VSS gf180mcu_fd_sc_mcu7t5v0__oai22_1
X_06293_ _07603_/B _06293_/A2 _10010_/D VDD VDD VSS VSS gf180mcu_fd_sc_mcu7t5v0__nor2_1
X_05244_ _11044_/Q _09665_/B2 VDD VDD VSS VSS gf180mcu_fd_sc_mcu7t5v0__clkinv_1
X_08032_ _10420_/Q _08591_/A2 _08589_/B1 _10732_/Q _08035_/A1 VDD VDD
+ VSS VSS gf180mcu_fd_sc_mcu7t5v0__aoi22_1
X_05175_ _11126_/Q _09863_/B2 VDD VDD VSS VSS gf180mcu_fd_sc_mcu7t5v0__clkinv_1
X_09983_ _09983_/D _11163_/CLK _09983_/Q VDD VDD VSS VSS gf180mcu_fd_sc_mcu7t5v0__dffq_1
X_08934_ _06047_/Z _08941_/A2 _08941_/B1 _08934_/B2 _10491_/D VDD VDD
+ VSS VSS gf180mcu_fd_sc_mcu7t5v0__oai22_1
X_08865_ _10455_/Q _08862_/Z _08865_/Z VDD VDD VSS VSS gf180mcu_fd_sc_mcu7t5v0__and2_1
X_08796_ _06061_/Z _08799_/A2 _08799_/B1 _08796_/B2 _10415_/D VDD VDD
+ VSS VSS gf180mcu_fd_sc_mcu7t5v0__oai22_1
X_07816_ _10234_/Q _07824_/A2 _07817_/B VDD VDD VSS VSS gf180mcu_fd_sc_mcu7t5v0__nand2_1
X_07747_ _09945_/A1 _07748_/A2 _07748_/B1 _08478_/A1 _10189_/D VDD VDD
+ VSS VSS gf180mcu_fd_sc_mcu7t5v0__oai22_1
X_07678_ _09832_/A1 _07678_/A2 _07678_/B1 _07678_/B2 _10150_/D VDD VDD
+ VSS VSS gf180mcu_fd_sc_mcu7t5v0__oai22_1
X_09417_ _06058_/Z _09421_/A2 _09421_/B1 _09417_/B2 _10878_/D VDD VDD
+ VSS VSS gf180mcu_fd_sc_mcu7t5v0__oai22_1
X_06629_ _06629_/A1 _06629_/A2 _06629_/Z VDD VDD VSS VSS gf180mcu_fd_sc_mcu7t5v0__xor2_1
X_09348_ _06061_/Z _09351_/A2 _09351_/B1 _09348_/B2 _10823_/D VDD VDD
+ VSS VSS gf180mcu_fd_sc_mcu7t5v0__oai22_1
X_09279_ _09924_/A1 _09281_/A2 _09281_/B1 _09279_/B2 _10768_/D VDD VDD
+ VSS VSS gf180mcu_fd_sc_mcu7t5v0__oai22_1
X_11172_ _11172_/D _11176_/CLK _11172_/Q VDD VDD VSS VSS gf180mcu_fd_sc_mcu7t5v0__dffq_1
X_10123_ _10123_/D _11150_/CLK _10123_/Q VDD VDD VSS VSS gf180mcu_fd_sc_mcu7t5v0__dffq_2
X_10054_ _10054_/D _11082_/CLK _10054_/Q VDD VDD VSS VSS gf180mcu_fd_sc_mcu7t5v0__dffq_1
X_10956_ _10956_/D _10978_/CLK _10956_/Q VDD VDD VSS VSS gf180mcu_fd_sc_mcu7t5v0__dffq_1
X_10887_ _10887_/D _11147_/CLK _10887_/Q VDD VDD VSS VSS gf180mcu_fd_sc_mcu7t5v0__dffq_1
X_06980_ _10001_/Q _07206_/A2 _06983_/B VDD VDD VSS VSS gf180mcu_fd_sc_mcu7t5v0__nand2_1
X_05931_ _10858_/Q _09391_/B2 VDD VDD VSS VSS gf180mcu_fd_sc_mcu7t5v0__clkinv_1
X_05862_ _10618_/Q _09091_/B2 VDD VDD VSS VSS gf180mcu_fd_sc_mcu7t5v0__clkinv_1
X_08650_ _10320_/Q _08659_/A1 _08654_/B _08651_/B VDD VDD VSS VSS
+ gf180mcu_fd_sc_mcu7t5v0__oai21_1
X_07601_ _07602_/A1 _07601_/A2 _07601_/B _07602_/B VDD VDD VSS VSS
+ gf180mcu_fd_sc_mcu7t5v0__aoi21_1
X_05793_ _10229_/Q _07806_/B2 VDD VDD VSS VSS gf180mcu_fd_sc_mcu7t5v0__clkinv_1
X_08581_ _09361_/B2 _08581_/A2 _08581_/B1 _09421_/B2 _08582_/C VDD VDD
+ VSS VSS gf180mcu_fd_sc_mcu7t5v0__oai22_1
X_07532_ _07554_/A1 _07583_/B2 _07530_/Z _07532_/Z VDD VDD VSS VSS
+ gf180mcu_fd_sc_mcu7t5v0__xor3_1
X_07463_ _10327_/Q _10086_/Q _10049_/Q _10335_/Q _10118_/Q _10117_/Q _07463_/Z VDD
+ VDD VSS VSS gf180mcu_fd_sc_mcu7t5v0__mux4_4
X_06414_ _10005_/Q _06413_/Z _06466_/A1 VDD VDD VSS VSS gf180mcu_fd_sc_mcu7t5v0__nand2_1
X_09202_ _09861_/A1 _08588_/B _09211_/A2 VDD VDD VSS VSS gf180mcu_fd_sc_mcu7t5v0__nand2_4
X_09133_ _09413_/A1 _09141_/A2 _09141_/B1 VDD VDD VSS VSS gf180mcu_fd_sc_mcu7t5v0__nand2_4
X_07394_ _10000_/Q _07393_/I _07395_/I VDD VDD VSS VSS gf180mcu_fd_sc_mcu7t5v0__nand2_1
X_06345_ _06351_/A1 _06351_/A2 _06352_/A2 VDD VDD VSS VSS gf180mcu_fd_sc_mcu7t5v0__nor2_1
X_09064_ _06047_/Z _09071_/A2 _09071_/B1 _09064_/B2 _10595_/D VDD VDD
+ VSS VSS gf180mcu_fd_sc_mcu7t5v0__oai22_1
X_06276_ _06276_/A1 _06276_/A2 _06276_/B _06283_/A1 VDD VDD VSS VSS
+ gf180mcu_fd_sc_mcu7t5v0__oai21_1
X_05227_ _10620_/Q _09095_/B2 VDD VDD VSS VSS gf180mcu_fd_sc_mcu7t5v0__clkinv_1
X_08015_ _08015_/A1 _09142_/A2 _08015_/B _08015_/C _08016_/A2 VDD VDD
+ VSS VSS gf180mcu_fd_sc_mcu7t5v0__aoi211_1
X_05158_ _10215_/Q _07790_/B2 VDD VDD VSS VSS gf180mcu_fd_sc_mcu7t5v0__clkinv_1
X_05089_ _10483_/Q _08924_/B2 VDD VDD VSS VSS gf180mcu_fd_sc_mcu7t5v0__clkinv_1
X_09966_ _09966_/D _11181_/CLK _09966_/Q VDD VDD VSS VSS gf180mcu_fd_sc_mcu7t5v0__dffq_1
X_09897_ _09897_/A1 _09898_/A2 _09898_/B1 _09897_/B2 _11148_/D VDD VDD
+ VSS VSS gf180mcu_fd_sc_mcu7t5v0__oai22_1
X_08917_ _09924_/A1 _08921_/A2 _08917_/B _10480_/D VDD VDD VSS VSS
+ gf180mcu_fd_sc_mcu7t5v0__oai21_1
X_08848_ _10449_/Q _08845_/Z _08849_/A3 VDD VDD VSS VSS gf180mcu_fd_sc_mcu7t5v0__nor2_1
X_08779_ _09832_/A1 _08779_/A2 _08779_/B1 _08779_/B2 _10402_/D VDD VDD
+ VSS VSS gf180mcu_fd_sc_mcu7t5v0__oai22_1
X_10810_ _10810_/D _11010_/CLK _10810_/Q VDD VDD VSS VSS gf180mcu_fd_sc_mcu7t5v0__dffq_1
X_10741_ _10741_/D _11142_/CLK _10741_/Q VDD VDD VSS VSS gf180mcu_fd_sc_mcu7t5v0__dffq_1
X_10672_ _10672_/D _11139_/CLK _10672_/Q VDD VDD VSS VSS gf180mcu_fd_sc_mcu7t5v0__dffq_1
Xclkbuf_leaf_20_clk clkbuf_1_0_0_clk/Z _11052_/CLK VDD VDD VSS VSS
+ gf180mcu_fd_sc_mcu7t5v0__clkbuf_16
X_11155_ _11155_/D _11163_/CLK _11155_/Q VDD VDD VSS VSS gf180mcu_fd_sc_mcu7t5v0__dffq_1
X_10106_ _10106_/D _11165_/CLK _10106_/Q VDD VDD VSS VSS gf180mcu_fd_sc_mcu7t5v0__dffq_1
X_11086_ _11086_/D _11097_/CLK _11086_/Q VDD VDD VSS VSS gf180mcu_fd_sc_mcu7t5v0__dffq_1
X_10037_ _10037_/D _11181_/CLK _10037_/Q VDD VDD VSS VSS gf180mcu_fd_sc_mcu7t5v0__dffq_1
X_10939_ _10939_/D _11018_/CLK _10939_/Q VDD VDD VSS VSS gf180mcu_fd_sc_mcu7t5v0__dffq_1
Xclkbuf_leaf_11_clk clkbuf_1_1_0_clk/Z _11018_/CLK VDD VDD VSS VSS
+ gf180mcu_fd_sc_mcu7t5v0__clkbuf_16
X_06130_ _06047_/Z _06144_/A2 _06130_/B _09979_/D VDD VDD VSS VSS
+ gf180mcu_fd_sc_mcu7t5v0__oai21_1
X_06061_ _09698_/A1 _07503_/A1 cgra_status[0] _06061_/Z VDD VDD VSS
+ VSS gf180mcu_fd_sc_mcu7t5v0__mux2_4
X_05012_ _10272_/Q _07905_/A1 VDD VDD VSS VSS gf180mcu_fd_sc_mcu7t5v0__clkinv_1
X_09820_ _09822_/A1 _09819_/Z _11100_/D VDD VDD VSS VSS gf180mcu_fd_sc_mcu7t5v0__nor2_1
X_09751_ _09751_/A1 _09749_/Z _09751_/A3 _11073_/D VDD VDD VSS VSS
+ gf180mcu_fd_sc_mcu7t5v0__nor3_1
X_06963_ _10120_/Q _10080_/Q _06964_/B2 VDD VDD VSS VSS gf180mcu_fd_sc_mcu7t5v0__nand2_1
X_05914_ _10938_/Q _09491_/B2 VDD VDD VSS VSS gf180mcu_fd_sc_mcu7t5v0__clkinv_1
X_08702_ _06047_/Z _08709_/A2 _08709_/B1 _08702_/B2 _10339_/D VDD VDD
+ VSS VSS gf180mcu_fd_sc_mcu7t5v0__oai22_1
X_09682_ _09678_/Z _09682_/A2 _09682_/B _11052_/D VDD VDD VSS VSS
+ gf180mcu_fd_sc_mcu7t5v0__aoi21_1
X_06894_ _09529_/A1 _06899_/A2 _06899_/B1 _06894_/B2 _10063_/D VDD VDD
+ VSS VSS gf180mcu_fd_sc_mcu7t5v0__oai22_1
X_05845_ _11109_/Q _09832_/B2 VDD VDD VSS VSS gf180mcu_fd_sc_mcu7t5v0__clkinv_1
X_08633_ _10266_/Q _08657_/A2 _08657_/B1 _10259_/Q _08633_/C _08635_/A2 VDD
+ VDD VSS VSS gf180mcu_fd_sc_mcu7t5v0__aoi221_1
X_05776_ _10377_/Q _08748_/B2 VDD VDD VSS VSS gf180mcu_fd_sc_mcu7t5v0__clkinv_1
X_08564_ _10626_/Q _06023_/I _08582_/A2 _10658_/Q _08564_/C1 _10634_/Q _08566_/A2
+ VDD VDD VSS VSS gf180mcu_fd_sc_mcu7t5v0__aoi222_2
X_07515_ _07515_/A1 _07515_/A2 _07564_/B2 VDD VDD VSS VSS gf180mcu_fd_sc_mcu7t5v0__xnor2_1
X_08495_ _10213_/Q _08528_/A2 _08529_/B1 _10197_/Q _08495_/C _08498_/A1 VDD
+ VDD VSS VSS gf180mcu_fd_sc_mcu7t5v0__aoi221_1
X_07446_ _07609_/A2 _07572_/A2 _07393_/I _07589_/B _07449_/A3 VDD VDD
+ VSS VSS gf180mcu_fd_sc_mcu7t5v0__oai31_1
X_07377_ _07545_/A1 _07401_/A1 _07377_/B _07378_/B VDD VDD VSS VSS
+ gf180mcu_fd_sc_mcu7t5v0__oai21_1
X_09116_ _09941_/A1 _09121_/A2 _09121_/B1 _09116_/B2 _10637_/D VDD VDD
+ VSS VSS gf180mcu_fd_sc_mcu7t5v0__oai22_1
X_06328_ _06328_/A1 _06441_/A1 _06328_/B1 _06328_/B2 _06328_/C _06329_/B VDD
+ VDD VSS VSS gf180mcu_fd_sc_mcu7t5v0__oai221_1
X_09047_ _06058_/Z _09051_/A2 _09051_/B1 _09047_/B2 _10582_/D VDD VDD
+ VSS VSS gf180mcu_fd_sc_mcu7t5v0__oai22_1
X_06259_ _06327_/B _06258_/Z _06260_/A2 VDD VDD VSS VSS gf180mcu_fd_sc_mcu7t5v0__nand2_1
X_09949_ _09949_/D _11010_/CLK _09949_/Q VDD VDD VSS VSS gf180mcu_fd_sc_mcu7t5v0__dffq_1
X_10724_ _10724_/D _11147_/CLK _10724_/Q VDD VDD VSS VSS gf180mcu_fd_sc_mcu7t5v0__dffq_1
X_10655_ _10655_/D _10978_/CLK _10655_/Q VDD VDD VSS VSS gf180mcu_fd_sc_mcu7t5v0__dffq_1
X_10586_ _10586_/D _10666_/CLK _10586_/Q VDD VDD VSS VSS gf180mcu_fd_sc_mcu7t5v0__dffq_1
X_11138_ _11138_/D _11138_/CLK _11138_/Q VDD VDD VSS VSS gf180mcu_fd_sc_mcu7t5v0__dffq_1
X_11069_ _11069_/D _11082_/CLK _11069_/Q VDD VDD VSS VSS gf180mcu_fd_sc_mcu7t5v0__dffq_2
Xclkbuf_leaf_0_clk clkbuf_1_0_0_clk/Z _11181_/CLK VDD VDD VSS VSS
+ gf180mcu_fd_sc_mcu7t5v0__clkbuf_16
X_05630_ _10992_/Q _09575_/B2 VDD VDD VSS VSS gf180mcu_fd_sc_mcu7t5v0__clkinv_1
X_05561_ _10743_/Q _09248_/B2 VDD VDD VSS VSS gf180mcu_fd_sc_mcu7t5v0__clkinv_1
X_07300_ _10108_/Q _07310_/A2 _07301_/B VDD VDD VSS VSS gf180mcu_fd_sc_mcu7t5v0__nand2_1
X_05492_ _10910_/Q _09457_/B2 VDD VDD VSS VSS gf180mcu_fd_sc_mcu7t5v0__clkinv_1
X_08280_ _10110_/Q _08580_/A2 _08589_/B1 _10073_/Q _08283_/A1 VDD VDD
+ VSS VSS gf180mcu_fd_sc_mcu7t5v0__aoi22_1
X_07231_ _07231_/A1 _07231_/A2 _07231_/B _07233_/A1 VDD VDD VSS VSS
+ gf180mcu_fd_sc_mcu7t5v0__oai21_1
X_07162_ _07162_/A1 _07145_/Z _07162_/B _07213_/A1 VDD VDD VSS VSS
+ gf180mcu_fd_sc_mcu7t5v0__aoi21_1
X_06113_ _07682_/A1 _08542_/A2 _09645_/A2 VDD VDD VSS VSS gf180mcu_fd_sc_mcu7t5v0__nor2_4
X_07093_ _07093_/I _07143_/A2 VDD VDD VSS VSS gf180mcu_fd_sc_mcu7t5v0__clkinv_1
X_06044_ _09502_/A1 _09645_/A1 _06074_/A1 VDD VDD VSS VSS gf180mcu_fd_sc_mcu7t5v0__nand2_2
X_09803_ _11095_/Q _09817_/A2 _09809_/B _09804_/B VDD VDD VSS VSS
+ gf180mcu_fd_sc_mcu7t5v0__oai21_1
X_07995_ _10395_/Q _08589_/B1 _08576_/B1 _10923_/Q _08591_/B1 _10987_/Q _07997_/A2
+ VDD VDD VSS VSS gf180mcu_fd_sc_mcu7t5v0__aoi222_2
X_09734_ _11067_/Q _09751_/A1 _11067_/D VDD VDD VSS VSS gf180mcu_fd_sc_mcu7t5v0__nor2_1
X_06946_ _10077_/Q _07014_/A1 _07250_/A1 VDD VDD VSS VSS gf180mcu_fd_sc_mcu7t5v0__nand2_1
X_09665_ _09920_/A1 _09671_/A2 _09671_/B1 _09665_/B2 _11044_/D VDD VDD
+ VSS VSS gf180mcu_fd_sc_mcu7t5v0__oai22_1
X_06877_ _06021_/Z _06878_/A2 _06877_/Z VDD VDD VSS VSS gf180mcu_fd_sc_mcu7t5v0__and2_4
X_08616_ _09896_/A1 _08618_/A2 _08618_/B1 _08616_/B2 _10309_/D VDD VDD
+ VSS VSS gf180mcu_fd_sc_mcu7t5v0__oai22_1
X_05828_ _10881_/Q _09420_/B2 VDD VDD VSS VSS gf180mcu_fd_sc_mcu7t5v0__clkinv_1
X_09596_ _09925_/A1 _09597_/A2 _09597_/B1 _09596_/B2 _11009_/D VDD VDD
+ VSS VSS gf180mcu_fd_sc_mcu7t5v0__oai22_1
X_08547_ _10954_/Q _08547_/A2 _08573_/B1 _11133_/Q _06125_/I _10938_/Q _08548_/A3
+ VDD VDD VSS VSS gf180mcu_fd_sc_mcu7t5v0__aoi222_4
X_05759_ _10641_/Q _09120_/B2 VDD VDD VSS VSS gf180mcu_fd_sc_mcu7t5v0__clkinv_1
X_08478_ _08478_/A1 _08581_/A2 _08585_/B1 _08607_/B2 _08479_/C VDD VDD
+ VSS VSS gf180mcu_fd_sc_mcu7t5v0__oai22_1
X_07429_ _10000_/Q _07428_/I _07465_/A1 VDD VDD VSS VSS gf180mcu_fd_sc_mcu7t5v0__nand2_1
X_10440_ _10440_/D _11017_/CLK _10440_/Q VDD VDD VSS VSS gf180mcu_fd_sc_mcu7t5v0__dffq_1
X_10371_ _10371_/D _11142_/CLK _10371_/Q VDD VDD VSS VSS gf180mcu_fd_sc_mcu7t5v0__dffq_1
X_10707_ _10707_/D _11139_/CLK _10707_/Q VDD VDD VSS VSS gf180mcu_fd_sc_mcu7t5v0__dffq_1
X_10638_ _10638_/D _10666_/CLK _10638_/Q VDD VDD VSS VSS gf180mcu_fd_sc_mcu7t5v0__dffq_1
X_10569_ _10569_/D _10666_/CLK _10569_/Q VDD VDD VSS VSS gf180mcu_fd_sc_mcu7t5v0__dffq_1
X_07780_ _10211_/Q _07786_/A2 _07781_/B VDD VDD VSS VSS gf180mcu_fd_sc_mcu7t5v0__nand2_1
X_04992_ _10328_/Q _08671_/A1 VDD VDD VSS VSS gf180mcu_fd_sc_mcu7t5v0__clkinv_1
X_06800_ _06800_/I _06853_/A1 VDD VDD VSS VSS gf180mcu_fd_sc_mcu7t5v0__clkinv_1
X_06731_ _06872_/I0 _06823_/A1 _06732_/A2 VDD VDD VSS VSS gf180mcu_fd_sc_mcu7t5v0__nand2_1
X_09450_ _09945_/A1 _09451_/A2 _09451_/B1 _09450_/B2 _10905_/D VDD VDD
+ VSS VSS gf180mcu_fd_sc_mcu7t5v0__oai22_1
X_08401_ _10760_/Q _08559_/A2 _08877_/A2 _10800_/Q _08401_/C _08402_/A3 VDD
+ VDD VSS VSS gf180mcu_fd_sc_mcu7t5v0__aoi221_2
X_06662_ _06664_/A1 _06664_/A3 _06699_/B VDD VDD VSS VSS gf180mcu_fd_sc_mcu7t5v0__nor2_1
X_05613_ _10855_/Q _09388_/B2 VDD VDD VSS VSS gf180mcu_fd_sc_mcu7t5v0__clkinv_1
X_09381_ _09926_/A1 _09381_/A2 _09381_/B1 _09381_/B2 _10850_/D VDD VDD
+ VSS VSS gf180mcu_fd_sc_mcu7t5v0__oai22_1
X_06593_ _10001_/Q _06593_/A2 _06590_/Z _06629_/A1 VDD VDD VSS VSS
+ gf180mcu_fd_sc_mcu7t5v0__nand3_2
X_05544_ _10615_/Q _09088_/B2 VDD VDD VSS VSS gf180mcu_fd_sc_mcu7t5v0__clkinv_1
X_08332_ _10967_/Q _08530_/A2 _06877_/Z _10235_/Q _08563_/C1 _10155_/Q _08333_/A3
+ VDD VDD VSS VSS gf180mcu_fd_sc_mcu7t5v0__aoi222_2
X_08263_ _10414_/Q _08559_/A2 _06112_/I _10438_/Q _08263_/C _08264_/A3 VDD VDD
+ VSS VSS gf180mcu_fd_sc_mcu7t5v0__aoi221_2
X_05475_ _10226_/Q _07803_/B2 VDD VDD VSS VSS gf180mcu_fd_sc_mcu7t5v0__clkinv_1
X_07214_ _07214_/A1 _07214_/A2 _07214_/B _07236_/A1 VDD VDD VSS VSS
+ gf180mcu_fd_sc_mcu7t5v0__oai21_1
X_08194_ _10966_/Q _08530_/A2 _06877_/Z _10234_/Q _08563_/C1 _10154_/Q _08195_/A3
+ VDD VDD VSS VSS gf180mcu_fd_sc_mcu7t5v0__aoi222_2
X_07145_ _10087_/Q _07144_/Z _07145_/Z VDD VDD VSS VSS gf180mcu_fd_sc_mcu7t5v0__or2_1
X_07076_ _07076_/A1 _07168_/A1 _07077_/I VDD VDD VSS VSS gf180mcu_fd_sc_mcu7t5v0__xnor2_1
X_06027_ _07829_/C bus_we _08619_/B _06028_/A2 VDD VDD VSS VSS gf180mcu_fd_sc_mcu7t5v0__nand3_1
X_07978_ _08268_/B2 _08534_/B2 _09332_/A2 VDD VDD VSS VSS gf180mcu_fd_sc_mcu7t5v0__nor2_4
X_09717_ _09717_/A1 _09721_/A2 _09718_/B VDD VDD VSS VSS gf180mcu_fd_sc_mcu7t5v0__nor2_1
X_06929_ _10081_/Q _07070_/A1 _10008_/Q _06967_/A1 VDD VDD VSS VSS
+ gf180mcu_fd_sc_mcu7t5v0__nor3_4
X_09648_ _11036_/Q _09660_/A2 _09649_/B VDD VDD VSS VSS gf180mcu_fd_sc_mcu7t5v0__nand2_1
X_09579_ _09852_/A1 _09587_/A2 _09587_/B1 VDD VDD VSS VSS gf180mcu_fd_sc_mcu7t5v0__nand2_2
X_10423_ _10423_/D _11142_/CLK _10423_/Q VDD VDD VSS VSS gf180mcu_fd_sc_mcu7t5v0__dffq_1
X_10354_ _10354_/D _11149_/CLK _10354_/Q VDD VDD VSS VSS gf180mcu_fd_sc_mcu7t5v0__dffq_1
X_10285_ _10285_/D _11052_/CLK _10285_/Q VDD VDD VSS VSS gf180mcu_fd_sc_mcu7t5v0__dffq_1
X_05260_ _10884_/Q _09425_/B2 VDD VDD VSS VSS gf180mcu_fd_sc_mcu7t5v0__clkinv_1
X_05191_ _10867_/Q _09404_/B2 VDD VDD VSS VSS gf180mcu_fd_sc_mcu7t5v0__clkinv_1
X_08950_ _09925_/A1 _08951_/A2 _08951_/B1 _08950_/B2 _10505_/D VDD VDD
+ VSS VSS gf180mcu_fd_sc_mcu7t5v0__oai22_1
X_08881_ _09904_/A1 _08893_/A2 _08881_/B _10460_/D VDD VDD VSS VSS
+ gf180mcu_fd_sc_mcu7t5v0__oai21_1
X_07901_ _07901_/A1 _07905_/A2 _07901_/B _10270_/D VDD VDD VSS VSS
+ gf180mcu_fd_sc_mcu7t5v0__aoi21_1
X_07832_ bus_addr[0] bus_addr[1] bus_addr[2] _07831_/I _07842_/A2 VDD VDD
+ VSS VSS gf180mcu_fd_sc_mcu7t5v0__nor4_4
X_07763_ _09920_/A1 _07769_/A2 _07769_/B1 _07763_/B2 _10200_/D VDD VDD
+ VSS VSS gf180mcu_fd_sc_mcu7t5v0__oai22_1
X_09502_ _09502_/A1 _09861_/A2 _09511_/A2 VDD VDD VSS VSS gf180mcu_fd_sc_mcu7t5v0__nand2_4
X_04975_ _11094_/Q _09804_/A1 VDD VDD VSS VSS gf180mcu_fd_sc_mcu7t5v0__clkinv_1
X_06714_ _06714_/A1 _06711_/I _06714_/Z VDD VDD VSS VSS gf180mcu_fd_sc_mcu7t5v0__xor2_1
X_07694_ _10156_/Q _07698_/A2 _07695_/B VDD VDD VSS VSS gf180mcu_fd_sc_mcu7t5v0__nand2_1
X_09433_ _09433_/A1 _09441_/A2 _09441_/B1 VDD VDD VSS VSS gf180mcu_fd_sc_mcu7t5v0__nand2_2
X_06645_ _10002_/Q _06873_/A2 _06629_/Z _06835_/A1 _06645_/C _06646_/A3 VDD
+ VDD VSS VSS gf180mcu_fd_sc_mcu7t5v0__aoi221_1
X_09364_ _06047_/Z _09371_/A2 _09371_/B1 _09364_/B2 _10835_/D VDD VDD
+ VSS VSS gf180mcu_fd_sc_mcu7t5v0__oai22_1
X_08315_ _10727_/Q _08580_/A2 _08576_/B1 _10999_/Q _08317_/A2 VDD VDD
+ VSS VSS gf180mcu_fd_sc_mcu7t5v0__aoi22_2
X_06576_ _10000_/Q _06873_/A2 _06873_/B _06577_/A2 VDD VDD VSS VSS
+ gf180mcu_fd_sc_mcu7t5v0__aoi21_1
X_05527_ _11106_/Q _09829_/B2 VDD VDD VSS VSS gf180mcu_fd_sc_mcu7t5v0__clkinv_1
X_09295_ _09904_/A1 _09301_/A2 _09301_/B1 _09295_/B2 _10780_/D VDD VDD
+ VSS VSS gf180mcu_fd_sc_mcu7t5v0__oai22_1
X_05458_ _10374_/Q _08745_/B2 VDD VDD VSS VSS gf180mcu_fd_sc_mcu7t5v0__clkinv_1
X_08246_ _10742_/Q _08547_/A2 _07680_/I _10374_/Q _08246_/C _08249_/A1 VDD VDD
+ VSS VSS gf180mcu_fd_sc_mcu7t5v0__aoi221_1
X_08177_ _10605_/Q _08563_/A2 _06877_/Z _10613_/Q _08563_/C1 _10645_/Q _08179_/A2
+ VDD VDD VSS VSS gf180mcu_fd_sc_mcu7t5v0__aoi222_2
X_05389_ _10757_/Q _09266_/B2 VDD VDD VSS VSS gf180mcu_fd_sc_mcu7t5v0__clkinv_1
X_07128_ _07128_/A1 _07128_/A2 _07168_/B1 VDD VDD VSS VSS gf180mcu_fd_sc_mcu7t5v0__xnor2_1
X_07059_ _10003_/Q _07223_/A2 _07231_/A1 VDD VDD VSS VSS gf180mcu_fd_sc_mcu7t5v0__nand2_2
X_10070_ _10070_/D _11150_/CLK _10070_/Q VDD VDD VSS VSS gf180mcu_fd_sc_mcu7t5v0__dffq_1
X_10972_ _10972_/D _10978_/CLK _10972_/Q VDD VDD VSS VSS gf180mcu_fd_sc_mcu7t5v0__dffq_1
X_10406_ _10406_/D _11138_/CLK _10406_/Q VDD VDD VSS VSS gf180mcu_fd_sc_mcu7t5v0__dffq_1
X_10337_ _10337_/D _11150_/CLK _10337_/Q VDD VDD VSS VSS gf180mcu_fd_sc_mcu7t5v0__dffq_1
X_10268_ _10268_/D _11052_/CLK _10268_/Q VDD VDD VSS VSS gf180mcu_fd_sc_mcu7t5v0__dffq_1
X_10199_ _10199_/D _11147_/CLK _10199_/Q VDD VDD VSS VSS gf180mcu_fd_sc_mcu7t5v0__dffq_1
X_06430_ _10051_/Q _06195_/Z _06432_/A1 VDD VDD VSS VSS gf180mcu_fd_sc_mcu7t5v0__nand2_1
X_06361_ _06327_/B _06361_/A2 _06375_/A2 VDD VDD VSS VSS gf180mcu_fd_sc_mcu7t5v0__nand2_1
X_05312_ _10989_/Q _09572_/B2 VDD VDD VSS VSS gf180mcu_fd_sc_mcu7t5v0__clkinv_1
X_08100_ _08100_/A1 _08100_/A2 _08101_/C VDD VDD VSS VSS gf180mcu_fd_sc_mcu7t5v0__nand2_1
X_09080_ _09945_/A1 _09081_/A2 _09081_/B1 _09080_/B2 _10609_/D VDD VDD
+ VSS VSS gf180mcu_fd_sc_mcu7t5v0__oai22_1
X_06292_ _10010_/Q _07601_/B _06292_/B _06293_/A2 VDD VDD VSS VSS
+ gf180mcu_fd_sc_mcu7t5v0__aoi21_1
X_05243_ _10740_/Q _09245_/B2 VDD VDD VSS VSS gf180mcu_fd_sc_mcu7t5v0__clkinv_1
X_08031_ _08533_/A1 _08329_/B _09662_/A2 VDD VDD VSS VSS gf180mcu_fd_sc_mcu7t5v0__nor2_4
X_05174_ _10907_/Q _09454_/B2 VDD VDD VSS VSS gf180mcu_fd_sc_mcu7t5v0__clkinv_1
X_09982_ _09982_/D _11163_/CLK _09982_/Q VDD VDD VSS VSS gf180mcu_fd_sc_mcu7t5v0__dffq_1
X_08933_ _09599_/A1 _08941_/A2 _08941_/B1 VDD VDD VSS VSS gf180mcu_fd_sc_mcu7t5v0__nand2_4
X_08864_ _08862_/Z _08864_/A2 _10454_/D VDD VDD VSS VSS gf180mcu_fd_sc_mcu7t5v0__nor2_1
X_08795_ _06058_/Z _08799_/A2 _08799_/B1 _08795_/B2 _10414_/D VDD VDD
+ VSS VSS gf180mcu_fd_sc_mcu7t5v0__oai22_1
X_07815_ _09529_/A1 _07825_/A2 _07815_/B _10233_/D VDD VDD VSS VSS
+ gf180mcu_fd_sc_mcu7t5v0__oai21_1
X_07746_ _09944_/A1 _07748_/A2 _07748_/B1 _07746_/B2 _10188_/D VDD VDD
+ VSS VSS gf180mcu_fd_sc_mcu7t5v0__oai22_1
X_07677_ _09925_/A1 _07678_/A2 _07678_/B1 _07677_/B2 _10149_/D VDD VDD
+ VSS VSS gf180mcu_fd_sc_mcu7t5v0__oai22_1
X_09416_ _09893_/A1 _09421_/A2 _09421_/B1 _09416_/B2 _10877_/D VDD VDD
+ VSS VSS gf180mcu_fd_sc_mcu7t5v0__oai22_1
X_06628_ _06629_/A1 _06629_/A2 _06669_/A1 VDD VDD VSS VSS gf180mcu_fd_sc_mcu7t5v0__nor2_1
X_09347_ _06058_/Z _09351_/A2 _09351_/B1 _09347_/B2 _10822_/D VDD VDD
+ VSS VSS gf180mcu_fd_sc_mcu7t5v0__oai22_1
X_06559_ _07379_/A1 _06804_/A3 _06593_/A2 VDD VDD VSS VSS gf180mcu_fd_sc_mcu7t5v0__nor2_2
X_09278_ _06061_/Z _09281_/A2 _09281_/B1 _09278_/B2 _10767_/D VDD VDD
+ VSS VSS gf180mcu_fd_sc_mcu7t5v0__oai22_1
X_08229_ _10478_/Q _08528_/B1 _09834_/A2 _11113_/Q _08230_/I VDD VDD VSS
+ VSS gf180mcu_fd_sc_mcu7t5v0__aoi22_1
X_11171_ _11171_/D _11181_/CLK _11171_/Q VDD VDD VSS VSS gf180mcu_fd_sc_mcu7t5v0__dffq_1
X_10122_ _10122_/D _11150_/CLK _10122_/Q VDD VDD VSS VSS gf180mcu_fd_sc_mcu7t5v0__dffq_1
X_10053_ _10053_/D _11181_/CLK _10053_/Q VDD VDD VSS VSS gf180mcu_fd_sc_mcu7t5v0__dffq_1
X_10955_ _10955_/D _10978_/CLK _10955_/Q VDD VDD VSS VSS gf180mcu_fd_sc_mcu7t5v0__dffq_1
X_10886_ _10886_/D _11147_/CLK _10886_/Q VDD VDD VSS VSS gf180mcu_fd_sc_mcu7t5v0__dffq_1
X_05930_ _10850_/Q _09381_/B2 VDD VDD VSS VSS gf180mcu_fd_sc_mcu7t5v0__clkinv_1
X_05861_ _10610_/Q _09081_/B2 VDD VDD VSS VSS gf180mcu_fd_sc_mcu7t5v0__clkinv_1
X_08580_ _10826_/Q _08580_/A2 _08591_/A2 _10858_/Q _08583_/A2 VDD VDD
+ VSS VSS gf180mcu_fd_sc_mcu7t5v0__aoi22_1
X_07600_ _07635_/A1 _07585_/Z _07625_/B _07600_/B2 _07600_/C _07601_/A2 VDD
+ VDD VSS VSS gf180mcu_fd_sc_mcu7t5v0__aoi221_2
X_05792_ _10345_/Q _08708_/B2 VDD VDD VSS VSS gf180mcu_fd_sc_mcu7t5v0__clkinv_1
X_07531_ _07554_/A1 _07530_/Z _07583_/B1 VDD VDD VSS VSS gf180mcu_fd_sc_mcu7t5v0__xnor2_1
X_07462_ _07465_/A1 _07462_/A2 _07462_/B _07480_/A2 VDD VDD VSS VSS
+ gf180mcu_fd_sc_mcu7t5v0__oai21_2
X_09201_ _09946_/A1 _09201_/A2 _09201_/B1 _09201_/B2 _10706_/D VDD VDD
+ VSS VSS gf180mcu_fd_sc_mcu7t5v0__oai22_1
X_06413_ _06483_/A2 _06462_/A1 _06413_/Z VDD VDD VSS VSS gf180mcu_fd_sc_mcu7t5v0__xor2_1
X_07393_ _07393_/I _07485_/A3 VDD VDD VSS VSS gf180mcu_fd_sc_mcu7t5v0__clkinv_2
X_09132_ _09861_/A1 _09142_/A2 _09141_/A2 VDD VDD VSS VSS gf180mcu_fd_sc_mcu7t5v0__nand2_4
X_06344_ _06429_/A1 _06380_/A2 _06352_/A1 VDD VDD VSS VSS gf180mcu_fd_sc_mcu7t5v0__nor2_1
X_09063_ _09193_/A1 _09071_/A2 _09071_/B1 VDD VDD VSS VSS gf180mcu_fd_sc_mcu7t5v0__nand2_2
X_06275_ _06275_/A1 _06274_/B _06275_/Z VDD VDD VSS VSS gf180mcu_fd_sc_mcu7t5v0__xor2_1
X_08014_ _08014_/A1 _08014_/A2 _08015_/C VDD VDD VSS VSS gf180mcu_fd_sc_mcu7t5v0__nand2_1
X_05226_ _10612_/Q _09085_/B2 VDD VDD VSS VSS gf180mcu_fd_sc_mcu7t5v0__clkinv_1
X_05157_ _10223_/Q _07800_/B2 VDD VDD VSS VSS gf180mcu_fd_sc_mcu7t5v0__clkinv_1
X_05088_ _10491_/Q _08934_/B2 VDD VDD VSS VSS gf180mcu_fd_sc_mcu7t5v0__clkinv_1
X_09965_ _09965_/D _11181_/CLK _09965_/Q VDD VDD VSS VSS gf180mcu_fd_sc_mcu7t5v0__dffq_1
X_09896_ _09896_/A1 _09898_/A2 _09898_/B1 _09896_/B2 _11147_/D VDD VDD
+ VSS VSS gf180mcu_fd_sc_mcu7t5v0__oai22_1
X_08916_ _10480_/Q _08920_/A2 _08917_/B VDD VDD VSS VSS gf180mcu_fd_sc_mcu7t5v0__nand2_1
X_08847_ _10449_/Q _08845_/Z _08847_/Z VDD VDD VSS VSS gf180mcu_fd_sc_mcu7t5v0__and2_1
X_08778_ _09897_/A1 _08779_/A2 _08779_/B1 _08778_/B2 _10401_/D VDD VDD
+ VSS VSS gf180mcu_fd_sc_mcu7t5v0__oai22_1
X_07729_ _09889_/A1 _09568_/A2 _07738_/A2 VDD VDD VSS VSS gf180mcu_fd_sc_mcu7t5v0__nand2_4
X_10740_ _10740_/D _11017_/CLK _10740_/Q VDD VDD VSS VSS gf180mcu_fd_sc_mcu7t5v0__dffq_1
X_10671_ _10671_/D _11139_/CLK _10671_/Q VDD VDD VSS VSS gf180mcu_fd_sc_mcu7t5v0__dffq_1
X_11154_ _11154_/D _11163_/CLK _11154_/Q VDD VDD VSS VSS gf180mcu_fd_sc_mcu7t5v0__dffq_1
X_11085_ _11085_/D _11097_/CLK _11085_/Q VDD VDD VSS VSS gf180mcu_fd_sc_mcu7t5v0__dffq_1
X_10105_ _10105_/D _11052_/CLK _10105_/Q VDD VDD VSS VSS gf180mcu_fd_sc_mcu7t5v0__dffq_1
X_10036_ _10036_/D _11181_/CLK _10036_/Q VDD VDD VSS VSS gf180mcu_fd_sc_mcu7t5v0__dffq_1
X_10938_ _10938_/D _11149_/CLK _10938_/Q VDD VDD VSS VSS gf180mcu_fd_sc_mcu7t5v0__dffq_1
X_10869_ _10869_/D _11165_/CLK _10869_/Q VDD VDD VSS VSS gf180mcu_fd_sc_mcu7t5v0__dffq_1
X_06060_ _09951_/Q _06071_/A2 _06062_/B VDD VDD VSS VSS gf180mcu_fd_sc_mcu7t5v0__nand2_1
X_05011_ bus_wdata[0] _09679_/A1 VDD VDD VSS VSS gf180mcu_fd_sc_mcu7t5v0__inv_2
X_09750_ _11072_/Q _09750_/A2 _11073_/Q _09751_/A3 VDD VDD VSS VSS
+ gf180mcu_fd_sc_mcu7t5v0__aoi21_1
X_06962_ _10324_/Q _10080_/Q _07122_/B _06964_/B1 VDD VDD VSS VSS
+ gf180mcu_fd_sc_mcu7t5v0__oai21_2
X_05913_ _10954_/Q _09511_/B2 VDD VDD VSS VSS gf180mcu_fd_sc_mcu7t5v0__clkinv_1
X_08701_ _09852_/A1 _08709_/A2 _08709_/B1 VDD VDD VSS VSS gf180mcu_fd_sc_mcu7t5v0__nand2_2
X_09681_ _11052_/Q _09678_/Z rst_n _09682_/B VDD VDD VSS VSS gf180mcu_fd_sc_mcu7t5v0__oai21_1
X_08632_ _08632_/A1 _07601_/B _08633_/C VDD VDD VSS VSS gf180mcu_fd_sc_mcu7t5v0__nor2_1
X_06893_ _09940_/A1 _06899_/A2 _06899_/B1 _06893_/B2 _10062_/D VDD VDD
+ VSS VSS gf180mcu_fd_sc_mcu7t5v0__oai22_1
X_05844_ _10930_/Q _09481_/B2 VDD VDD VSS VSS gf180mcu_fd_sc_mcu7t5v0__clkinv_1
X_05775_ _10425_/Q _08808_/B2 VDD VDD VSS VSS gf180mcu_fd_sc_mcu7t5v0__clkinv_1
X_08563_ _10610_/Q _08563_/A2 _06877_/Z _10618_/Q _08563_/C1 _10650_/Q _08566_/A1
+ VDD VDD VSS VSS gf180mcu_fd_sc_mcu7t5v0__aoi222_2
X_07514_ _07515_/A1 _07515_/A2 _07560_/A2 VDD VDD VSS VSS gf180mcu_fd_sc_mcu7t5v0__nor2_1
X_08494_ _08494_/I _08495_/C VDD VDD VSS VSS gf180mcu_fd_sc_mcu7t5v0__clkinv_1
X_07445_ _10122_/Q _07461_/A1 _07441_/Z _07445_/Z VDD VDD VSS VSS
+ gf180mcu_fd_sc_mcu7t5v0__xor3_1
X_07376_ _07632_/I1 _07401_/A1 _07633_/C _07377_/B VDD VDD VSS VSS
+ gf180mcu_fd_sc_mcu7t5v0__aoi21_1
X_09115_ _09940_/A1 _09121_/A2 _09121_/B1 _09115_/B2 _10636_/D VDD VDD
+ VSS VSS gf180mcu_fd_sc_mcu7t5v0__oai22_1
X_06327_ _10003_/Q _06505_/B _06327_/B _06328_/C VDD VDD VSS VSS gf180mcu_fd_sc_mcu7t5v0__aoi21_1
X_09046_ _09893_/A1 _09051_/A2 _09051_/B1 _09046_/B2 _10581_/D VDD VDD
+ VSS VSS gf180mcu_fd_sc_mcu7t5v0__oai22_1
X_06258_ _06258_/A1 _06256_/Z _06258_/Z VDD VDD VSS VSS gf180mcu_fd_sc_mcu7t5v0__xor2_1
X_05209_ _11103_/Q _09826_/B2 VDD VDD VSS VSS gf180mcu_fd_sc_mcu7t5v0__clkinv_1
X_06189_ _10336_/Q _08675_/A2 _08672_/B _06190_/B VDD VDD VSS VSS
+ gf180mcu_fd_sc_mcu7t5v0__oai21_1
X_09948_ _09948_/D _11010_/CLK _09948_/Q VDD VDD VSS VSS gf180mcu_fd_sc_mcu7t5v0__dffq_1
X_09879_ _11137_/Q _09887_/A2 _09880_/B VDD VDD VSS VSS gf180mcu_fd_sc_mcu7t5v0__nand2_1
X_10723_ _10723_/D _11147_/CLK _10723_/Q VDD VDD VSS VSS gf180mcu_fd_sc_mcu7t5v0__dffq_1
X_10654_ _10654_/D _10978_/CLK _10654_/Q VDD VDD VSS VSS gf180mcu_fd_sc_mcu7t5v0__dffq_1
X_10585_ _10585_/D _10666_/CLK _10585_/Q VDD VDD VSS VSS gf180mcu_fd_sc_mcu7t5v0__dffq_1
X_11137_ _11137_/D _11163_/CLK _11137_/Q VDD VDD VSS VSS gf180mcu_fd_sc_mcu7t5v0__dffq_1
X_11068_ _11068_/D _11082_/CLK _11068_/Q VDD VDD VSS VSS gf180mcu_fd_sc_mcu7t5v0__dffq_1
X_10019_ _10019_/D _10905_/CLK _10019_/Q VDD VDD VSS VSS gf180mcu_fd_sc_mcu7t5v0__dffq_1
X_05560_ _10735_/Q _09238_/B2 VDD VDD VSS VSS gf180mcu_fd_sc_mcu7t5v0__clkinv_1
X_05491_ _10918_/Q _09467_/B2 VDD VDD VSS VSS gf180mcu_fd_sc_mcu7t5v0__clkinv_1
X_07230_ _07230_/A1 _07230_/A2 _07229_/Z _07230_/Z VDD VDD VSS VSS
+ gf180mcu_fd_sc_mcu7t5v0__xor3_1
X_07161_ _07161_/A1 _07161_/A2 _07603_/B _10087_/D VDD VDD VSS VSS
+ gf180mcu_fd_sc_mcu7t5v0__aoi21_1
X_06112_ _06112_/I _08542_/A2 VDD VDD VSS VSS gf180mcu_fd_sc_mcu7t5v0__inv_4
X_07092_ _07095_/A1 _07094_/A2 _07093_/I VDD VDD VSS VSS gf180mcu_fd_sc_mcu7t5v0__nor2_2
X_06043_ _08268_/B2 _08533_/B2 _09645_/A1 VDD VDD VSS VSS gf180mcu_fd_sc_mcu7t5v0__nor2_4
X_09802_ _09802_/A1 _09817_/A2 _09802_/B _11093_/D VDD VDD VSS VSS
+ gf180mcu_fd_sc_mcu7t5v0__aoi21_1
X_07994_ _10175_/Q _08589_/A2 _08591_/A2 _10379_/Q _07997_/A1 VDD VDD
+ VSS VSS gf180mcu_fd_sc_mcu7t5v0__aoi22_1
X_09733_ _09754_/B _09733_/A2 _09751_/A1 VDD VDD VSS VSS gf180mcu_fd_sc_mcu7t5v0__nand2_1
X_06945_ _06953_/A3 _06945_/A2 _07208_/A1 VDD VDD VSS VSS gf180mcu_fd_sc_mcu7t5v0__nor2_2
X_09664_ _06047_/Z _09671_/A2 _09671_/B1 _09664_/B2 _11043_/D VDD VDD
+ VSS VSS gf180mcu_fd_sc_mcu7t5v0__oai22_1
X_06876_ _06876_/A1 _07601_/B _06876_/B1 _06876_/B2 _07603_/B _10052_/D VDD
+ VDD VSS VSS gf180mcu_fd_sc_mcu7t5v0__aoi221_1
X_08615_ _06061_/Z _08618_/A2 _08618_/B1 _08615_/B2 _10308_/D VDD VDD
+ VSS VSS gf180mcu_fd_sc_mcu7t5v0__oai22_1
X_05827_ _10873_/Q _09410_/B2 VDD VDD VSS VSS gf180mcu_fd_sc_mcu7t5v0__clkinv_1
X_09595_ _09924_/A1 _09597_/A2 _09597_/B1 _09595_/B2 _11008_/D VDD VDD
+ VSS VSS gf180mcu_fd_sc_mcu7t5v0__oai22_1
X_08546_ _10962_/Q _06877_/Z _08584_/B1 _10754_/Q _07680_/I _10914_/Q _08548_/A2 VDD
+ VDD VSS VSS gf180mcu_fd_sc_mcu7t5v0__aoi222_2
X_05758_ _10633_/Q _09110_/B2 VDD VDD VSS VSS gf180mcu_fd_sc_mcu7t5v0__clkinv_1
X_05689_ _10204_/Q _07767_/B2 VDD VDD VSS VSS gf180mcu_fd_sc_mcu7t5v0__clkinv_1
X_08477_ _08477_/A1 _08477_/A2 _08477_/A3 _08483_/A2 VDD VDD VSS VSS
+ gf180mcu_fd_sc_mcu7t5v0__nand3_1
X_07428_ _07428_/I _07485_/A4 VDD VDD VSS VSS gf180mcu_fd_sc_mcu7t5v0__clkinv_1
X_07359_ _10000_/Q _07485_/A1 _07373_/A1 VDD VDD VSS VSS gf180mcu_fd_sc_mcu7t5v0__nor2_1
X_10370_ _10370_/D _10905_/CLK _10370_/Q VDD VDD VSS VSS gf180mcu_fd_sc_mcu7t5v0__dffq_1
X_09029_ _09944_/A1 _09031_/A2 _09031_/B1 _09029_/B2 _10568_/D VDD VDD
+ VSS VSS gf180mcu_fd_sc_mcu7t5v0__oai22_1
X_10706_ _10706_/D _10905_/CLK _10706_/Q VDD VDD VSS VSS gf180mcu_fd_sc_mcu7t5v0__dffq_1
X_10637_ _10637_/D _10666_/CLK _10637_/Q VDD VDD VSS VSS gf180mcu_fd_sc_mcu7t5v0__dffq_1
X_10568_ _10568_/D _10666_/CLK _10568_/Q VDD VDD VSS VSS gf180mcu_fd_sc_mcu7t5v0__dffq_1
X_10499_ _10499_/D _11109_/CLK _10499_/Q VDD VDD VSS VSS gf180mcu_fd_sc_mcu7t5v0__dffq_1
X_04991_ _10329_/Q _08673_/A1 VDD VDD VSS VSS gf180mcu_fd_sc_mcu7t5v0__inv_1
X_06730_ _10004_/Q _06823_/A1 _06735_/B1 VDD VDD VSS VSS gf180mcu_fd_sc_mcu7t5v0__nor2_1
X_06661_ _10003_/Q _06661_/A2 _06661_/A3 _06704_/A2 VDD VDD VSS VSS
+ gf180mcu_fd_sc_mcu7t5v0__nand3_1
X_08400_ _09289_/B2 _08585_/A2 _08581_/A2 _09279_/B2 _08401_/C VDD VDD
+ VSS VSS gf180mcu_fd_sc_mcu7t5v0__oai22_1
X_05612_ _10847_/Q _09378_/B2 VDD VDD VSS VSS gf180mcu_fd_sc_mcu7t5v0__clkinv_1
X_09380_ _09945_/A1 _09381_/A2 _09381_/B1 _09380_/B2 _10849_/D VDD VDD
+ VSS VSS gf180mcu_fd_sc_mcu7t5v0__oai22_1
X_06592_ _10001_/Q _06661_/A2 _06661_/A3 _06627_/A1 VDD VDD VSS VSS
+ gf180mcu_fd_sc_mcu7t5v0__nand3_2
X_05543_ _10607_/Q _09078_/B2 VDD VDD VSS VSS gf180mcu_fd_sc_mcu7t5v0__clkinv_1
X_08331_ _10102_/Q _08586_/A2 _08529_/B1 _10195_/Q _08333_/A2 VDD VDD
+ VSS VSS gf180mcu_fd_sc_mcu7t5v0__aoi22_1
X_05474_ _10342_/Q _08705_/B2 VDD VDD VSS VSS gf180mcu_fd_sc_mcu7t5v0__clkinv_1
X_08262_ _08927_/B2 _08585_/A2 _08581_/A2 _08937_/B2 _08263_/C VDD VDD
+ VSS VSS gf180mcu_fd_sc_mcu7t5v0__oai22_1
X_07213_ _07213_/A1 _07213_/A2 _07213_/B _07237_/A2 VDD VDD VSS VSS
+ gf180mcu_fd_sc_mcu7t5v0__oai21_1
X_08193_ _10101_/Q _08586_/A2 _08529_/B1 _10194_/Q _08195_/A2 VDD VDD
+ VSS VSS gf180mcu_fd_sc_mcu7t5v0__aoi22_1
X_07144_ _07093_/I _07144_/A2 _07141_/Z _07144_/Z VDD VDD VSS VSS
+ gf180mcu_fd_sc_mcu7t5v0__xor3_1
X_07075_ _10001_/Q _07075_/A2 _07199_/A1 _07163_/A1 VDD VDD VSS VSS
+ gf180mcu_fd_sc_mcu7t5v0__nand3_1
X_06026_ _10314_/Q _08620_/A2 _10312_/Q _08628_/A1 VDD VDD VSS VSS
+ gf180mcu_fd_sc_mcu7t5v0__nand3_1
X_07977_ _07977_/A1 _07977_/A2 _07977_/A3 _08012_/B2 VDD VDD VSS VSS
+ gf180mcu_fd_sc_mcu7t5v0__nand3_1
X_09716_ _11060_/Q _09716_/A2 _09721_/A2 VDD VDD VSS VSS gf180mcu_fd_sc_mcu7t5v0__nand2_1
X_06928_ _10081_/Q _07070_/A1 _07216_/A2 VDD VDD VSS VSS gf180mcu_fd_sc_mcu7t5v0__nor2_4
X_09647_ _06047_/Z _09661_/A2 _09647_/B _11035_/D VDD VDD VSS VSS
+ gf180mcu_fd_sc_mcu7t5v0__oai21_1
X_06859_ _06859_/A1 _06859_/A2 _06858_/Z _06859_/Z VDD VDD VSS VSS
+ gf180mcu_fd_sc_mcu7t5v0__xor3_1
X_09578_ _09927_/A2 _09662_/A2 _09587_/A2 VDD VDD VSS VSS gf180mcu_fd_sc_mcu7t5v0__nand2_4
X_08529_ _10105_/Q _08586_/A2 _08529_/B1 _10198_/Q _08531_/A2 VDD VDD
+ VSS VSS gf180mcu_fd_sc_mcu7t5v0__aoi22_1
X_10422_ _10422_/D _11142_/CLK _10422_/Q VDD VDD VSS VSS gf180mcu_fd_sc_mcu7t5v0__dffq_1
X_10353_ _10353_/D _11147_/CLK _10353_/Q VDD VDD VSS VSS gf180mcu_fd_sc_mcu7t5v0__dffq_1
X_10284_ _10284_/D _11139_/CLK _10284_/Q VDD VDD VSS VSS gf180mcu_fd_sc_mcu7t5v0__dffq_1
X_05190_ _10859_/Q _09394_/B2 VDD VDD VSS VSS gf180mcu_fd_sc_mcu7t5v0__clkinv_1
X_08880_ _10460_/Q _08892_/A2 _08881_/B VDD VDD VSS VSS gf180mcu_fd_sc_mcu7t5v0__nand2_1
X_07900_ bus_wdata[4] _07905_/A2 _08654_/B _07901_/B VDD VDD VSS VSS
+ gf180mcu_fd_sc_mcu7t5v0__oai21_1
X_07831_ _07831_/I _07906_/A3 VDD VDD VSS VSS gf180mcu_fd_sc_mcu7t5v0__clkinv_3
X_09501_ _09832_/A1 _09501_/A2 _09501_/B1 _09501_/B2 _10946_/D VDD VDD
+ VSS VSS gf180mcu_fd_sc_mcu7t5v0__oai22_1
X_07762_ _06047_/Z _07769_/A2 _07769_/B1 _07762_/B2 _10199_/D VDD VDD
+ VSS VSS gf180mcu_fd_sc_mcu7t5v0__oai22_1
X_04974_ _11095_/Q _09806_/A1 VDD VDD VSS VSS gf180mcu_fd_sc_mcu7t5v0__clkinv_1
X_06713_ _06714_/A1 _06708_/Z _06760_/A2 _06713_/Z VDD VDD VSS VSS
+ gf180mcu_fd_sc_mcu7t5v0__or3_1
X_07693_ _06061_/Z _07699_/A2 _07693_/B _10155_/D VDD VDD VSS VSS
+ gf180mcu_fd_sc_mcu7t5v0__oai21_1
X_09432_ _09851_/A1 _09823_/A2 _09441_/A2 VDD VDD VSS VSS gf180mcu_fd_sc_mcu7t5v0__nand2_4
X_06644_ _06832_/A1 _06704_/A1 _06644_/B1 _06644_/B2 _06645_/C VDD VDD
+ VSS VSS gf180mcu_fd_sc_mcu7t5v0__oai22_1
X_09363_ _09599_/A1 _09371_/A2 _09371_/B1 VDD VDD VSS VSS gf180mcu_fd_sc_mcu7t5v0__nand2_2
X_06575_ _10042_/Q _06732_/A1 _06873_/B VDD VDD VSS VSS gf180mcu_fd_sc_mcu7t5v0__nor2_2
X_05526_ _10927_/Q _09478_/B2 VDD VDD VSS VSS gf180mcu_fd_sc_mcu7t5v0__clkinv_1
X_08314_ _10423_/Q _08591_/A2 _07680_/I _10375_/Q _06125_/I _11047_/Q _08317_/A1 VDD
+ VDD VSS VSS gf180mcu_fd_sc_mcu7t5v0__aoi222_2
X_09294_ _06047_/Z _09301_/A2 _09301_/B1 _09294_/B2 _10779_/D VDD VDD
+ VSS VSS gf180mcu_fd_sc_mcu7t5v0__oai22_1
X_08245_ _08805_/B2 _08542_/A2 _08581_/A2 _09237_/B2 _08246_/C VDD VDD
+ VSS VSS gf180mcu_fd_sc_mcu7t5v0__oai22_1
X_05457_ _10422_/Q _08805_/B2 VDD VDD VSS VSS gf180mcu_fd_sc_mcu7t5v0__clkinv_1
X_05388_ _10749_/Q _09256_/B2 VDD VDD VSS VSS gf180mcu_fd_sc_mcu7t5v0__clkinv_1
X_08176_ _10637_/Q _08584_/A2 _08584_/B1 _10661_/Q _08179_/A1 VDD VDD
+ VSS VSS gf180mcu_fd_sc_mcu7t5v0__aoi22_1
X_07127_ _10002_/Q _07199_/A1 _07231_/A2 VDD VDD VSS VSS gf180mcu_fd_sc_mcu7t5v0__nand2_1
X_07058_ _10003_/Q _07223_/A2 _07062_/B2 VDD VDD VSS VSS gf180mcu_fd_sc_mcu7t5v0__nor2_1
X_06009_ _10286_/Q _07829_/C _06011_/B VDD VDD VSS VSS gf180mcu_fd_sc_mcu7t5v0__nand2_1
X_10971_ _10971_/D _10978_/CLK _10971_/Q VDD VDD VSS VSS gf180mcu_fd_sc_mcu7t5v0__dffq_1
X_10405_ _10405_/D _11139_/CLK _10405_/Q VDD VDD VSS VSS gf180mcu_fd_sc_mcu7t5v0__dffq_1
X_10336_ _10336_/D _11150_/CLK _10336_/Q VDD VDD VSS VSS gf180mcu_fd_sc_mcu7t5v0__dffq_1
X_10267_ _10267_/D _11150_/CLK _10267_/Q VDD VDD VSS VSS gf180mcu_fd_sc_mcu7t5v0__dffq_1
X_10198_ _10198_/D _11097_/CLK _10198_/Q VDD VDD VSS VSS gf180mcu_fd_sc_mcu7t5v0__dffq_1
X_06360_ _06379_/A1 _06358_/Z _06361_/A2 VDD VDD VSS VSS gf180mcu_fd_sc_mcu7t5v0__nand2_1
X_05311_ _10381_/Q _08754_/B2 VDD VDD VSS VSS gf180mcu_fd_sc_mcu7t5v0__clkinv_1
X_06291_ _06327_/B _06275_/Z _06291_/B _07601_/B _06292_/B VDD VDD VSS
+ VSS gf180mcu_fd_sc_mcu7t5v0__aoi211_1
X_05242_ _10732_/Q _09235_/B2 VDD VDD VSS VSS gf180mcu_fd_sc_mcu7t5v0__clkinv_1
X_08030_ _08327_/B2 _08030_/A2 _08030_/B1 _08345_/A1 _08030_/C1 _08345_/B2 _08102_/A2
+ VDD VDD VSS VSS gf180mcu_fd_sc_mcu7t5v0__aoi222_1
X_05173_ _10915_/Q _09464_/B2 VDD VDD VSS VSS gf180mcu_fd_sc_mcu7t5v0__clkinv_1
X_09981_ _09981_/D _11164_/CLK _09981_/Q VDD VDD VSS VSS gf180mcu_fd_sc_mcu7t5v0__dffq_1
X_08932_ _09851_/A1 _09917_/A2 _08941_/A2 VDD VDD VSS VSS gf180mcu_fd_sc_mcu7t5v0__nand2_4
X_08863_ _10454_/Q _08859_/Z _08872_/B _08864_/A2 VDD VDD VSS VSS
+ gf180mcu_fd_sc_mcu7t5v0__oai21_1
X_08794_ _09921_/A1 _08799_/A2 _08799_/B1 _08794_/B2 _10413_/D VDD VDD
+ VSS VSS gf180mcu_fd_sc_mcu7t5v0__oai22_1
X_07814_ _10233_/Q _07824_/A2 _07815_/B VDD VDD VSS VSS gf180mcu_fd_sc_mcu7t5v0__nand2_1
X_07745_ _06061_/Z _07748_/A2 _07748_/B1 _07745_/B2 _10187_/D VDD VDD
+ VSS VSS gf180mcu_fd_sc_mcu7t5v0__oai22_1
X_09415_ _09920_/A1 _09421_/A2 _09421_/B1 _09415_/B2 _10876_/D VDD VDD
+ VSS VSS gf180mcu_fd_sc_mcu7t5v0__oai22_1
X_07676_ _09924_/A1 _07678_/A2 _07678_/B1 _07676_/B2 _10148_/D VDD VDD
+ VSS VSS gf180mcu_fd_sc_mcu7t5v0__oai22_1
X_06627_ _06627_/A1 _06622_/Z _06627_/A3 _06629_/A2 VDD VDD VSS VSS
+ gf180mcu_fd_sc_mcu7t5v0__xnor3_1
X_09346_ _09893_/A1 _09351_/A2 _09351_/B1 _09346_/B2 _10821_/D VDD VDD
+ VSS VSS gf180mcu_fd_sc_mcu7t5v0__oai22_1
X_06558_ _06700_/A2 _06700_/A3 _06804_/A3 VDD VDD VSS VSS gf180mcu_fd_sc_mcu7t5v0__nand2_2
X_09277_ _06058_/Z _09281_/A2 _09281_/B1 _09277_/B2 _10766_/D VDD VDD
+ VSS VSS gf180mcu_fd_sc_mcu7t5v0__oai22_1
X_05509_ _10870_/Q _09407_/B2 VDD VDD VSS VSS gf180mcu_fd_sc_mcu7t5v0__clkinv_1
X_06489_ _06493_/A2 _06482_/Z _06489_/A3 _06489_/Z VDD VDD VSS VSS
+ gf180mcu_fd_sc_mcu7t5v0__xor3_1
X_08228_ _08228_/A1 _08228_/A2 _08228_/A3 _08269_/A2 VDD VDD VSS VSS
+ gf180mcu_fd_sc_mcu7t5v0__nand3_1
X_08159_ _09376_/B2 _08587_/B1 _08581_/A2 _09356_/B2 _08160_/C VDD VDD
+ VSS VSS gf180mcu_fd_sc_mcu7t5v0__oai22_1
X_11170_ _11170_/D _11181_/CLK _11170_/Q VDD VDD VSS VSS gf180mcu_fd_sc_mcu7t5v0__dffq_1
X_10121_ _10121_/D _10327_/CLK _10121_/Q VDD VDD VSS VSS gf180mcu_fd_sc_mcu7t5v0__dffq_2
X_10052_ _10052_/D _11039_/CLK _10052_/Q VDD VDD VSS VSS gf180mcu_fd_sc_mcu7t5v0__dffq_1
X_10954_ _10954_/D _11149_/CLK _10954_/Q VDD VDD VSS VSS gf180mcu_fd_sc_mcu7t5v0__dffq_1
X_10885_ _10885_/D _11147_/CLK _10885_/Q VDD VDD VSS VSS gf180mcu_fd_sc_mcu7t5v0__dffq_1
X_10319_ _10319_/D _11052_/CLK _10319_/Q VDD VDD VSS VSS gf180mcu_fd_sc_mcu7t5v0__dffq_1
X_05860_ _10602_/Q _09071_/B2 VDD VDD VSS VSS gf180mcu_fd_sc_mcu7t5v0__clkinv_1
X_05791_ _10353_/Q _08718_/B2 VDD VDD VSS VSS gf180mcu_fd_sc_mcu7t5v0__clkinv_1
X_07530_ _07530_/A1 _07528_/Z _07530_/Z VDD VDD VSS VSS gf180mcu_fd_sc_mcu7t5v0__xor2_1
X_07461_ _07461_/A1 _07461_/A2 _07461_/B _07505_/A1 VDD VDD VSS VSS
+ gf180mcu_fd_sc_mcu7t5v0__aoi21_1
X_06412_ _06502_/B _06439_/A2 _06412_/B _06462_/A1 VDD VDD VSS VSS
+ gf180mcu_fd_sc_mcu7t5v0__aoi21_1
X_07392_ _10325_/Q _10084_/Q _10047_/Q _10333_/Q _10118_/Q _10117_/Q _07393_/I VDD
+ VDD VSS VSS gf180mcu_fd_sc_mcu7t5v0__mux4_4
X_09200_ _09897_/A1 _09201_/A2 _09201_/B1 _09200_/B2 _10705_/D VDD VDD
+ VSS VSS gf180mcu_fd_sc_mcu7t5v0__oai22_1
X_09131_ _09946_/A1 _09131_/A2 _09131_/B1 _09131_/B2 _10650_/D VDD VDD
+ VSS VSS gf180mcu_fd_sc_mcu7t5v0__oai22_1
X_06343_ _10001_/Q _06484_/A2 _06439_/A2 _10000_/Q _06380_/A2 VDD VDD
+ VSS VSS gf180mcu_fd_sc_mcu7t5v0__aoi22_1
X_09062_ _09927_/A2 _09062_/A2 _09071_/A2 VDD VDD VSS VSS gf180mcu_fd_sc_mcu7t5v0__nand2_4
X_06274_ _06274_/A1 _06274_/A2 _06274_/B _06294_/A2 VDD VDD VSS VSS
+ gf180mcu_fd_sc_mcu7t5v0__aoi21_1
X_08013_ _09900_/A2 _08013_/A2 _09332_/A2 _08013_/B2 _08013_/C1 _09889_/A2 _08014_/A2
+ VDD VDD VSS VSS gf180mcu_fd_sc_mcu7t5v0__aoi222_1
X_05225_ _10604_/Q _09075_/B2 VDD VDD VSS VSS gf180mcu_fd_sc_mcu7t5v0__clkinv_1
X_05156_ _10339_/Q _08702_/B2 VDD VDD VSS VSS gf180mcu_fd_sc_mcu7t5v0__clkinv_1
X_05087_ _10411_/Q _08792_/B2 VDD VDD VSS VSS gf180mcu_fd_sc_mcu7t5v0__clkinv_1
X_09964_ _09964_/D _11181_/CLK _09964_/Q VDD VDD VSS VSS gf180mcu_fd_sc_mcu7t5v0__dffq_1
X_09895_ _06061_/Z _09898_/A2 _09898_/B1 _09895_/B2 _11146_/D VDD VDD
+ VSS VSS gf180mcu_fd_sc_mcu7t5v0__oai22_1
X_08915_ _06061_/Z _08921_/A2 _08915_/B _10479_/D VDD VDD VSS VSS
+ gf180mcu_fd_sc_mcu7t5v0__oai21_1
X_08846_ _08831_/I _08846_/A2 _08845_/Z _10448_/D VDD VDD VSS VSS
+ gf180mcu_fd_sc_mcu7t5v0__nor3_1
X_08777_ _09896_/A1 _08779_/A2 _08779_/B1 _08777_/B2 _10400_/D VDD VDD
+ VSS VSS gf180mcu_fd_sc_mcu7t5v0__oai22_1
X_05989_ _10280_/Q _07829_/C _05993_/C VDD VDD VSS VSS gf180mcu_fd_sc_mcu7t5v0__nand2_1
X_07728_ _08534_/A1 _08102_/A1 _09568_/A2 VDD VDD VSS VSS gf180mcu_fd_sc_mcu7t5v0__nor2_4
X_07659_ _08658_/B _07667_/A2 _07667_/B1 VDD VDD VSS VSS gf180mcu_fd_sc_mcu7t5v0__nand2_2
X_10670_ _10670_/D _11139_/CLK _10670_/Q VDD VDD VSS VSS gf180mcu_fd_sc_mcu7t5v0__dffq_1
X_09329_ _09924_/A1 _09331_/A2 _09331_/B1 _09329_/B2 _10808_/D VDD VDD
+ VSS VSS gf180mcu_fd_sc_mcu7t5v0__oai22_1
X_11153_ _11153_/D _11163_/CLK _11153_/Q VDD VDD VSS VSS gf180mcu_fd_sc_mcu7t5v0__dffq_1
X_11084_ _11084_/D _11097_/CLK _11084_/Q VDD VDD VSS VSS gf180mcu_fd_sc_mcu7t5v0__dffq_1
X_10104_ _10104_/D _11052_/CLK _10104_/Q VDD VDD VSS VSS gf180mcu_fd_sc_mcu7t5v0__dffq_1
X_10035_ _10035_/D _11181_/CLK _10035_/Q VDD VDD VSS VSS gf180mcu_fd_sc_mcu7t5v0__dffq_1
X_10937_ _10937_/D _11149_/CLK _10937_/Q VDD VDD VSS VSS gf180mcu_fd_sc_mcu7t5v0__dffq_1
X_10868_ _10868_/D _11138_/CLK _10868_/Q VDD VDD VSS VSS gf180mcu_fd_sc_mcu7t5v0__dffq_1
X_10799_ _10799_/D _11010_/CLK _10799_/Q VDD VDD VSS VSS gf180mcu_fd_sc_mcu7t5v0__dffq_1
X_05010_ _10273_/Q _08632_/A1 VDD VDD VSS VSS gf180mcu_fd_sc_mcu7t5v0__clkinv_1
X_06961_ _07379_/A1 _07222_/A2 _06972_/A1 VDD VDD VSS VSS gf180mcu_fd_sc_mcu7t5v0__nand2_1
X_05912_ _10962_/Q _09521_/B2 VDD VDD VSS VSS gf180mcu_fd_sc_mcu7t5v0__clkinv_1
X_08700_ _09645_/A2 _09889_/A2 _08709_/A2 VDD VDD VSS VSS gf180mcu_fd_sc_mcu7t5v0__nand2_4
X_09680_ _11053_/Q _10289_/Q _09680_/B _09682_/A2 VDD VDD VSS VSS
+ gf180mcu_fd_sc_mcu7t5v0__aoi21_1
X_08631_ _08626_/Z _08657_/B1 _08659_/A1 VDD VDD VSS VSS gf180mcu_fd_sc_mcu7t5v0__nand2_4
X_06892_ _06047_/Z _06899_/A2 _06899_/B1 _06892_/B2 _10061_/D VDD VDD
+ VSS VSS gf180mcu_fd_sc_mcu7t5v0__oai22_1
X_05843_ _10946_/Q _09501_/B2 VDD VDD VSS VSS gf180mcu_fd_sc_mcu7t5v0__clkinv_1
X_05774_ _11049_/Q _09670_/B2 VDD VDD VSS VSS gf180mcu_fd_sc_mcu7t5v0__clkinv_1
X_08562_ _08562_/A1 _08562_/A2 _08562_/A3 _08572_/A2 VDD VDD VSS VSS
+ gf180mcu_fd_sc_mcu7t5v0__nand3_1
X_07513_ _07513_/A1 _07614_/A1 _07515_/A2 VDD VDD VSS VSS gf180mcu_fd_sc_mcu7t5v0__xnor2_1
X_08493_ _10096_/Q _08532_/A2 _08563_/C1 _10157_/Q _08494_/I VDD VDD VSS
+ VSS gf180mcu_fd_sc_mcu7t5v0__aoi22_1
X_07444_ _07444_/A1 _07444_/A2 _07461_/B VDD VDD VSS VSS gf180mcu_fd_sc_mcu7t5v0__nor2_1
X_07375_ _07471_/A1 _07471_/A2 _07471_/B _10001_/Q _07401_/A1 VDD VDD
+ VSS VSS gf180mcu_fd_sc_mcu7t5v0__oai211_4
X_09114_ _06047_/Z _09121_/A2 _09121_/B1 _09114_/B2 _10635_/D VDD VDD
+ VSS VSS gf180mcu_fd_sc_mcu7t5v0__oai22_1
X_06326_ _06372_/B2 _06441_/A1 _06372_/C _06328_/B1 VDD VDD VSS VSS
+ gf180mcu_fd_sc_mcu7t5v0__aoi21_1
X_09045_ _09920_/A1 _09051_/A2 _09051_/B1 _09045_/B2 _10580_/D VDD VDD
+ VSS VSS gf180mcu_fd_sc_mcu7t5v0__oai22_1
X_06257_ _10008_/Q _06257_/A2 _06256_/Z _06274_/A2 VDD VDD VSS VSS
+ gf180mcu_fd_sc_mcu7t5v0__nand3_1
X_05208_ _10924_/Q _09475_/B2 VDD VDD VSS VSS gf180mcu_fd_sc_mcu7t5v0__clkinv_1
X_06188_ _07470_/A1 _08675_/A2 _06188_/B _10004_/D VDD VDD VSS VSS
+ gf180mcu_fd_sc_mcu7t5v0__aoi21_1
X_05139_ _10419_/Q _08802_/B2 VDD VDD VSS VSS gf180mcu_fd_sc_mcu7t5v0__clkinv_1
X_09947_ _09947_/D _11039_/CLK _09947_/Q VDD VDD VSS VSS gf180mcu_fd_sc_mcu7t5v0__dffq_1
X_09878_ _09941_/A1 _09888_/A2 _09878_/B _11136_/D VDD VDD VSS VSS
+ gf180mcu_fd_sc_mcu7t5v0__oai21_1
X_08829_ _09832_/A1 _08829_/A2 _08829_/B1 _08829_/B2 _10442_/D VDD VDD
+ VSS VSS gf180mcu_fd_sc_mcu7t5v0__oai22_1
X_10722_ _10722_/D _10905_/CLK _10722_/Q VDD VDD VSS VSS gf180mcu_fd_sc_mcu7t5v0__dffq_1
X_10653_ _10653_/D _10978_/CLK _10653_/Q VDD VDD VSS VSS gf180mcu_fd_sc_mcu7t5v0__dffq_1
X_10584_ _10584_/D _11138_/CLK _10584_/Q VDD VDD VSS VSS gf180mcu_fd_sc_mcu7t5v0__dffq_1
X_11136_ _11136_/D _11139_/CLK _11136_/Q VDD VDD VSS VSS gf180mcu_fd_sc_mcu7t5v0__dffq_1
X_11067_ _11067_/D _11082_/CLK _11067_/Q VDD VDD VSS VSS gf180mcu_fd_sc_mcu7t5v0__dffq_1
X_10018_ _10018_/D _10905_/CLK _10018_/Q VDD VDD VSS VSS gf180mcu_fd_sc_mcu7t5v0__dffq_1
X_05490_ _10934_/Q _09487_/B2 VDD VDD VSS VSS gf180mcu_fd_sc_mcu7t5v0__clkinv_1
X_07160_ _07019_/C _07147_/Z _07160_/B _07636_/B _07161_/A2 VDD VDD VSS
+ VSS gf180mcu_fd_sc_mcu7t5v0__oai211_1
X_06111_ _06021_/Z _06110_/Z _08528_/B1 VDD VDD VSS VSS gf180mcu_fd_sc_mcu7t5v0__nor2_4
X_07091_ _07091_/I _07094_/A2 VDD VDD VSS VSS gf180mcu_fd_sc_mcu7t5v0__clkinv_1
X_06042_ _06145_/A1 _06146_/A2 _08533_/B2 VDD VDD VSS VSS gf180mcu_fd_sc_mcu7t5v0__nand2_4
X_09801_ _11094_/Q _09817_/A2 _09809_/B _09802_/B VDD VDD VSS VSS
+ gf180mcu_fd_sc_mcu7t5v0__oai21_1
X_07993_ _07993_/A1 _07993_/A2 _07993_/A3 _08012_/C1 VDD VDD VSS VSS
+ gf180mcu_fd_sc_mcu7t5v0__nand3_2
X_09732_ _09732_/A1 _09731_/Z _09733_/A2 VDD VDD VSS VSS gf180mcu_fd_sc_mcu7t5v0__nand2_1
X_06944_ _07014_/A1 _07247_/I0 _06951_/B _07246_/A1 VDD VDD VSS VSS
+ gf180mcu_fd_sc_mcu7t5v0__nor3_4
X_09663_ _09852_/A1 _09671_/A2 _09671_/B1 VDD VDD VSS VSS gf180mcu_fd_sc_mcu7t5v0__nand2_2
X_06875_ _06834_/C _06875_/A2 _07601_/B _06876_/B2 VDD VDD VSS VSS
+ gf180mcu_fd_sc_mcu7t5v0__aoi21_1
X_08614_ _06058_/Z _08618_/A2 _08618_/B1 _08614_/B2 _10307_/D VDD VDD
+ VSS VSS gf180mcu_fd_sc_mcu7t5v0__oai22_1
X_05826_ _10865_/Q _09400_/B2 VDD VDD VSS VSS gf180mcu_fd_sc_mcu7t5v0__clkinv_1
X_09594_ _06061_/Z _09597_/A2 _09597_/B1 _09594_/B2 _11007_/D VDD VDD
+ VSS VSS gf180mcu_fd_sc_mcu7t5v0__oai22_1
X_08545_ _10978_/Q _08555_/A2 _08584_/A2 _10922_/Q _08548_/A1 VDD VDD
+ VSS VSS gf180mcu_fd_sc_mcu7t5v0__aoi22_1
X_05757_ _10625_/Q _09100_/B2 VDD VDD VSS VSS gf180mcu_fd_sc_mcu7t5v0__clkinv_1
X_05688_ _10220_/Q _07795_/B2 VDD VDD VSS VSS gf180mcu_fd_sc_mcu7t5v0__clkinv_1
X_08476_ _10673_/Q _08580_/A2 _09872_/A1 _10697_/Q _08476_/C1 _10409_/Q _08477_/A3
+ VDD VDD VSS VSS gf180mcu_fd_sc_mcu7t5v0__aoi222_2
X_07427_ _10326_/Q _10085_/Q _10048_/Q _10334_/Q _10118_/Q _10117_/Q _07428_/I VDD
+ VDD VSS VSS gf180mcu_fd_sc_mcu7t5v0__mux4_4
X_07358_ _07358_/A1 _07601_/B _07603_/B _07358_/C _10119_/D VDD VDD VSS
+ VSS gf180mcu_fd_sc_mcu7t5v0__aoi211_1
X_06309_ _06310_/A2 _06310_/A3 _06335_/A2 VDD VDD VSS VSS gf180mcu_fd_sc_mcu7t5v0__nor2_1
X_07289_ _09884_/A1 _07293_/A2 _07289_/B _10103_/D VDD VDD VSS VSS
+ gf180mcu_fd_sc_mcu7t5v0__oai21_1
X_09028_ _06061_/Z _09031_/A2 _09031_/B1 _09028_/B2 _10567_/D VDD VDD
+ VSS VSS gf180mcu_fd_sc_mcu7t5v0__oai22_1
X_10705_ _10705_/D _10905_/CLK _10705_/Q VDD VDD VSS VSS gf180mcu_fd_sc_mcu7t5v0__dffq_1
X_10636_ _10636_/D _10666_/CLK _10636_/Q VDD VDD VSS VSS gf180mcu_fd_sc_mcu7t5v0__dffq_1
X_10567_ _10567_/D _10666_/CLK _10567_/Q VDD VDD VSS VSS gf180mcu_fd_sc_mcu7t5v0__dffq_1
X_10498_ _10498_/D _11165_/CLK _10498_/Q VDD VDD VSS VSS gf180mcu_fd_sc_mcu7t5v0__dffq_1
X_11119_ _11119_/D _11142_/CLK _11119_/Q VDD VDD VSS VSS gf180mcu_fd_sc_mcu7t5v0__dffq_1
X_04990_ _10330_/Q _08675_/A1 VDD VDD VSS VSS gf180mcu_fd_sc_mcu7t5v0__clkinv_1
X_06660_ _10003_/Q _06700_/A2 _06700_/A3 _06664_/A3 VDD VDD VSS VSS
+ gf180mcu_fd_sc_mcu7t5v0__nand3_2
X_05611_ _10839_/Q _09368_/B2 VDD VDD VSS VSS gf180mcu_fd_sc_mcu7t5v0__clkinv_1
X_06591_ _06661_/A2 _06661_/A3 _06804_/A4 VDD VDD VSS VSS gf180mcu_fd_sc_mcu7t5v0__nand2_2
X_05542_ _10599_/Q _09068_/B2 VDD VDD VSS VSS gf180mcu_fd_sc_mcu7t5v0__clkinv_1
X_08330_ _10211_/Q _08528_/A2 _08528_/B1 _10171_/Q _08333_/A1 VDD VDD
+ VSS VSS gf180mcu_fd_sc_mcu7t5v0__aoi22_1
X_05473_ _10350_/Q _08715_/B2 VDD VDD VSS VSS gf180mcu_fd_sc_mcu7t5v0__clkinv_1
X_08261_ _10470_/Q _08591_/C1 _08591_/B1 _10430_/Q _08264_/A2 VDD VDD
+ VSS VSS gf180mcu_fd_sc_mcu7t5v0__aoi22_1
X_07212_ _07603_/B _07212_/A2 _10088_/D VDD VDD VSS VSS gf180mcu_fd_sc_mcu7t5v0__nor2_1
X_08192_ _10210_/Q _08528_/A2 _08528_/B1 _10170_/Q _08195_/A1 VDD VDD
+ VSS VSS gf180mcu_fd_sc_mcu7t5v0__aoi22_1
X_07143_ _07143_/A1 _07143_/A2 _07143_/A3 _07141_/Z _07214_/A1 VDD VDD
+ VSS VSS gf180mcu_fd_sc_mcu7t5v0__nand4_2
X_07074_ _10001_/Q _07199_/A1 _07128_/A1 VDD VDD VSS VSS gf180mcu_fd_sc_mcu7t5v0__nand2_1
X_06025_ _08620_/A2 _10312_/Q _08629_/A2 VDD VDD VSS VSS gf180mcu_fd_sc_mcu7t5v0__nand2_1
X_07976_ _10819_/Q _08555_/A2 _08584_/B1 _10875_/Q _07977_/A3 VDD VDD
+ VSS VSS gf180mcu_fd_sc_mcu7t5v0__aoi22_1
X_09715_ _09715_/I _11059_/D VDD VDD VSS VSS gf180mcu_fd_sc_mcu7t5v0__clkinv_1
X_06927_ _07122_/B _08675_/A2 _06927_/B _10081_/D VDD VDD VSS VSS
+ gf180mcu_fd_sc_mcu7t5v0__aoi21_1
X_09646_ _11035_/Q _09660_/A2 _09647_/B VDD VDD VSS VSS gf180mcu_fd_sc_mcu7t5v0__nand2_1
X_06858_ _06858_/A1 _06856_/Z _06857_/Z _06858_/Z VDD VDD VSS VSS
+ gf180mcu_fd_sc_mcu7t5v0__xor3_1
X_09577_ _09832_/A1 _09577_/A2 _09577_/B1 _09577_/B2 _10994_/D VDD VDD
+ VSS VSS gf180mcu_fd_sc_mcu7t5v0__oai22_1
X_05809_ _10921_/Q _09470_/B2 VDD VDD VSS VSS gf180mcu_fd_sc_mcu7t5v0__clkinv_1
X_06789_ _10014_/Q _06843_/A2 _06843_/B1 _10125_/Q _06790_/A2 VDD VDD
+ VSS VSS gf180mcu_fd_sc_mcu7t5v0__aoi22_1
X_08528_ _10214_/Q _08528_/A2 _08528_/B1 _10174_/Q _08531_/A1 VDD VDD
+ VSS VSS gf180mcu_fd_sc_mcu7t5v0__aoi22_1
X_08459_ _10561_/Q _06023_/I _08582_/A2 _10593_/Q _08584_/B1 _10601_/Q _08461_/A2
+ VDD VDD VSS VSS gf180mcu_fd_sc_mcu7t5v0__aoi222_2
X_10421_ _10421_/D _11142_/CLK _10421_/Q VDD VDD VSS VSS gf180mcu_fd_sc_mcu7t5v0__dffq_1
X_10352_ _10352_/D _11147_/CLK _10352_/Q VDD VDD VSS VSS gf180mcu_fd_sc_mcu7t5v0__dffq_1
X_10283_ _10283_/D _11150_/CLK _10283_/Q VDD VDD VSS VSS gf180mcu_fd_sc_mcu7t5v0__dffq_1
X_10619_ _10619_/D _10978_/CLK _10619_/Q VDD VDD VSS VSS gf180mcu_fd_sc_mcu7t5v0__dffq_1
X_07830_ bus_addr[4] bus_we _07828_/Z _07830_/A4 _07831_/I VDD VDD VSS
+ VSS gf180mcu_fd_sc_mcu7t5v0__nand4_4
X_07761_ _09852_/A1 _07769_/A2 _07769_/B1 VDD VDD VSS VSS gf180mcu_fd_sc_mcu7t5v0__nand2_2
X_09500_ _09897_/A1 _09501_/A2 _09501_/B1 _09500_/B2 _10945_/D VDD VDD
+ VSS VSS gf180mcu_fd_sc_mcu7t5v0__oai22_1
X_06712_ _06714_/A1 _06712_/A2 _06817_/A1 VDD VDD VSS VSS gf180mcu_fd_sc_mcu7t5v0__nor2_1
X_04973_ _11096_/Q _09808_/A1 VDD VDD VSS VSS gf180mcu_fd_sc_mcu7t5v0__clkinv_1
X_07692_ _10155_/Q _07698_/A2 _07693_/B VDD VDD VSS VSS gf180mcu_fd_sc_mcu7t5v0__nand2_1
X_09431_ _09926_/A1 _09431_/A2 _09431_/B1 _09431_/B2 _10890_/D VDD VDD
+ VSS VSS gf180mcu_fd_sc_mcu7t5v0__oai22_1
X_06643_ _06872_/I1 _06704_/A1 _06873_/B _06644_/B1 VDD VDD VSS VSS
+ gf180mcu_fd_sc_mcu7t5v0__aoi21_1
X_09362_ _09502_/A1 _09412_/A2 _09371_/A2 VDD VDD VSS VSS gf180mcu_fd_sc_mcu7t5v0__nand2_4
X_06574_ _06578_/A1 _06732_/A1 _06873_/A2 VDD VDD VSS VSS gf180mcu_fd_sc_mcu7t5v0__nor2_2
X_05525_ _10943_/Q _09498_/B2 VDD VDD VSS VSS gf180mcu_fd_sc_mcu7t5v0__clkinv_1
X_08313_ _08313_/A1 _08313_/A2 _08313_/A3 _08328_/A2 VDD VDD VSS VSS
+ gf180mcu_fd_sc_mcu7t5v0__nand3_1
X_09293_ _09433_/A1 _09301_/A2 _09301_/B1 VDD VDD VSS VSS gf180mcu_fd_sc_mcu7t5v0__nand2_4
X_05456_ _11046_/Q _09667_/B2 VDD VDD VSS VSS gf180mcu_fd_sc_mcu7t5v0__clkinv_1
X_08244_ _08244_/A1 _08244_/A2 _08244_/A3 _08267_/A2 VDD VDD VSS VSS
+ gf180mcu_fd_sc_mcu7t5v0__nand3_2
X_05387_ _11128_/Q _09865_/B2 VDD VDD VSS VSS gf180mcu_fd_sc_mcu7t5v0__clkinv_1
X_08175_ _08175_/A1 _08175_/A2 _08175_/A3 _08180_/A2 VDD VDD VSS VSS
+ gf180mcu_fd_sc_mcu7t5v0__nand3_1
X_07126_ _10002_/Q _07223_/A2 _07128_/A2 VDD VDD VSS VSS gf180mcu_fd_sc_mcu7t5v0__nand2_1
X_07057_ _07109_/A2 _07057_/A2 _07057_/Z VDD VDD VSS VSS gf180mcu_fd_sc_mcu7t5v0__or2_1
X_06008_ _09728_/A1 _06008_/A2 _06008_/B bus_rdata[5] VDD VDD VSS VSS
+ gf180mcu_fd_sc_mcu7t5v0__oai21_4
X_07959_ _10963_/Q _08530_/A2 _08586_/A2 _10098_/Q _07960_/A3 VDD VDD
+ VSS VSS gf180mcu_fd_sc_mcu7t5v0__aoi22_1
X_10970_ _10970_/D _11181_/CLK _10970_/Q VDD VDD VSS VSS gf180mcu_fd_sc_mcu7t5v0__dffq_1
X_09629_ _06047_/Z _09643_/A2 _09629_/B _11027_/D VDD VDD VSS VSS
+ gf180mcu_fd_sc_mcu7t5v0__oai21_1
X_10404_ _10404_/D _11139_/CLK _10404_/Q VDD VDD VSS VSS gf180mcu_fd_sc_mcu7t5v0__dffq_1
X_10335_ _10335_/D _11150_/CLK _10335_/Q VDD VDD VSS VSS gf180mcu_fd_sc_mcu7t5v0__dffq_1
X_10266_ _10266_/D _11052_/CLK _10266_/Q VDD VDD VSS VSS gf180mcu_fd_sc_mcu7t5v0__dffq_1
X_10197_ _10197_/D _11101_/CLK _10197_/Q VDD VDD VSS VSS gf180mcu_fd_sc_mcu7t5v0__dffq_1
X_05310_ _10389_/Q _08764_/B2 VDD VDD VSS VSS gf180mcu_fd_sc_mcu7t5v0__clkinv_1
X_06290_ _06212_/Z _06283_/Z _06290_/B _06291_/B VDD VDD VSS VSS gf180mcu_fd_sc_mcu7t5v0__aoi21_1
X_05241_ _10724_/Q _09225_/B2 VDD VDD VSS VSS gf180mcu_fd_sc_mcu7t5v0__clkinv_1
X_05172_ _10931_/Q _09484_/B2 VDD VDD VSS VSS gf180mcu_fd_sc_mcu7t5v0__clkinv_1
X_09980_ _09980_/D _11163_/CLK _09980_/Q VDD VDD VSS VSS gf180mcu_fd_sc_mcu7t5v0__dffq_1
X_08931_ _09832_/A1 _08931_/A2 _08931_/B1 _08931_/B2 _10490_/D VDD VDD
+ VSS VSS gf180mcu_fd_sc_mcu7t5v0__oai22_1
X_08862_ _10454_/Q _08859_/Z _08862_/Z VDD VDD VSS VSS gf180mcu_fd_sc_mcu7t5v0__and2_1
X_07813_ _09940_/A1 _07825_/A2 _07813_/B _10232_/D VDD VDD VSS VSS
+ gf180mcu_fd_sc_mcu7t5v0__oai21_1
X_08793_ _09904_/A1 _08799_/A2 _08799_/B1 _08793_/B2 _10412_/D VDD VDD
+ VSS VSS gf180mcu_fd_sc_mcu7t5v0__oai22_1
X_07744_ _06058_/Z _07748_/A2 _07748_/B1 _07744_/B2 _10186_/D VDD VDD
+ VSS VSS gf180mcu_fd_sc_mcu7t5v0__oai22_1
X_07675_ _06061_/Z _07678_/A2 _07678_/B1 _07675_/B2 _10147_/D VDD VDD
+ VSS VSS gf180mcu_fd_sc_mcu7t5v0__oai22_1
X_09414_ _06047_/Z _09421_/A2 _09421_/B1 _09414_/B2 _10875_/D VDD VDD
+ VSS VSS gf180mcu_fd_sc_mcu7t5v0__oai22_1
X_06626_ _06627_/A1 _06627_/A3 _06658_/A2 VDD VDD VSS VSS gf180mcu_fd_sc_mcu7t5v0__nand2_1
X_09345_ _09920_/A1 _09351_/A2 _09351_/B1 _09345_/B2 _10820_/D VDD VDD
+ VSS VSS gf180mcu_fd_sc_mcu7t5v0__oai22_1
X_06557_ _06700_/A2 _06700_/A3 _06557_/Z VDD VDD VSS VSS gf180mcu_fd_sc_mcu7t5v0__and2_1
X_05508_ _10862_/Q _09397_/B2 VDD VDD VSS VSS gf180mcu_fd_sc_mcu7t5v0__clkinv_1
X_09276_ _09921_/A1 _09281_/A2 _09281_/B1 _09276_/B2 _10765_/D VDD VDD
+ VSS VSS gf180mcu_fd_sc_mcu7t5v0__oai22_1
X_06488_ _10001_/Q _06502_/A1 _06490_/A3 VDD VDD VSS VSS gf180mcu_fd_sc_mcu7t5v0__nand2_1
X_08227_ _10542_/Q _08555_/A2 _08589_/B1 _10550_/Q _07680_/I _10582_/Q _08228_/A3
+ VDD VDD VSS VSS gf180mcu_fd_sc_mcu7t5v0__aoi222_2
X_05439_ _10622_/Q _09097_/B2 VDD VDD VSS VSS gf180mcu_fd_sc_mcu7t5v0__clkinv_1
X_08158_ _10837_/Q _08590_/A2 _08580_/A2 _10821_/Q _08161_/A2 VDD VDD
+ VSS VSS gf180mcu_fd_sc_mcu7t5v0__aoi22_1
X_08089_ _08703_/B2 _08542_/A2 _08581_/A2 _09854_/B2 _08090_/C VDD VDD
+ VSS VSS gf180mcu_fd_sc_mcu7t5v0__oai22_1
X_07109_ _07052_/Z _07109_/A2 _07108_/B _07115_/A1 VDD VDD VSS VSS
+ gf180mcu_fd_sc_mcu7t5v0__nor3_1
X_10120_ _10120_/D _10327_/CLK _10120_/Q VDD VDD VSS VSS gf180mcu_fd_sc_mcu7t5v0__dffq_2
X_10051_ _10051_/D _11039_/CLK _10051_/Q VDD VDD VSS VSS gf180mcu_fd_sc_mcu7t5v0__dffq_2
X_10953_ _10953_/D _11149_/CLK _10953_/Q VDD VDD VSS VSS gf180mcu_fd_sc_mcu7t5v0__dffq_1
X_10884_ _10884_/D _11147_/CLK _10884_/Q VDD VDD VSS VSS gf180mcu_fd_sc_mcu7t5v0__dffq_1
Xclkbuf_leaf_23_clk clkbuf_opt_1_1_clk/Z _11082_/CLK VDD VDD VSS VSS
+ gf180mcu_fd_sc_mcu7t5v0__clkbuf_16
X_10318_ _10318_/D _11150_/CLK _10318_/Q VDD VDD VSS VSS gf180mcu_fd_sc_mcu7t5v0__dffq_1
X_10249_ _10249_/D _11150_/CLK _10249_/Q VDD VDD VSS VSS gf180mcu_fd_sc_mcu7t5v0__dffq_1
X_05790_ _10889_/Q _09430_/B2 VDD VDD VSS VSS gf180mcu_fd_sc_mcu7t5v0__clkinv_1
X_07460_ _07460_/A1 _07460_/A2 _07603_/B _10122_/D VDD VDD VSS VSS
+ gf180mcu_fd_sc_mcu7t5v0__aoi21_1
X_06411_ _06509_/A1 _06411_/A2 _06425_/A2 VDD VDD VSS VSS gf180mcu_fd_sc_mcu7t5v0__nor2_1
X_07391_ _07391_/A1 _07386_/Z _07391_/B _07426_/A1 VDD VDD VSS VSS
+ gf180mcu_fd_sc_mcu7t5v0__aoi21_1
Xclkbuf_leaf_14_clk clkbuf_1_1_0_clk/Z _11164_/CLK VDD VDD VSS VSS
+ gf180mcu_fd_sc_mcu7t5v0__clkbuf_16
X_09130_ _09945_/A1 _09131_/A2 _09131_/B1 _09130_/B2 _10649_/D VDD VDD
+ VSS VSS gf180mcu_fd_sc_mcu7t5v0__oai22_1
X_06342_ _06342_/A1 _06388_/A1 _06429_/A1 VDD VDD VSS VSS gf180mcu_fd_sc_mcu7t5v0__nor2_2
X_09061_ _09926_/A1 _09061_/A2 _09061_/B1 _09061_/B2 _10594_/D VDD VDD
+ VSS VSS gf180mcu_fd_sc_mcu7t5v0__oai22_1
X_08012_ _09823_/A2 _08012_/A2 _09412_/A2 _08012_/B2 _08012_/C1 _09442_/A1 _08014_/A1
+ VDD VDD VSS VSS gf180mcu_fd_sc_mcu7t5v0__aoi222_1
X_06273_ _10010_/Q _06271_/Z _06274_/B VDD VDD VSS VSS gf180mcu_fd_sc_mcu7t5v0__xor2_1
X_05224_ _10596_/Q _09065_/B2 VDD VDD VSS VSS gf180mcu_fd_sc_mcu7t5v0__clkinv_1
X_05155_ _10347_/Q _08712_/B2 VDD VDD VSS VSS gf180mcu_fd_sc_mcu7t5v0__clkinv_1
X_05086_ _10302_/Q _09732_/A1 VDD VDD VSS VSS gf180mcu_fd_sc_mcu7t5v0__clkinv_1
X_09963_ _09963_/D _11181_/CLK _09963_/Q VDD VDD VSS VSS gf180mcu_fd_sc_mcu7t5v0__dffq_1
X_08914_ _10479_/Q _08920_/A2 _08915_/B VDD VDD VSS VSS gf180mcu_fd_sc_mcu7t5v0__nand2_1
X_09894_ _06058_/Z _09898_/A2 _09898_/B1 _09894_/B2 _11145_/D VDD VDD
+ VSS VSS gf180mcu_fd_sc_mcu7t5v0__oai22_1
X_08845_ _10448_/Q _08842_/Z _08845_/Z VDD VDD VSS VSS gf180mcu_fd_sc_mcu7t5v0__and2_1
X_08776_ _06061_/Z _08779_/A2 _08779_/B1 _08776_/B2 _10399_/D VDD VDD
+ VSS VSS gf180mcu_fd_sc_mcu7t5v0__oai22_1
X_05988_ _07843_/A2 _08626_/A3 _05988_/Z VDD VDD VSS VSS gf180mcu_fd_sc_mcu7t5v0__or2_2
X_07727_ _09946_/A1 _07727_/A2 _07727_/B _10174_/D VDD VDD VSS VSS
+ gf180mcu_fd_sc_mcu7t5v0__oai21_1
X_07658_ _09442_/A1 _09871_/A1 _07667_/A2 VDD VDD VSS VSS gf180mcu_fd_sc_mcu7t5v0__nand2_4
X_07589_ _07463_/Z _07589_/A2 _07508_/Z _07589_/B _07630_/A1 VDD VDD VSS
+ VSS gf180mcu_fd_sc_mcu7t5v0__oai31_1
X_06609_ _10001_/Q _06590_/Z _06612_/B1 VDD VDD VSS VSS gf180mcu_fd_sc_mcu7t5v0__nor2_1
X_09328_ _06061_/Z _09331_/A2 _09331_/B1 _09328_/B2 _10807_/D VDD VDD
+ VSS VSS gf180mcu_fd_sc_mcu7t5v0__oai22_1
X_09259_ _09944_/A1 _09261_/A2 _09261_/B1 _09259_/B2 _10752_/D VDD VDD
+ VSS VSS gf180mcu_fd_sc_mcu7t5v0__oai22_1
X_11152_ _11152_/D _11163_/CLK _11152_/Q VDD VDD VSS VSS gf180mcu_fd_sc_mcu7t5v0__dffq_1
X_10103_ _10103_/D _11052_/CLK _10103_/Q VDD VDD VSS VSS gf180mcu_fd_sc_mcu7t5v0__dffq_1
X_11083_ _11083_/D _11097_/CLK _11083_/Q VDD VDD VSS VSS gf180mcu_fd_sc_mcu7t5v0__dffq_1
X_10034_ _10034_/D _10905_/CLK _10034_/Q VDD VDD VSS VSS gf180mcu_fd_sc_mcu7t5v0__dffq_1
X_10936_ _10936_/D _11149_/CLK _10936_/Q VDD VDD VSS VSS gf180mcu_fd_sc_mcu7t5v0__dffq_1
X_10867_ _10867_/D _11138_/CLK _10867_/Q VDD VDD VSS VSS gf180mcu_fd_sc_mcu7t5v0__dffq_1
X_10798_ _10798_/D _11164_/CLK _10798_/Q VDD VDD VSS VSS gf180mcu_fd_sc_mcu7t5v0__dffq_1
Xclkbuf_leaf_3_clk clkbuf_1_0_0_clk/Z _11138_/CLK VDD VDD VSS VSS
+ gf180mcu_fd_sc_mcu7t5v0__clkbuf_16
X_06960_ _07333_/A2 _07601_/B _07603_/B _06960_/C _10082_/D VDD VDD VSS
+ VSS gf180mcu_fd_sc_mcu7t5v0__aoi211_1
X_05911_ _10978_/Q _09549_/B2 VDD VDD VSS VSS gf180mcu_fd_sc_mcu7t5v0__clkinv_1
X_06891_ _09754_/B _06899_/A2 _06899_/B1 VDD VDD VSS VSS gf180mcu_fd_sc_mcu7t5v0__nand2_2
X_05842_ _10994_/Q _09577_/B2 VDD VDD VSS VSS gf180mcu_fd_sc_mcu7t5v0__clkinv_1
X_08630_ _07636_/B _08657_/A2 _08657_/B1 VDD VDD VSS VSS gf180mcu_fd_sc_mcu7t5v0__nor2_4
X_05773_ _10745_/Q _09250_/B2 VDD VDD VSS VSS gf180mcu_fd_sc_mcu7t5v0__clkinv_1
X_08561_ _11042_/Q _06112_/I _08877_/A2 _11026_/Q _09872_/A1 _09986_/Q _08562_/A3
+ VDD VDD VSS VSS gf180mcu_fd_sc_mcu7t5v0__aoi222_2
X_08492_ _09645_/A1 _08492_/A2 _08492_/B1 _09917_/A2 _08513_/A2 VDD VDD
+ VSS VSS gf180mcu_fd_sc_mcu7t5v0__aoi22_2
X_07512_ _07513_/A1 _07614_/A1 _07560_/A1 VDD VDD VSS VSS gf180mcu_fd_sc_mcu7t5v0__nor2_1
X_07443_ _07444_/A1 _07444_/A2 _07461_/A2 VDD VDD VSS VSS gf180mcu_fd_sc_mcu7t5v0__nand2_1
X_09113_ _09413_/A1 _09121_/A2 _09121_/B1 VDD VDD VSS VSS gf180mcu_fd_sc_mcu7t5v0__nand2_2
X_07374_ _07594_/A1 _07414_/A2 _07373_/Z _07388_/A1 VDD VDD VSS VSS
+ gf180mcu_fd_sc_mcu7t5v0__nor3_1
X_06325_ _10003_/Q _06484_/A2 _06441_/A1 VDD VDD VSS VSS gf180mcu_fd_sc_mcu7t5v0__nand2_1
X_09044_ _06047_/Z _09051_/A2 _09051_/B1 _09044_/B2 _10579_/D VDD VDD
+ VSS VSS gf180mcu_fd_sc_mcu7t5v0__oai22_1
X_06256_ _06964_/A1 _06250_/Z _06256_/Z VDD VDD VSS VSS gf180mcu_fd_sc_mcu7t5v0__xor2_1
X_05207_ _10940_/Q _09495_/B2 VDD VDD VSS VSS gf180mcu_fd_sc_mcu7t5v0__clkinv_1
X_06187_ _10335_/Q _08675_/A2 _08672_/B _06188_/B VDD VDD VSS VSS
+ gf180mcu_fd_sc_mcu7t5v0__oai21_1
X_05138_ _11043_/Q _09664_/B2 VDD VDD VSS VSS gf180mcu_fd_sc_mcu7t5v0__clkinv_1
X_05069_ _09995_/Q _06223_/A3 VDD VDD VSS VSS gf180mcu_fd_sc_mcu7t5v0__clkinv_3
X_09946_ _09946_/A1 _09946_/A2 _09946_/B1 _09946_/B2 _11181_/D VDD VDD
+ VSS VSS gf180mcu_fd_sc_mcu7t5v0__oai22_1
X_09877_ _11136_/Q _09887_/A2 _09878_/B VDD VDD VSS VSS gf180mcu_fd_sc_mcu7t5v0__nand2_1
X_08828_ _09925_/A1 _08829_/A2 _08829_/B1 _08828_/B2 _10441_/D VDD VDD
+ VSS VSS gf180mcu_fd_sc_mcu7t5v0__oai22_1
X_08759_ _09832_/A1 _08759_/A2 _08759_/B1 _08759_/B2 _10386_/D VDD VDD
+ VSS VSS gf180mcu_fd_sc_mcu7t5v0__oai22_1
X_10721_ _10721_/D _10905_/CLK _10721_/Q VDD VDD VSS VSS gf180mcu_fd_sc_mcu7t5v0__dffq_1
X_10652_ _10652_/D _10978_/CLK _10652_/Q VDD VDD VSS VSS gf180mcu_fd_sc_mcu7t5v0__dffq_1
X_10583_ _10583_/D _11138_/CLK _10583_/Q VDD VDD VSS VSS gf180mcu_fd_sc_mcu7t5v0__dffq_1
X_11135_ _11135_/D _11163_/CLK _11135_/Q VDD VDD VSS VSS gf180mcu_fd_sc_mcu7t5v0__dffq_1
X_11066_ _11066_/D _11097_/CLK _11066_/Q VDD VDD VSS VSS gf180mcu_fd_sc_mcu7t5v0__dffq_1
X_10017_ _10017_/D _11176_/CLK _10017_/Q VDD VDD VSS VSS gf180mcu_fd_sc_mcu7t5v0__dffq_1
X_10919_ _10919_/D _10978_/CLK _10919_/Q VDD VDD VSS VSS gf180mcu_fd_sc_mcu7t5v0__dffq_1
X_07090_ _07077_/I _07090_/A2 _07086_/B _07091_/I VDD VDD VSS VSS
+ gf180mcu_fd_sc_mcu7t5v0__xor3_1
X_06110_ _06110_/A1 _06017_/Z _06110_/Z VDD VDD VSS VSS gf180mcu_fd_sc_mcu7t5v0__or2_2
X_06041_ _06038_/I _06040_/I _08327_/B2 VDD VDD VSS VSS gf180mcu_fd_sc_mcu7t5v0__nor2_2
X_07992_ _10363_/Q _08584_/B1 _08563_/C1 _10292_/Q _07993_/A3 VDD VDD
+ VSS VSS gf180mcu_fd_sc_mcu7t5v0__aoi22_1
X_09800_ _09800_/A1 _09817_/A2 _09800_/B _11092_/D VDD VDD VSS VSS
+ gf180mcu_fd_sc_mcu7t5v0__aoi21_1
X_09731_ _09796_/A2 _09743_/A2 _09731_/Z VDD VDD VSS VSS gf180mcu_fd_sc_mcu7t5v0__or2_1
X_06943_ _10078_/Q _10077_/Q _07248_/B VDD VDD VSS VSS gf180mcu_fd_sc_mcu7t5v0__nand2_1
X_09662_ _09871_/A1 _09662_/A2 _09671_/A2 VDD VDD VSS VSS gf180mcu_fd_sc_mcu7t5v0__nand2_4
X_06874_ _06874_/A1 _06861_/Z _06874_/B1 _06874_/B2 _06874_/C _06875_/A2 VDD
+ VDD VSS VSS gf180mcu_fd_sc_mcu7t5v0__oai221_1
X_08613_ _09921_/A1 _08618_/A2 _08618_/B1 _08613_/B2 _10306_/D VDD VDD
+ VSS VSS gf180mcu_fd_sc_mcu7t5v0__oai22_1
X_05825_ _10857_/Q _09390_/B2 VDD VDD VSS VSS gf180mcu_fd_sc_mcu7t5v0__clkinv_1
X_09593_ _06058_/Z _09597_/A2 _09597_/B1 _09593_/B2 _11006_/D VDD VDD
+ VSS VSS gf180mcu_fd_sc_mcu7t5v0__oai22_1
X_08544_ _08544_/A1 _08544_/A2 _08544_/A3 _08595_/A2 VDD VDD VSS VSS
+ gf180mcu_fd_sc_mcu7t5v0__nand3_2
X_05756_ _10617_/Q _09090_/B2 VDD VDD VSS VSS gf180mcu_fd_sc_mcu7t5v0__clkinv_1
X_05687_ _10228_/Q _08405_/B2 VDD VDD VSS VSS gf180mcu_fd_sc_mcu7t5v0__clkinv_1
X_08475_ _10689_/Q _06023_/I _08586_/A2 _10713_/Q _08584_/B1 _10721_/Q _08477_/A2
+ VDD VDD VSS VSS gf180mcu_fd_sc_mcu7t5v0__aoi222_1
X_07426_ _07426_/A1 _07426_/A2 _07426_/B _07461_/A1 VDD VDD VSS VSS
+ gf180mcu_fd_sc_mcu7t5v0__oai21_1
X_07357_ _07548_/C _07356_/Z _07357_/B _07601_/B _07358_/C VDD VDD VSS
+ VSS gf180mcu_fd_sc_mcu7t5v0__aoi211_1
X_06308_ _06310_/A2 _06310_/A3 _06335_/B VDD VDD VSS VSS gf180mcu_fd_sc_mcu7t5v0__nand2_1
X_09027_ _06058_/Z _09031_/A2 _09031_/B1 _09027_/B2 _10566_/D VDD VDD
+ VSS VSS gf180mcu_fd_sc_mcu7t5v0__oai22_1
X_07288_ _10103_/Q _07292_/A2 _07289_/B VDD VDD VSS VSS gf180mcu_fd_sc_mcu7t5v0__nand2_1
X_06239_ _06446_/A2 _06239_/A2 _06239_/Z VDD VDD VSS VSS gf180mcu_fd_sc_mcu7t5v0__xor2_1
X_09929_ _06047_/Z _09936_/A2 _09936_/B1 _09929_/B2 _11166_/D VDD VDD
+ VSS VSS gf180mcu_fd_sc_mcu7t5v0__oai22_1
X_10704_ _10704_/D _10905_/CLK _10704_/Q VDD VDD VSS VSS gf180mcu_fd_sc_mcu7t5v0__dffq_1
X_10635_ _10635_/D _10666_/CLK _10635_/Q VDD VDD VSS VSS gf180mcu_fd_sc_mcu7t5v0__dffq_1
X_10566_ _10566_/D _10666_/CLK _10566_/Q VDD VDD VSS VSS gf180mcu_fd_sc_mcu7t5v0__dffq_1
X_10497_ _10497_/D _11164_/CLK _10497_/Q VDD VDD VSS VSS gf180mcu_fd_sc_mcu7t5v0__dffq_1
X_11118_ _11118_/D _11142_/CLK _11118_/Q VDD VDD VSS VSS gf180mcu_fd_sc_mcu7t5v0__dffq_1
X_11049_ _11049_/D _11142_/CLK _11049_/Q VDD VDD VSS VSS gf180mcu_fd_sc_mcu7t5v0__dffq_1
X_05610_ _10831_/Q _09358_/B2 VDD VDD VSS VSS gf180mcu_fd_sc_mcu7t5v0__clkinv_1
X_06590_ _06661_/A2 _06661_/A3 _06590_/Z VDD VDD VSS VSS gf180mcu_fd_sc_mcu7t5v0__and2_2
X_05541_ _10591_/Q _09058_/B2 VDD VDD VSS VSS gf180mcu_fd_sc_mcu7t5v0__clkinv_1
X_05472_ _10886_/Q _09427_/B2 VDD VDD VSS VSS gf180mcu_fd_sc_mcu7t5v0__clkinv_1
X_08260_ _10146_/Q _08560_/B1 _08576_/B1 _11161_/Q _08264_/A1 VDD VDD
+ VSS VSS gf180mcu_fd_sc_mcu7t5v0__aoi22_1
X_07211_ _10088_/Q _07601_/B _07211_/B1 _07211_/B2 _07212_/A2 VDD VDD
+ VSS VSS gf180mcu_fd_sc_mcu7t5v0__aoi22_1
X_08191_ _10035_/Q _08528_/A2 _08532_/A2 _11169_/Q _08191_/C _08203_/A2 VDD
+ VDD VSS VSS gf180mcu_fd_sc_mcu7t5v0__aoi221_4
X_07142_ _07093_/I _07141_/Z _07194_/A1 VDD VDD VSS VSS gf180mcu_fd_sc_mcu7t5v0__nand2_1
X_07073_ _10001_/Q _07223_/A2 _07168_/A1 VDD VDD VSS VSS gf180mcu_fd_sc_mcu7t5v0__nand2_1
X_06024_ _10314_/Q _08620_/A2 _08625_/A1 VDD VDD VSS VSS gf180mcu_fd_sc_mcu7t5v0__nand2_2
X_07975_ _10867_/Q _08582_/A2 _06125_/I _10843_/Q _07977_/A2 VDD VDD VSS
+ VSS gf180mcu_fd_sc_mcu7t5v0__aoi22_1
X_09714_ _11059_/Q _09678_/Z _09714_/B _09715_/I VDD VDD VSS VSS gf180mcu_fd_sc_mcu7t5v0__oai21_1
X_06926_ _10248_/Q _08675_/A2 _08674_/B _06927_/B VDD VDD VSS VSS
+ gf180mcu_fd_sc_mcu7t5v0__oai21_1
X_09645_ _09645_/A1 _09645_/A2 _09900_/B _09660_/A2 VDD VDD VSS VSS
+ gf180mcu_fd_sc_mcu7t5v0__aoi21_4
X_06857_ _06857_/A1 _06857_/A2 _06857_/A3 _06857_/Z VDD VDD VSS VSS
+ gf180mcu_fd_sc_mcu7t5v0__xor3_1
X_05808_ _10937_/Q _09490_/B2 VDD VDD VSS VSS gf180mcu_fd_sc_mcu7t5v0__clkinv_1
X_09576_ _09897_/A1 _09577_/A2 _09577_/B1 _09576_/B2 _10993_/D VDD VDD
+ VSS VSS gf180mcu_fd_sc_mcu7t5v0__oai22_1
X_06788_ _10337_/Q _06651_/Z _06790_/A1 VDD VDD VSS VSS gf180mcu_fd_sc_mcu7t5v0__nand2_1
X_05739_ _11108_/Q _09831_/B2 VDD VDD VSS VSS gf180mcu_fd_sc_mcu7t5v0__clkinv_1
X_08527_ _10346_/Q _08591_/A2 _08589_/B1 _11125_/Q _08527_/C _08534_/B1 VDD
+ VDD VSS VSS gf180mcu_fd_sc_mcu7t5v0__aoi221_4
X_08458_ _10545_/Q _08555_/A2 _08589_/B1 _10553_/Q _08461_/A1 VDD VDD
+ VSS VSS gf180mcu_fd_sc_mcu7t5v0__aoi22_1
X_07409_ _07485_/A1 _07365_/I _07409_/B _07412_/A3 VDD VDD VSS VSS
+ gf180mcu_fd_sc_mcu7t5v0__aoi21_1
X_08389_ _10424_/Q _08591_/A2 _08589_/B1 _10736_/Q _08392_/A1 VDD VDD
+ VSS VSS gf180mcu_fd_sc_mcu7t5v0__aoi22_1
X_10420_ _10420_/D _11142_/CLK _10420_/Q VDD VDD VSS VSS gf180mcu_fd_sc_mcu7t5v0__dffq_1
X_10351_ _10351_/D _10978_/CLK _10351_/Q VDD VDD VSS VSS gf180mcu_fd_sc_mcu7t5v0__dffq_1
X_10282_ _10282_/D _11150_/CLK _10282_/Q VDD VDD VSS VSS gf180mcu_fd_sc_mcu7t5v0__dffq_1
X_10618_ _10618_/D _11176_/CLK _10618_/Q VDD VDD VSS VSS gf180mcu_fd_sc_mcu7t5v0__dffq_1
X_10549_ _10549_/D _11138_/CLK _10549_/Q VDD VDD VSS VSS gf180mcu_fd_sc_mcu7t5v0__dffq_1
X_07760_ _09927_/A2 _09889_/A2 _07769_/A2 VDD VDD VSS VSS gf180mcu_fd_sc_mcu7t5v0__nand2_4
Xclkbuf_1_1_0_clk clkbuf_0_clk/Z clkbuf_1_1_0_clk/Z VDD VDD VSS VSS
+ gf180mcu_fd_sc_mcu7t5v0__clkbuf_2
X_04972_ _11097_/Q _09810_/A1 VDD VDD VSS VSS gf180mcu_fd_sc_mcu7t5v0__clkinv_1
X_06711_ _06711_/I _06712_/A2 VDD VDD VSS VSS gf180mcu_fd_sc_mcu7t5v0__clkinv_1
X_09430_ _09897_/A1 _09431_/A2 _09431_/B1 _09430_/B2 _10889_/D VDD VDD
+ VSS VSS gf180mcu_fd_sc_mcu7t5v0__oai22_1
X_07691_ _06058_/Z _07699_/A2 _07691_/B _10154_/D VDD VDD VSS VSS
+ gf180mcu_fd_sc_mcu7t5v0__oai21_1
X_06642_ _10002_/Q _06850_/A2 _06704_/A1 VDD VDD VSS VSS gf180mcu_fd_sc_mcu7t5v0__nand2_1
X_09361_ _09926_/A1 _09361_/A2 _09361_/B1 _09361_/B2 _10834_/D VDD VDD
+ VSS VSS gf180mcu_fd_sc_mcu7t5v0__oai22_1
X_06573_ _06593_/A2 _06872_/I1 _06871_/C _06573_/B _06577_/A1 VDD VDD
+ VSS VSS gf180mcu_fd_sc_mcu7t5v0__oai31_1
X_05524_ _10991_/Q _09574_/B2 VDD VDD VSS VSS gf180mcu_fd_sc_mcu7t5v0__clkinv_1
X_09292_ _09871_/A1 _09332_/A2 _09301_/A2 VDD VDD VSS VSS gf180mcu_fd_sc_mcu7t5v0__nand2_4
X_08312_ _10607_/Q _08563_/A2 _08584_/A2 _10639_/Q _08584_/B1 _10663_/Q _08313_/A3
+ VDD VDD VSS VSS gf180mcu_fd_sc_mcu7t5v0__aoi222_1
X_08243_ _10502_/Q _08591_/C1 _08591_/B1 _10518_/Q _08244_/A3 VDD VDD
+ VSS VSS gf180mcu_fd_sc_mcu7t5v0__aoi22_1
X_05455_ _10742_/Q _09247_/B2 VDD VDD VSS VSS gf180mcu_fd_sc_mcu7t5v0__clkinv_1
X_08174_ _10437_/Q _08591_/A2 _08591_/B1 _10429_/Q _08591_/C1 _10469_/Q _08175_/A3
+ VDD VDD VSS VSS gf180mcu_fd_sc_mcu7t5v0__aoi222_2
X_05386_ _10909_/Q _09456_/B2 VDD VDD VSS VSS gf180mcu_fd_sc_mcu7t5v0__clkinv_1
X_07125_ _10000_/Q _07226_/A2 _07168_/B2 VDD VDD VSS VSS gf180mcu_fd_sc_mcu7t5v0__nand2_1
X_07056_ _07246_/A1 _07056_/A2 _07057_/A2 VDD VDD VSS VSS gf180mcu_fd_sc_mcu7t5v0__nand2_1
X_06007_ _11057_/Q _07876_/A2 _05986_/I _11088_/Q _06008_/A2 VDD VDD VSS
+ VSS gf180mcu_fd_sc_mcu7t5v0__aoi22_2
X_07958_ _10090_/Q _08532_/A2 _08476_/C1 _10151_/Q _07960_/A2 VDD VDD
+ VSS VSS gf180mcu_fd_sc_mcu7t5v0__aoi22_1
X_06909_ _06058_/Z _06917_/A2 _06909_/B _10072_/D VDD VDD VSS VSS
+ gf180mcu_fd_sc_mcu7t5v0__oai21_1
X_07889_ bus_wdata[6] _07890_/A2 rst_n _07890_/B VDD VDD VSS VSS gf180mcu_fd_sc_mcu7t5v0__oai21_1
X_09628_ _11027_/Q _09642_/A2 _09629_/B VDD VDD VSS VSS gf180mcu_fd_sc_mcu7t5v0__nand2_1
X_09559_ _06058_/Z _09567_/A2 _09559_/B _10982_/D VDD VDD VSS VSS
+ gf180mcu_fd_sc_mcu7t5v0__oai21_1
X_10403_ _10403_/D _11139_/CLK _10403_/Q VDD VDD VSS VSS gf180mcu_fd_sc_mcu7t5v0__dffq_1
X_10334_ _10334_/D _11150_/CLK _10334_/Q VDD VDD VSS VSS gf180mcu_fd_sc_mcu7t5v0__dffq_1
X_10265_ _10265_/D _11052_/CLK _10265_/Q VDD VDD VSS VSS gf180mcu_fd_sc_mcu7t5v0__dffq_1
X_10196_ _10196_/D _11101_/CLK _10196_/Q VDD VDD VSS VSS gf180mcu_fd_sc_mcu7t5v0__dffq_1
X_05240_ _10716_/Q _09215_/B2 VDD VDD VSS VSS gf180mcu_fd_sc_mcu7t5v0__clkinv_1
X_05171_ _10947_/Q _09504_/B2 VDD VDD VSS VSS gf180mcu_fd_sc_mcu7t5v0__clkinv_1
X_08930_ _09925_/A1 _08931_/A2 _08931_/B1 _08930_/B2 _10489_/D VDD VDD
+ VSS VSS gf180mcu_fd_sc_mcu7t5v0__oai22_1
X_08861_ _08859_/Z _08861_/A2 _10453_/D VDD VDD VSS VSS gf180mcu_fd_sc_mcu7t5v0__nor2_1
X_07812_ _10232_/Q _07824_/A2 _07813_/B VDD VDD VSS VSS gf180mcu_fd_sc_mcu7t5v0__nand2_1
X_08792_ _06047_/Z _08799_/A2 _08799_/B1 _08792_/B2 _10411_/D VDD VDD
+ VSS VSS gf180mcu_fd_sc_mcu7t5v0__oai22_1
X_07743_ _09941_/A1 _07748_/A2 _07748_/B1 _07743_/B2 _10185_/D VDD VDD
+ VSS VSS gf180mcu_fd_sc_mcu7t5v0__oai22_1
X_07674_ _06058_/Z _07678_/A2 _07678_/B1 _07674_/B2 _10146_/D VDD VDD
+ VSS VSS gf180mcu_fd_sc_mcu7t5v0__oai22_1
X_09413_ _09413_/A1 _09421_/A2 _09421_/B1 VDD VDD VSS VSS gf180mcu_fd_sc_mcu7t5v0__nand2_4
X_06625_ _06627_/A1 _06627_/A3 _06658_/B VDD VDD VSS VSS gf180mcu_fd_sc_mcu7t5v0__nor2_1
X_09344_ _06047_/Z _09351_/A2 _09351_/B1 _09344_/B2 _10819_/D VDD VDD
+ VSS VSS gf180mcu_fd_sc_mcu7t5v0__oai22_1
X_06556_ _10043_/Q _06556_/A2 _06556_/B _06700_/A3 VDD VDD VSS VSS
+ gf180mcu_fd_sc_mcu7t5v0__oai21_4
X_09275_ _09904_/A1 _09281_/A2 _09281_/B1 _09275_/B2 _10764_/D VDD VDD
+ VSS VSS gf180mcu_fd_sc_mcu7t5v0__oai22_1
X_05507_ _10854_/Q _09387_/B2 VDD VDD VSS VSS gf180mcu_fd_sc_mcu7t5v0__clkinv_1
X_06487_ _10000_/Q _06508_/B1 _06490_/A2 VDD VDD VSS VSS gf180mcu_fd_sc_mcu7t5v0__nand2_1
X_08226_ _10558_/Q _06023_/I _08582_/A2 _10590_/Q _08584_/A2 _10574_/Q _08228_/A2
+ VDD VDD VSS VSS gf180mcu_fd_sc_mcu7t5v0__aoi222_1
X_05438_ _10614_/Q _09087_/B2 VDD VDD VSS VSS gf180mcu_fd_sc_mcu7t5v0__clkinv_1
X_08157_ _10853_/Q _08591_/A2 _07255_/I _10877_/Q _08161_/A1 VDD VDD VSS
+ VSS gf180mcu_fd_sc_mcu7t5v0__aoi22_1
X_05369_ _10225_/Q _07802_/B2 VDD VDD VSS VSS gf180mcu_fd_sc_mcu7t5v0__clkinv_1
X_07108_ _07052_/Z _07109_/A2 _07108_/B _07152_/A2 VDD VDD VSS VSS
+ gf180mcu_fd_sc_mcu7t5v0__oai21_1
X_08088_ _08088_/A1 _08088_/A2 _08088_/A3 _08098_/C2 VDD VDD VSS VSS
+ gf180mcu_fd_sc_mcu7t5v0__nand3_2
X_07039_ _07078_/A1 _07036_/Z _07078_/A2 _07039_/Z VDD VDD VSS VSS
+ gf180mcu_fd_sc_mcu7t5v0__or3_1
X_10050_ _10050_/D _11039_/CLK _10050_/Q VDD VDD VSS VSS gf180mcu_fd_sc_mcu7t5v0__dffq_2
X_10952_ _10952_/D _11149_/CLK _10952_/Q VDD VDD VSS VSS gf180mcu_fd_sc_mcu7t5v0__dffq_1
X_10883_ _10883_/D _11147_/CLK _10883_/Q VDD VDD VSS VSS gf180mcu_fd_sc_mcu7t5v0__dffq_1
X_10317_ _10317_/D _11052_/CLK _10317_/Q VDD VDD VSS VSS gf180mcu_fd_sc_mcu7t5v0__dffq_1
X_10248_ _10248_/D _10327_/CLK _10248_/Q VDD VDD VSS VSS gf180mcu_fd_sc_mcu7t5v0__dffq_1
X_10179_ _10179_/D _11017_/CLK _10179_/Q VDD VDD VSS VSS gf180mcu_fd_sc_mcu7t5v0__dffq_1
X_06410_ _10013_/Q _06428_/A1 _06411_/A2 _06410_/Z VDD VDD VSS VSS
+ gf180mcu_fd_sc_mcu7t5v0__xor3_1
X_07390_ _07636_/B _07390_/A2 _07390_/B _07603_/B _10120_/D VDD VDD VSS
+ VSS gf180mcu_fd_sc_mcu7t5v0__aoi211_1
X_06341_ _10001_/Q _06439_/A2 _06388_/A1 VDD VDD VSS VSS gf180mcu_fd_sc_mcu7t5v0__nand2_1
X_09060_ _09945_/A1 _09061_/A2 _09061_/B1 _09060_/B2 _10593_/D VDD VDD
+ VSS VSS gf180mcu_fd_sc_mcu7t5v0__oai22_1
X_06272_ _06994_/A1 _06271_/Z _06294_/A1 VDD VDD VSS VSS gf180mcu_fd_sc_mcu7t5v0__nor2_1
X_05223_ _10588_/Q _09055_/B2 VDD VDD VSS VSS gf180mcu_fd_sc_mcu7t5v0__clkinv_1
X_08011_ _08011_/A1 _08011_/A2 _08011_/A3 _08015_/B VDD VDD VSS VSS
+ gf180mcu_fd_sc_mcu7t5v0__nand3_1
X_05154_ _10883_/Q _09424_/B2 VDD VDD VSS VSS gf180mcu_fd_sc_mcu7t5v0__clkinv_1
X_09962_ _09962_/D _10905_/CLK _09962_/Q VDD VDD VSS VSS gf180mcu_fd_sc_mcu7t5v0__dffq_1
X_05085_ _10291_/Q _09724_/A3 VDD VDD VSS VSS gf180mcu_fd_sc_mcu7t5v0__clkinv_1
X_08913_ _06058_/Z _08921_/A2 _08913_/B _10478_/D VDD VDD VSS VSS
+ gf180mcu_fd_sc_mcu7t5v0__oai21_1
X_09893_ _09893_/A1 _09898_/A2 _09898_/B1 _09893_/B2 _11144_/D VDD VDD
+ VSS VSS gf180mcu_fd_sc_mcu7t5v0__oai22_1
X_08844_ _10448_/Q _08842_/Z _08846_/A2 VDD VDD VSS VSS gf180mcu_fd_sc_mcu7t5v0__nor2_1
X_08775_ _06058_/Z _08779_/A2 _08779_/B1 _08775_/B2 _10398_/D VDD VDD
+ VSS VSS gf180mcu_fd_sc_mcu7t5v0__oai22_1
X_05987_ bus_addr[5] _05987_/A2 _05987_/A3 _08626_/A3 VDD VDD VSS VSS
+ gf180mcu_fd_sc_mcu7t5v0__nand3_1
X_07726_ _10174_/Q _07726_/A2 _07727_/B VDD VDD VSS VSS gf180mcu_fd_sc_mcu7t5v0__nand2_1
X_07657_ _09916_/A1 _07657_/A2 _07657_/B _10134_/D VDD VDD VSS VSS
+ gf180mcu_fd_sc_mcu7t5v0__oai21_1
X_07588_ _10125_/Q _07604_/A1 _07585_/Z _07588_/Z VDD VDD VSS VSS
+ gf180mcu_fd_sc_mcu7t5v0__xor3_1
X_06608_ _06874_/A1 _06608_/A2 _06613_/B VDD VDD VSS VSS gf180mcu_fd_sc_mcu7t5v0__nor2_1
X_09327_ _06058_/Z _09331_/A2 _09331_/B1 _09327_/B2 _10806_/D VDD VDD
+ VSS VSS gf180mcu_fd_sc_mcu7t5v0__oai22_1
X_06539_ _09944_/A1 _06541_/A2 _06541_/B1 _06539_/B2 _10037_/D VDD VDD
+ VSS VSS gf180mcu_fd_sc_mcu7t5v0__oai22_1
X_09258_ _06061_/Z _09261_/A2 _09261_/B1 _09258_/B2 _10751_/D VDD VDD
+ VSS VSS gf180mcu_fd_sc_mcu7t5v0__oai22_1
X_08209_ _10758_/Q _08559_/A2 _08209_/B _08223_/A2 VDD VDD VSS VSS
+ gf180mcu_fd_sc_mcu7t5v0__aoi21_2
X_09189_ _09884_/A1 _09191_/A2 _09191_/B1 _09189_/B2 _10696_/D VDD VDD
+ VSS VSS gf180mcu_fd_sc_mcu7t5v0__oai22_1
X_11151_ _11151_/D _11163_/CLK _11151_/Q VDD VDD VSS VSS gf180mcu_fd_sc_mcu7t5v0__dffq_1
X_10102_ _10102_/D _11097_/CLK _10102_/Q VDD VDD VSS VSS gf180mcu_fd_sc_mcu7t5v0__dffq_1
X_11082_ _11082_/D _11082_/CLK _11082_/Q VDD VDD VSS VSS gf180mcu_fd_sc_mcu7t5v0__dffq_1
X_10033_ _10033_/D _11181_/CLK _10033_/Q VDD VDD VSS VSS gf180mcu_fd_sc_mcu7t5v0__dffq_1
X_10935_ _10935_/D _11149_/CLK _10935_/Q VDD VDD VSS VSS gf180mcu_fd_sc_mcu7t5v0__dffq_1
X_10866_ _10866_/D _11165_/CLK _10866_/Q VDD VDD VSS VSS gf180mcu_fd_sc_mcu7t5v0__dffq_1
X_10797_ _10797_/D _11010_/CLK _10797_/Q VDD VDD VSS VSS gf180mcu_fd_sc_mcu7t5v0__dffq_1
X_05910_ _11010_/Q _09597_/B2 VDD VDD VSS VSS gf180mcu_fd_sc_mcu7t5v0__clkinv_1
X_06890_ _09889_/A1 _09937_/A1 _06899_/A2 VDD VDD VSS VSS gf180mcu_fd_sc_mcu7t5v0__nand2_4
X_05841_ _10386_/Q _08759_/B2 VDD VDD VSS VSS gf180mcu_fd_sc_mcu7t5v0__clkinv_1
X_05772_ _10737_/Q _09240_/B2 VDD VDD VSS VSS gf180mcu_fd_sc_mcu7t5v0__clkinv_1
X_08560_ _09954_/Q _08560_/A2 _08560_/B1 _11010_/Q _07255_/I _10986_/Q _08562_/A2
+ VDD VDD VSS VSS gf180mcu_fd_sc_mcu7t5v0__aoi222_2
X_08491_ _08491_/A1 _08491_/A2 _08491_/A3 _08492_/B1 VDD VDD VSS VSS
+ gf180mcu_fd_sc_mcu7t5v0__nand3_1
X_07511_ _10002_/Q _07463_/Z _07568_/A2 VDD VDD VSS VSS gf180mcu_fd_sc_mcu7t5v0__nand2_1
X_07442_ _07404_/Z _07438_/Z _07444_/A2 VDD VDD VSS VSS gf180mcu_fd_sc_mcu7t5v0__xnor2_1
X_07373_ _07373_/A1 _07371_/Z _07373_/Z VDD VDD VSS VSS gf180mcu_fd_sc_mcu7t5v0__and2_1
X_09112_ _09645_/A2 _09142_/A2 _09121_/A2 VDD VDD VSS VSS gf180mcu_fd_sc_mcu7t5v0__nand2_4
X_06324_ _10003_/Q _06484_/A2 _06328_/B2 VDD VDD VSS VSS gf180mcu_fd_sc_mcu7t5v0__nor2_1
X_09043_ _09413_/A1 _09051_/A2 _09051_/B1 VDD VDD VSS VSS gf180mcu_fd_sc_mcu7t5v0__nand2_2
X_06255_ _06255_/I _06274_/A1 VDD VDD VSS VSS gf180mcu_fd_sc_mcu7t5v0__clkinv_1
X_05206_ _10988_/Q _09571_/B2 VDD VDD VSS VSS gf180mcu_fd_sc_mcu7t5v0__clkinv_1
X_06186_ _07470_/B2 _08675_/A2 _06186_/B _10003_/D VDD VDD VSS VSS
+ gf180mcu_fd_sc_mcu7t5v0__aoi21_1
X_05137_ _10739_/Q _09244_/B2 VDD VDD VSS VSS gf180mcu_fd_sc_mcu7t5v0__clkinv_1
X_05068_ _09996_/Q _06204_/A2 VDD VDD VSS VSS gf180mcu_fd_sc_mcu7t5v0__clkinv_1
X_09945_ _09945_/A1 _09946_/A2 _09946_/B1 _09945_/B2 _11180_/D VDD VDD
+ VSS VSS gf180mcu_fd_sc_mcu7t5v0__oai22_1
X_09876_ _09920_/A1 _09888_/A2 _09876_/B _11135_/D VDD VDD VSS VSS
+ gf180mcu_fd_sc_mcu7t5v0__oai21_1
X_08827_ _09896_/A1 _08829_/A2 _08829_/B1 _08827_/B2 _10440_/D VDD VDD
+ VSS VSS gf180mcu_fd_sc_mcu7t5v0__oai22_1
X_08758_ _09897_/A1 _08759_/A2 _08759_/B1 _08758_/B2 _10385_/D VDD VDD
+ VSS VSS gf180mcu_fd_sc_mcu7t5v0__oai22_1
X_07709_ _09946_/A1 _07709_/A2 _07709_/B1 _07709_/B2 _10166_/D VDD VDD
+ VSS VSS gf180mcu_fd_sc_mcu7t5v0__oai22_1
X_08689_ _10335_/Q _08698_/A2 _08690_/A2 VDD VDD VSS VSS gf180mcu_fd_sc_mcu7t5v0__nand2_1
X_10720_ _10720_/D _10905_/CLK _10720_/Q VDD VDD VSS VSS gf180mcu_fd_sc_mcu7t5v0__dffq_1
X_10651_ _10651_/D _10666_/CLK _10651_/Q VDD VDD VSS VSS gf180mcu_fd_sc_mcu7t5v0__dffq_1
X_10582_ _10582_/D _10978_/CLK _10582_/Q VDD VDD VSS VSS gf180mcu_fd_sc_mcu7t5v0__dffq_1
X_11134_ _11134_/D _11165_/CLK _11134_/Q VDD VDD VSS VSS gf180mcu_fd_sc_mcu7t5v0__dffq_1
X_11065_ _11065_/D _11101_/CLK _11065_/Q VDD VDD VSS VSS gf180mcu_fd_sc_mcu7t5v0__dffq_1
X_10016_ _10016_/D _11176_/CLK _10016_/Q VDD VDD VSS VSS gf180mcu_fd_sc_mcu7t5v0__dffq_1
X_10918_ _10918_/D _11149_/CLK _10918_/Q VDD VDD VSS VSS gf180mcu_fd_sc_mcu7t5v0__dffq_1
X_10849_ _10849_/D _11138_/CLK _10849_/Q VDD VDD VSS VSS gf180mcu_fd_sc_mcu7t5v0__dffq_1
X_06040_ _06040_/I _06146_/A2 VDD VDD VSS VSS gf180mcu_fd_sc_mcu7t5v0__clkinv_3
X_07991_ _09955_/Q _08563_/A2 _08586_/A2 _10016_/Q _07993_/A2 VDD VDD
+ VSS VSS gf180mcu_fd_sc_mcu7t5v0__aoi22_1
X_09730_ _10301_/Q _10303_/Q _09743_/A2 VDD VDD VSS VSS gf180mcu_fd_sc_mcu7t5v0__nor2_1
X_06942_ _06942_/A1 _06953_/A3 _06951_/B VDD VDD VSS VSS gf180mcu_fd_sc_mcu7t5v0__nor2_2
X_09661_ _09916_/A1 _09661_/A2 _09661_/B _11042_/D VDD VDD VSS VSS
+ gf180mcu_fd_sc_mcu7t5v0__oai21_1
X_06873_ _10007_/Q _06873_/A2 _06873_/B _06873_/C _06874_/B2 VDD VDD VSS
+ VSS gf180mcu_fd_sc_mcu7t5v0__aoi211_1
X_08612_ _09920_/A1 _08618_/A2 _08618_/B1 _08612_/B2 _10305_/D VDD VDD
+ VSS VSS gf180mcu_fd_sc_mcu7t5v0__oai22_1
X_05824_ _10849_/Q _09380_/B2 VDD VDD VSS VSS gf180mcu_fd_sc_mcu7t5v0__clkinv_1
X_09592_ _09921_/A1 _09597_/A2 _09597_/B1 _09592_/B2 _11005_/D VDD VDD
+ VSS VSS gf180mcu_fd_sc_mcu7t5v0__oai22_1
X_08543_ _10810_/Q _08560_/B1 _07255_/I _10818_/Q _08543_/C _08544_/A3 VDD VDD
+ VSS VSS gf180mcu_fd_sc_mcu7t5v0__aoi221_2
X_05755_ _10609_/Q _09080_/B2 VDD VDD VSS VSS gf180mcu_fd_sc_mcu7t5v0__clkinv_1
X_05686_ _10344_/Q _08707_/B2 VDD VDD VSS VSS gf180mcu_fd_sc_mcu7t5v0__clkinv_1
X_08474_ _10705_/Q _08584_/A2 _06877_/Z _10681_/Q _08477_/A1 VDD VDD VSS
+ VSS gf180mcu_fd_sc_mcu7t5v0__aoi22_1
X_07425_ _10122_/Q _07601_/B _07460_/A1 VDD VDD VSS VSS gf180mcu_fd_sc_mcu7t5v0__nand2_1
X_07356_ _07358_/A1 _07381_/A1 _07356_/Z VDD VDD VSS VSS gf180mcu_fd_sc_mcu7t5v0__xor2_1
X_06307_ _06307_/A1 _06307_/A2 _06390_/B2 _06310_/A3 VDD VDD VSS VSS
+ gf180mcu_fd_sc_mcu7t5v0__xnor3_1
X_07287_ _06061_/Z _07293_/A2 _07287_/B _10102_/D VDD VDD VSS VSS
+ gf180mcu_fd_sc_mcu7t5v0__oai21_1
X_09026_ _09941_/A1 _09031_/A2 _09031_/B1 _09026_/B2 _10565_/D VDD VDD
+ VSS VSS gf180mcu_fd_sc_mcu7t5v0__oai22_1
X_06238_ _06481_/A2 _06502_/B _06239_/A2 VDD VDD VSS VSS gf180mcu_fd_sc_mcu7t5v0__nand2_1
X_06169_ _10254_/Q _08675_/A2 rst_n _06170_/B VDD VDD VSS VSS gf180mcu_fd_sc_mcu7t5v0__oai21_1
X_09928_ _09754_/B _09936_/A2 _09936_/B1 VDD VDD VSS VSS gf180mcu_fd_sc_mcu7t5v0__nand2_2
X_09859_ _09897_/A1 _09860_/A2 _09860_/B1 _09859_/B2 _11124_/D VDD VDD
+ VSS VSS gf180mcu_fd_sc_mcu7t5v0__oai22_1
X_10703_ _10703_/D _10905_/CLK _10703_/Q VDD VDD VSS VSS gf180mcu_fd_sc_mcu7t5v0__dffq_1
X_10634_ _10634_/D _10978_/CLK _10634_/Q VDD VDD VSS VSS gf180mcu_fd_sc_mcu7t5v0__dffq_1
X_10565_ _10565_/D _10666_/CLK _10565_/Q VDD VDD VSS VSS gf180mcu_fd_sc_mcu7t5v0__dffq_1
X_10496_ _10496_/D _11017_/CLK _10496_/Q VDD VDD VSS VSS gf180mcu_fd_sc_mcu7t5v0__dffq_1
X_11117_ _11117_/D _11150_/CLK _11117_/Q VDD VDD VSS VSS gf180mcu_fd_sc_mcu7t5v0__dffq_1
X_11048_ _11048_/D _11147_/CLK _11048_/Q VDD VDD VSS VSS gf180mcu_fd_sc_mcu7t5v0__dffq_1
X_05540_ _10583_/Q _09048_/B2 VDD VDD VSS VSS gf180mcu_fd_sc_mcu7t5v0__clkinv_1
X_05471_ _11121_/Q _09856_/B2 VDD VDD VSS VSS gf180mcu_fd_sc_mcu7t5v0__clkinv_1
X_08190_ _08190_/A1 _08190_/A2 _08191_/C VDD VDD VSS VSS gf180mcu_fd_sc_mcu7t5v0__nand2_1
X_07210_ _07063_/C _07197_/Z _07601_/B _07211_/B2 VDD VDD VSS VSS
+ gf180mcu_fd_sc_mcu7t5v0__aoi21_1
X_07141_ _07163_/A1 _07140_/Z _07141_/Z VDD VDD VSS VSS gf180mcu_fd_sc_mcu7t5v0__xor2_2
X_07072_ _10000_/Q _07199_/A1 _07076_/A1 VDD VDD VSS VSS gf180mcu_fd_sc_mcu7t5v0__nand2_1
X_06023_ _06023_/I _08585_/A2 VDD VDD VSS VSS gf180mcu_fd_sc_mcu7t5v0__clkinv_8
X_07974_ _10835_/Q _08590_/A2 _07680_/I _10859_/Q _07974_/C _07977_/A1 VDD VDD
+ VSS VSS gf180mcu_fd_sc_mcu7t5v0__aoi221_2
X_09713_ _09678_/Z _09713_/A2 _09900_/B _09714_/B VDD VDD VSS VSS
+ gf180mcu_fd_sc_mcu7t5v0__aoi21_1
X_06925_ _07070_/A1 _08675_/A2 _06925_/B _10080_/D VDD VDD VSS VSS
+ gf180mcu_fd_sc_mcu7t5v0__aoi21_1
X_09644_ _09645_/A1 _09645_/A2 _09661_/A2 VDD VDD VSS VSS gf180mcu_fd_sc_mcu7t5v0__nand2_2
X_06856_ _06856_/A1 _06856_/A2 _06855_/Z _06856_/Z VDD VDD VSS VSS
+ gf180mcu_fd_sc_mcu7t5v0__xor3_1
X_05807_ _10953_/Q _09510_/B2 VDD VDD VSS VSS gf180mcu_fd_sc_mcu7t5v0__clkinv_1
X_09575_ _09896_/A1 _09577_/A2 _09577_/B1 _09575_/B2 _10992_/D VDD VDD
+ VSS VSS gf180mcu_fd_sc_mcu7t5v0__oai22_1
X_06787_ _06787_/A1 _06761_/Z _06787_/B _06816_/A1 VDD VDD VSS VSS
+ gf180mcu_fd_sc_mcu7t5v0__oai21_1
X_08526_ _08526_/A1 _08526_/A2 _08527_/C VDD VDD VSS VSS gf180mcu_fd_sc_mcu7t5v0__nand2_1
X_05738_ _10929_/Q _09480_/B2 VDD VDD VSS VSS gf180mcu_fd_sc_mcu7t5v0__clkinv_1
X_05669_ _10424_/Q _08807_/B2 VDD VDD VSS VSS gf180mcu_fd_sc_mcu7t5v0__clkinv_1
X_08457_ _08457_/A1 _08457_/A2 _08457_/A3 _08462_/A2 VDD VDD VSS VSS
+ gf180mcu_fd_sc_mcu7t5v0__nand3_2
X_07408_ _10121_/Q _07426_/A1 _07405_/Z _07408_/Z VDD VDD VSS VSS
+ gf180mcu_fd_sc_mcu7t5v0__xor3_1
X_08388_ _08388_/A1 _08388_/A2 _08388_/A3 _08388_/A4 _08430_/A1 VDD VDD
+ VSS VSS gf180mcu_fd_sc_mcu7t5v0__nand4_1
X_07339_ _10116_/Q _07341_/A2 _07349_/A2 VDD VDD VSS VSS gf180mcu_fd_sc_mcu7t5v0__nand2_2
X_10350_ _10350_/D _11149_/CLK _10350_/Q VDD VDD VSS VSS gf180mcu_fd_sc_mcu7t5v0__dffq_1
X_09009_ _09944_/A1 _09011_/A2 _09011_/B1 _09009_/B2 _10552_/D VDD VDD
+ VSS VSS gf180mcu_fd_sc_mcu7t5v0__oai22_1
X_10281_ _10281_/D _11139_/CLK _10281_/Q VDD VDD VSS VSS gf180mcu_fd_sc_mcu7t5v0__dffq_1
X_10617_ _10617_/D _10666_/CLK _10617_/Q VDD VDD VSS VSS gf180mcu_fd_sc_mcu7t5v0__dffq_1
X_10548_ _10548_/D _11142_/CLK _10548_/Q VDD VDD VSS VSS gf180mcu_fd_sc_mcu7t5v0__dffq_1
X_10479_ _10479_/D _11139_/CLK _10479_/Q VDD VDD VSS VSS gf180mcu_fd_sc_mcu7t5v0__dffq_1
X_04971_ _11064_/Q _05981_/A1 VDD VDD VSS VSS gf180mcu_fd_sc_mcu7t5v0__clkinv_1
X_06710_ _06698_/I _06710_/A2 _06711_/I VDD VDD VSS VSS gf180mcu_fd_sc_mcu7t5v0__xor2_1
X_07690_ _10154_/Q _07698_/A2 _07691_/B VDD VDD VSS VSS gf180mcu_fd_sc_mcu7t5v0__nand2_1
X_06641_ _10002_/Q _06850_/A2 _06641_/Z VDD VDD VSS VSS gf180mcu_fd_sc_mcu7t5v0__and2_1
X_09360_ _09897_/A1 _09361_/A2 _09361_/B1 _09360_/B2 _10833_/D VDD VDD
+ VSS VSS gf180mcu_fd_sc_mcu7t5v0__oai22_1
X_06572_ _06593_/A2 _06832_/A1 _06874_/A1 _06573_/B VDD VDD VSS VSS
+ gf180mcu_fd_sc_mcu7t5v0__nand3_1
X_05523_ _10383_/Q _08756_/B2 VDD VDD VSS VSS gf180mcu_fd_sc_mcu7t5v0__clkinv_1
X_09291_ _09916_/A1 _09291_/A2 _09291_/B1 _09291_/B2 _10778_/D VDD VDD
+ VSS VSS gf180mcu_fd_sc_mcu7t5v0__oai22_1
X_08311_ _10615_/Q _06877_/Z _08563_/C1 _10647_/Q _10655_/Q _08582_/A2 _08313_/A2
+ VDD VDD VSS VSS gf180mcu_fd_sc_mcu7t5v0__aoi222_2
X_08242_ _10526_/Q _08590_/B1 _08576_/B1 _10534_/Q _08244_/A2 VDD VDD
+ VSS VSS gf180mcu_fd_sc_mcu7t5v0__aoi22_1
X_05454_ _10734_/Q _09237_/B2 VDD VDD VSS VSS gf180mcu_fd_sc_mcu7t5v0__clkinv_1
X_05385_ _10917_/Q _09466_/B2 VDD VDD VSS VSS gf180mcu_fd_sc_mcu7t5v0__clkinv_1
X_08173_ _10485_/Q _08540_/A2 _08560_/B1 _10145_/Q _07255_/I _11160_/Q _08175_/A2
+ VDD VDD VSS VSS gf180mcu_fd_sc_mcu7t5v0__aoi222_2
X_07124_ _07124_/A1 _07216_/A2 _07124_/B1 _07124_/B2 _07226_/A2 VDD VDD
+ VSS VSS gf180mcu_fd_sc_mcu7t5v0__aoi22_4
X_07055_ _07055_/A1 _07055_/A2 _07054_/B _07056_/A2 VDD VDD VSS VSS
+ gf180mcu_fd_sc_mcu7t5v0__nand3_1
X_06006_ _10285_/Q _07829_/C _06008_/B VDD VDD VSS VSS gf180mcu_fd_sc_mcu7t5v0__nand2_1
X_07957_ _10207_/Q _08528_/A2 _06877_/Z _10231_/Q _07957_/C _07960_/A1 VDD VDD
+ VSS VSS gf180mcu_fd_sc_mcu7t5v0__aoi221_2
X_06908_ _10072_/Q _06916_/A2 _06909_/B VDD VDD VSS VSS gf180mcu_fd_sc_mcu7t5v0__nand2_1
X_07888_ _07888_/A1 _07890_/A2 _07888_/B _10264_/D VDD VDD VSS VSS
+ gf180mcu_fd_sc_mcu7t5v0__aoi21_1
X_09627_ _09645_/A1 _09889_/A1 _09900_/B _09642_/A2 VDD VDD VSS VSS
+ gf180mcu_fd_sc_mcu7t5v0__aoi21_4
X_06839_ _06839_/A1 _06839_/A2 _06839_/B _06862_/A2 VDD VDD VSS VSS
+ gf180mcu_fd_sc_mcu7t5v0__oai21_1
X_09558_ _10982_/Q _09566_/A2 _09559_/B VDD VDD VSS VSS gf180mcu_fd_sc_mcu7t5v0__nand2_1
X_08509_ _10361_/Q _08540_/A2 _08560_/B1 _10529_/Q _08589_/B1 _10897_/Q _08511_/A2
+ VDD VDD VSS VSS gf180mcu_fd_sc_mcu7t5v0__aoi222_2
X_09489_ _09944_/A1 _09491_/A2 _09491_/B1 _09489_/B2 _10936_/D VDD VDD
+ VSS VSS gf180mcu_fd_sc_mcu7t5v0__oai22_1
X_10402_ _10402_/D _11018_/CLK _10402_/Q VDD VDD VSS VSS gf180mcu_fd_sc_mcu7t5v0__dffq_1
X_10333_ _10333_/D _11150_/CLK _10333_/Q VDD VDD VSS VSS gf180mcu_fd_sc_mcu7t5v0__dffq_1
X_10264_ _10264_/D _11097_/CLK _10264_/Q VDD VDD VSS VSS gf180mcu_fd_sc_mcu7t5v0__dffq_1
X_10195_ _10195_/D _11097_/CLK _10195_/Q VDD VDD VSS VSS gf180mcu_fd_sc_mcu7t5v0__dffq_1
X_05170_ _10955_/Q _09514_/B2 VDD VDD VSS VSS gf180mcu_fd_sc_mcu7t5v0__clkinv_1
X_08860_ _10453_/Q _08856_/Z _08872_/B _08861_/A2 VDD VDD VSS VSS
+ gf180mcu_fd_sc_mcu7t5v0__oai21_1
X_07811_ _06047_/Z _07825_/A2 _07811_/B _10231_/D VDD VDD VSS VSS
+ gf180mcu_fd_sc_mcu7t5v0__oai21_1
X_08791_ _09918_/A1 _08799_/A2 _08799_/B1 VDD VDD VSS VSS gf180mcu_fd_sc_mcu7t5v0__nand2_2
X_07742_ _09940_/A1 _07748_/A2 _07748_/B1 _07742_/B2 _10184_/D VDD VDD
+ VSS VSS gf180mcu_fd_sc_mcu7t5v0__oai22_1
X_07673_ _09921_/A1 _07678_/A2 _07678_/B1 _07673_/B2 _10145_/D VDD VDD
+ VSS VSS gf180mcu_fd_sc_mcu7t5v0__oai22_1
X_09412_ _09927_/A2 _09412_/A2 _09421_/A2 VDD VDD VSS VSS gf180mcu_fd_sc_mcu7t5v0__nand2_4
X_06624_ _10002_/Q _06661_/A2 _06661_/A3 _06664_/A1 VDD VDD VSS VSS
+ gf180mcu_fd_sc_mcu7t5v0__nand3_1
X_09343_ _09890_/A1 _09351_/A2 _09351_/B1 VDD VDD VSS VSS gf180mcu_fd_sc_mcu7t5v0__nand2_2
X_06555_ _10331_/Q _10044_/Q _06556_/B VDD VDD VSS VSS gf180mcu_fd_sc_mcu7t5v0__nand2_1
X_09274_ _06047_/Z _09281_/A2 _09281_/B1 _09274_/B2 _10763_/D VDD VDD
+ VSS VSS gf180mcu_fd_sc_mcu7t5v0__oai22_1
X_05506_ _10846_/Q _09377_/B2 VDD VDD VSS VSS gf180mcu_fd_sc_mcu7t5v0__clkinv_1
X_06486_ _07252_/A1 _06198_/Z _06486_/B _06508_/B1 VDD VDD VSS VSS
+ gf180mcu_fd_sc_mcu7t5v0__oai21_2
X_08225_ _10566_/Q _08564_/C1 _08584_/B1 _10598_/Q _08228_/A1 VDD VDD
+ VSS VSS gf180mcu_fd_sc_mcu7t5v0__aoi22_1
X_05437_ _10606_/Q _09077_/B2 VDD VDD VSS VSS gf180mcu_fd_sc_mcu7t5v0__clkinv_1
X_05368_ _10341_/Q _08704_/B2 VDD VDD VSS VSS gf180mcu_fd_sc_mcu7t5v0__clkinv_1
X_08156_ _08156_/A1 _08156_/A2 _08156_/A3 _08162_/A2 VDD VDD VSS VSS
+ gf180mcu_fd_sc_mcu7t5v0__nand3_1
X_07107_ _10004_/Q _07107_/A2 _07108_/B VDD VDD VSS VSS gf180mcu_fd_sc_mcu7t5v0__xor2_1
X_05299_ _10413_/Q _08794_/B2 VDD VDD VSS VSS gf180mcu_fd_sc_mcu7t5v0__clkinv_1
X_08087_ _10900_/Q _08584_/A2 _06877_/Z _10184_/Q _08088_/A3 VDD VDD VSS
+ VSS gf180mcu_fd_sc_mcu7t5v0__aoi22_1
X_07038_ _10003_/Q _07222_/A2 _07181_/A2 _10002_/Q _07078_/A2 VDD VDD
+ VSS VSS gf180mcu_fd_sc_mcu7t5v0__aoi22_1
X_08989_ _09924_/A1 _08991_/A2 _08991_/B1 _08989_/B2 _10536_/D VDD VDD
+ VSS VSS gf180mcu_fd_sc_mcu7t5v0__oai22_1
X_10951_ _10951_/D _11149_/CLK _10951_/Q VDD VDD VSS VSS gf180mcu_fd_sc_mcu7t5v0__dffq_1
X_10882_ _10882_/D _11165_/CLK _10882_/Q VDD VDD VSS VSS gf180mcu_fd_sc_mcu7t5v0__dffq_1
Xclkbuf_1_0_0_clk clkbuf_0_clk/Z clkbuf_1_0_0_clk/Z VDD VDD VSS VSS
+ gf180mcu_fd_sc_mcu7t5v0__clkbuf_2
X_10316_ _10316_/D _11052_/CLK _10316_/Q VDD VDD VSS VSS gf180mcu_fd_sc_mcu7t5v0__dffq_1
X_10247_ _10247_/D _11150_/CLK _10247_/Q VDD VDD VSS VSS gf180mcu_fd_sc_mcu7t5v0__dffq_1
X_10178_ _10178_/D _11017_/CLK _10178_/Q VDD VDD VSS VSS gf180mcu_fd_sc_mcu7t5v0__dffq_1
X_06340_ _10001_/Q _06484_/A2 _06434_/A1 VDD VDD VSS VSS gf180mcu_fd_sc_mcu7t5v0__nand2_1
X_06271_ _06271_/A1 _06269_/Z _06271_/Z VDD VDD VSS VSS gf180mcu_fd_sc_mcu7t5v0__xor2_1
X_05222_ _10580_/Q _09045_/B2 VDD VDD VSS VSS gf180mcu_fd_sc_mcu7t5v0__clkinv_1
X_08010_ _09568_/A2 _08010_/A2 _08010_/B1 _09645_/A1 _08011_/A3 VDD VDD
+ VSS VSS gf180mcu_fd_sc_mcu7t5v0__aoi22_2
X_05153_ _11118_/Q _09853_/B2 VDD VDD VSS VSS gf180mcu_fd_sc_mcu7t5v0__clkinv_1
X_09961_ _09961_/D _10905_/CLK _09961_/Q VDD VDD VSS VSS gf180mcu_fd_sc_mcu7t5v0__dffq_1
X_05084_ _10288_/Q _09724_/A2 VDD VDD VSS VSS gf180mcu_fd_sc_mcu7t5v0__clkinv_1
Xrepeater1 _08476_/C1 _08563_/C1 VDD VDD VSS VSS gf180mcu_fd_sc_mcu7t5v0__buf_16
X_08912_ _10478_/Q _08920_/A2 _08913_/B VDD VDD VSS VSS gf180mcu_fd_sc_mcu7t5v0__nand2_1
X_09892_ _09920_/A1 _09898_/A2 _09898_/B1 _09892_/B2 _11143_/D VDD VDD
+ VSS VSS gf180mcu_fd_sc_mcu7t5v0__oai22_1
X_08843_ _08831_/I _08843_/A2 _08842_/Z _10447_/D VDD VDD VSS VSS
+ gf180mcu_fd_sc_mcu7t5v0__nor3_1
X_08774_ _09921_/A1 _08779_/A2 _08779_/B1 _08774_/B2 _10397_/D VDD VDD
+ VSS VSS gf180mcu_fd_sc_mcu7t5v0__oai22_1
X_05986_ _05986_/I _07843_/A2 VDD VDD VSS VSS gf180mcu_fd_sc_mcu7t5v0__inv_1
X_07725_ _09537_/A1 _07727_/A2 _07725_/B _10173_/D VDD VDD VSS VSS
+ gf180mcu_fd_sc_mcu7t5v0__oai21_1
X_07656_ _10134_/Q _07656_/A2 _07657_/B VDD VDD VSS VSS gf180mcu_fd_sc_mcu7t5v0__nand2_1
X_07587_ _10125_/Q _07585_/Z _07587_/Z VDD VDD VSS VSS gf180mcu_fd_sc_mcu7t5v0__or2_1
X_06607_ _06607_/A1 _06604_/Z _06607_/B _06613_/A2 VDD VDD VSS VSS
+ gf180mcu_fd_sc_mcu7t5v0__aoi21_1
X_09326_ _09921_/A1 _09331_/A2 _09331_/B1 _09326_/B2 _10805_/D VDD VDD
+ VSS VSS gf180mcu_fd_sc_mcu7t5v0__oai22_1
X_06538_ _06061_/Z _06541_/A2 _06541_/B1 _06538_/B2 _10036_/D VDD VDD
+ VSS VSS gf180mcu_fd_sc_mcu7t5v0__oai22_1
X_09257_ _06058_/Z _09261_/A2 _09261_/B1 _09257_/B2 _10750_/D VDD VDD
+ VSS VSS gf180mcu_fd_sc_mcu7t5v0__oai22_1
X_08208_ _08208_/A1 _08208_/A2 _08208_/A3 _08209_/B VDD VDD VSS VSS
+ gf180mcu_fd_sc_mcu7t5v0__nand3_1
X_06469_ _06505_/A1 _06502_/A1 _06470_/A2 VDD VDD VSS VSS gf180mcu_fd_sc_mcu7t5v0__nand2_1
X_09188_ _06061_/Z _09191_/A2 _09191_/B1 _09188_/B2 _10695_/D VDD VDD
+ VSS VSS gf180mcu_fd_sc_mcu7t5v0__oai22_1
X_08139_ _10525_/Q _08590_/B1 _08576_/B1 _10533_/Q _08139_/C _08140_/B VDD VDD
+ VSS VSS gf180mcu_fd_sc_mcu7t5v0__aoi221_1
X_11150_ _11150_/D _11150_/CLK _11150_/Q VDD VDD VSS VSS gf180mcu_fd_sc_mcu7t5v0__dffq_1
X_10101_ _10101_/D _11052_/CLK _10101_/Q VDD VDD VSS VSS gf180mcu_fd_sc_mcu7t5v0__dffq_1
X_11081_ _11081_/D _11082_/CLK _11081_/Q VDD VDD VSS VSS gf180mcu_fd_sc_mcu7t5v0__dffq_1
X_10032_ _10032_/D _11181_/CLK _10032_/Q VDD VDD VSS VSS gf180mcu_fd_sc_mcu7t5v0__dffq_1
X_10934_ _10934_/D _11149_/CLK _10934_/Q VDD VDD VSS VSS gf180mcu_fd_sc_mcu7t5v0__dffq_1
X_10865_ _10865_/D _11142_/CLK _10865_/Q VDD VDD VSS VSS gf180mcu_fd_sc_mcu7t5v0__dffq_1
X_10796_ _10796_/D _11109_/CLK _10796_/Q VDD VDD VSS VSS gf180mcu_fd_sc_mcu7t5v0__dffq_1
X_05840_ _10394_/Q _08769_/B2 VDD VDD VSS VSS gf180mcu_fd_sc_mcu7t5v0__clkinv_1
X_05771_ _10729_/Q _09230_/B2 VDD VDD VSS VSS gf180mcu_fd_sc_mcu7t5v0__clkinv_1
X_07510_ _10002_/Q _07428_/I _07614_/A1 VDD VDD VSS VSS gf180mcu_fd_sc_mcu7t5v0__nand2_1
X_08490_ _10497_/Q _08589_/B1 _08576_/B1 _11164_/Q _08591_/B1 _10433_/Q _08491_/A3
+ VDD VDD VSS VSS gf180mcu_fd_sc_mcu7t5v0__aoi222_1
X_07441_ _07404_/Z _07438_/Z _07441_/Z VDD VDD VSS VSS gf180mcu_fd_sc_mcu7t5v0__xor2_1
X_07372_ _07373_/A1 _07371_/Z _07414_/A2 VDD VDD VSS VSS gf180mcu_fd_sc_mcu7t5v0__nor2_1
X_09111_ _09946_/A1 _09111_/A2 _09111_/B1 _09111_/B2 _10634_/D VDD VDD
+ VSS VSS gf180mcu_fd_sc_mcu7t5v0__oai22_1
X_06323_ _06212_/Z _06368_/A2 _06330_/A2 VDD VDD VSS VSS gf180mcu_fd_sc_mcu7t5v0__nand2_1
X_09042_ _09937_/A2 _09062_/A2 _09051_/A2 VDD VDD VSS VSS gf180mcu_fd_sc_mcu7t5v0__nand2_4
X_06254_ _06964_/A1 _06250_/Z _06255_/I VDD VDD VSS VSS gf180mcu_fd_sc_mcu7t5v0__nor2_1
X_05205_ _10380_/Q _08753_/B2 VDD VDD VSS VSS gf180mcu_fd_sc_mcu7t5v0__clkinv_1
X_06185_ _10334_/Q _08675_/A2 _08672_/B _06186_/B VDD VDD VSS VSS
+ gf180mcu_fd_sc_mcu7t5v0__oai21_1
X_05136_ _10731_/Q _09234_/B2 VDD VDD VSS VSS gf180mcu_fd_sc_mcu7t5v0__clkinv_1
X_05067_ _09997_/Q _06222_/A1 VDD VDD VSS VSS gf180mcu_fd_sc_mcu7t5v0__inv_2
X_09944_ _09944_/A1 _09946_/A2 _09946_/B1 _09944_/B2 _11179_/D VDD VDD
+ VSS VSS gf180mcu_fd_sc_mcu7t5v0__oai22_1
X_09875_ _11135_/Q _09887_/A2 _09876_/B VDD VDD VSS VSS gf180mcu_fd_sc_mcu7t5v0__nand2_1
X_08826_ _06061_/Z _08829_/A2 _08829_/B1 _08826_/B2 _10439_/D VDD VDD
+ VSS VSS gf180mcu_fd_sc_mcu7t5v0__oai22_1
X_08757_ _09896_/A1 _08759_/A2 _08759_/B1 _08757_/B2 _10384_/D VDD VDD
+ VSS VSS gf180mcu_fd_sc_mcu7t5v0__oai22_1
X_05969_ _10303_/Q _09796_/A2 _09795_/A2 VDD VDD VSS VSS gf180mcu_fd_sc_mcu7t5v0__nand2_4
X_08688_ _10284_/Q _08621_/I _08690_/A1 VDD VDD VSS VSS gf180mcu_fd_sc_mcu7t5v0__nand2_1
X_07708_ _09945_/A1 _07709_/A2 _07709_/B1 _07708_/B2 _10165_/D VDD VDD
+ VSS VSS gf180mcu_fd_sc_mcu7t5v0__oai22_1
X_07639_ _07603_/B _07639_/A2 _07639_/A3 _10126_/D VDD VDD VSS VSS
+ gf180mcu_fd_sc_mcu7t5v0__nor3_1
X_10650_ _10650_/D _11176_/CLK _10650_/Q VDD VDD VSS VSS gf180mcu_fd_sc_mcu7t5v0__dffq_1
X_09309_ _09924_/A1 _09311_/A2 _09311_/B1 _09309_/B2 _10792_/D VDD VDD
+ VSS VSS gf180mcu_fd_sc_mcu7t5v0__oai22_1
X_10581_ _10581_/D _10666_/CLK _10581_/Q VDD VDD VSS VSS gf180mcu_fd_sc_mcu7t5v0__dffq_1
X_11133_ _11133_/D _11149_/CLK _11133_/Q VDD VDD VSS VSS gf180mcu_fd_sc_mcu7t5v0__dffq_1
X_11064_ _11064_/D _11097_/CLK _11064_/Q VDD VDD VSS VSS gf180mcu_fd_sc_mcu7t5v0__dffq_1
X_10015_ _10015_/D _10327_/CLK _10015_/Q VDD VDD VSS VSS gf180mcu_fd_sc_mcu7t5v0__dffq_1
X_10917_ _10917_/D _10978_/CLK _10917_/Q VDD VDD VSS VSS gf180mcu_fd_sc_mcu7t5v0__dffq_1
X_10848_ _10848_/D _11138_/CLK _10848_/Q VDD VDD VSS VSS gf180mcu_fd_sc_mcu7t5v0__dffq_1
X_10779_ _10779_/D _11164_/CLK _10779_/Q VDD VDD VSS VSS gf180mcu_fd_sc_mcu7t5v0__dffq_1
X_07990_ _10159_/Q _06023_/I _08564_/C1 _10135_/Q _07990_/C _07993_/A1 VDD VDD
+ VSS VSS gf180mcu_fd_sc_mcu7t5v0__aoi221_2
X_06941_ _10079_/Q _10078_/Q _06966_/A2 VDD VDD VSS VSS gf180mcu_fd_sc_mcu7t5v0__nor2_1
X_09660_ _11042_/Q _09660_/A2 _09661_/B VDD VDD VSS VSS gf180mcu_fd_sc_mcu7t5v0__nand2_1
X_08611_ _06047_/Z _08618_/A2 _08618_/B1 _08611_/B2 _10304_/D VDD VDD
+ VSS VSS gf180mcu_fd_sc_mcu7t5v0__oai22_1
X_06872_ _06872_/I0 _06872_/I1 _06872_/S _06873_/C VDD VDD VSS VSS
+ gf180mcu_fd_sc_mcu7t5v0__mux2_1
X_05823_ _10841_/Q _09370_/B2 VDD VDD VSS VSS gf180mcu_fd_sc_mcu7t5v0__clkinv_1
X_09591_ _09904_/A1 _09597_/A2 _09597_/B1 _09591_/B2 _11004_/D VDD VDD
+ VSS VSS gf180mcu_fd_sc_mcu7t5v0__oai22_1
X_08542_ _09311_/B2 _08542_/A2 _08581_/A2 _09281_/B2 _08543_/C VDD VDD
+ VSS VSS gf180mcu_fd_sc_mcu7t5v0__oai22_1
X_05754_ _10601_/Q _09070_/B2 VDD VDD VSS VSS gf180mcu_fd_sc_mcu7t5v0__clkinv_1
X_08473_ _08473_/A1 _08473_/A2 _08473_/A3 _08473_/A4 _08514_/A1 VDD VDD
+ VSS VSS gf180mcu_fd_sc_mcu7t5v0__nand4_1
X_05685_ _10352_/Q _08717_/B2 VDD VDD VSS VSS gf180mcu_fd_sc_mcu7t5v0__clkinv_1
X_07424_ _07603_/B _07424_/A2 _10121_/D VDD VDD VSS VSS gf180mcu_fd_sc_mcu7t5v0__nor2_1
X_07355_ _07358_/A1 _07381_/A1 _07391_/A1 VDD VDD VSS VSS gf180mcu_fd_sc_mcu7t5v0__nor2_1
X_06306_ _06307_/A2 _06351_/A1 _06306_/A3 _06351_/A2 VDD VDD VSS VSS
+ gf180mcu_fd_sc_mcu7t5v0__nor3_2
X_07286_ _10102_/Q _07292_/A2 _07287_/B VDD VDD VSS VSS gf180mcu_fd_sc_mcu7t5v0__nand2_1
X_09025_ _09940_/A1 _09031_/A2 _09031_/B1 _09025_/B2 _10564_/D VDD VDD
+ VSS VSS gf180mcu_fd_sc_mcu7t5v0__oai22_1
X_06237_ _09995_/Q _06237_/A2 _06502_/B VDD VDD VSS VSS gf180mcu_fd_sc_mcu7t5v0__nand2_2
X_06168_ _06168_/A1 _10313_/Q _10312_/Q _08675_/A2 VDD VDD VSS VSS
+ gf180mcu_fd_sc_mcu7t5v0__nand3_4
X_05119_ _10603_/Q _09074_/B2 VDD VDD VSS VSS gf180mcu_fd_sc_mcu7t5v0__clkinv_1
X_06099_ _06021_/Z _07682_/A1 _07254_/A2 _06099_/ZN VDD VDD VSS VSS
+ gf180mcu_fd_sc_mcu7t5v0__nor3_4
X_09927_ _09937_/A1 _09927_/A2 _09936_/A2 VDD VDD VSS VSS gf180mcu_fd_sc_mcu7t5v0__nand2_4
X_09858_ _09896_/A1 _09860_/A2 _09860_/B1 _09858_/B2 _11123_/D VDD VDD
+ VSS VSS gf180mcu_fd_sc_mcu7t5v0__oai22_1
X_08809_ _09832_/A1 _08809_/A2 _08809_/B1 _08809_/B2 _10426_/D VDD VDD
+ VSS VSS gf180mcu_fd_sc_mcu7t5v0__oai22_1
X_09789_ _09789_/A1 _09795_/A2 _09789_/B _11087_/D VDD VDD VSS VSS
+ gf180mcu_fd_sc_mcu7t5v0__aoi21_1
X_10702_ _10702_/D _10905_/CLK _10702_/Q VDD VDD VSS VSS gf180mcu_fd_sc_mcu7t5v0__dffq_1
X_10633_ _10633_/D _10978_/CLK _10633_/Q VDD VDD VSS VSS gf180mcu_fd_sc_mcu7t5v0__dffq_1
X_10564_ _10564_/D _10666_/CLK _10564_/Q VDD VDD VSS VSS gf180mcu_fd_sc_mcu7t5v0__dffq_1
X_10495_ _10495_/D _11017_/CLK _10495_/Q VDD VDD VSS VSS gf180mcu_fd_sc_mcu7t5v0__dffq_1
X_11116_ _11116_/D _11163_/CLK _11116_/Q VDD VDD VSS VSS gf180mcu_fd_sc_mcu7t5v0__dffq_1
X_11047_ _11047_/D _11147_/CLK _11047_/Q VDD VDD VSS VSS gf180mcu_fd_sc_mcu7t5v0__dffq_1
X_05470_ _11145_/Q _09894_/B2 VDD VDD VSS VSS gf180mcu_fd_sc_mcu7t5v0__clkinv_1
X_07140_ _07140_/A1 _07139_/B _07140_/Z VDD VDD VSS VSS gf180mcu_fd_sc_mcu7t5v0__xor2_1
X_07071_ _08669_/A1 _07217_/B1 _07071_/B1 _07071_/B2 _07199_/A1 VDD VDD
+ VSS VSS gf180mcu_fd_sc_mcu7t5v0__aoi22_4
X_06022_ _06124_/A1 _06021_/Z _08560_/A2 VDD VDD VSS VSS gf180mcu_fd_sc_mcu7t5v0__nor2_4
X_07973_ _09384_/B2 _08542_/A2 _08581_/A2 _09354_/B2 _07974_/C VDD VDD
+ VSS VSS gf180mcu_fd_sc_mcu7t5v0__oai22_1
X_09712_ _09722_/A1 bus_wdata[7] _09713_/A2 VDD VDD VSS VSS gf180mcu_fd_sc_mcu7t5v0__nand2_1
X_06924_ _10247_/Q _08675_/A2 _08672_/B _06925_/B VDD VDD VSS VSS
+ gf180mcu_fd_sc_mcu7t5v0__oai21_1
X_09643_ _09916_/A1 _09643_/A2 _09643_/B _11034_/D VDD VDD VSS VSS
+ gf180mcu_fd_sc_mcu7t5v0__oai21_1
X_06855_ _06855_/A1 _06855_/A2 _06855_/Z VDD VDD VSS VSS gf180mcu_fd_sc_mcu7t5v0__xor2_1
X_09574_ _06061_/Z _09577_/A2 _09577_/B1 _09574_/B2 _10991_/D VDD VDD
+ VSS VSS gf180mcu_fd_sc_mcu7t5v0__oai22_1
X_05806_ _10961_/Q _09520_/B2 VDD VDD VSS VSS gf180mcu_fd_sc_mcu7t5v0__clkinv_1
X_08525_ _11149_/Q _08555_/A2 _06125_/I _10354_/Q _07680_/I _10230_/Q _08526_/A2 VDD
+ VDD VSS VSS gf180mcu_fd_sc_mcu7t5v0__aoi222_2
X_06786_ _06786_/A1 _06767_/Z _06786_/B _06839_/A1 VDD VDD VSS VSS
+ gf180mcu_fd_sc_mcu7t5v0__aoi21_1
X_05737_ _10945_/Q _09500_/B2 VDD VDD VSS VSS gf180mcu_fd_sc_mcu7t5v0__clkinv_1
X_05668_ _11048_/Q _09669_/B2 VDD VDD VSS VSS gf180mcu_fd_sc_mcu7t5v0__clkinv_1
X_08456_ _10067_/Q _08530_/A2 _08528_/B1 _09977_/Q _08457_/A3 VDD VDD
+ VSS VSS gf180mcu_fd_sc_mcu7t5v0__aoi22_2
X_08387_ _08588_/B _08387_/A2 _08387_/B1 _09823_/A2 _08388_/A4 VDD VDD
+ VSS VSS gf180mcu_fd_sc_mcu7t5v0__aoi22_1
X_07407_ _10121_/Q _07405_/Z _07426_/B VDD VDD VSS VSS gf180mcu_fd_sc_mcu7t5v0__nand2_1
X_05599_ _11130_/Q _09867_/B2 VDD VDD VSS VSS gf180mcu_fd_sc_mcu7t5v0__clkinv_1
X_07338_ _10000_/Q _07609_/A2 _07381_/A1 VDD VDD VSS VSS gf180mcu_fd_sc_mcu7t5v0__nand2_2
X_07269_ _06061_/Z _07275_/A2 _07269_/B _10094_/D VDD VDD VSS VSS
+ gf180mcu_fd_sc_mcu7t5v0__oai21_1
X_09008_ _06061_/Z _09011_/A2 _09011_/B1 _09008_/B2 _10551_/D VDD VDD
+ VSS VSS gf180mcu_fd_sc_mcu7t5v0__oai22_1
X_10280_ _10280_/D _11139_/CLK _10280_/Q VDD VDD VSS VSS gf180mcu_fd_sc_mcu7t5v0__dffq_2
X_10616_ _10616_/D _11176_/CLK _10616_/Q VDD VDD VSS VSS gf180mcu_fd_sc_mcu7t5v0__dffq_1
X_10547_ _10547_/D _11142_/CLK _10547_/Q VDD VDD VSS VSS gf180mcu_fd_sc_mcu7t5v0__dffq_1
X_10478_ _10478_/D _11150_/CLK _10478_/Q VDD VDD VSS VSS gf180mcu_fd_sc_mcu7t5v0__dffq_1
X_04970_ _11098_/Q _09812_/A1 VDD VDD VSS VSS gf180mcu_fd_sc_mcu7t5v0__clkinv_1
X_06640_ _10002_/Q _06850_/A2 _06644_/B2 VDD VDD VSS VSS gf180mcu_fd_sc_mcu7t5v0__nor2_1
X_06571_ _10042_/Q _06571_/A2 _10040_/Q _06874_/A1 VDD VDD VSS VSS
+ gf180mcu_fd_sc_mcu7t5v0__nand3_2
X_05522_ _10391_/Q _08766_/B2 VDD VDD VSS VSS gf180mcu_fd_sc_mcu7t5v0__clkinv_1
X_08310_ _10623_/Q _06023_/I _08564_/C1 _10631_/Q _08313_/A1 VDD VDD VSS
+ VSS gf180mcu_fd_sc_mcu7t5v0__aoi22_1
X_09290_ _09925_/A1 _09291_/A2 _09291_/B1 _09290_/B2 _10777_/D VDD VDD
+ VSS VSS gf180mcu_fd_sc_mcu7t5v0__oai22_1
X_05453_ _10726_/Q _09227_/B2 VDD VDD VSS VSS gf180mcu_fd_sc_mcu7t5v0__clkinv_1
X_08241_ _10358_/Q _08540_/A2 _08559_/A2 _11105_/Q _08241_/C _08244_/A1 VDD
+ VDD VSS VSS gf180mcu_fd_sc_mcu7t5v0__aoi221_2
X_05384_ _10933_/Q _09486_/B2 VDD VDD VSS VSS gf180mcu_fd_sc_mcu7t5v0__clkinv_1
X_08172_ _10413_/Q _08589_/A2 _08589_/B1 _10493_/Q _08175_/A1 VDD VDD
+ VSS VSS gf180mcu_fd_sc_mcu7t5v0__aoi22_1
X_07123_ _10124_/Q _10080_/Q _07124_/B2 VDD VDD VSS VSS gf180mcu_fd_sc_mcu7t5v0__nand2_1
X_07054_ _07055_/A1 _07055_/A2 _07054_/B _07109_/A2 VDD VDD VSS VSS
+ gf180mcu_fd_sc_mcu7t5v0__aoi21_1
X_06005_ _09728_/A1 _06005_/A2 _06005_/B bus_rdata[4] VDD VDD VSS VSS
+ gf180mcu_fd_sc_mcu7t5v0__oai21_4
X_07956_ _07956_/I _07957_/C VDD VDD VSS VSS gf180mcu_fd_sc_mcu7t5v0__clkinv_1
X_06907_ _09941_/A1 _06917_/A2 _06907_/B _10071_/D VDD VDD VSS VSS
+ gf180mcu_fd_sc_mcu7t5v0__oai21_1
X_07887_ bus_wdata[5] _07890_/A2 rst_n _07888_/B VDD VDD VSS VSS gf180mcu_fd_sc_mcu7t5v0__oai21_1
X_09626_ _09645_/A1 _09889_/A1 _09643_/A2 VDD VDD VSS VSS gf180mcu_fd_sc_mcu7t5v0__nand2_2
X_06838_ _07603_/B _06838_/A2 _10051_/D VDD VDD VSS VSS gf180mcu_fd_sc_mcu7t5v0__nor2_1
X_09557_ _09921_/A1 _09567_/A2 _09557_/B _10981_/D VDD VDD VSS VSS
+ gf180mcu_fd_sc_mcu7t5v0__oai21_1
X_06769_ _10050_/Q _06786_/A1 _06766_/Z _06769_/Z VDD VDD VSS VSS
+ gf180mcu_fd_sc_mcu7t5v0__xor3_1
X_08508_ _10513_/Q _06112_/I _08591_/B1 _10521_/Q _08591_/C1 _10505_/Q _08511_/A1
+ VDD VDD VSS VSS gf180mcu_fd_sc_mcu7t5v0__aoi222_2
X_09488_ _06061_/Z _09491_/A2 _09491_/B1 _09488_/B2 _10935_/D VDD VDD
+ VSS VSS gf180mcu_fd_sc_mcu7t5v0__oai22_1
X_08439_ _08439_/I _08440_/C VDD VDD VSS VSS gf180mcu_fd_sc_mcu7t5v0__clkinv_1
X_10401_ _10401_/D _11018_/CLK _10401_/Q VDD VDD VSS VSS gf180mcu_fd_sc_mcu7t5v0__dffq_1
X_10332_ _10332_/D _11150_/CLK _10332_/Q VDD VDD VSS VSS gf180mcu_fd_sc_mcu7t5v0__dffq_1
X_10263_ _10263_/D _11052_/CLK _10263_/Q VDD VDD VSS VSS gf180mcu_fd_sc_mcu7t5v0__dffq_1
X_10194_ _10194_/D _11097_/CLK _10194_/Q VDD VDD VSS VSS gf180mcu_fd_sc_mcu7t5v0__dffq_1
X_08790_ _09889_/A1 _09917_/A2 _08799_/A2 VDD VDD VSS VSS gf180mcu_fd_sc_mcu7t5v0__nand2_4
X_07810_ _10231_/Q _07824_/A2 _07811_/B VDD VDD VSS VSS gf180mcu_fd_sc_mcu7t5v0__nand2_1
X_07741_ _06047_/Z _07748_/A2 _07748_/B1 _07741_/B2 _10183_/D VDD VDD
+ VSS VSS gf180mcu_fd_sc_mcu7t5v0__oai22_1
X_07672_ _09920_/A1 _07678_/A2 _07678_/B1 _07672_/B2 _10144_/D VDD VDD
+ VSS VSS gf180mcu_fd_sc_mcu7t5v0__oai22_1
X_09411_ _09926_/A1 _09411_/A2 _09411_/B1 _09411_/B2 _10874_/D VDD VDD
+ VSS VSS gf180mcu_fd_sc_mcu7t5v0__oai22_1
X_06623_ _10002_/Q _06700_/A2 _06700_/A3 _06627_/A3 VDD VDD VSS VSS
+ gf180mcu_fd_sc_mcu7t5v0__nand3_1
X_09342_ _09889_/A1 _09412_/A2 _09351_/A2 VDD VDD VSS VSS gf180mcu_fd_sc_mcu7t5v0__nand2_4
Xclkbuf_leaf_17_clk clkbuf_1_1_0_clk/Z _10327_/CLK VDD VDD VSS VSS
+ gf180mcu_fd_sc_mcu7t5v0__clkbuf_16
X_06554_ _10119_/Q _10044_/Q _06556_/A2 VDD VDD VSS VSS gf180mcu_fd_sc_mcu7t5v0__nor2_1
X_05505_ _10838_/Q _09367_/B2 VDD VDD VSS VSS gf180mcu_fd_sc_mcu7t5v0__clkinv_1
X_09273_ _09433_/A1 _09281_/A2 _09281_/B1 VDD VDD VSS VSS gf180mcu_fd_sc_mcu7t5v0__nand2_2
X_06485_ _10052_/Q _06195_/Z _06486_/B VDD VDD VSS VSS gf180mcu_fd_sc_mcu7t5v0__nand2_1
X_08224_ _08345_/A1 _08224_/A2 _08224_/B _08268_/B1 VDD VDD VSS VSS
+ gf180mcu_fd_sc_mcu7t5v0__aoi21_1
X_05436_ _10598_/Q _09067_/B2 VDD VDD VSS VSS gf180mcu_fd_sc_mcu7t5v0__clkinv_1
X_05367_ _10349_/Q _08714_/B2 VDD VDD VSS VSS gf180mcu_fd_sc_mcu7t5v0__clkinv_1
X_08155_ _10541_/Q _08555_/A2 _07680_/I _10581_/Q _08155_/C _08156_/A3 VDD VDD
+ VSS VSS gf180mcu_fd_sc_mcu7t5v0__aoi221_1
X_07106_ _10004_/Q _07107_/A2 _07152_/A1 VDD VDD VSS VSS gf180mcu_fd_sc_mcu7t5v0__nand2_1
X_05298_ _10876_/Q _09415_/B2 VDD VDD VSS VSS gf180mcu_fd_sc_mcu7t5v0__clkinv_1
X_08086_ _10160_/Q _06023_/I _08564_/C1 _10136_/Q _08088_/A2 VDD VDD VSS
+ VSS gf180mcu_fd_sc_mcu7t5v0__aoi22_1
X_07037_ _10003_/Q _10002_/Q _07222_/A2 _07181_/A2 _07078_/B VDD VDD VSS
+ VSS gf180mcu_fd_sc_mcu7t5v0__nand4_2
X_08988_ _06061_/Z _08991_/A2 _08991_/B1 _08988_/B2 _10535_/D VDD VDD
+ VSS VSS gf180mcu_fd_sc_mcu7t5v0__oai22_1
X_07939_ _10523_/Q _08590_/B1 _08591_/B1 _10515_/Q _07943_/A1 VDD VDD
+ VSS VSS gf180mcu_fd_sc_mcu7t5v0__aoi22_2
X_10950_ _10950_/D _11149_/CLK _10950_/Q VDD VDD VSS VSS gf180mcu_fd_sc_mcu7t5v0__dffq_1
X_10881_ _10881_/D _11142_/CLK _10881_/Q VDD VDD VSS VSS gf180mcu_fd_sc_mcu7t5v0__dffq_1
X_09609_ _09645_/A1 _09937_/A2 _09900_/B _09624_/A2 VDD VDD VSS VSS
+ gf180mcu_fd_sc_mcu7t5v0__aoi21_4
X_10315_ _10315_/D _10327_/CLK cgra_status[1] VDD VDD VSS VSS gf180mcu_fd_sc_mcu7t5v0__dffq_2
X_10246_ _10246_/D _11150_/CLK _10246_/Q VDD VDD VSS VSS gf180mcu_fd_sc_mcu7t5v0__dffq_1
X_10177_ _10177_/D _11017_/CLK _10177_/Q VDD VDD VSS VSS gf180mcu_fd_sc_mcu7t5v0__dffq_1
X_06270_ _06270_/A1 _06270_/A2 _06269_/Z _06312_/A1 VDD VDD VSS VSS
+ gf180mcu_fd_sc_mcu7t5v0__nor3_1
X_05221_ _10572_/Q _09035_/B2 VDD VDD VSS VSS gf180mcu_fd_sc_mcu7t5v0__clkinv_1
X_05152_ _11142_/Q _09891_/B2 VDD VDD VSS VSS gf180mcu_fd_sc_mcu7t5v0__clkinv_1
Xclkbuf_leaf_6_clk clkbuf_1_0_0_clk/Z _11149_/CLK VDD VDD VSS VSS
+ gf180mcu_fd_sc_mcu7t5v0__clkbuf_16
Xrepeater2 _08877_/A2 _07680_/I VDD VDD VSS VSS gf180mcu_fd_sc_mcu7t5v0__buf_16
X_09960_ _09960_/D _11176_/CLK _09960_/Q VDD VDD VSS VSS gf180mcu_fd_sc_mcu7t5v0__dffq_1
X_05083_ _10445_/Q _05939_/A4 VDD VDD VSS VSS gf180mcu_fd_sc_mcu7t5v0__clkinv_1
X_08911_ _09941_/A1 _08921_/A2 _08911_/B _10477_/D VDD VDD VSS VSS
+ gf180mcu_fd_sc_mcu7t5v0__oai21_1
X_09891_ _06047_/Z _09898_/A2 _09898_/B1 _09891_/B2 _11142_/D VDD VDD
+ VSS VSS gf180mcu_fd_sc_mcu7t5v0__oai22_1
X_08842_ _10447_/Q _08839_/Z _08842_/Z VDD VDD VSS VSS gf180mcu_fd_sc_mcu7t5v0__and2_1
X_08773_ _09920_/A1 _08779_/A2 _08779_/B1 _08773_/B2 _10396_/D VDD VDD
+ VSS VSS gf180mcu_fd_sc_mcu7t5v0__oai22_1
X_05985_ _07865_/A1 bus_addr[1] _05986_/I VDD VDD VSS VSS gf180mcu_fd_sc_mcu7t5v0__nor2_4
X_07724_ _10173_/Q _07726_/A2 _07725_/B VDD VDD VSS VSS gf180mcu_fd_sc_mcu7t5v0__nand2_1
X_07655_ _09925_/A1 _07657_/A2 _07655_/B _10133_/D VDD VDD VSS VSS
+ gf180mcu_fd_sc_mcu7t5v0__oai21_1
X_06606_ _06607_/A1 _06604_/Z _06606_/Z VDD VDD VSS VSS gf180mcu_fd_sc_mcu7t5v0__or2_1
X_07586_ _10125_/Q _07585_/Z _07604_/B VDD VDD VSS VSS gf180mcu_fd_sc_mcu7t5v0__and2_1
X_09325_ _09904_/A1 _09331_/A2 _09331_/B1 _09325_/B2 _10804_/D VDD VDD
+ VSS VSS gf180mcu_fd_sc_mcu7t5v0__oai22_1
X_06537_ _06058_/Z _06541_/A2 _06541_/B1 _06537_/B2 _10035_/D VDD VDD
+ VSS VSS gf180mcu_fd_sc_mcu7t5v0__oai22_1
X_09256_ _09893_/A1 _09261_/A2 _09261_/B1 _09256_/B2 _10749_/D VDD VDD
+ VSS VSS gf180mcu_fd_sc_mcu7t5v0__oai22_1
X_06468_ _06468_/A1 _06468_/A2 _06473_/A3 VDD VDD VSS VSS gf180mcu_fd_sc_mcu7t5v0__nand2_1
X_05419_ _10942_/Q _09497_/B2 VDD VDD VSS VSS gf180mcu_fd_sc_mcu7t5v0__clkinv_1
X_08207_ _10766_/Q _08589_/B1 _07255_/I _10814_/Q _08877_/A2 _10798_/Q _08208_/A3
+ VDD VDD VSS VSS gf180mcu_fd_sc_mcu7t5v0__aoi222_1
X_06399_ _06399_/A1 _06398_/Z _06451_/A2 VDD VDD VSS VSS gf180mcu_fd_sc_mcu7t5v0__nand2_1
X_09187_ _06058_/Z _09191_/A2 _09191_/B1 _09187_/B2 _10694_/D VDD VDD
+ VSS VSS gf180mcu_fd_sc_mcu7t5v0__oai22_1
X_08138_ _08956_/B2 _08542_/A2 _08581_/A2 _09436_/B2 _08138_/C _08139_/C VDD
+ VDD VSS VSS gf180mcu_fd_sc_mcu7t5v0__oai221_2
X_08069_ _10208_/Q _08528_/A2 _08530_/A2 _10964_/Q _08070_/I VDD VDD VSS
+ VSS gf180mcu_fd_sc_mcu7t5v0__aoi22_1
X_11080_ _11080_/D _11082_/CLK _11080_/Q VDD VDD VSS VSS gf180mcu_fd_sc_mcu7t5v0__dffq_1
X_10100_ _10100_/D _11052_/CLK _10100_/Q VDD VDD VSS VSS gf180mcu_fd_sc_mcu7t5v0__dffq_1
X_10031_ _10031_/D _11181_/CLK _10031_/Q VDD VDD VSS VSS gf180mcu_fd_sc_mcu7t5v0__dffq_1
X_10933_ _10933_/D _11149_/CLK _10933_/Q VDD VDD VSS VSS gf180mcu_fd_sc_mcu7t5v0__dffq_1
X_10864_ _10864_/D _11142_/CLK _10864_/Q VDD VDD VSS VSS gf180mcu_fd_sc_mcu7t5v0__dffq_1
X_10795_ _10795_/D _11010_/CLK _10795_/Q VDD VDD VSS VSS gf180mcu_fd_sc_mcu7t5v0__dffq_1
X_10229_ _10229_/D _11149_/CLK _10229_/Q VDD VDD VSS VSS gf180mcu_fd_sc_mcu7t5v0__dffq_1
X_05770_ _10721_/Q _09220_/B2 VDD VDD VSS VSS gf180mcu_fd_sc_mcu7t5v0__clkinv_1
X_07440_ _07404_/Z _07438_/Z _07583_/A1 VDD VDD VSS VSS gf180mcu_fd_sc_mcu7t5v0__nand2_1
X_07371_ _07431_/A1 _07365_/I _07371_/A3 _07371_/Z VDD VDD VSS VSS
+ gf180mcu_fd_sc_mcu7t5v0__xor3_1
X_09110_ _09945_/A1 _09111_/A2 _09111_/B1 _09110_/B2 _10633_/D VDD VDD
+ VSS VSS gf180mcu_fd_sc_mcu7t5v0__oai22_1
X_06322_ _06322_/A1 _06282_/Z _06321_/B _06330_/A1 VDD VDD VSS VSS
+ gf180mcu_fd_sc_mcu7t5v0__nor3_1
X_09041_ _09926_/A1 _09041_/A2 _09041_/B1 _09041_/B2 _10578_/D VDD VDD
+ VSS VSS gf180mcu_fd_sc_mcu7t5v0__oai22_1
X_06253_ _06509_/B2 _06242_/Z _06253_/B _06253_/C _06260_/A1 VDD VDD VSS
+ VSS gf180mcu_fd_sc_mcu7t5v0__oai211_1
X_05204_ _10388_/Q _08763_/B2 VDD VDD VSS VSS gf180mcu_fd_sc_mcu7t5v0__clkinv_1
X_06184_ _07434_/A1 _08675_/A2 _06184_/B _10002_/D VDD VDD VSS VSS
+ gf180mcu_fd_sc_mcu7t5v0__aoi21_1
X_05135_ _10723_/Q _09224_/B2 VDD VDD VSS VSS gf180mcu_fd_sc_mcu7t5v0__clkinv_1
X_05066_ _09998_/Q _06176_/A1 VDD VDD VSS VSS gf180mcu_fd_sc_mcu7t5v0__clkinv_1
X_09943_ _06061_/Z _09946_/A2 _09946_/B1 _09943_/B2 _11178_/D VDD VDD
+ VSS VSS gf180mcu_fd_sc_mcu7t5v0__oai22_1
X_09874_ _06047_/Z _09888_/A2 _09874_/B _11134_/D VDD VDD VSS VSS
+ gf180mcu_fd_sc_mcu7t5v0__oai21_1
X_08825_ _06058_/Z _08829_/A2 _08829_/B1 _08825_/B2 _10438_/D VDD VDD
+ VSS VSS gf180mcu_fd_sc_mcu7t5v0__oai22_1
X_08756_ _06061_/Z _08759_/A2 _08759_/B1 _08756_/B2 _10383_/D VDD VDD
+ VSS VSS gf180mcu_fd_sc_mcu7t5v0__oai22_1
X_05968_ _05979_/A1 _05968_/A2 _05968_/A3 _09796_/A2 VDD VDD VSS VSS
+ gf180mcu_fd_sc_mcu7t5v0__nor3_4
X_05899_ _10230_/Q _07807_/B2 VDD VDD VSS VSS gf180mcu_fd_sc_mcu7t5v0__clkinv_1
X_08687_ _08687_/A1 _08687_/A2 _09900_/B _10334_/D VDD VDD VSS VSS
+ gf180mcu_fd_sc_mcu7t5v0__aoi21_1
X_07707_ _09944_/A1 _07709_/A2 _07709_/B1 _07707_/B2 _10164_/D VDD VDD
+ VSS VSS gf180mcu_fd_sc_mcu7t5v0__oai22_1
X_07638_ _10126_/Q _07636_/B _07639_/A3 VDD VDD VSS VSS gf180mcu_fd_sc_mcu7t5v0__nor2_1
X_07569_ _07524_/B _07569_/A2 _07569_/B _07576_/A1 VDD VDD VSS VSS
+ gf180mcu_fd_sc_mcu7t5v0__aoi21_1
X_09308_ _06061_/Z _09311_/A2 _09311_/B1 _09308_/B2 _10791_/D VDD VDD
+ VSS VSS gf180mcu_fd_sc_mcu7t5v0__oai22_1
X_10580_ _10580_/D _11138_/CLK _10580_/Q VDD VDD VSS VSS gf180mcu_fd_sc_mcu7t5v0__dffq_1
X_09239_ _09896_/A1 _09241_/A2 _09241_/B1 _09239_/B2 _10736_/D VDD VDD
+ VSS VSS gf180mcu_fd_sc_mcu7t5v0__oai22_1
X_11132_ _11132_/D _11149_/CLK _11132_/Q VDD VDD VSS VSS gf180mcu_fd_sc_mcu7t5v0__dffq_1
X_11063_ _11063_/D _11097_/CLK uart_tx VDD VDD VSS VSS gf180mcu_fd_sc_mcu7t5v0__dffq_2
X_10014_ _10014_/D _10327_/CLK _10014_/Q VDD VDD VSS VSS gf180mcu_fd_sc_mcu7t5v0__dffq_1
X_10916_ _10916_/D _10978_/CLK _10916_/Q VDD VDD VSS VSS gf180mcu_fd_sc_mcu7t5v0__dffq_1
X_10847_ _10847_/D _11165_/CLK _10847_/Q VDD VDD VSS VSS gf180mcu_fd_sc_mcu7t5v0__dffq_1
X_10778_ _10778_/D _11164_/CLK _10778_/Q VDD VDD VSS VSS gf180mcu_fd_sc_mcu7t5v0__dffq_1
X_06940_ _06952_/A1 _10078_/Q _06953_/A3 _07207_/A1 VDD VDD VSS VSS
+ gf180mcu_fd_sc_mcu7t5v0__nand3_4
X_06871_ _06871_/A1 _06869_/Z _06871_/B _06871_/C _06874_/C VDD VDD VSS
+ VSS gf180mcu_fd_sc_mcu7t5v0__oai211_1
X_08610_ _09824_/A1 _08618_/A2 _08618_/B1 VDD VDD VSS VSS gf180mcu_fd_sc_mcu7t5v0__nand2_4
X_05822_ _10833_/Q _09360_/B2 VDD VDD VSS VSS gf180mcu_fd_sc_mcu7t5v0__clkinv_1
X_09590_ _06047_/Z _09597_/A2 _09597_/B1 _09590_/B2 _11003_/D VDD VDD
+ VSS VSS gf180mcu_fd_sc_mcu7t5v0__oai22_1
X_08541_ _10762_/Q _08559_/A2 _08877_/A2 _10802_/Q _08544_/A2 VDD VDD
+ VSS VSS gf180mcu_fd_sc_mcu7t5v0__aoi22_1
X_05753_ _10593_/Q _09060_/B2 VDD VDD VSS VSS gf180mcu_fd_sc_mcu7t5v0__clkinv_1
X_05684_ _10888_/Q _09429_/B2 VDD VDD VSS VSS gf180mcu_fd_sc_mcu7t5v0__clkinv_1
X_08472_ _09861_/A2 _08472_/A2 _08472_/B1 _09412_/A2 _08473_/A4 VDD VDD
+ VSS VSS gf180mcu_fd_sc_mcu7t5v0__aoi22_1
X_07423_ _10121_/Q _07601_/B _07423_/B _07424_/A2 VDD VDD VSS VSS
+ gf180mcu_fd_sc_mcu7t5v0__aoi21_1
X_07354_ _07379_/A1 _07485_/A1 _07354_/B1 _07354_/B2 _07548_/C _07357_/B VDD
+ VDD VSS VSS gf180mcu_fd_sc_mcu7t5v0__aoi221_1
X_06305_ _10003_/Q _06481_/A2 _06446_/A2 _10002_/Q _06306_/A3 VDD VDD
+ VSS VSS gf180mcu_fd_sc_mcu7t5v0__aoi22_1
X_07285_ _06058_/Z _07293_/A2 _07285_/B _10101_/D VDD VDD VSS VSS
+ gf180mcu_fd_sc_mcu7t5v0__oai21_1
X_09024_ _06047_/Z _09031_/A2 _09031_/B1 _09024_/B2 _10563_/D VDD VDD
+ VSS VSS gf180mcu_fd_sc_mcu7t5v0__oai22_1
X_06236_ _09995_/Q _06237_/A2 _06362_/B VDD VDD VSS VSS gf180mcu_fd_sc_mcu7t5v0__and2_1
X_06167_ _09916_/A1 _06167_/A2 _06167_/B _09994_/D VDD VDD VSS VSS
+ gf180mcu_fd_sc_mcu7t5v0__oai21_1
X_05118_ _10595_/Q _09064_/B2 VDD VDD VSS VSS gf180mcu_fd_sc_mcu7t5v0__clkinv_1
X_06098_ _06021_/Z _07254_/A2 _08444_/B1 VDD VDD VSS VSS gf180mcu_fd_sc_mcu7t5v0__nor2_4
X_09926_ _09926_/A1 _09926_/A2 _09926_/B1 _09926_/B2 _11165_/D VDD VDD
+ VSS VSS gf180mcu_fd_sc_mcu7t5v0__oai22_1
X_05049_ _10041_/Q _06571_/A2 VDD VDD VSS VSS gf180mcu_fd_sc_mcu7t5v0__inv_1
X_09857_ _06061_/Z _09860_/A2 _09860_/B1 _09857_/B2 _11122_/D VDD VDD
+ VSS VSS gf180mcu_fd_sc_mcu7t5v0__oai22_1
X_08808_ _09897_/A1 _08809_/A2 _08809_/B1 _08808_/B2 _10425_/D VDD VDD
+ VSS VSS gf180mcu_fd_sc_mcu7t5v0__oai22_1
X_09788_ _11095_/Q _09795_/A2 _09809_/B _09789_/B VDD VDD VSS VSS
+ gf180mcu_fd_sc_mcu7t5v0__oai21_1
X_08739_ _09946_/A1 _08739_/A2 _08739_/B1 _08739_/B2 _10370_/D VDD VDD
+ VSS VSS gf180mcu_fd_sc_mcu7t5v0__oai22_1
X_10701_ _10701_/D _10905_/CLK _10701_/Q VDD VDD VSS VSS gf180mcu_fd_sc_mcu7t5v0__dffq_1
X_10632_ _10632_/D _10666_/CLK _10632_/Q VDD VDD VSS VSS gf180mcu_fd_sc_mcu7t5v0__dffq_1
X_10563_ _10563_/D _10666_/CLK _10563_/Q VDD VDD VSS VSS gf180mcu_fd_sc_mcu7t5v0__dffq_1
X_10494_ _10494_/D _11164_/CLK _10494_/Q VDD VDD VSS VSS gf180mcu_fd_sc_mcu7t5v0__dffq_1
X_11115_ _11115_/D _11150_/CLK _11115_/Q VDD VDD VSS VSS gf180mcu_fd_sc_mcu7t5v0__dffq_1
X_11046_ _11046_/D _11147_/CLK _11046_/Q VDD VDD VSS VSS gf180mcu_fd_sc_mcu7t5v0__dffq_1
X_07070_ _07070_/A1 _10012_/Q _07122_/B _07071_/B2 VDD VDD VSS VSS
+ gf180mcu_fd_sc_mcu7t5v0__oai21_2
X_06021_ _10316_/Q bus_addr[0] _08619_/B _06021_/Z VDD VDD VSS VSS
+ gf180mcu_fd_sc_mcu7t5v0__mux2_4
X_07972_ _08268_/B2 _08533_/A1 _09412_/A2 VDD VDD VSS VSS gf180mcu_fd_sc_mcu7t5v0__nor2_4
X_09711_ _09711_/A1 _09711_/A2 _11058_/D VDD VDD VSS VSS gf180mcu_fd_sc_mcu7t5v0__nor2_1
X_06923_ _06952_/A1 _08675_/A2 _06923_/B _10079_/D VDD VDD VSS VSS
+ gf180mcu_fd_sc_mcu7t5v0__aoi21_1
X_09642_ _11034_/Q _09642_/A2 _09643_/B VDD VDD VSS VSS gf180mcu_fd_sc_mcu7t5v0__nand2_1
X_06854_ _10004_/Q _06854_/A2 _06855_/A2 VDD VDD VSS VSS gf180mcu_fd_sc_mcu7t5v0__nand2_1
X_09573_ _06058_/Z _09577_/A2 _09577_/B1 _09573_/B2 _10990_/D VDD VDD
+ VSS VSS gf180mcu_fd_sc_mcu7t5v0__oai22_1
X_05805_ _10977_/Q _09548_/B2 VDD VDD VSS VSS gf180mcu_fd_sc_mcu7t5v0__clkinv_1
X_06785_ _06785_/A1 _06785_/A2 _07603_/B _10050_/D VDD VDD VSS VSS
+ gf180mcu_fd_sc_mcu7t5v0__aoi21_1
X_08524_ _10890_/Q _08547_/A2 _08573_/B1 _10222_/Q _08576_/B1 _10206_/Q _08526_/A1
+ VDD VDD VSS VSS gf180mcu_fd_sc_mcu7t5v0__aoi222_2
X_05736_ _10993_/Q _09576_/B2 VDD VDD VSS VSS gf180mcu_fd_sc_mcu7t5v0__clkinv_1
X_05667_ _10744_/Q _09249_/B2 VDD VDD VSS VSS gf180mcu_fd_sc_mcu7t5v0__clkinv_1
X_08455_ _10038_/Q _08528_/A2 _08586_/A2 _09969_/Q _08564_/C1 _10030_/Q _08457_/A2
+ VDD VDD VSS VSS gf180mcu_fd_sc_mcu7t5v0__aoi222_2
X_05598_ _10911_/Q _09458_/B2 VDD VDD VSS VSS gf180mcu_fd_sc_mcu7t5v0__clkinv_1
X_08386_ _08727_/B2 _08585_/A2 _08386_/B _08387_/B1 VDD VDD VSS VSS
+ gf180mcu_fd_sc_mcu7t5v0__oai21_2
X_07406_ _10121_/Q _07405_/Z _07426_/A2 VDD VDD VSS VSS gf180mcu_fd_sc_mcu7t5v0__nor2_1
X_07337_ _07519_/A1 _07519_/A2 _07519_/B _07485_/A1 VDD VDD VSS VSS
+ gf180mcu_fd_sc_mcu7t5v0__oai21_4
X_07268_ _10094_/Q _07274_/A2 _07269_/B VDD VDD VSS VSS gf180mcu_fd_sc_mcu7t5v0__nand2_1
X_09007_ _06058_/Z _09011_/A2 _09011_/B1 _09007_/B2 _10550_/D VDD VDD
+ VSS VSS gf180mcu_fd_sc_mcu7t5v0__oai22_1
X_06219_ _09997_/Q _06470_/A1 _06372_/C VDD VDD VSS VSS gf180mcu_fd_sc_mcu7t5v0__nor2_4
X_07199_ _07199_/A1 _07148_/B _07226_/A2 _07199_/B _07244_/A1 VDD VDD
+ VSS VSS gf180mcu_fd_sc_mcu7t5v0__oai31_1
X_09909_ _11154_/Q _09915_/A2 _09910_/B VDD VDD VSS VSS gf180mcu_fd_sc_mcu7t5v0__nand2_1
X_10615_ _10615_/D _10666_/CLK _10615_/Q VDD VDD VSS VSS gf180mcu_fd_sc_mcu7t5v0__dffq_1
X_10546_ _10546_/D _11138_/CLK _10546_/Q VDD VDD VSS VSS gf180mcu_fd_sc_mcu7t5v0__dffq_1
X_10477_ _10477_/D _11139_/CLK _10477_/Q VDD VDD VSS VSS gf180mcu_fd_sc_mcu7t5v0__dffq_1
X_11029_ _11029_/D _11164_/CLK _11029_/Q VDD VDD VSS VSS gf180mcu_fd_sc_mcu7t5v0__dffq_1
X_06570_ _06579_/A3 _06570_/A2 _06835_/A1 VDD VDD VSS VSS gf180mcu_fd_sc_mcu7t5v0__nor2_2
X_05521_ _10308_/Q _08615_/B2 VDD VDD VSS VSS gf180mcu_fd_sc_mcu7t5v0__clkinv_1
X_08240_ _08240_/I _08241_/C VDD VDD VSS VSS gf180mcu_fd_sc_mcu7t5v0__clkinv_1
X_05452_ _10718_/Q _09217_/B2 VDD VDD VSS VSS gf180mcu_fd_sc_mcu7t5v0__clkinv_1
X_08171_ _09861_/A2 _08171_/A2 _08171_/B1 _08588_/B _08181_/A3 VDD VDD
+ VSS VSS gf180mcu_fd_sc_mcu7t5v0__aoi22_1
X_05383_ _10949_/Q _09506_/B2 VDD VDD VSS VSS gf180mcu_fd_sc_mcu7t5v0__clkinv_1
X_07122_ _10328_/Q _10080_/Q _07122_/B _07124_/B1 VDD VDD VSS VSS
+ gf180mcu_fd_sc_mcu7t5v0__oai21_2
X_07053_ _07470_/B2 _07051_/Z _07054_/B VDD VDD VSS VSS gf180mcu_fd_sc_mcu7t5v0__xor2_1
X_06004_ _11056_/Q _07876_/A2 _05986_/I _11087_/Q _06005_/A2 VDD VDD VSS
+ VSS gf180mcu_fd_sc_mcu7t5v0__aoi22_2
X_07955_ _10167_/Q _08528_/B1 _08529_/B1 _10191_/Q _07956_/I VDD VDD VSS
+ VSS gf180mcu_fd_sc_mcu7t5v0__aoi22_1
X_06906_ _10071_/Q _06916_/A2 _06907_/B VDD VDD VSS VSS gf180mcu_fd_sc_mcu7t5v0__nand2_1
X_09625_ _09916_/A1 _09625_/A2 _09625_/B _11026_/D VDD VDD VSS VSS
+ gf180mcu_fd_sc_mcu7t5v0__oai21_1
X_07886_ _07886_/A1 _07890_/A2 _07886_/B _10263_/D VDD VDD VSS VSS
+ gf180mcu_fd_sc_mcu7t5v0__aoi21_1
X_06837_ _10051_/Q _07601_/B _06837_/B _06838_/A2 VDD VDD VSS VSS
+ gf180mcu_fd_sc_mcu7t5v0__aoi21_1
X_09556_ _10981_/Q _09566_/A2 _09557_/B VDD VDD VSS VSS gf180mcu_fd_sc_mcu7t5v0__nand2_1
X_06768_ _10050_/Q _06766_/Z _06786_/B VDD VDD VSS VSS gf180mcu_fd_sc_mcu7t5v0__and2_1
X_09487_ _06058_/Z _09491_/A2 _09491_/B1 _09487_/B2 _10934_/D VDD VDD
+ VSS VSS gf180mcu_fd_sc_mcu7t5v0__oai22_1
X_05719_ _10856_/Q _09389_/B2 VDD VDD VSS VSS gf180mcu_fd_sc_mcu7t5v0__clkinv_1
X_08507_ _09290_/B2 _08585_/A2 _08507_/B _08512_/A2 VDD VDD VSS VSS
+ gf180mcu_fd_sc_mcu7t5v0__oai21_1
X_06699_ _06659_/Z _06699_/A2 _06699_/B _06707_/A1 VDD VDD VSS VSS
+ gf180mcu_fd_sc_mcu7t5v0__aoi21_2
X_08438_ _10889_/Q _08547_/A2 _08576_/B1 _10205_/Q _08439_/I VDD VDD VSS
+ VSS gf180mcu_fd_sc_mcu7t5v0__aoi22_1
X_08369_ _10920_/Q _08584_/A2 _08584_/B1 _10752_/Q _08372_/A1 VDD VDD
+ VSS VSS gf180mcu_fd_sc_mcu7t5v0__aoi22_1
X_10400_ _10400_/D _11017_/CLK _10400_/Q VDD VDD VSS VSS gf180mcu_fd_sc_mcu7t5v0__dffq_1
X_10331_ _10331_/D _11150_/CLK _10331_/Q VDD VDD VSS VSS gf180mcu_fd_sc_mcu7t5v0__dffq_2
X_10262_ _10262_/D _11052_/CLK _10262_/Q VDD VDD VSS VSS gf180mcu_fd_sc_mcu7t5v0__dffq_1
X_10193_ _10193_/D _11101_/CLK _10193_/Q VDD VDD VSS VSS gf180mcu_fd_sc_mcu7t5v0__dffq_1
X_10529_ _10529_/D _11109_/CLK _10529_/Q VDD VDD VSS VSS gf180mcu_fd_sc_mcu7t5v0__dffq_1
X_07740_ _08658_/B _07748_/A2 _07748_/B1 VDD VDD VSS VSS gf180mcu_fd_sc_mcu7t5v0__nand2_2
X_07671_ _06047_/Z _07678_/A2 _07678_/B1 _07671_/B2 _10143_/D VDD VDD
+ VSS VSS gf180mcu_fd_sc_mcu7t5v0__oai22_1
X_09410_ _09945_/A1 _09411_/A2 _09411_/B1 _09410_/B2 _10873_/D VDD VDD
+ VSS VSS gf180mcu_fd_sc_mcu7t5v0__oai22_1
X_06622_ _10000_/Q _06850_/A2 _06622_/Z VDD VDD VSS VSS gf180mcu_fd_sc_mcu7t5v0__and2_1
X_09341_ _09916_/A1 _09341_/A2 _09341_/B1 _09341_/B2 _10818_/D VDD VDD
+ VSS VSS gf180mcu_fd_sc_mcu7t5v0__oai22_1
X_06553_ _10044_/Q _06691_/B _06553_/A3 _06700_/A2 VDD VDD VSS VSS
+ gf180mcu_fd_sc_mcu7t5v0__nand3_4
X_05504_ _10830_/Q _09357_/B2 VDD VDD VSS VSS gf180mcu_fd_sc_mcu7t5v0__clkinv_1
X_09272_ _09851_/A1 _09332_/A2 _09281_/A2 VDD VDD VSS VSS gf180mcu_fd_sc_mcu7t5v0__nand2_4
X_06484_ _10004_/Q _06484_/A2 _06489_/A3 VDD VDD VSS VSS gf180mcu_fd_sc_mcu7t5v0__nand2_1
X_05435_ _10590_/Q _09057_/B2 VDD VDD VSS VSS gf180mcu_fd_sc_mcu7t5v0__clkinv_1
X_08223_ _08534_/B2 _08223_/A2 _08223_/B _08224_/B VDD VDD VSS VSS
+ gf180mcu_fd_sc_mcu7t5v0__oai21_1
X_05366_ _10885_/Q _09426_/B2 VDD VDD VSS VSS gf180mcu_fd_sc_mcu7t5v0__clkinv_1
X_08154_ _09016_/B2 _08585_/A2 _08581_/A2 _09006_/B2 _08155_/C VDD VDD
+ VSS VSS gf180mcu_fd_sc_mcu7t5v0__oai22_1
X_08085_ _10017_/Q _08586_/A2 _08563_/C1 _10293_/Q _08085_/C _08088_/A1 VDD
+ VDD VSS VSS gf180mcu_fd_sc_mcu7t5v0__aoi221_2
X_07105_ _07199_/A1 _07148_/B _07107_/A2 VDD VDD VSS VSS gf180mcu_fd_sc_mcu7t5v0__xnor2_1
X_05297_ _10868_/Q _09405_/B2 VDD VDD VSS VSS gf180mcu_fd_sc_mcu7t5v0__clkinv_1
X_07036_ _10003_/Q _10002_/Q _07222_/A2 _07181_/A2 _07036_/Z VDD VDD VSS
+ VSS gf180mcu_fd_sc_mcu7t5v0__and4_1
X_08987_ _06058_/Z _08991_/A2 _08991_/B1 _08987_/B2 _10534_/D VDD VDD
+ VSS VSS gf180mcu_fd_sc_mcu7t5v0__oai22_1
X_07938_ _08533_/A1 _08102_/A1 _09823_/A2 VDD VDD VSS VSS gf180mcu_fd_sc_mcu7t5v0__nor2_4
X_07869_ rst_n _07868_/Z _10255_/D VDD VDD VSS VSS gf180mcu_fd_sc_mcu7t5v0__and2_1
X_10880_ _10880_/D _11165_/CLK _10880_/Q VDD VDD VSS VSS gf180mcu_fd_sc_mcu7t5v0__dffq_1
X_09608_ _09645_/A1 _09937_/A2 _09625_/A2 VDD VDD VSS VSS gf180mcu_fd_sc_mcu7t5v0__nand2_2
X_09539_ _09946_/A1 _09539_/A2 _09539_/B _10970_/D VDD VDD VSS VSS
+ gf180mcu_fd_sc_mcu7t5v0__oai21_1
X_10314_ _10314_/D _11150_/CLK _10314_/Q VDD VDD VSS VSS gf180mcu_fd_sc_mcu7t5v0__dffq_4
X_10245_ _10245_/D _11150_/CLK _10245_/Q VDD VDD VSS VSS gf180mcu_fd_sc_mcu7t5v0__dffq_1
X_10176_ _10176_/D _11017_/CLK _10176_/Q VDD VDD VSS VSS gf180mcu_fd_sc_mcu7t5v0__dffq_1
X_05220_ _10564_/Q _09025_/B2 VDD VDD VSS VSS gf180mcu_fd_sc_mcu7t5v0__clkinv_1
X_05151_ _11166_/Q _09929_/B2 VDD VDD VSS VSS gf180mcu_fd_sc_mcu7t5v0__clkinv_1
Xrepeater3 _08877_/A2 _08591_/B1 VDD VDD VSS VSS gf180mcu_fd_sc_mcu7t5v0__buf_12
X_05082_ _10444_/Q _08833_/A1 VDD VDD VSS VSS gf180mcu_fd_sc_mcu7t5v0__clkinv_1
X_09890_ _09890_/A1 _09898_/A2 _09898_/B1 VDD VDD VSS VSS gf180mcu_fd_sc_mcu7t5v0__nand2_2
X_08910_ _10477_/Q _08920_/A2 _08911_/B VDD VDD VSS VSS gf180mcu_fd_sc_mcu7t5v0__nand2_1
X_08841_ _10447_/Q _08839_/Z _08843_/A2 VDD VDD VSS VSS gf180mcu_fd_sc_mcu7t5v0__nor2_1
X_08772_ _06047_/Z _08779_/A2 _08779_/B1 _08772_/B2 _10395_/D VDD VDD
+ VSS VSS gf180mcu_fd_sc_mcu7t5v0__oai22_1
X_05984_ _09900_/B _05984_/A2 _10301_/D VDD VDD VSS VSS gf180mcu_fd_sc_mcu7t5v0__nor2_1
X_07723_ _09944_/A1 _07727_/A2 _07723_/B _10172_/D VDD VDD VSS VSS
+ gf180mcu_fd_sc_mcu7t5v0__oai21_1
X_07654_ _10133_/Q _07656_/A2 _07655_/B VDD VDD VSS VSS gf180mcu_fd_sc_mcu7t5v0__nand2_1
X_06605_ _06607_/A1 _06604_/Z _06638_/A2 VDD VDD VSS VSS gf180mcu_fd_sc_mcu7t5v0__nor2_1
X_07585_ _07582_/Z _07585_/A2 _07585_/Z VDD VDD VSS VSS gf180mcu_fd_sc_mcu7t5v0__xor2_1
X_09324_ _06047_/Z _09331_/A2 _09331_/B1 _09324_/B2 _10803_/D VDD VDD
+ VSS VSS gf180mcu_fd_sc_mcu7t5v0__oai22_1
X_06536_ _09941_/A1 _06541_/A2 _06541_/B1 _06536_/B2 _10034_/D VDD VDD
+ VSS VSS gf180mcu_fd_sc_mcu7t5v0__oai22_1
X_09255_ _09940_/A1 _09261_/A2 _09261_/B1 _09255_/B2 _10748_/D VDD VDD
+ VSS VSS gf180mcu_fd_sc_mcu7t5v0__oai22_1
X_06467_ _06509_/B2 _06501_/B _06468_/A2 VDD VDD VSS VSS gf180mcu_fd_sc_mcu7t5v0__nor2_1
X_05418_ _10990_/Q _09573_/B2 VDD VDD VSS VSS gf180mcu_fd_sc_mcu7t5v0__clkinv_1
X_08206_ _10806_/Q _08560_/B1 _09872_/A1 _10782_/Q _08208_/A2 VDD VDD
+ VSS VSS gf180mcu_fd_sc_mcu7t5v0__aoi22_1
X_06398_ _06398_/A1 _06398_/A2 _06398_/Z VDD VDD VSS VSS gf180mcu_fd_sc_mcu7t5v0__xor2_1
X_09186_ _09941_/A1 _09191_/A2 _09191_/B1 _09186_/B2 _10693_/D VDD VDD
+ VSS VSS gf180mcu_fd_sc_mcu7t5v0__oai22_1
X_08137_ _11104_/Q _08559_/A2 _08591_/C1 _10501_/Q _08591_/B1 _10517_/Q _08138_/C
+ VDD VDD VSS VSS gf180mcu_fd_sc_mcu7t5v0__aoi222_4
X_05349_ _10741_/Q _09246_/B2 VDD VDD VSS VSS gf180mcu_fd_sc_mcu7t5v0__clkinv_1
X_08068_ _10192_/Q _08529_/B1 _08532_/A2 _10091_/Q _08072_/A2 VDD VDD
+ VSS VSS gf180mcu_fd_sc_mcu7t5v0__aoi22_1
X_07019_ _07207_/A1 _07085_/A1 _07019_/B _07019_/C _07020_/C VDD VDD VSS
+ VSS gf180mcu_fd_sc_mcu7t5v0__oai211_1
X_10030_ _10030_/D _11181_/CLK _10030_/Q VDD VDD VSS VSS gf180mcu_fd_sc_mcu7t5v0__dffq_1
X_10932_ _10932_/D _11149_/CLK _10932_/Q VDD VDD VSS VSS gf180mcu_fd_sc_mcu7t5v0__dffq_1
X_10863_ _10863_/D _11165_/CLK _10863_/Q VDD VDD VSS VSS gf180mcu_fd_sc_mcu7t5v0__dffq_1
X_10794_ _10794_/D _11010_/CLK _10794_/Q VDD VDD VSS VSS gf180mcu_fd_sc_mcu7t5v0__dffq_1
X_10228_ _10228_/D _11147_/CLK _10228_/Q VDD VDD VSS VSS gf180mcu_fd_sc_mcu7t5v0__dffq_1
X_10159_ _10159_/D _10905_/CLK _10159_/Q VDD VDD VSS VSS gf180mcu_fd_sc_mcu7t5v0__dffq_1
X_07370_ _10001_/Q _07369_/Z _07370_/Z VDD VDD VSS VSS gf180mcu_fd_sc_mcu7t5v0__and2_1
X_06321_ _06322_/A1 _06282_/Z _06321_/B _06368_/A2 VDD VDD VSS VSS
+ gf180mcu_fd_sc_mcu7t5v0__oai21_1
X_09040_ _09945_/A1 _09041_/A2 _09041_/B1 _09040_/B2 _10577_/D VDD VDD
+ VSS VSS gf180mcu_fd_sc_mcu7t5v0__oai22_1
X_06252_ _10001_/Q _06505_/B _06327_/B _06252_/C _06253_/C VDD VDD VSS
+ VSS gf180mcu_fd_sc_mcu7t5v0__aoi211_1
X_05203_ _10305_/Q _08612_/B2 VDD VDD VSS VSS gf180mcu_fd_sc_mcu7t5v0__clkinv_1
X_06183_ _10333_/Q _08675_/A2 _08672_/B _06184_/B VDD VDD VSS VSS
+ gf180mcu_fd_sc_mcu7t5v0__oai21_1
X_05134_ _10715_/Q _09214_/B2 VDD VDD VSS VSS gf180mcu_fd_sc_mcu7t5v0__clkinv_1
X_05065_ _09999_/Q _06178_/A1 VDD VDD VSS VSS gf180mcu_fd_sc_mcu7t5v0__clkinv_1
X_09942_ _06058_/Z _09946_/A2 _09946_/B1 _09942_/B2 _11177_/D VDD VDD
+ VSS VSS gf180mcu_fd_sc_mcu7t5v0__oai22_1
X_09873_ _11134_/Q _09887_/A2 _09874_/B VDD VDD VSS VSS gf180mcu_fd_sc_mcu7t5v0__nand2_1
X_08824_ _09921_/A1 _08829_/A2 _08829_/B1 _08824_/B2 _10437_/D VDD VDD
+ VSS VSS gf180mcu_fd_sc_mcu7t5v0__oai22_1
X_08755_ _06058_/Z _08759_/A2 _08759_/B1 _08755_/B2 _10382_/D VDD VDD
+ VSS VSS gf180mcu_fd_sc_mcu7t5v0__oai22_1
X_07706_ _06061_/Z _07709_/A2 _07709_/B1 _07706_/B2 _10163_/D VDD VDD
+ VSS VSS gf180mcu_fd_sc_mcu7t5v0__oai22_1
X_05967_ _11068_/Q _11069_/Q _05967_/A3 _05968_/A3 VDD VDD VSS VSS
+ gf180mcu_fd_sc_mcu7t5v0__nand3_2
X_05898_ _10346_/Q _08709_/B2 VDD VDD VSS VSS gf180mcu_fd_sc_mcu7t5v0__clkinv_1
X_08686_ _10334_/Q _08698_/A2 _08687_/A2 VDD VDD VSS VSS gf180mcu_fd_sc_mcu7t5v0__nand2_1
X_07637_ _07548_/C _07637_/A2 _07637_/B _07639_/A2 VDD VDD VSS VSS
+ gf180mcu_fd_sc_mcu7t5v0__aoi21_1
X_07568_ _07568_/A1 _07568_/A2 _07614_/B2 _07568_/Z VDD VDD VSS VSS
+ gf180mcu_fd_sc_mcu7t5v0__xor3_1
X_09307_ _06058_/Z _09311_/A2 _09311_/B1 _09307_/B2 _10790_/D VDD VDD
+ VSS VSS gf180mcu_fd_sc_mcu7t5v0__oai22_1
X_06519_ _09944_/A1 _06521_/A2 _06521_/B1 _06519_/B2 _10021_/D VDD VDD
+ VSS VSS gf180mcu_fd_sc_mcu7t5v0__oai22_1
X_07499_ _07499_/A1 _07499_/A2 _07499_/B1 _07499_/B2 _07500_/B VDD VDD
+ VSS VSS gf180mcu_fd_sc_mcu7t5v0__oai22_1
X_09238_ _06061_/Z _09241_/A2 _09241_/B1 _09238_/B2 _10735_/D VDD VDD
+ VSS VSS gf180mcu_fd_sc_mcu7t5v0__oai22_1
X_09169_ _09884_/A1 _09171_/A2 _09171_/B1 _09169_/B2 _10680_/D VDD VDD
+ VSS VSS gf180mcu_fd_sc_mcu7t5v0__oai22_1
X_11131_ _11131_/D _11149_/CLK _11131_/Q VDD VDD VSS VSS gf180mcu_fd_sc_mcu7t5v0__dffq_1
X_11062_ _11062_/D _11097_/CLK _11062_/Q VDD VDD VSS VSS gf180mcu_fd_sc_mcu7t5v0__dffq_1
X_10013_ _10013_/D _10327_/CLK _10013_/Q VDD VDD VSS VSS gf180mcu_fd_sc_mcu7t5v0__dffq_1
X_10915_ _10915_/D _11149_/CLK _10915_/Q VDD VDD VSS VSS gf180mcu_fd_sc_mcu7t5v0__dffq_1
X_10846_ _10846_/D _11165_/CLK _10846_/Q VDD VDD VSS VSS gf180mcu_fd_sc_mcu7t5v0__dffq_1
X_10777_ _10777_/D _11010_/CLK _10777_/Q VDD VDD VSS VSS gf180mcu_fd_sc_mcu7t5v0__dffq_1
X_06870_ _06871_/A1 _06869_/Z _06871_/B VDD VDD VSS VSS gf180mcu_fd_sc_mcu7t5v0__nand2_1
X_05821_ _10825_/Q _09350_/B2 VDD VDD VSS VSS gf180mcu_fd_sc_mcu7t5v0__clkinv_1
X_08540_ _10778_/Q _08540_/A2 _09872_/A1 _10786_/Q _08544_/A1 VDD VDD
+ VSS VSS gf180mcu_fd_sc_mcu7t5v0__aoi22_1
X_05752_ _10585_/Q _09050_/B2 VDD VDD VSS VSS gf180mcu_fd_sc_mcu7t5v0__clkinv_1
X_05683_ _11123_/Q _09858_/B2 VDD VDD VSS VSS gf180mcu_fd_sc_mcu7t5v0__clkinv_1
X_08471_ _08471_/A1 _08471_/A2 _08471_/A3 _08472_/B1 VDD VDD VSS VSS
+ gf180mcu_fd_sc_mcu7t5v0__nand3_1
X_07422_ _07548_/C _07408_/Z _07422_/B1 _07422_/B2 _07601_/B _07423_/B VDD VDD
+ VSS VSS gf180mcu_fd_sc_mcu7t5v0__aoi221_1
X_07353_ _10116_/Q _10115_/Q _07353_/A3 _07602_/A1 VDD VDD VSS VSS
+ gf180mcu_fd_sc_mcu7t5v0__nand3_4
X_06304_ _07470_/B2 _07434_/A1 _06444_/A2 _06304_/A4 _06351_/A1 VDD VDD
+ VSS VSS gf180mcu_fd_sc_mcu7t5v0__nor4_4
X_07284_ _10101_/Q _07292_/A2 _07285_/B VDD VDD VSS VSS gf180mcu_fd_sc_mcu7t5v0__nand2_1
X_09023_ _09193_/A1 _09031_/A2 _09031_/B1 VDD VDD VSS VSS gf180mcu_fd_sc_mcu7t5v0__nand2_2
X_06235_ _07361_/A2 _06198_/Z _06235_/B _06446_/A2 VDD VDD VSS VSS
+ gf180mcu_fd_sc_mcu7t5v0__oai21_4
X_06166_ _09994_/Q _06166_/A2 _06167_/B VDD VDD VSS VSS gf180mcu_fd_sc_mcu7t5v0__nand2_1
X_05117_ _10587_/Q _09054_/B2 VDD VDD VSS VSS gf180mcu_fd_sc_mcu7t5v0__clkinv_1
X_06097_ _06016_/I _06017_/Z _07254_/A2 VDD VDD VSS VSS gf180mcu_fd_sc_mcu7t5v0__nand2_4
X_09925_ _09925_/A1 _09926_/A2 _09926_/B1 _09925_/B2 _11164_/D VDD VDD
+ VSS VSS gf180mcu_fd_sc_mcu7t5v0__oai22_1
X_05048_ _10042_/Q _06578_/A1 VDD VDD VSS VSS gf180mcu_fd_sc_mcu7t5v0__clkinv_2
X_09856_ _06058_/Z _09860_/A2 _09860_/B1 _09856_/B2 _11121_/D VDD VDD
+ VSS VSS gf180mcu_fd_sc_mcu7t5v0__oai22_1
X_08807_ _09896_/A1 _08809_/A2 _08809_/B1 _08807_/B2 _10424_/D VDD VDD
+ VSS VSS gf180mcu_fd_sc_mcu7t5v0__oai22_1
X_09787_ _09787_/A1 _09795_/A2 _09787_/B _11086_/D VDD VDD VSS VSS
+ gf180mcu_fd_sc_mcu7t5v0__aoi21_1
X_06999_ _10002_/Q _07222_/A2 _07181_/A2 _10001_/Q _07001_/A3 VDD VDD
+ VSS VSS gf180mcu_fd_sc_mcu7t5v0__aoi22_1
X_08738_ _09945_/A1 _08739_/A2 _08739_/B1 _08738_/B2 _10369_/D VDD VDD
+ VSS VSS gf180mcu_fd_sc_mcu7t5v0__oai22_1
X_08669_ _08669_/A1 _08675_/A2 _08669_/B _10327_/D VDD VDD VSS VSS
+ gf180mcu_fd_sc_mcu7t5v0__aoi21_1
X_10700_ _10700_/D _10905_/CLK _10700_/Q VDD VDD VSS VSS gf180mcu_fd_sc_mcu7t5v0__dffq_1
X_10631_ _10631_/D _10666_/CLK _10631_/Q VDD VDD VSS VSS gf180mcu_fd_sc_mcu7t5v0__dffq_1
X_10562_ _10562_/D _11138_/CLK _10562_/Q VDD VDD VSS VSS gf180mcu_fd_sc_mcu7t5v0__dffq_1
X_10493_ _10493_/D _11165_/CLK _10493_/Q VDD VDD VSS VSS gf180mcu_fd_sc_mcu7t5v0__dffq_1
X_11114_ _11114_/D _11150_/CLK _11114_/Q VDD VDD VSS VSS gf180mcu_fd_sc_mcu7t5v0__dffq_1
X_11045_ _11045_/D _11142_/CLK _11045_/Q VDD VDD VSS VSS gf180mcu_fd_sc_mcu7t5v0__dffq_1
X_10829_ _10829_/D _11165_/CLK _10829_/Q VDD VDD VSS VSS gf180mcu_fd_sc_mcu7t5v0__dffq_1
X_06020_ _10316_/Q cgra_status[0] _06020_/B _07679_/A1 VDD VDD VSS VSS
+ gf180mcu_fd_sc_mcu7t5v0__aoi21_4
X_07971_ _08268_/B2 _08534_/A1 _09861_/A2 VDD VDD VSS VSS gf180mcu_fd_sc_mcu7t5v0__nor2_4
X_09710_ bus_wdata[6] _09722_/A1 _09710_/B _09711_/A2 VDD VDD VSS VSS
+ gf180mcu_fd_sc_mcu7t5v0__aoi21_1
X_06922_ _10246_/Q _08675_/A2 _08674_/B _06923_/B VDD VDD VSS VSS
+ gf180mcu_fd_sc_mcu7t5v0__oai21_1
X_09641_ _09925_/A1 _09643_/A2 _09641_/B _11033_/D VDD VDD VSS VSS
+ gf180mcu_fd_sc_mcu7t5v0__oai21_1
X_06853_ _06853_/A1 _06853_/A2 _06853_/B _06859_/A2 VDD VDD VSS VSS
+ gf180mcu_fd_sc_mcu7t5v0__aoi21_1
X_09572_ _09921_/A1 _09577_/A2 _09577_/B1 _09572_/B2 _10989_/D VDD VDD
+ VSS VSS gf180mcu_fd_sc_mcu7t5v0__oai22_1
X_05804_ _11009_/Q _09596_/B2 VDD VDD VSS VSS gf180mcu_fd_sc_mcu7t5v0__clkinv_1
X_06784_ _06834_/C _06769_/Z _06784_/B _07636_/B _06785_/A2 VDD VDD VSS
+ VSS gf180mcu_fd_sc_mcu7t5v0__oai211_1
X_05735_ _10385_/Q _08758_/B2 VDD VDD VSS VSS gf180mcu_fd_sc_mcu7t5v0__clkinv_1
X_08523_ _09962_/Q _08563_/A2 _06877_/Z _10190_/Q _08523_/C _08533_/A2 VDD VDD
+ VSS VSS gf180mcu_fd_sc_mcu7t5v0__aoi221_2
X_05666_ _10736_/Q _09239_/B2 VDD VDD VSS VSS gf180mcu_fd_sc_mcu7t5v0__clkinv_1
X_08454_ _10059_/Q _06877_/Z _08532_/A2 _11172_/Q _08563_/C1 _11180_/Q _08457_/A1
+ VDD VDD VSS VSS gf180mcu_fd_sc_mcu7t5v0__aoi222_2
X_05597_ _10919_/Q _09468_/B2 VDD VDD VSS VSS gf180mcu_fd_sc_mcu7t5v0__clkinv_1
X_08385_ _10528_/Q _08590_/B1 _08576_/B1 _10536_/Q _08385_/C _08386_/B VDD VDD
+ VSS VSS gf180mcu_fd_sc_mcu7t5v0__aoi221_2
X_07405_ _07405_/A1 _07403_/Z _07405_/Z VDD VDD VSS VSS gf180mcu_fd_sc_mcu7t5v0__xor2_1
X_07336_ _07368_/A1 _07368_/A2 _07368_/B _07609_/A2 VDD VDD VSS VSS
+ gf180mcu_fd_sc_mcu7t5v0__aoi21_4
X_09006_ _09893_/A1 _09011_/A2 _09011_/B1 _09006_/B2 _10549_/D VDD VDD
+ VSS VSS gf180mcu_fd_sc_mcu7t5v0__oai22_1
X_07267_ _06058_/Z _07275_/A2 _07267_/B _10093_/D VDD VDD VSS VSS
+ gf180mcu_fd_sc_mcu7t5v0__oai21_1
X_06218_ _06222_/A1 _06470_/A1 _06505_/B VDD VDD VSS VSS gf180mcu_fd_sc_mcu7t5v0__nor2_2
X_07198_ _10005_/Q _07149_/Z _07198_/B _07239_/A1 VDD VDD VSS VSS
+ gf180mcu_fd_sc_mcu7t5v0__aoi21_1
X_06149_ _09502_/A1 _09900_/A2 _06167_/A2 VDD VDD VSS VSS gf180mcu_fd_sc_mcu7t5v0__nand2_2
X_09908_ _06058_/Z _09916_/A2 _09908_/B _11153_/D VDD VDD VSS VSS
+ gf180mcu_fd_sc_mcu7t5v0__oai21_1
X_09839_ _11112_/Q _09849_/A2 _09840_/B VDD VDD VSS VSS gf180mcu_fd_sc_mcu7t5v0__nand2_1
X_10614_ _10614_/D _10666_/CLK _10614_/Q VDD VDD VSS VSS gf180mcu_fd_sc_mcu7t5v0__dffq_1
X_10545_ _10545_/D _10978_/CLK _10545_/Q VDD VDD VSS VSS gf180mcu_fd_sc_mcu7t5v0__dffq_1
X_10476_ _10476_/D _11139_/CLK _10476_/Q VDD VDD VSS VSS gf180mcu_fd_sc_mcu7t5v0__dffq_1
X_11028_ _11028_/D _11164_/CLK _11028_/Q VDD VDD VSS VSS gf180mcu_fd_sc_mcu7t5v0__dffq_1
X_05520_ _10399_/Q _08776_/B2 VDD VDD VSS VSS gf180mcu_fd_sc_mcu7t5v0__clkinv_1
X_05451_ _10710_/Q _09207_/B2 VDD VDD VSS VSS gf180mcu_fd_sc_mcu7t5v0__clkinv_1
X_08170_ _08170_/A1 _08170_/A2 _08170_/A3 _08171_/B1 VDD VDD VSS VSS
+ gf180mcu_fd_sc_mcu7t5v0__nand3_1
X_05382_ _10957_/Q _09516_/B2 VDD VDD VSS VSS gf180mcu_fd_sc_mcu7t5v0__clkinv_1
X_07121_ _07121_/A1 _07121_/A2 _07121_/B _07140_/A1 VDD VDD VSS VSS
+ gf180mcu_fd_sc_mcu7t5v0__aoi21_1
X_07052_ _10003_/Q _07051_/Z _07052_/Z VDD VDD VSS VSS gf180mcu_fd_sc_mcu7t5v0__and2_1
X_06003_ _10284_/Q _07829_/C _06005_/B VDD VDD VSS VSS gf180mcu_fd_sc_mcu7t5v0__nand2_1
X_07954_ _07954_/A1 _07954_/A2 _07954_/A3 _08013_/A2 VDD VDD VSS VSS
+ gf180mcu_fd_sc_mcu7t5v0__nand3_1
X_07885_ bus_wdata[4] _07890_/A2 _08654_/B _07886_/B VDD VDD VSS VSS
+ gf180mcu_fd_sc_mcu7t5v0__oai21_1
X_06905_ _09904_/A1 _06917_/A2 _06905_/B _10070_/D VDD VDD VSS VSS
+ gf180mcu_fd_sc_mcu7t5v0__oai21_1
X_09624_ _11026_/Q _09624_/A2 _09625_/B VDD VDD VSS VSS gf180mcu_fd_sc_mcu7t5v0__nand2_1
X_06836_ _06682_/B _06822_/Z _06836_/B _07601_/B _06837_/B VDD VDD VSS
+ VSS gf180mcu_fd_sc_mcu7t5v0__aoi211_1
X_09555_ _09904_/A1 _09567_/A2 _09555_/B _10980_/D VDD VDD VSS VSS
+ gf180mcu_fd_sc_mcu7t5v0__oai21_1
X_06767_ _10050_/Q _06766_/Z _06767_/Z VDD VDD VSS VSS gf180mcu_fd_sc_mcu7t5v0__or2_1
X_09486_ _09893_/A1 _09491_/A2 _09491_/B1 _09486_/B2 _10933_/D VDD VDD
+ VSS VSS gf180mcu_fd_sc_mcu7t5v0__oai22_1
X_05718_ _10848_/Q _09379_/B2 VDD VDD VSS VSS gf180mcu_fd_sc_mcu7t5v0__clkinv_1
X_08506_ _10809_/Q _08560_/B1 _07255_/I _10817_/Q _08506_/C _08507_/B VDD VDD
+ VSS VSS gf180mcu_fd_sc_mcu7t5v0__aoi221_2
X_06698_ _06698_/I _06740_/A1 VDD VDD VSS VSS gf180mcu_fd_sc_mcu7t5v0__clkinv_1
X_08437_ _11148_/Q _08555_/A2 _07680_/I _10229_/Q _08441_/A2 VDD VDD VSS
+ VSS gf180mcu_fd_sc_mcu7t5v0__aoi22_1
X_05649_ _10608_/Q _09079_/B2 VDD VDD VSS VSS gf180mcu_fd_sc_mcu7t5v0__clkinv_1
X_08368_ _09937_/A1 _08368_/A2 _08368_/B1 _09523_/A2 _08388_/A2 VDD VDD
+ VSS VSS gf180mcu_fd_sc_mcu7t5v0__aoi22_2
X_08299_ _11039_/Q _06112_/I _08877_/A2 _11023_/Q _09872_/A1 _09983_/Q _08300_/A3
+ VDD VDD VSS VSS gf180mcu_fd_sc_mcu7t5v0__aoi222_1
X_07319_ _07557_/B2 _08675_/A2 _07319_/B _10117_/D VDD VDD VSS VSS
+ gf180mcu_fd_sc_mcu7t5v0__aoi21_1
X_10330_ _10330_/D _11150_/CLK _10330_/Q VDD VDD VSS VSS gf180mcu_fd_sc_mcu7t5v0__dffq_1
X_10261_ _10261_/D _11052_/CLK _10261_/Q VDD VDD VSS VSS gf180mcu_fd_sc_mcu7t5v0__dffq_1
X_10192_ _10192_/D _11052_/CLK _10192_/Q VDD VDD VSS VSS gf180mcu_fd_sc_mcu7t5v0__dffq_1
X_10528_ _10528_/D _11109_/CLK _10528_/Q VDD VDD VSS VSS gf180mcu_fd_sc_mcu7t5v0__dffq_1
X_10459_ _10459_/D _11163_/CLK _10459_/Q VDD VDD VSS VSS gf180mcu_fd_sc_mcu7t5v0__dffq_1
X_07670_ _09918_/A1 _07678_/A2 _07678_/B1 VDD VDD VSS VSS gf180mcu_fd_sc_mcu7t5v0__nand2_2
X_06621_ _06994_/A1 _06843_/A2 _06621_/B1 _06621_/B2 _06850_/A2 VDD VDD
+ VSS VSS gf180mcu_fd_sc_mcu7t5v0__aoi22_4
X_09340_ _09925_/A1 _09341_/A2 _09341_/B1 _09340_/B2 _10817_/D VDD VDD
+ VSS VSS gf180mcu_fd_sc_mcu7t5v0__oai22_1
X_06552_ _06691_/A1 _10043_/Q _06843_/A2 VDD VDD VSS VSS gf180mcu_fd_sc_mcu7t5v0__nor2_2
X_09271_ _09916_/A1 _09271_/A2 _09271_/B1 _09271_/B2 _10762_/D VDD VDD
+ VSS VSS gf180mcu_fd_sc_mcu7t5v0__oai22_1
X_05503_ _10822_/Q _09347_/B2 VDD VDD VSS VSS gf180mcu_fd_sc_mcu7t5v0__clkinv_1
X_08222_ _08327_/B2 _08222_/A2 _08222_/B1 _08327_/A1 _08223_/B VDD VDD
+ VSS VSS gf180mcu_fd_sc_mcu7t5v0__aoi22_1
X_06483_ _10002_/Q _06483_/A2 _06490_/A1 VDD VDD VSS VSS gf180mcu_fd_sc_mcu7t5v0__nand2_1
X_05434_ _10582_/Q _09047_/B2 VDD VDD VSS VSS gf180mcu_fd_sc_mcu7t5v0__clkinv_1
X_05365_ _11120_/Q _09855_/B2 VDD VDD VSS VSS gf180mcu_fd_sc_mcu7t5v0__clkinv_1
X_08153_ _10565_/Q _08564_/C1 _08584_/B1 _10597_/Q _08156_/A2 VDD VDD
+ VSS VSS gf180mcu_fd_sc_mcu7t5v0__aoi22_1
X_08084_ _08084_/I _08085_/C VDD VDD VSS VSS gf180mcu_fd_sc_mcu7t5v0__clkinv_1
X_07104_ _07104_/A1 _07104_/A2 _07148_/B VDD VDD VSS VSS gf180mcu_fd_sc_mcu7t5v0__nand2_1
X_05296_ _10860_/Q _09395_/B2 VDD VDD VSS VSS gf180mcu_fd_sc_mcu7t5v0__clkinv_1
X_07035_ _10003_/Q _07181_/A2 _07085_/A2 VDD VDD VSS VSS gf180mcu_fd_sc_mcu7t5v0__nand2_1
X_08986_ _09921_/A1 _08991_/A2 _08991_/B1 _08986_/B2 _10533_/D VDD VDD
+ VSS VSS gf180mcu_fd_sc_mcu7t5v0__oai22_1
X_07937_ _08329_/B _07937_/A2 _07937_/Z VDD VDD VSS VSS gf180mcu_fd_sc_mcu7t5v0__or2_1
X_07868_ bus_wdata[1] _10255_/Q _07874_/S _07868_/Z VDD VDD VSS VSS
+ gf180mcu_fd_sc_mcu7t5v0__mux2_1
X_09607_ _09832_/A1 _09607_/A2 _09607_/B1 _09607_/B2 _11018_/D VDD VDD
+ VSS VSS gf180mcu_fd_sc_mcu7t5v0__oai22_1
X_07799_ _09852_/A1 _07807_/A2 _07807_/B1 VDD VDD VSS VSS gf180mcu_fd_sc_mcu7t5v0__nand2_2
X_06819_ _06819_/A1 _06765_/Z _06816_/Z _06835_/A2 VDD VDD VSS VSS
+ gf180mcu_fd_sc_mcu7t5v0__xnor3_2
X_09538_ _10970_/Q _09538_/A2 _09539_/B VDD VDD VSS VSS gf180mcu_fd_sc_mcu7t5v0__nand2_1
X_09469_ _09944_/A1 _09471_/A2 _09471_/B1 _09469_/B2 _10920_/D VDD VDD
+ VSS VSS gf180mcu_fd_sc_mcu7t5v0__oai22_1
X_10313_ _10313_/D _11150_/CLK _10313_/Q VDD VDD VSS VSS gf180mcu_fd_sc_mcu7t5v0__dffq_2
X_10244_ _10244_/D _11150_/CLK _10244_/Q VDD VDD VSS VSS gf180mcu_fd_sc_mcu7t5v0__dffq_1
X_10175_ _10175_/D _11017_/CLK _10175_/Q VDD VDD VSS VSS gf180mcu_fd_sc_mcu7t5v0__dffq_1
X_05150_ _09963_/Q _06102_/B2 VDD VDD VSS VSS gf180mcu_fd_sc_mcu7t5v0__clkinv_1
Xrepeater4 _08476_/C1 _08877_/A2 VDD VDD VSS VSS gf180mcu_fd_sc_mcu7t5v0__buf_16
X_05081_ _10289_/Q _09722_/A1 VDD VDD VSS VSS gf180mcu_fd_sc_mcu7t5v0__clkinv_3
X_08840_ _08831_/I _08840_/A2 _08839_/Z _10446_/D VDD VDD VSS VSS
+ gf180mcu_fd_sc_mcu7t5v0__nor3_1
X_08771_ _09824_/A1 _08779_/A2 _08779_/B1 VDD VDD VSS VSS gf180mcu_fd_sc_mcu7t5v0__nand2_2
X_05983_ _10301_/Q _05983_/A2 _05983_/B1 _10302_/Q _05984_/A2 VDD VDD
+ VSS VSS gf180mcu_fd_sc_mcu7t5v0__aoi22_1
X_07722_ _10172_/Q _07726_/A2 _07723_/B VDD VDD VSS VSS gf180mcu_fd_sc_mcu7t5v0__nand2_1
X_07653_ _09924_/A1 _07657_/A2 _07653_/B _10132_/D VDD VDD VSS VSS
+ gf180mcu_fd_sc_mcu7t5v0__oai21_1
X_06604_ _10001_/Q _06804_/A4 _06604_/A3 _06604_/Z VDD VDD VSS VSS
+ gf180mcu_fd_sc_mcu7t5v0__xor3_1
X_09323_ _09918_/A1 _09331_/A2 _09331_/B1 VDD VDD VSS VSS gf180mcu_fd_sc_mcu7t5v0__nand2_2
X_07584_ _07582_/Z _07585_/A2 _07623_/A1 VDD VDD VSS VSS gf180mcu_fd_sc_mcu7t5v0__nand2_1
X_06535_ _09940_/A1 _06541_/A2 _06541_/B1 _06535_/B2 _10033_/D VDD VDD
+ VSS VSS gf180mcu_fd_sc_mcu7t5v0__oai22_1
X_09254_ _06047_/Z _09261_/A2 _09261_/B1 _09254_/B2 _10747_/D VDD VDD
+ VSS VSS gf180mcu_fd_sc_mcu7t5v0__oai22_1
X_06466_ _06466_/A1 _06466_/A2 _06465_/B _06468_/A1 VDD VDD VSS VSS
+ gf180mcu_fd_sc_mcu7t5v0__nand3_1
X_05417_ _10382_/Q _08755_/B2 VDD VDD VSS VSS gf180mcu_fd_sc_mcu7t5v0__clkinv_1
X_08205_ _10774_/Q _08540_/A2 _06112_/I _10790_/Q _08208_/A1 VDD VDD VSS
+ VSS gf180mcu_fd_sc_mcu7t5v0__aoi22_1
X_09185_ _09940_/A1 _09191_/A2 _09191_/B1 _09185_/B2 _10692_/D VDD VDD
+ VSS VSS gf180mcu_fd_sc_mcu7t5v0__oai22_1
X_08136_ _08136_/A1 _08136_/A2 _08136_/A3 _08141_/A2 VDD VDD VSS VSS
+ gf180mcu_fd_sc_mcu7t5v0__nand3_1
X_06397_ _06398_/A1 _06398_/A2 _06437_/A2 VDD VDD VSS VSS gf180mcu_fd_sc_mcu7t5v0__nor2_1
X_05348_ _10733_/Q _09236_/B2 VDD VDD VSS VSS gf180mcu_fd_sc_mcu7t5v0__clkinv_1
X_05279_ _10916_/Q _09465_/B2 VDD VDD VSS VSS gf180mcu_fd_sc_mcu7t5v0__clkinv_1
X_08067_ _10232_/Q _06877_/Z _08563_/C1 _10152_/Q _08072_/A1 VDD VDD VSS
+ VSS gf180mcu_fd_sc_mcu7t5v0__aoi22_1
X_07018_ _10002_/Q _07206_/A2 _07019_/B VDD VDD VSS VSS gf180mcu_fd_sc_mcu7t5v0__nand2_1
X_08969_ _09924_/A1 _08971_/A2 _08971_/B1 _08969_/B2 _10520_/D VDD VDD
+ VSS VSS gf180mcu_fd_sc_mcu7t5v0__oai22_1
X_10931_ _10931_/D _11149_/CLK _10931_/Q VDD VDD VSS VSS gf180mcu_fd_sc_mcu7t5v0__dffq_1
X_10862_ _10862_/D _11142_/CLK _10862_/Q VDD VDD VSS VSS gf180mcu_fd_sc_mcu7t5v0__dffq_1
X_10793_ _10793_/D _11010_/CLK _10793_/Q VDD VDD VSS VSS gf180mcu_fd_sc_mcu7t5v0__dffq_1
X_10227_ _10227_/D _11149_/CLK _10227_/Q VDD VDD VSS VSS gf180mcu_fd_sc_mcu7t5v0__dffq_1
X_10158_ _10158_/D _11101_/CLK _10158_/Q VDD VDD VSS VSS gf180mcu_fd_sc_mcu7t5v0__dffq_1
X_10089_ _10089_/D _10327_/CLK _10089_/Q VDD VDD VSS VSS gf180mcu_fd_sc_mcu7t5v0__dffq_1
X_06320_ _10003_/Q _06318_/Z _06321_/B VDD VDD VSS VSS gf180mcu_fd_sc_mcu7t5v0__xor2_1
X_06251_ _06509_/A1 _06250_/Z _06252_/C VDD VDD VSS VSS gf180mcu_fd_sc_mcu7t5v0__nor2_1
X_05202_ _10396_/Q _08773_/B2 VDD VDD VSS VSS gf180mcu_fd_sc_mcu7t5v0__clkinv_1
X_06182_ _07431_/A1 _08675_/A2 _06182_/B _10001_/D VDD VDD VSS VSS
+ gf180mcu_fd_sc_mcu7t5v0__aoi21_1
X_05133_ _10707_/Q _09204_/B2 VDD VDD VSS VSS gf180mcu_fd_sc_mcu7t5v0__clkinv_1
X_05064_ _10000_/Q _07379_/A1 VDD VDD VSS VSS gf180mcu_fd_sc_mcu7t5v0__clkinv_3
X_09941_ _09941_/A1 _09946_/A2 _09946_/B1 _09941_/B2 _11176_/D VDD VDD
+ VSS VSS gf180mcu_fd_sc_mcu7t5v0__oai22_1
X_09872_ _09872_/A1 _09872_/A2 _09900_/B _09887_/A2 VDD VDD VSS VSS
+ gf180mcu_fd_sc_mcu7t5v0__aoi21_4
X_08823_ _09904_/A1 _08829_/A2 _08829_/B1 _08823_/B2 _10436_/D VDD VDD
+ VSS VSS gf180mcu_fd_sc_mcu7t5v0__oai22_1
X_08754_ _09921_/A1 _08759_/A2 _08759_/B1 _08754_/B2 _10381_/D VDD VDD
+ VSS VSS gf180mcu_fd_sc_mcu7t5v0__oai22_1
X_05966_ _11067_/Q _11070_/Q _05967_/A3 VDD VDD VSS VSS gf180mcu_fd_sc_mcu7t5v0__nor2_1
X_07705_ _06058_/Z _07709_/A2 _07709_/B1 _07705_/B2 _10162_/D VDD VDD
+ VSS VSS gf180mcu_fd_sc_mcu7t5v0__oai22_1
X_05897_ _10354_/Q _08719_/B2 VDD VDD VSS VSS gf180mcu_fd_sc_mcu7t5v0__clkinv_1
X_08685_ _10283_/Q _08621_/I _08687_/A1 VDD VDD VSS VSS gf180mcu_fd_sc_mcu7t5v0__nand2_1
X_07636_ _07548_/C _07636_/A2 _07636_/B _07637_/B VDD VDD VSS VSS
+ gf180mcu_fd_sc_mcu7t5v0__oai21_1
X_07567_ _07568_/A1 _07568_/A2 _07567_/Z VDD VDD VSS VSS gf180mcu_fd_sc_mcu7t5v0__and2_1
X_09306_ _09921_/A1 _09311_/A2 _09311_/B1 _09306_/B2 _10789_/D VDD VDD
+ VSS VSS gf180mcu_fd_sc_mcu7t5v0__oai22_1
X_06518_ _06061_/Z _06521_/A2 _06521_/B1 _06518_/B2 _10020_/D VDD VDD
+ VSS VSS gf180mcu_fd_sc_mcu7t5v0__oai22_1
X_09237_ _06058_/Z _09241_/A2 _09241_/B1 _09237_/B2 _10734_/D VDD VDD
+ VSS VSS gf180mcu_fd_sc_mcu7t5v0__oai22_1
X_07498_ _10004_/Q _07498_/A2 _07498_/B1 _07632_/I1 _07633_/C _07499_/B2 VDD
+ VDD VSS VSS gf180mcu_fd_sc_mcu7t5v0__aoi221_1
X_06449_ _06450_/A2 _06447_/Z _06494_/A2 VDD VDD VSS VSS gf180mcu_fd_sc_mcu7t5v0__nor2_1
X_09168_ _06061_/Z _09171_/A2 _09171_/B1 _09168_/B2 _10679_/D VDD VDD
+ VSS VSS gf180mcu_fd_sc_mcu7t5v0__oai22_1
X_09099_ _09944_/A1 _09101_/A2 _09101_/B1 _09099_/B2 _10624_/D VDD VDD
+ VSS VSS gf180mcu_fd_sc_mcu7t5v0__oai22_1
X_08119_ _09949_/Q _08560_/A2 _08560_/B1 _11005_/Q _07255_/I _10981_/Q _08121_/A2
+ VDD VDD VSS VSS gf180mcu_fd_sc_mcu7t5v0__aoi222_2
X_11130_ _11130_/D _11149_/CLK _11130_/Q VDD VDD VSS VSS gf180mcu_fd_sc_mcu7t5v0__dffq_1
X_11061_ _11061_/D _11097_/CLK _11061_/Q VDD VDD VSS VSS gf180mcu_fd_sc_mcu7t5v0__dffq_1
X_10012_ _10012_/D _10327_/CLK _10012_/Q VDD VDD VSS VSS gf180mcu_fd_sc_mcu7t5v0__dffq_2
X_10914_ _10914_/D _10978_/CLK _10914_/Q VDD VDD VSS VSS gf180mcu_fd_sc_mcu7t5v0__dffq_1
X_10845_ _10845_/D _11165_/CLK _10845_/Q VDD VDD VSS VSS gf180mcu_fd_sc_mcu7t5v0__dffq_1
X_10776_ _10776_/D _11164_/CLK _10776_/Q VDD VDD VSS VSS gf180mcu_fd_sc_mcu7t5v0__dffq_1
X_05820_ _10817_/Q _09340_/B2 VDD VDD VSS VSS gf180mcu_fd_sc_mcu7t5v0__clkinv_1
X_05751_ _10577_/Q _09040_/B2 VDD VDD VSS VSS gf180mcu_fd_sc_mcu7t5v0__clkinv_1
X_05682_ _11147_/Q _09896_/B2 VDD VDD VSS VSS gf180mcu_fd_sc_mcu7t5v0__clkinv_1
X_08470_ _10825_/Q _08580_/A2 _08584_/B1 _10881_/Q _08471_/A3 VDD VDD
+ VSS VSS gf180mcu_fd_sc_mcu7t5v0__aoi22_1
X_07421_ _07635_/A1 _07405_/Z _07413_/Z _07415_/Z _07421_/C _07422_/B2 VDD VDD
+ VSS VSS gf180mcu_fd_sc_mcu7t5v0__aoi221_1
X_07352_ _07352_/A1 _07352_/A2 _07548_/C VDD VDD VSS VSS gf180mcu_fd_sc_mcu7t5v0__nor2_4
X_06303_ _07470_/B2 _06304_/A4 _06349_/A2 VDD VDD VSS VSS gf180mcu_fd_sc_mcu7t5v0__nor2_1
X_07283_ _09941_/A1 _07293_/A2 _07283_/B _10100_/D VDD VDD VSS VSS
+ gf180mcu_fd_sc_mcu7t5v0__oai21_1
X_09022_ _09871_/A1 _09062_/A2 _09031_/A2 VDD VDD VSS VSS gf180mcu_fd_sc_mcu7t5v0__nand2_4
X_06234_ _10046_/Q _06195_/Z _06431_/A2 _10083_/Q _06304_/A4 VDD VDD VSS
+ VSS gf180mcu_fd_sc_mcu7t5v0__aoi22_2
X_06165_ _09925_/A1 _06167_/A2 _06165_/B _09993_/D VDD VDD VSS VSS
+ gf180mcu_fd_sc_mcu7t5v0__oai21_1
X_05116_ _10579_/Q _09044_/B2 VDD VDD VSS VSS gf180mcu_fd_sc_mcu7t5v0__clkinv_1
X_06096_ _08347_/A1 _08534_/A1 _09937_/A1 VDD VDD VSS VSS gf180mcu_fd_sc_mcu7t5v0__nor2_4
X_09924_ _09924_/A1 _09926_/A2 _09926_/B1 _09924_/B2 _11163_/D VDD VDD
+ VSS VSS gf180mcu_fd_sc_mcu7t5v0__oai22_1
X_05047_ _10043_/Q _06691_/B VDD VDD VSS VSS gf180mcu_fd_sc_mcu7t5v0__inv_3
X_09855_ _09893_/A1 _09860_/A2 _09860_/B1 _09855_/B2 _11120_/D VDD VDD
+ VSS VSS gf180mcu_fd_sc_mcu7t5v0__oai22_1
X_08806_ _06061_/Z _08809_/A2 _08809_/B1 _08806_/B2 _10423_/D VDD VDD
+ VSS VSS gf180mcu_fd_sc_mcu7t5v0__oai22_1
X_09786_ _11094_/Q _09795_/A2 _09809_/B _09787_/B VDD VDD VSS VSS
+ gf180mcu_fd_sc_mcu7t5v0__oai21_1
X_06998_ _06998_/A1 _07040_/A1 _06998_/Z VDD VDD VSS VSS gf180mcu_fd_sc_mcu7t5v0__or2_1
X_08737_ _09944_/A1 _08739_/A2 _08739_/B1 _08737_/B2 _10368_/D VDD VDD
+ VSS VSS gf180mcu_fd_sc_mcu7t5v0__oai22_1
X_05949_ bus_addr[2] bus_addr[3] bus_addr[4] _05987_/A2 VDD VDD VSS
+ VSS gf180mcu_fd_sc_mcu7t5v0__nor3_2
X_08668_ _10284_/Q _08675_/A2 _08672_/B _08669_/B VDD VDD VSS VSS
+ gf180mcu_fd_sc_mcu7t5v0__oai21_1
X_07619_ _07619_/A1 _07619_/A2 _07619_/A3 _07619_/Z VDD VDD VSS VSS
+ gf180mcu_fd_sc_mcu7t5v0__xor3_1
X_10630_ _10630_/D _10978_/CLK _10630_/Q VDD VDD VSS VSS gf180mcu_fd_sc_mcu7t5v0__dffq_1
X_08599_ _09442_/A1 _09937_/A2 _08608_/A2 VDD VDD VSS VSS gf180mcu_fd_sc_mcu7t5v0__nand2_4
X_10561_ _10561_/D _11138_/CLK _10561_/Q VDD VDD VSS VSS gf180mcu_fd_sc_mcu7t5v0__dffq_1
X_10492_ _10492_/D _11165_/CLK _10492_/Q VDD VDD VSS VSS gf180mcu_fd_sc_mcu7t5v0__dffq_1
X_11113_ _11113_/D _11150_/CLK _11113_/Q VDD VDD VSS VSS gf180mcu_fd_sc_mcu7t5v0__dffq_1
X_11044_ _11044_/D _11147_/CLK _11044_/Q VDD VDD VSS VSS gf180mcu_fd_sc_mcu7t5v0__dffq_1
X_10828_ _10828_/D _11142_/CLK _10828_/Q VDD VDD VSS VSS gf180mcu_fd_sc_mcu7t5v0__dffq_1
X_10759_ _10759_/D _11010_/CLK _10759_/Q VDD VDD VSS VSS gf180mcu_fd_sc_mcu7t5v0__dffq_1
X_07970_ _07970_/A1 _07970_/A2 _07970_/A3 _08008_/B1 VDD VDD VSS VSS
+ gf180mcu_fd_sc_mcu7t5v0__nand3_2
X_06921_ _06942_/A1 _08675_/A2 _06921_/B _10078_/D VDD VDD VSS VSS
+ gf180mcu_fd_sc_mcu7t5v0__aoi21_1
X_09640_ _11033_/Q _09642_/A2 _09641_/B VDD VDD VSS VSS gf180mcu_fd_sc_mcu7t5v0__nand2_1
X_06852_ _06852_/A1 _06852_/A2 _06852_/A3 _06856_/A2 VDD VDD VSS VSS
+ gf180mcu_fd_sc_mcu7t5v0__xnor3_1
X_09571_ _09920_/A1 _09577_/A2 _09577_/B1 _09571_/B2 _10988_/D VDD VDD
+ VSS VSS gf180mcu_fd_sc_mcu7t5v0__oai22_1
X_05803_ _10369_/Q _08738_/B2 VDD VDD VSS VSS gf180mcu_fd_sc_mcu7t5v0__clkinv_1
X_06783_ _06834_/C _06783_/A2 _06783_/A3 _06783_/A4 _06784_/B VDD VDD
+ VSS VSS gf180mcu_fd_sc_mcu7t5v0__nand4_1
X_05734_ _10393_/Q _08768_/B2 VDD VDD VSS VSS gf180mcu_fd_sc_mcu7t5v0__clkinv_1
X_08522_ _08522_/A1 _08522_/A2 _08523_/C VDD VDD VSS VSS gf180mcu_fd_sc_mcu7t5v0__nand2_1
X_08453_ _09900_/A2 _08453_/A2 _08453_/B1 _09662_/A2 _08473_/A2 VDD VDD
+ VSS VSS gf180mcu_fd_sc_mcu7t5v0__aoi22_1
X_05665_ _10728_/Q _09229_/B2 VDD VDD VSS VSS gf180mcu_fd_sc_mcu7t5v0__clkinv_1
X_07404_ _07405_/A1 _07403_/Z _07404_/Z VDD VDD VSS VSS gf180mcu_fd_sc_mcu7t5v0__and2_1
X_05596_ _10935_/Q _09488_/B2 VDD VDD VSS VSS gf180mcu_fd_sc_mcu7t5v0__clkinv_1
X_08384_ _09830_/B2 _08587_/A2 _08581_/A2 _09439_/B2 _08384_/C _08385_/C VDD
+ VDD VSS VSS gf180mcu_fd_sc_mcu7t5v0__oai221_2
X_07335_ _08661_/A1 _07332_/C _07519_/B VDD VDD VSS VSS gf180mcu_fd_sc_mcu7t5v0__nand2_4
X_07266_ _10093_/Q _07274_/A2 _07267_/B VDD VDD VSS VSS gf180mcu_fd_sc_mcu7t5v0__nand2_1
X_09005_ _09920_/A1 _09011_/A2 _09011_/B1 _09005_/B2 _10548_/D VDD VDD
+ VSS VSS gf180mcu_fd_sc_mcu7t5v0__oai22_1
X_06217_ _06270_/A1 _06505_/A1 _06460_/A1 _06221_/A2 VDD VDD VSS VSS
+ gf180mcu_fd_sc_mcu7t5v0__nor3_1
X_07197_ _10088_/Q _07213_/A1 _07194_/Z _07197_/Z VDD VDD VSS VSS
+ gf180mcu_fd_sc_mcu7t5v0__xor3_1
X_06148_ _08534_/B2 _08102_/A1 _09900_/A2 VDD VDD VSS VSS gf180mcu_fd_sc_mcu7t5v0__nor2_4
X_06079_ _08533_/A1 _08347_/A1 _09442_/A1 VDD VDD VSS VSS gf180mcu_fd_sc_mcu7t5v0__nor2_4
X_09907_ _11153_/Q _09915_/A2 _09908_/B VDD VDD VSS VSS gf180mcu_fd_sc_mcu7t5v0__nand2_1
X_09838_ _09904_/A1 _09850_/A2 _09838_/B _11111_/D VDD VDD VSS VSS
+ gf180mcu_fd_sc_mcu7t5v0__oai21_1
X_09769_ _11079_/Q _09766_/Z _09769_/Z VDD VDD VSS VSS gf180mcu_fd_sc_mcu7t5v0__and2_1
X_10613_ _10613_/D _11176_/CLK _10613_/Q VDD VDD VSS VSS gf180mcu_fd_sc_mcu7t5v0__dffq_1
X_10544_ _10544_/D _11138_/CLK _10544_/Q VDD VDD VSS VSS gf180mcu_fd_sc_mcu7t5v0__dffq_1
X_10475_ _10475_/D _11150_/CLK _10475_/Q VDD VDD VSS VSS gf180mcu_fd_sc_mcu7t5v0__dffq_1
X_11027_ _11027_/D _11164_/CLK _11027_/Q VDD VDD VSS VSS gf180mcu_fd_sc_mcu7t5v0__dffq_1
X_05450_ _10406_/Q _08785_/B2 VDD VDD VSS VSS gf180mcu_fd_sc_mcu7t5v0__clkinv_1
X_05381_ _10973_/Q _09544_/B2 VDD VDD VSS VSS gf180mcu_fd_sc_mcu7t5v0__clkinv_1
X_07120_ _07120_/A1 _07120_/A2 _07120_/B _07162_/A1 VDD VDD VSS VSS
+ gf180mcu_fd_sc_mcu7t5v0__oai21_1
X_07051_ _07223_/A2 _07104_/A1 _07051_/Z VDD VDD VSS VSS gf180mcu_fd_sc_mcu7t5v0__xor2_1
X_06002_ _09728_/A1 _06002_/A2 _06002_/B bus_rdata[3] VDD VDD VSS VSS
+ gf180mcu_fd_sc_mcu7t5v0__oai21_4
X_07953_ _10106_/Q _08580_/A2 _06125_/I _11134_/Q _07954_/A3 VDD VDD VSS
+ VSS gf180mcu_fd_sc_mcu7t5v0__aoi22_1
X_07884_ _07884_/A1 _07890_/A2 _07884_/B _10262_/D VDD VDD VSS VSS
+ gf180mcu_fd_sc_mcu7t5v0__aoi21_1
X_06904_ _10070_/Q _06916_/A2 _06905_/B VDD VDD VSS VSS gf180mcu_fd_sc_mcu7t5v0__nand2_1
X_09623_ _09925_/A1 _09625_/A2 _09623_/B _11025_/D VDD VDD VSS VSS
+ gf180mcu_fd_sc_mcu7t5v0__oai21_1
X_06835_ _06835_/A1 _06835_/A2 _06835_/B _06836_/B VDD VDD VSS VSS
+ gf180mcu_fd_sc_mcu7t5v0__aoi21_1
X_09554_ _10980_/Q _09566_/A2 _09555_/B VDD VDD VSS VSS gf180mcu_fd_sc_mcu7t5v0__nand2_1
X_06766_ _06766_/A1 _06766_/A2 _06766_/Z VDD VDD VSS VSS gf180mcu_fd_sc_mcu7t5v0__xor2_1
X_09485_ _09920_/A1 _09491_/A2 _09491_/B1 _09485_/B2 _10932_/D VDD VDD
+ VSS VSS gf180mcu_fd_sc_mcu7t5v0__oai22_1
X_08505_ _09270_/B2 _08587_/A2 _08581_/A2 _09280_/B2 _08505_/C _08506_/C VDD
+ VDD VSS VSS gf180mcu_fd_sc_mcu7t5v0__oai221_2
X_05717_ _10840_/Q _09369_/B2 VDD VDD VSS VSS gf180mcu_fd_sc_mcu7t5v0__clkinv_1
X_06697_ _06697_/A1 _06697_/A2 _06698_/I VDD VDD VSS VSS gf180mcu_fd_sc_mcu7t5v0__xnor2_1
X_08436_ _10221_/Q _08573_/B1 _08589_/B1 _11124_/Q _08441_/A1 VDD VDD
+ VSS VSS gf180mcu_fd_sc_mcu7t5v0__aoi22_1
X_05648_ _10600_/Q _09069_/B2 VDD VDD VSS VSS gf180mcu_fd_sc_mcu7t5v0__clkinv_1
X_08367_ _08367_/A1 _08367_/A2 _08367_/A3 _08368_/B1 VDD VDD VSS VSS
+ gf180mcu_fd_sc_mcu7t5v0__nand3_1
X_05579_ _10351_/Q _08716_/B2 VDD VDD VSS VSS gf180mcu_fd_sc_mcu7t5v0__clkinv_1
X_07318_ _10242_/Q _08675_/A2 _08672_/B _07319_/B VDD VDD VSS VSS
+ gf180mcu_fd_sc_mcu7t5v0__oai21_1
X_08298_ _09951_/Q _08560_/A2 _08589_/A2 _11031_/Q _08300_/A2 VDD VDD
+ VSS VSS gf180mcu_fd_sc_mcu7t5v0__aoi22_1
X_07249_ _07247_/Z _07249_/A2 _07249_/B _07250_/C VDD VDD VSS VSS
+ gf180mcu_fd_sc_mcu7t5v0__oai21_1
X_10260_ _10260_/D _11052_/CLK _10260_/Q VDD VDD VSS VSS gf180mcu_fd_sc_mcu7t5v0__dffq_1
X_10191_ _10191_/D _11097_/CLK _10191_/Q VDD VDD VSS VSS gf180mcu_fd_sc_mcu7t5v0__dffq_1
X_10527_ _10527_/D _11109_/CLK _10527_/Q VDD VDD VSS VSS gf180mcu_fd_sc_mcu7t5v0__dffq_1
X_10458_ _10458_/D _11101_/CLK _10458_/Q VDD VDD VSS VSS gf180mcu_fd_sc_mcu7t5v0__dffq_1
X_10389_ _10389_/D _11018_/CLK _10389_/Q VDD VDD VSS VSS gf180mcu_fd_sc_mcu7t5v0__dffq_1
X_06620_ _10333_/Q _10044_/Q _06621_/B2 VDD VDD VSS VSS gf180mcu_fd_sc_mcu7t5v0__nand2_1
X_06551_ _06691_/A1 _08675_/A2 _06551_/B _10044_/D VDD VDD VSS VSS
+ gf180mcu_fd_sc_mcu7t5v0__aoi21_1
X_09270_ _09925_/A1 _09271_/A2 _09271_/B1 _09270_/B2 _10761_/D VDD VDD
+ VSS VSS gf180mcu_fd_sc_mcu7t5v0__oai22_1
X_05502_ _10814_/Q _09337_/B2 VDD VDD VSS VSS gf180mcu_fd_sc_mcu7t5v0__clkinv_1
X_06482_ _06482_/A1 _06482_/A2 _06482_/Z VDD VDD VSS VSS gf180mcu_fd_sc_mcu7t5v0__xor2_1
X_08221_ _08221_/A1 _08221_/A2 _08221_/A3 _08222_/B1 VDD VDD VSS VSS
+ gf180mcu_fd_sc_mcu7t5v0__nand3_1
X_05433_ _10574_/Q _09037_/B2 VDD VDD VSS VSS gf180mcu_fd_sc_mcu7t5v0__clkinv_1
X_05364_ _11144_/Q _09893_/B2 VDD VDD VSS VSS gf180mcu_fd_sc_mcu7t5v0__clkinv_1
X_08152_ _10589_/Q _08582_/A2 _08584_/A2 _10573_/Q _08156_/A1 VDD VDD
+ VSS VSS gf180mcu_fd_sc_mcu7t5v0__aoi22_1
Xclkbuf_leaf_9_clk clkbuf_1_1_0_clk/Z _11165_/CLK VDD VDD VSS VSS
+ gf180mcu_fd_sc_mcu7t5v0__clkbuf_16
X_05295_ _10852_/Q _09385_/B2 VDD VDD VSS VSS gf180mcu_fd_sc_mcu7t5v0__clkinv_1
X_08083_ _09956_/Q _08563_/A2 _08584_/B1 _10364_/Q _08084_/I VDD VDD VSS
+ VSS gf180mcu_fd_sc_mcu7t5v0__aoi22_1
X_07103_ _07199_/B _07223_/A2 _07104_/A2 VDD VDD VSS VSS gf180mcu_fd_sc_mcu7t5v0__nand2_1
X_07034_ _10003_/Q _07222_/A2 _07040_/A3 VDD VDD VSS VSS gf180mcu_fd_sc_mcu7t5v0__nand2_1
X_08985_ _09904_/A1 _08991_/A2 _08991_/B1 _08985_/B2 _10532_/D VDD VDD
+ VSS VSS gf180mcu_fd_sc_mcu7t5v0__oai22_1
X_07936_ _08327_/B2 _07936_/A2 _07936_/B1 _08327_/A1 _08345_/B2 _07936_/C2 _07937_/A2
+ VDD VDD VSS VSS gf180mcu_fd_sc_mcu7t5v0__aoi222_1
X_07867_ rst_n _07866_/Z _10254_/D VDD VDD VSS VSS gf180mcu_fd_sc_mcu7t5v0__and2_1
X_09606_ _09897_/A1 _09607_/A2 _09607_/B1 _09606_/B2 _11017_/D VDD VDD
+ VSS VSS gf180mcu_fd_sc_mcu7t5v0__oai22_1
X_07798_ _09937_/A2 _09889_/A2 _07807_/A2 VDD VDD VSS VSS gf180mcu_fd_sc_mcu7t5v0__nand2_4
X_06818_ _06765_/Z _06816_/Z _06840_/A2 VDD VDD VSS VSS gf180mcu_fd_sc_mcu7t5v0__nand2_1
X_09537_ _09537_/A1 _09539_/A2 _09537_/B _10969_/D VDD VDD VSS VSS
+ gf180mcu_fd_sc_mcu7t5v0__oai21_1
X_06749_ _06749_/A1 _06848_/A1 _06749_/Z VDD VDD VSS VSS gf180mcu_fd_sc_mcu7t5v0__xor2_1
X_09468_ _06061_/Z _09471_/A2 _09471_/B1 _09468_/B2 _10919_/D VDD VDD
+ VSS VSS gf180mcu_fd_sc_mcu7t5v0__oai22_1
X_08419_ _10400_/Q _08589_/B1 _08576_/B1 _10928_/Q _08591_/B1 _10992_/Q _08422_/A1
+ VDD VDD VSS VSS gf180mcu_fd_sc_mcu7t5v0__aoi222_2
X_09399_ _09896_/A1 _09401_/A2 _09401_/B1 _09399_/B2 _10864_/D VDD VDD
+ VSS VSS gf180mcu_fd_sc_mcu7t5v0__oai22_1
X_10312_ _10312_/D _10327_/CLK _10312_/Q VDD VDD VSS VSS gf180mcu_fd_sc_mcu7t5v0__dffq_4
X_10243_ _10243_/D _10327_/CLK _10243_/Q VDD VDD VSS VSS gf180mcu_fd_sc_mcu7t5v0__dffq_1
X_10174_ _10174_/D _11052_/CLK _10174_/Q VDD VDD VSS VSS gf180mcu_fd_sc_mcu7t5v0__dffq_1
X_05080_ _10303_/Q _05974_/A1 VDD VDD VSS VSS gf180mcu_fd_sc_mcu7t5v0__clkinv_1
Xrepeater5 _08532_/A2 _08584_/B1 VDD VDD VSS VSS gf180mcu_fd_sc_mcu7t5v0__buf_16
X_08770_ _09851_/A1 _09568_/A2 _08779_/A2 VDD VDD VSS VSS gf180mcu_fd_sc_mcu7t5v0__nand2_4
X_05982_ _05980_/Z _05982_/A2 _09900_/B _10302_/D VDD VDD VSS VSS
+ gf180mcu_fd_sc_mcu7t5v0__aoi21_1
X_07721_ _06061_/Z _07727_/A2 _07721_/B _10171_/D VDD VDD VSS VSS
+ gf180mcu_fd_sc_mcu7t5v0__oai21_1
X_07652_ _10132_/Q _07656_/A2 _07653_/B VDD VDD VSS VSS gf180mcu_fd_sc_mcu7t5v0__nand2_1
X_07583_ _07583_/A1 _07583_/A2 _07532_/Z _07583_/B1 _07583_/B2 _07585_/A2 VDD
+ VDD VSS VSS gf180mcu_fd_sc_mcu7t5v0__oai32_1
X_06603_ _10001_/Q _06602_/Z _06603_/Z VDD VDD VSS VSS gf180mcu_fd_sc_mcu7t5v0__and2_1
X_09322_ _09900_/A1 _09332_/A2 _09331_/A2 VDD VDD VSS VSS gf180mcu_fd_sc_mcu7t5v0__nand2_4
X_06534_ _06047_/Z _06541_/A2 _06541_/B1 _06534_/B2 _10032_/D VDD VDD
+ VSS VSS gf180mcu_fd_sc_mcu7t5v0__oai22_1
X_09253_ _09890_/A1 _09261_/A2 _09261_/B1 VDD VDD VSS VSS gf180mcu_fd_sc_mcu7t5v0__nand2_4
X_06465_ _06466_/A1 _06466_/A2 _06465_/B _06501_/B VDD VDD VSS VSS
+ gf180mcu_fd_sc_mcu7t5v0__aoi21_1
X_05416_ _10390_/Q _08765_/B2 VDD VDD VSS VSS gf180mcu_fd_sc_mcu7t5v0__clkinv_1
X_08204_ _08327_/A1 _08204_/A2 _08204_/B _08204_/C _08268_/A2 VDD VDD
+ VSS VSS gf180mcu_fd_sc_mcu7t5v0__aoi211_1
X_06396_ _06398_/A1 _06398_/A2 _06437_/B VDD VDD VSS VSS gf180mcu_fd_sc_mcu7t5v0__nand2_1
X_09184_ _06047_/Z _09191_/A2 _09191_/B1 _09184_/B2 _10691_/D VDD VDD
+ VSS VSS gf180mcu_fd_sc_mcu7t5v0__oai22_1
X_05347_ _10725_/Q _09226_/B2 VDD VDD VSS VSS gf180mcu_fd_sc_mcu7t5v0__clkinv_1
X_08135_ _10725_/Q _08580_/A2 _08576_/B1 _10997_/Q _08136_/A3 VDD VDD
+ VSS VSS gf180mcu_fd_sc_mcu7t5v0__aoi22_1
X_05278_ _10932_/Q _09485_/B2 VDD VDD VSS VSS gf180mcu_fd_sc_mcu7t5v0__clkinv_1
X_08066_ _08066_/A1 _08066_/A2 _08066_/A3 _08099_/C1 VDD VDD VSS VSS
+ gf180mcu_fd_sc_mcu7t5v0__nand3_2
X_07017_ _10002_/Q _07221_/A2 _07016_/Z _07206_/C _07021_/B1 VDD VDD VSS
+ VSS gf180mcu_fd_sc_mcu7t5v0__oai22_1
X_08968_ _06061_/Z _08971_/A2 _08971_/B1 _08968_/B2 _10519_/D VDD VDD
+ VSS VSS gf180mcu_fd_sc_mcu7t5v0__oai22_1
X_08899_ _06058_/Z _08903_/A2 _08903_/B1 _08899_/B2 _10470_/D VDD VDD
+ VSS VSS gf180mcu_fd_sc_mcu7t5v0__oai22_1
X_07919_ bus_wdata[6] _07920_/A2 rst_n _07920_/B VDD VDD VSS VSS gf180mcu_fd_sc_mcu7t5v0__oai21_1
X_10930_ _10930_/D _11018_/CLK _10930_/Q VDD VDD VSS VSS gf180mcu_fd_sc_mcu7t5v0__dffq_1
X_10861_ _10861_/D _11142_/CLK _10861_/Q VDD VDD VSS VSS gf180mcu_fd_sc_mcu7t5v0__dffq_1
X_10792_ _10792_/D _11010_/CLK _10792_/Q VDD VDD VSS VSS gf180mcu_fd_sc_mcu7t5v0__dffq_1
X_10226_ _10226_/D _11147_/CLK _10226_/Q VDD VDD VSS VSS gf180mcu_fd_sc_mcu7t5v0__dffq_1
X_10157_ _10157_/D _10905_/CLK _10157_/Q VDD VDD VSS VSS gf180mcu_fd_sc_mcu7t5v0__dffq_1
X_10088_ _10088_/D _10327_/CLK _10088_/Q VDD VDD VSS VSS gf180mcu_fd_sc_mcu7t5v0__dffq_2
X_06250_ _06271_/A1 _06250_/A2 _06250_/Z VDD VDD VSS VSS gf180mcu_fd_sc_mcu7t5v0__or2_1
X_05201_ _10176_/Q _07732_/B2 VDD VDD VSS VSS gf180mcu_fd_sc_mcu7t5v0__clkinv_1
X_06181_ _10332_/Q _08675_/A2 _08672_/B _06182_/B VDD VDD VSS VSS
+ gf180mcu_fd_sc_mcu7t5v0__oai21_1
X_05132_ _10403_/Q _08782_/B2 VDD VDD VSS VSS gf180mcu_fd_sc_mcu7t5v0__clkinv_1
X_05063_ _10001_/Q _07431_/A1 VDD VDD VSS VSS gf180mcu_fd_sc_mcu7t5v0__clkinv_3
X_09940_ _09940_/A1 _09946_/A2 _09946_/B1 _09940_/B2 _11175_/D VDD VDD
+ VSS VSS gf180mcu_fd_sc_mcu7t5v0__oai22_1
X_09871_ _09871_/A1 _09900_/A2 _09888_/A2 VDD VDD VSS VSS gf180mcu_fd_sc_mcu7t5v0__nand2_4
X_08822_ _06047_/Z _08829_/A2 _08829_/B1 _08822_/B2 _10435_/D VDD VDD
+ VSS VSS gf180mcu_fd_sc_mcu7t5v0__oai22_1
X_08753_ _09920_/A1 _08759_/A2 _08759_/B1 _08753_/B2 _10380_/D VDD VDD
+ VSS VSS gf180mcu_fd_sc_mcu7t5v0__oai22_1
X_05965_ _05976_/A1 _11071_/Q _05965_/A3 _11073_/Q _05968_/A2 VDD VDD
+ VSS VSS gf180mcu_fd_sc_mcu7t5v0__nand4_2
X_07704_ _09941_/A1 _07709_/A2 _07709_/B1 _07704_/B2 _10161_/D VDD VDD
+ VSS VSS gf180mcu_fd_sc_mcu7t5v0__oai22_1
X_05896_ _10890_/Q _09431_/B2 VDD VDD VSS VSS gf180mcu_fd_sc_mcu7t5v0__clkinv_1
X_08684_ _08684_/A1 _08684_/A2 _09900_/B _10333_/D VDD VDD VSS VSS
+ gf180mcu_fd_sc_mcu7t5v0__aoi21_1
X_07635_ _07635_/A1 _07635_/A2 _07631_/Z _07346_/Z _07635_/C _07636_/A2 VDD
+ VDD VSS VSS gf180mcu_fd_sc_mcu7t5v0__aoi221_1
X_07566_ _10003_/Q _07463_/Z _07614_/A2 VDD VDD VSS VSS gf180mcu_fd_sc_mcu7t5v0__nand2_1
X_09305_ _09904_/A1 _09311_/A2 _09311_/B1 _09305_/B2 _10788_/D VDD VDD
+ VSS VSS gf180mcu_fd_sc_mcu7t5v0__oai22_1
X_06517_ _06058_/Z _06521_/A2 _06521_/B1 _06517_/B2 _10019_/D VDD VDD
+ VSS VSS gf180mcu_fd_sc_mcu7t5v0__oai22_1
X_09236_ _09893_/A1 _09241_/A2 _09241_/B1 _09236_/B2 _10733_/D VDD VDD
+ VSS VSS gf180mcu_fd_sc_mcu7t5v0__oai22_1
X_07497_ _10004_/Q _07463_/Z _07498_/B1 VDD VDD VSS VSS gf180mcu_fd_sc_mcu7t5v0__nand2_1
X_06448_ _06450_/A2 _06447_/Z _06494_/B VDD VDD VSS VSS gf180mcu_fd_sc_mcu7t5v0__nand2_1
X_09167_ _06058_/Z _09171_/A2 _09171_/B1 _09167_/B2 _10678_/D VDD VDD
+ VSS VSS gf180mcu_fd_sc_mcu7t5v0__oai22_1
X_06379_ _06379_/A1 _06358_/Z _06379_/B _06428_/A1 VDD VDD VSS VSS
+ gf180mcu_fd_sc_mcu7t5v0__oai21_1
X_09098_ _06061_/Z _09101_/A2 _09101_/B1 _09098_/B2 _10623_/D VDD VDD
+ VSS VSS gf180mcu_fd_sc_mcu7t5v0__oai22_1
X_08118_ _11029_/Q _08559_/A2 _08877_/A2 _11021_/Q _08121_/A1 VDD VDD
+ VSS VSS gf180mcu_fd_sc_mcu7t5v0__aoi22_1
X_08049_ _10804_/Q _08560_/B1 _07255_/I _10812_/Q _08049_/C _08050_/B VDD VDD
+ VSS VSS gf180mcu_fd_sc_mcu7t5v0__aoi221_2
X_11060_ _11060_/D _11097_/CLK _11060_/Q VDD VDD VSS VSS gf180mcu_fd_sc_mcu7t5v0__dffq_1
X_10011_ _10011_/D _10327_/CLK _10011_/Q VDD VDD VSS VSS gf180mcu_fd_sc_mcu7t5v0__dffq_2
X_10913_ _10913_/D _11149_/CLK _10913_/Q VDD VDD VSS VSS gf180mcu_fd_sc_mcu7t5v0__dffq_1
X_10844_ _10844_/D _11138_/CLK _10844_/Q VDD VDD VSS VSS gf180mcu_fd_sc_mcu7t5v0__dffq_1
X_10775_ _10775_/D _11010_/CLK _10775_/Q VDD VDD VSS VSS gf180mcu_fd_sc_mcu7t5v0__dffq_1
X_10209_ _10209_/D _11139_/CLK _10209_/Q VDD VDD VSS VSS gf180mcu_fd_sc_mcu7t5v0__dffq_1
X_05750_ _10569_/Q _09030_/B2 VDD VDD VSS VSS gf180mcu_fd_sc_mcu7t5v0__clkinv_1
X_05681_ _11171_/Q _09934_/B2 VDD VDD VSS VSS gf180mcu_fd_sc_mcu7t5v0__clkinv_1
X_07420_ _07420_/I _07421_/C VDD VDD VSS VSS gf180mcu_fd_sc_mcu7t5v0__clkinv_1
X_07351_ _07352_/A1 _07496_/A1 _07633_/A2 VDD VDD VSS VSS gf180mcu_fd_sc_mcu7t5v0__nor2_2
X_06302_ _10003_/Q _06481_/A2 _06390_/B2 VDD VDD VSS VSS gf180mcu_fd_sc_mcu7t5v0__nand2_1
X_07282_ _10100_/Q _07292_/A2 _07283_/B VDD VDD VSS VSS gf180mcu_fd_sc_mcu7t5v0__nand2_1
X_09021_ _09926_/A1 _09021_/A2 _09021_/B1 _09021_/B2 _10562_/D VDD VDD
+ VSS VSS gf180mcu_fd_sc_mcu7t5v0__oai22_1
X_06233_ _10046_/Q _09999_/Q _09998_/Q _06235_/B VDD VDD VSS VSS gf180mcu_fd_sc_mcu7t5v0__nand3_2
X_06164_ _09993_/Q _06166_/A2 _06165_/B VDD VDD VSS VSS gf180mcu_fd_sc_mcu7t5v0__nand2_1
X_05115_ _10571_/Q _09034_/B2 VDD VDD VSS VSS gf180mcu_fd_sc_mcu7t5v0__clkinv_1
X_06095_ _06145_/A1 _06040_/I _08534_/A1 VDD VDD VSS VSS gf180mcu_fd_sc_mcu7t5v0__nand2_4
X_09923_ _06061_/Z _09926_/A2 _09926_/B1 _09923_/B2 _11162_/D VDD VDD
+ VSS VSS gf180mcu_fd_sc_mcu7t5v0__oai22_1
X_05046_ _10044_/Q _06691_/A1 VDD VDD VSS VSS gf180mcu_fd_sc_mcu7t5v0__clkinv_2
X_09854_ _09920_/A1 _09860_/A2 _09860_/B1 _09854_/B2 _11119_/D VDD VDD
+ VSS VSS gf180mcu_fd_sc_mcu7t5v0__oai22_1
X_08805_ _06058_/Z _08809_/A2 _08809_/B1 _08805_/B2 _10422_/D VDD VDD
+ VSS VSS gf180mcu_fd_sc_mcu7t5v0__oai22_1
X_09785_ _09785_/A1 _09795_/A2 _09785_/B _11085_/D VDD VDD VSS VSS
+ gf180mcu_fd_sc_mcu7t5v0__aoi21_1
X_06997_ _10002_/Q _10001_/Q _07222_/A2 _07181_/A2 _06997_/Z VDD VDD VSS
+ VSS gf180mcu_fd_sc_mcu7t5v0__and4_1
X_08736_ _06061_/Z _08739_/A2 _08739_/B1 _08736_/B2 _10367_/D VDD VDD
+ VSS VSS gf180mcu_fd_sc_mcu7t5v0__oai22_1
X_05948_ _10290_/Q _08830_/B _05955_/B VDD VDD VSS VSS gf180mcu_fd_sc_mcu7t5v0__nand2_1
X_05879_ _10746_/Q _09251_/B2 VDD VDD VSS VSS gf180mcu_fd_sc_mcu7t5v0__clkinv_1
X_08667_ _08667_/A1 _08675_/A2 _08667_/B _10326_/D VDD VDD VSS VSS
+ gf180mcu_fd_sc_mcu7t5v0__aoi21_1
X_07618_ _07618_/A1 _07618_/A2 _07618_/Z VDD VDD VSS VSS gf180mcu_fd_sc_mcu7t5v0__xor2_1
X_08598_ _08598_/A1 _08597_/Z _09900_/B _10287_/D VDD VDD VSS VSS
+ gf180mcu_fd_sc_mcu7t5v0__aoi21_1
X_07549_ _07601_/B _07549_/A2 _07550_/B VDD VDD VSS VSS gf180mcu_fd_sc_mcu7t5v0__nor2_1
X_10560_ _10560_/D _11138_/CLK _10560_/Q VDD VDD VSS VSS gf180mcu_fd_sc_mcu7t5v0__dffq_1
X_10491_ _10491_/D _11165_/CLK _10491_/Q VDD VDD VSS VSS gf180mcu_fd_sc_mcu7t5v0__dffq_1
X_09219_ _09884_/A1 _09221_/A2 _09221_/B1 _09219_/B2 _10720_/D VDD VDD
+ VSS VSS gf180mcu_fd_sc_mcu7t5v0__oai22_1
X_11112_ _11112_/D _11150_/CLK _11112_/Q VDD VDD VSS VSS gf180mcu_fd_sc_mcu7t5v0__dffq_1
X_11043_ _11043_/D _11142_/CLK _11043_/Q VDD VDD VSS VSS gf180mcu_fd_sc_mcu7t5v0__dffq_1
X_10827_ _10827_/D _11142_/CLK _10827_/Q VDD VDD VSS VSS gf180mcu_fd_sc_mcu7t5v0__dffq_1
X_10758_ _10758_/D _11010_/CLK _10758_/Q VDD VDD VSS VSS gf180mcu_fd_sc_mcu7t5v0__dffq_1
X_10689_ _10689_/D _10905_/CLK _10689_/Q VDD VDD VSS VSS gf180mcu_fd_sc_mcu7t5v0__dffq_1
X_06920_ _10245_/Q _08675_/A2 _08674_/B _06921_/B VDD VDD VSS VSS
+ gf180mcu_fd_sc_mcu7t5v0__oai21_1
X_06851_ _10007_/Q _06557_/Z _06852_/A3 VDD VDD VSS VSS gf180mcu_fd_sc_mcu7t5v0__nand2_1
X_09570_ _06047_/Z _09577_/A2 _09577_/B1 _09570_/B2 _10987_/D VDD VDD
+ VSS VSS gf180mcu_fd_sc_mcu7t5v0__oai22_1
X_06782_ _10005_/Q _06847_/A2 _06782_/B _06783_/A4 VDD VDD VSS VSS
+ gf180mcu_fd_sc_mcu7t5v0__oai21_1
X_05802_ _10022_/Q _06520_/B2 VDD VDD VSS VSS gf180mcu_fd_sc_mcu7t5v0__clkinv_1
X_05733_ _10310_/Q _08617_/B2 VDD VDD VSS VSS gf180mcu_fd_sc_mcu7t5v0__clkinv_1
X_08521_ _10166_/Q _06023_/I _08586_/A2 _10023_/Q _08584_/B1 _10370_/Q _08522_/A2
+ VDD VDD VSS VSS gf180mcu_fd_sc_mcu7t5v0__aoi222_1
X_08452_ _08452_/A1 _08452_/A2 _08452_/A3 _08453_/B1 VDD VDD VSS VSS
+ gf180mcu_fd_sc_mcu7t5v0__nand3_1
X_05664_ _10720_/Q _09219_/B2 VDD VDD VSS VSS gf180mcu_fd_sc_mcu7t5v0__clkinv_1
X_07403_ _07395_/I _07403_/A2 _07403_/Z VDD VDD VSS VSS gf180mcu_fd_sc_mcu7t5v0__xor2_1
X_08383_ _10512_/Q _06112_/I _08591_/B1 _10520_/Q _08591_/C1 _10504_/Q _08384_/C VDD
+ VDD VSS VSS gf180mcu_fd_sc_mcu7t5v0__aoi222_2
X_05595_ _10951_/Q _09508_/B2 VDD VDD VSS VSS gf180mcu_fd_sc_mcu7t5v0__clkinv_1
X_07334_ _10323_/Q _07333_/C _07368_/B VDD VDD VSS VSS gf180mcu_fd_sc_mcu7t5v0__nor2_2
X_07265_ _09941_/A1 _07275_/A2 _07265_/B _10092_/D VDD VDD VSS VSS
+ gf180mcu_fd_sc_mcu7t5v0__oai21_1
X_09004_ _06047_/Z _09011_/A2 _09011_/B1 _09004_/B2 _10547_/D VDD VDD
+ VSS VSS gf180mcu_fd_sc_mcu7t5v0__oai22_1
X_06216_ _09995_/Q _06216_/A2 _06509_/A1 VDD VDD VSS VSS gf180mcu_fd_sc_mcu7t5v0__nand2_2
X_07196_ _10088_/Q _07194_/Z _07213_/A2 VDD VDD VSS VSS gf180mcu_fd_sc_mcu7t5v0__nor2_1
X_06147_ _07921_/A1 _06147_/A2 _08102_/A1 VDD VDD VSS VSS gf180mcu_fd_sc_mcu7t5v0__nand2_4
X_06078_ _06032_/I _06147_/A2 _08347_/A1 VDD VDD VSS VSS gf180mcu_fd_sc_mcu7t5v0__nand2_4
X_09906_ _09921_/A1 _09916_/A2 _09906_/B _11152_/D VDD VDD VSS VSS
+ gf180mcu_fd_sc_mcu7t5v0__oai21_1
X_05029_ _10117_/Q _07557_/B2 VDD VDD VSS VSS gf180mcu_fd_sc_mcu7t5v0__clkinv_4
X_09837_ _11111_/Q _09849_/A2 _09838_/B VDD VDD VSS VSS gf180mcu_fd_sc_mcu7t5v0__nand2_1
X_09768_ _09766_/Z _09768_/A2 _11078_/D VDD VDD VSS VSS gf180mcu_fd_sc_mcu7t5v0__nor2_1
X_08719_ _09926_/A1 _08719_/A2 _08719_/B1 _08719_/B2 _10354_/D VDD VDD
+ VSS VSS gf180mcu_fd_sc_mcu7t5v0__oai22_1
X_09699_ _11057_/Q _10289_/Q _09699_/B _09701_/A2 VDD VDD VSS VSS
+ gf180mcu_fd_sc_mcu7t5v0__aoi21_1
X_10612_ _10612_/D _10666_/CLK _10612_/Q VDD VDD VSS VSS gf180mcu_fd_sc_mcu7t5v0__dffq_1
X_10543_ _10543_/D _11138_/CLK _10543_/Q VDD VDD VSS VSS gf180mcu_fd_sc_mcu7t5v0__dffq_1
X_10474_ _10474_/D _11017_/CLK _10474_/Q VDD VDD VSS VSS gf180mcu_fd_sc_mcu7t5v0__dffq_1
X_11026_ _11026_/D _11039_/CLK _11026_/Q VDD VDD VSS VSS gf180mcu_fd_sc_mcu7t5v0__dffq_1
X_05380_ _11005_/Q _09592_/B2 VDD VDD VSS VSS gf180mcu_fd_sc_mcu7t5v0__clkinv_1
X_07050_ _07222_/A2 _07181_/A2 _07221_/A2 _07199_/B _07104_/A1 VDD VDD
+ VSS VSS gf180mcu_fd_sc_mcu7t5v0__oai31_1
X_06001_ _11055_/Q _07876_/A2 _05986_/I _11086_/Q _06002_/A2 VDD VDD VSS
+ VSS gf180mcu_fd_sc_mcu7t5v0__aoi22_2
X_07952_ _09987_/Q _08540_/A2 _08591_/B1 _10459_/Q _07954_/A2 VDD VDD
+ VSS VSS gf180mcu_fd_sc_mcu7t5v0__aoi22_1
X_07883_ bus_wdata[3] _07890_/A2 _08658_/B _07884_/B VDD VDD VSS VSS
+ gf180mcu_fd_sc_mcu7t5v0__oai21_1
X_06903_ _06047_/Z _06917_/A2 _06903_/B _10069_/D VDD VDD VSS VSS
+ gf180mcu_fd_sc_mcu7t5v0__oai21_1
X_09622_ _11025_/Q _09624_/A2 _09623_/B VDD VDD VSS VSS gf180mcu_fd_sc_mcu7t5v0__nand2_1
X_06834_ _06834_/A1 _06834_/A2 _06834_/B _06834_/C _06835_/B VDD VDD VSS
+ VSS gf180mcu_fd_sc_mcu7t5v0__oai211_1
X_09553_ _06047_/Z _09567_/A2 _09553_/B _10979_/D VDD VDD VSS VSS
+ gf180mcu_fd_sc_mcu7t5v0__oai21_1
X_08504_ _10793_/Q _06112_/I _08877_/A2 _10801_/Q _09872_/A1 _10785_/Q _08505_/C VDD
+ VDD VSS VSS gf180mcu_fd_sc_mcu7t5v0__aoi222_2
X_06765_ _06766_/A1 _06766_/A2 _06765_/Z VDD VDD VSS VSS gf180mcu_fd_sc_mcu7t5v0__and2_1
X_09484_ _06047_/Z _09491_/A2 _09491_/B1 _09484_/B2 _10931_/D VDD VDD
+ VSS VSS gf180mcu_fd_sc_mcu7t5v0__oai22_1
X_05716_ _10832_/Q _09359_/B2 VDD VDD VSS VSS gf180mcu_fd_sc_mcu7t5v0__clkinv_1
X_06696_ _10001_/Q _06696_/A2 _06823_/A1 _06787_/A1 VDD VDD VSS VSS
+ gf180mcu_fd_sc_mcu7t5v0__nand3_2
X_08435_ _08435_/A1 _08435_/A2 _08435_/A3 _08442_/A2 VDD VDD VSS VSS
+ gf180mcu_fd_sc_mcu7t5v0__nand3_2
X_05647_ _10592_/Q _09059_/B2 VDD VDD VSS VSS gf180mcu_fd_sc_mcu7t5v0__clkinv_1
X_08366_ _10172_/Q _08528_/B1 _08529_/B1 _10196_/Q _10236_/Q _06877_/Z _08367_/A3
+ VDD VDD VSS VSS gf180mcu_fd_sc_mcu7t5v0__aoi222_2
X_05578_ _10887_/Q _09428_/B2 VDD VDD VSS VSS gf180mcu_fd_sc_mcu7t5v0__clkinv_1
X_07317_ _07352_/A1 _08675_/A2 _07317_/B _10116_/D VDD VDD VSS VSS
+ gf180mcu_fd_sc_mcu7t5v0__aoi21_1
X_08297_ _11007_/Q _08444_/B1 _07255_/I _10983_/Q _08300_/A1 VDD VDD VSS
+ VSS gf180mcu_fd_sc_mcu7t5v0__aoi22_1
X_07248_ _10079_/Q _07628_/A1 _07248_/B _07249_/A2 VDD VDD VSS VSS
+ gf180mcu_fd_sc_mcu7t5v0__aoi21_1
X_07179_ _10004_/Q _07221_/A2 _07227_/B2 VDD VDD VSS VSS gf180mcu_fd_sc_mcu7t5v0__nand2_1
X_10190_ _10190_/D _10905_/CLK _10190_/Q VDD VDD VSS VSS gf180mcu_fd_sc_mcu7t5v0__dffq_1
X_10526_ _10526_/D _11018_/CLK _10526_/Q VDD VDD VSS VSS gf180mcu_fd_sc_mcu7t5v0__dffq_1
X_10457_ _10457_/D _11101_/CLK _10457_/Q VDD VDD VSS VSS gf180mcu_fd_sc_mcu7t5v0__dffq_1
X_10388_ _10388_/D _11017_/CLK _10388_/Q VDD VDD VSS VSS gf180mcu_fd_sc_mcu7t5v0__dffq_1
X_11009_ _11009_/D _11039_/CLK _11009_/Q VDD VDD VSS VSS gf180mcu_fd_sc_mcu7t5v0__dffq_1
X_06550_ _10253_/Q _08675_/A2 _08674_/B _06551_/B VDD VDD VSS VSS
+ gf180mcu_fd_sc_mcu7t5v0__oai21_1
X_05501_ _10806_/Q _09327_/B2 VDD VDD VSS VSS gf180mcu_fd_sc_mcu7t5v0__clkinv_1
X_06481_ _10007_/Q _06481_/A2 _06482_/A2 VDD VDD VSS VSS gf180mcu_fd_sc_mcu7t5v0__nand2_1
X_08220_ _10838_/Q _08590_/A2 _08582_/A2 _10870_/Q _06125_/I _10846_/Q _08221_/A3
+ VDD VDD VSS VSS gf180mcu_fd_sc_mcu7t5v0__aoi222_1
X_05432_ _10566_/Q _09027_/B2 VDD VDD VSS VSS gf180mcu_fd_sc_mcu7t5v0__clkinv_1
X_08151_ _09523_/A2 _08151_/A2 _08151_/B1 _09889_/A2 _08181_/A1 VDD VDD
+ VSS VSS gf180mcu_fd_sc_mcu7t5v0__aoi22_1
X_05363_ _11168_/Q _09931_/B2 VDD VDD VSS VSS gf180mcu_fd_sc_mcu7t5v0__clkinv_1
X_05294_ _10844_/Q _09375_/B2 VDD VDD VSS VSS gf180mcu_fd_sc_mcu7t5v0__clkinv_1
X_08082_ _08082_/A1 _08082_/A2 _08082_/A3 _08094_/A2 VDD VDD VSS VSS
+ gf180mcu_fd_sc_mcu7t5v0__nand3_2
X_07102_ _07208_/A1 _07097_/Z _07115_/C VDD VDD VSS VSS gf180mcu_fd_sc_mcu7t5v0__nand2_1
X_07033_ _10001_/Q _07221_/A2 _07078_/A1 VDD VDD VSS VSS gf180mcu_fd_sc_mcu7t5v0__nand2_1
X_08984_ _06047_/Z _08991_/A2 _08991_/B1 _08984_/B2 _10531_/D VDD VDD
+ VSS VSS gf180mcu_fd_sc_mcu7t5v0__oai22_1
X_07935_ _07935_/A1 _07935_/A2 _07935_/A3 _07936_/B1 VDD VDD VSS VSS
+ gf180mcu_fd_sc_mcu7t5v0__nand3_1
X_09605_ _09896_/A1 _09607_/A2 _09607_/B1 _09605_/B2 _11016_/D VDD VDD
+ VSS VSS gf180mcu_fd_sc_mcu7t5v0__oai22_1
X_07866_ bus_wdata[0] _10254_/Q _07874_/S _07866_/Z VDD VDD VSS VSS
+ gf180mcu_fd_sc_mcu7t5v0__mux2_1
X_07797_ _09926_/A1 _07797_/A2 _07797_/B1 _07797_/B2 _10222_/D VDD VDD
+ VSS VSS gf180mcu_fd_sc_mcu7t5v0__oai22_1
X_06817_ _06817_/A1 _06762_/Z _06816_/Z _06840_/A1 VDD VDD VSS VSS
+ gf180mcu_fd_sc_mcu7t5v0__nand3_1
X_06748_ _06749_/A1 _06848_/A1 _06792_/B VDD VDD VSS VSS gf180mcu_fd_sc_mcu7t5v0__nor2_1
X_09536_ _10969_/Q _09538_/A2 _09537_/B VDD VDD VSS VSS gf180mcu_fd_sc_mcu7t5v0__nand2_1
X_09467_ _06058_/Z _09471_/A2 _09471_/B1 _09467_/B2 _10918_/D VDD VDD
+ VSS VSS gf180mcu_fd_sc_mcu7t5v0__oai22_1
X_08418_ _09900_/A2 _08418_/A2 _08418_/B1 _09917_/A2 _08429_/A3 VDD VDD
+ VSS VSS gf180mcu_fd_sc_mcu7t5v0__aoi22_2
X_06679_ _10003_/Q _06854_/A2 _06683_/B2 VDD VDD VSS VSS gf180mcu_fd_sc_mcu7t5v0__nor2_1
X_09398_ _06061_/Z _09401_/A2 _09401_/B1 _09398_/B2 _10863_/D VDD VDD
+ VSS VSS gf180mcu_fd_sc_mcu7t5v0__oai22_1
X_08349_ _08349_/A1 _08349_/A2 _08349_/B _08349_/C _08350_/A2 VDD VDD
+ VSS VSS gf180mcu_fd_sc_mcu7t5v0__aoi211_1
X_10311_ _10311_/D _11018_/CLK _10311_/Q VDD VDD VSS VSS gf180mcu_fd_sc_mcu7t5v0__dffq_1
X_10242_ _10242_/D _10327_/CLK _10242_/Q VDD VDD VSS VSS gf180mcu_fd_sc_mcu7t5v0__dffq_1
X_10173_ _10173_/D _11097_/CLK _10173_/Q VDD VDD VSS VSS gf180mcu_fd_sc_mcu7t5v0__dffq_1
X_10509_ _10509_/D _11109_/CLK _10509_/Q VDD VDD VSS VSS gf180mcu_fd_sc_mcu7t5v0__dffq_1
Xrepeater6 _07255_/I _08576_/B1 VDD VDD VSS VSS gf180mcu_fd_sc_mcu7t5v0__buf_16
X_05981_ _05981_/A1 _10300_/Q _05982_/A2 VDD VDD VSS VSS gf180mcu_fd_sc_mcu7t5v0__nand2_1
X_07720_ _10171_/Q _07726_/A2 _07721_/B VDD VDD VSS VSS gf180mcu_fd_sc_mcu7t5v0__nand2_1
X_07651_ _06061_/Z _07657_/A2 _07651_/B _10131_/D VDD VDD VSS VSS
+ gf180mcu_fd_sc_mcu7t5v0__oai21_1
X_07582_ _07582_/A1 _07580_/Z _07582_/Z VDD VDD VSS VSS gf180mcu_fd_sc_mcu7t5v0__xor2_1
X_06602_ _06590_/Z _06604_/A3 _06602_/Z VDD VDD VSS VSS gf180mcu_fd_sc_mcu7t5v0__xor2_1
X_09321_ _09916_/A1 _09321_/A2 _09321_/B1 _09321_/B2 _10802_/D VDD VDD
+ VSS VSS gf180mcu_fd_sc_mcu7t5v0__oai22_1
X_06533_ _09754_/B _06541_/A2 _06541_/B1 VDD VDD VSS VSS gf180mcu_fd_sc_mcu7t5v0__nand2_2
X_09252_ _09927_/A2 _09861_/A2 _09261_/A2 VDD VDD VSS VSS gf180mcu_fd_sc_mcu7t5v0__nand2_4
X_06464_ _06470_/B _06501_/A2 _06465_/B VDD VDD VSS VSS gf180mcu_fd_sc_mcu7t5v0__xor2_1
X_05415_ _10307_/Q _08614_/B2 VDD VDD VSS VSS gf180mcu_fd_sc_mcu7t5v0__clkinv_1
X_08203_ _08534_/A1 _08203_/A2 _08203_/B1 _08534_/B2 _08204_/C VDD VDD
+ VSS VSS gf180mcu_fd_sc_mcu7t5v0__oai22_1
X_06395_ _06395_/A1 _06442_/B2 _06480_/A1 _06398_/A2 VDD VDD VSS VSS
+ gf180mcu_fd_sc_mcu7t5v0__xnor3_1
X_09183_ _08658_/B _09191_/A2 _09191_/B1 VDD VDD VSS VSS gf180mcu_fd_sc_mcu7t5v0__nand2_2
X_08134_ _11013_/Q _08573_/B1 _06125_/I _11045_/Q _08136_/A2 VDD VDD VSS
+ VSS gf180mcu_fd_sc_mcu7t5v0__aoi22_1
X_05346_ _10717_/Q _09216_/B2 VDD VDD VSS VSS gf180mcu_fd_sc_mcu7t5v0__clkinv_1
X_05277_ _10948_/Q _09505_/B2 VDD VDD VSS VSS gf180mcu_fd_sc_mcu7t5v0__clkinv_1
X_08065_ _10033_/Q _08528_/A2 _08586_/A2 _09964_/Q _08564_/C1 _10025_/Q _08066_/A3
+ VDD VDD VSS VSS gf180mcu_fd_sc_mcu7t5v0__aoi222_2
X_07016_ _07247_/I1 _07085_/A1 _07016_/Z VDD VDD VSS VSS gf180mcu_fd_sc_mcu7t5v0__and2_1
X_08967_ _06058_/Z _08971_/A2 _08971_/B1 _08967_/B2 _10518_/D VDD VDD
+ VSS VSS gf180mcu_fd_sc_mcu7t5v0__oai22_1
X_08898_ _09921_/A1 _08903_/A2 _08903_/B1 _08898_/B2 _10469_/D VDD VDD
+ VSS VSS gf180mcu_fd_sc_mcu7t5v0__oai22_1
X_07918_ _08652_/A1 _07920_/A2 _07918_/B _10278_/D VDD VDD VSS VSS
+ gf180mcu_fd_sc_mcu7t5v0__aoi21_1
X_07849_ _07860_/A1 _07853_/A2 _07849_/B _09900_/B _10246_/D VDD VDD VSS
+ VSS gf180mcu_fd_sc_mcu7t5v0__aoi211_1
X_10860_ _10860_/D _11142_/CLK _10860_/Q VDD VDD VSS VSS gf180mcu_fd_sc_mcu7t5v0__dffq_1
X_09519_ _09944_/A1 _09521_/A2 _09521_/B1 _09519_/B2 _10960_/D VDD VDD
+ VSS VSS gf180mcu_fd_sc_mcu7t5v0__oai22_1
X_10791_ _10791_/D _11164_/CLK _10791_/Q VDD VDD VSS VSS gf180mcu_fd_sc_mcu7t5v0__dffq_1
X_10225_ _10225_/D _11149_/CLK _10225_/Q VDD VDD VSS VSS gf180mcu_fd_sc_mcu7t5v0__dffq_1
X_10156_ _10156_/D _11181_/CLK _10156_/Q VDD VDD VSS VSS gf180mcu_fd_sc_mcu7t5v0__dffq_1
X_10087_ _10087_/D _10327_/CLK _10087_/Q VDD VDD VSS VSS gf180mcu_fd_sc_mcu7t5v0__dffq_1
X_10989_ _10989_/D _11018_/CLK _10989_/Q VDD VDD VSS VSS gf180mcu_fd_sc_mcu7t5v0__dffq_1
X_05200_ _11159_/Q _09920_/B2 VDD VDD VSS VSS gf180mcu_fd_sc_mcu7t5v0__clkinv_1
X_06180_ _07379_/A1 _08675_/A2 _06180_/B _10000_/D VDD VDD VSS VSS
+ gf180mcu_fd_sc_mcu7t5v0__aoi21_1
X_05131_ _10699_/Q _09194_/B2 VDD VDD VSS VSS gf180mcu_fd_sc_mcu7t5v0__clkinv_1
X_05062_ _10002_/Q _07434_/A1 VDD VDD VSS VSS gf180mcu_fd_sc_mcu7t5v0__inv_3
X_09870_ _09926_/A1 _09870_/A2 _09870_/B1 _09870_/B2 _11133_/D VDD VDD
+ VSS VSS gf180mcu_fd_sc_mcu7t5v0__oai22_1
X_08821_ _09918_/A1 _08829_/A2 _08829_/B1 VDD VDD VSS VSS gf180mcu_fd_sc_mcu7t5v0__nand2_2
X_08752_ _06047_/Z _08759_/A2 _08759_/B1 _08752_/B2 _10379_/D VDD VDD
+ VSS VSS gf180mcu_fd_sc_mcu7t5v0__oai22_1
X_05964_ _05964_/A1 _05964_/A2 _05979_/A1 VDD VDD VSS VSS gf180mcu_fd_sc_mcu7t5v0__nand2_1
X_07703_ _09940_/A1 _07709_/A2 _07709_/B1 _07703_/B2 _10160_/D VDD VDD
+ VSS VSS gf180mcu_fd_sc_mcu7t5v0__oai22_1
X_08683_ _10333_/Q _08698_/A2 _08684_/A2 VDD VDD VSS VSS gf180mcu_fd_sc_mcu7t5v0__nand2_1
X_05895_ _11125_/Q _09860_/B2 VDD VDD VSS VSS gf180mcu_fd_sc_mcu7t5v0__clkinv_1
X_07634_ _07634_/A1 _07634_/A2 _07635_/C VDD VDD VSS VSS gf180mcu_fd_sc_mcu7t5v0__nor2_1
X_07565_ _10001_/Q _07508_/Z _07614_/B2 VDD VDD VSS VSS gf180mcu_fd_sc_mcu7t5v0__nand2_1
X_09304_ _06047_/Z _09311_/A2 _09311_/B1 _09304_/B2 _10787_/D VDD VDD
+ VSS VSS gf180mcu_fd_sc_mcu7t5v0__oai22_1
X_07496_ _07496_/A1 _07496_/A2 _07498_/A2 VDD VDD VSS VSS gf180mcu_fd_sc_mcu7t5v0__nand2_1
X_06516_ _09941_/A1 _06521_/A2 _06521_/B1 _06516_/B2 _10018_/D VDD VDD
+ VSS VSS gf180mcu_fd_sc_mcu7t5v0__oai22_1
X_09235_ _09920_/A1 _09241_/A2 _09241_/B1 _09235_/B2 _10732_/D VDD VDD
+ VSS VSS gf180mcu_fd_sc_mcu7t5v0__oai22_1
X_06447_ _06447_/A1 _06480_/B2 _06446_/B _06447_/Z VDD VDD VSS VSS
+ gf180mcu_fd_sc_mcu7t5v0__xor3_1
X_06378_ _10013_/Q _07601_/B _06426_/A1 VDD VDD VSS VSS gf180mcu_fd_sc_mcu7t5v0__nand2_1
X_09166_ _09941_/A1 _09171_/A2 _09171_/B1 _09166_/B2 _10677_/D VDD VDD
+ VSS VSS gf180mcu_fd_sc_mcu7t5v0__oai22_1
X_08117_ _08117_/A1 _08117_/A2 _08117_/A3 _08122_/A2 VDD VDD VSS VSS
+ gf180mcu_fd_sc_mcu7t5v0__nand3_2
X_09097_ _06058_/Z _09101_/A2 _09101_/B1 _09097_/B2 _10622_/D VDD VDD
+ VSS VSS gf180mcu_fd_sc_mcu7t5v0__oai22_1
X_05329_ _10589_/Q _09056_/B2 VDD VDD VSS VSS gf180mcu_fd_sc_mcu7t5v0__clkinv_1
X_08048_ _09305_/B2 _08542_/A2 _08581_/A2 _09275_/B2 _08048_/C _08049_/C VDD
+ VDD VSS VSS gf180mcu_fd_sc_mcu7t5v0__oai221_2
X_10010_ _10010_/D _10327_/CLK _10010_/Q VDD VDD VSS VSS gf180mcu_fd_sc_mcu7t5v0__dffq_1
X_09999_ _09999_/D _10327_/CLK _09999_/Q VDD VDD VSS VSS gf180mcu_fd_sc_mcu7t5v0__dffq_4
X_10912_ _10912_/D _10978_/CLK _10912_/Q VDD VDD VSS VSS gf180mcu_fd_sc_mcu7t5v0__dffq_1
X_10843_ _10843_/D _11138_/CLK _10843_/Q VDD VDD VSS VSS gf180mcu_fd_sc_mcu7t5v0__dffq_1
X_10774_ _10774_/D _11164_/CLK _10774_/Q VDD VDD VSS VSS gf180mcu_fd_sc_mcu7t5v0__dffq_1
X_10208_ _10208_/D _11052_/CLK _10208_/Q VDD VDD VSS VSS gf180mcu_fd_sc_mcu7t5v0__dffq_1
X_10139_ _10139_/D _11176_/CLK _10139_/Q VDD VDD VSS VSS gf180mcu_fd_sc_mcu7t5v0__dffq_1
X_05680_ _09968_/Q _06107_/B2 VDD VDD VSS VSS gf180mcu_fd_sc_mcu7t5v0__clkinv_1
X_07350_ _07381_/A1 _07632_/I0 _07635_/A1 _07350_/B _07354_/B1 VDD VDD
+ VSS VSS gf180mcu_fd_sc_mcu7t5v0__oai31_1
X_06301_ _10001_/Q _06479_/A2 _06307_/A2 VDD VDD VSS VSS gf180mcu_fd_sc_mcu7t5v0__nand2_1
X_09020_ _09945_/A1 _09021_/A2 _09021_/B1 _09020_/B2 _10561_/D VDD VDD
+ VSS VSS gf180mcu_fd_sc_mcu7t5v0__oai22_1
X_07281_ _09940_/A1 _07293_/A2 _07281_/B _10099_/D VDD VDD VSS VSS
+ gf180mcu_fd_sc_mcu7t5v0__oai21_1
X_06232_ _10000_/Q _06444_/A2 _06276_/A1 VDD VDD VSS VSS gf180mcu_fd_sc_mcu7t5v0__nor2_1
X_06163_ _09924_/A1 _06167_/A2 _06163_/B _09992_/D VDD VDD VSS VSS
+ gf180mcu_fd_sc_mcu7t5v0__oai21_1
X_05114_ _10563_/Q _09024_/B2 VDD VDD VSS VSS gf180mcu_fd_sc_mcu7t5v0__clkinv_1
X_06094_ _06038_/I _06146_/A2 _08345_/A1 VDD VDD VSS VSS gf180mcu_fd_sc_mcu7t5v0__nor2_2
X_09922_ _06058_/Z _09926_/A2 _09926_/B1 _09922_/B2 _11161_/D VDD VDD
+ VSS VSS gf180mcu_fd_sc_mcu7t5v0__oai22_1
X_05045_ _10045_/Q _07326_/A3 VDD VDD VSS VSS gf180mcu_fd_sc_mcu7t5v0__clkinv_2
X_09853_ _06047_/Z _09860_/A2 _09860_/B1 _09853_/B2 _11118_/D VDD VDD
+ VSS VSS gf180mcu_fd_sc_mcu7t5v0__oai22_1
X_08804_ _09893_/A1 _08809_/A2 _08809_/B1 _08804_/B2 _10421_/D VDD VDD
+ VSS VSS gf180mcu_fd_sc_mcu7t5v0__oai22_1
X_09784_ _11093_/Q _09795_/A2 _09809_/B _09785_/B VDD VDD VSS VSS
+ gf180mcu_fd_sc_mcu7t5v0__oai21_1
X_08735_ _06058_/Z _08739_/A2 _08739_/B1 _08735_/B2 _10366_/D VDD VDD
+ VSS VSS gf180mcu_fd_sc_mcu7t5v0__oai22_1
X_06996_ _10002_/Q _07181_/A2 _07040_/A1 VDD VDD VSS VSS gf180mcu_fd_sc_mcu7t5v0__nand2_1
X_05947_ _09900_/B _09722_/A1 _05956_/A3 _05947_/B _10291_/D VDD VDD VSS
+ VSS gf180mcu_fd_sc_mcu7t5v0__oai31_1
X_05878_ _10738_/Q _09241_/B2 VDD VDD VSS VSS gf180mcu_fd_sc_mcu7t5v0__clkinv_1
X_08666_ _10283_/Q _08675_/A2 _08672_/B _08667_/B VDD VDD VSS VSS
+ gf180mcu_fd_sc_mcu7t5v0__oai21_1
X_08597_ _08597_/A1 _08597_/A2 _08597_/A3 _08597_/A4 _08597_/Z VDD VDD
+ VSS VSS gf180mcu_fd_sc_mcu7t5v0__and4_1
X_07617_ _07617_/A1 _07617_/A2 _07617_/B1 _07617_/B2 _07618_/A2 VDD VDD
+ VSS VSS gf180mcu_fd_sc_mcu7t5v0__oai22_1
X_07548_ _07635_/A1 _07533_/Z _07548_/B _07548_/C _07549_/A2 VDD VDD VSS
+ VSS gf180mcu_fd_sc_mcu7t5v0__aoi211_1
X_07479_ _07439_/Z _07478_/I _07533_/A1 VDD VDD VSS VSS gf180mcu_fd_sc_mcu7t5v0__nand2_1
X_10490_ _10490_/D _11165_/CLK _10490_/Q VDD VDD VSS VSS gf180mcu_fd_sc_mcu7t5v0__dffq_1
X_09218_ _06061_/Z _09221_/A2 _09221_/B1 _09218_/B2 _10719_/D VDD VDD
+ VSS VSS gf180mcu_fd_sc_mcu7t5v0__oai22_1
X_09149_ _09944_/A1 _09151_/A2 _09151_/B1 _09149_/B2 _10664_/D VDD VDD
+ VSS VSS gf180mcu_fd_sc_mcu7t5v0__oai22_1
X_11111_ _11111_/D _11150_/CLK _11111_/Q VDD VDD VSS VSS gf180mcu_fd_sc_mcu7t5v0__dffq_1
X_11042_ _11042_/D _11163_/CLK _11042_/Q VDD VDD VSS VSS gf180mcu_fd_sc_mcu7t5v0__dffq_1
X_10826_ _10826_/D _11142_/CLK _10826_/Q VDD VDD VSS VSS gf180mcu_fd_sc_mcu7t5v0__dffq_1
X_10757_ _10757_/D _11010_/CLK _10757_/Q VDD VDD VSS VSS gf180mcu_fd_sc_mcu7t5v0__dffq_1
X_10688_ _10688_/D _11138_/CLK _10688_/Q VDD VDD VSS VSS gf180mcu_fd_sc_mcu7t5v0__dffq_1
X_06850_ _10005_/Q _06850_/A2 _06852_/A2 VDD VDD VSS VSS gf180mcu_fd_sc_mcu7t5v0__nand2_1
X_05801_ _10298_/Q _08607_/B2 VDD VDD VSS VSS gf180mcu_fd_sc_mcu7t5v0__clkinv_1
X_06781_ _06832_/A1 _06781_/A2 _06781_/B _06782_/B VDD VDD VSS VSS
+ gf180mcu_fd_sc_mcu7t5v0__oai21_1
X_05732_ _10401_/Q _08778_/B2 VDD VDD VSS VSS gf180mcu_fd_sc_mcu7t5v0__clkinv_1
X_08520_ _10906_/Q _08584_/A2 _08563_/C1 _10299_/Q _08564_/C1 _10142_/Q _08522_/A1
+ VDD VDD VSS VSS gf180mcu_fd_sc_mcu7t5v0__aoi222_2
X_08451_ _10425_/Q _08591_/A2 _08589_/B1 _10737_/Q _08452_/A3 VDD VDD
+ VSS VSS gf180mcu_fd_sc_mcu7t5v0__aoi22_1
X_05663_ _10712_/Q _09209_/B2 VDD VDD VSS VSS gf180mcu_fd_sc_mcu7t5v0__clkinv_1
X_07402_ _07395_/I _07403_/A2 _07437_/A2 VDD VDD VSS VSS gf180mcu_fd_sc_mcu7t5v0__nor2_1
X_05594_ _10959_/Q _09518_/B2 VDD VDD VSS VSS gf180mcu_fd_sc_mcu7t5v0__clkinv_1
X_08382_ _08382_/A1 _08382_/A2 _08382_/A3 _08387_/A2 VDD VDD VSS VSS
+ gf180mcu_fd_sc_mcu7t5v0__nand3_1
X_07333_ _10117_/Q _07333_/A2 _07333_/B _07333_/C _07519_/A2 VDD VDD VSS
+ VSS gf180mcu_fd_sc_mcu7t5v0__oai211_4
X_07264_ _10092_/Q _07274_/A2 _07265_/B VDD VDD VSS VSS gf180mcu_fd_sc_mcu7t5v0__nand2_1
X_09003_ _09890_/A1 _09011_/A2 _09011_/B1 VDD VDD VSS VSS gf180mcu_fd_sc_mcu7t5v0__nand2_2
X_06215_ _06223_/A3 _06215_/A2 _06460_/A1 VDD VDD VSS VSS gf180mcu_fd_sc_mcu7t5v0__nor2_2
X_07195_ _10088_/Q _07194_/Z _07213_/B VDD VDD VSS VSS gf180mcu_fd_sc_mcu7t5v0__nand2_1
X_06146_ _06038_/I _06146_/A2 _08534_/B2 VDD VDD VSS VSS gf180mcu_fd_sc_mcu7t5v0__nand2_4
X_06077_ _07921_/A1 _06034_/I _08535_/B VDD VDD VSS VSS gf180mcu_fd_sc_mcu7t5v0__nor2_1
X_09905_ _11152_/Q _09915_/A2 _09906_/B VDD VDD VSS VSS gf180mcu_fd_sc_mcu7t5v0__nand2_1
X_05028_ _10118_/Q _07557_/A1 VDD VDD VSS VSS gf180mcu_fd_sc_mcu7t5v0__clkinv_2
X_09836_ _06047_/Z _09850_/A2 _09836_/B _11110_/D VDD VDD VSS VSS
+ gf180mcu_fd_sc_mcu7t5v0__oai21_1
X_09767_ _11078_/Q _09763_/Z _09776_/B _09768_/A2 VDD VDD VSS VSS
+ gf180mcu_fd_sc_mcu7t5v0__oai21_1
X_06979_ _07004_/A1 _06979_/A2 _06979_/Z VDD VDD VSS VSS gf180mcu_fd_sc_mcu7t5v0__or2_1
X_08718_ _09897_/A1 _08719_/A2 _08719_/B1 _08718_/B2 _10353_/D VDD VDD
+ VSS VSS gf180mcu_fd_sc_mcu7t5v0__oai22_1
X_09698_ _09698_/A1 _10289_/Q _09699_/B VDD VDD VSS VSS gf180mcu_fd_sc_mcu7t5v0__nor2_1
X_08649_ _10270_/Q _08657_/A2 _08657_/B1 _10263_/Q _08649_/C _08651_/A2 VDD
+ VDD VSS VSS gf180mcu_fd_sc_mcu7t5v0__aoi221_1
X_10611_ _10611_/D _10666_/CLK _10611_/Q VDD VDD VSS VSS gf180mcu_fd_sc_mcu7t5v0__dffq_1
X_10542_ _10542_/D _10978_/CLK _10542_/Q VDD VDD VSS VSS gf180mcu_fd_sc_mcu7t5v0__dffq_1
X_10473_ _10473_/D _11165_/CLK _10473_/Q VDD VDD VSS VSS gf180mcu_fd_sc_mcu7t5v0__dffq_1
X_11025_ _11025_/D _11164_/CLK _11025_/Q VDD VDD VSS VSS gf180mcu_fd_sc_mcu7t5v0__dffq_1
X_10809_ _10809_/D _11010_/CLK _10809_/Q VDD VDD VSS VSS gf180mcu_fd_sc_mcu7t5v0__dffq_1
X_06000_ _10283_/Q _07829_/C _06002_/B VDD VDD VSS VSS gf180mcu_fd_sc_mcu7t5v0__nand2_1
X_07951_ _11150_/Q _08444_/B1 _08589_/B1 _10069_/Q _07951_/C _07954_/A1 VDD
+ VDD VSS VSS gf180mcu_fd_sc_mcu7t5v0__aoi221_2
X_06902_ _10069_/Q _06916_/A2 _06903_/B VDD VDD VSS VSS gf180mcu_fd_sc_mcu7t5v0__nand2_1
X_07882_ _07882_/A1 _07890_/A2 _07882_/B _10261_/D VDD VDD VSS VSS
+ gf180mcu_fd_sc_mcu7t5v0__aoi21_1
X_09621_ _09924_/A1 _09625_/A2 _09621_/B _11024_/D VDD VDD VSS VSS
+ gf180mcu_fd_sc_mcu7t5v0__oai21_1
X_06833_ _10006_/Q _06867_/A2 _06833_/B _06834_/B VDD VDD VSS VSS
+ gf180mcu_fd_sc_mcu7t5v0__oai21_1
X_09552_ _10979_/Q _09566_/A2 _09553_/B VDD VDD VSS VSS gf180mcu_fd_sc_mcu7t5v0__nand2_1
X_06764_ _06787_/A1 _06713_/Z _06761_/Z _06766_/A2 VDD VDD VSS VSS
+ gf180mcu_fd_sc_mcu7t5v0__xnor3_1
X_05715_ _10824_/Q _09349_/B2 VDD VDD VSS VSS gf180mcu_fd_sc_mcu7t5v0__clkinv_1
X_08503_ _09523_/A2 _08503_/A2 _08503_/B1 _09142_/A2 _08513_/A3 VDD VDD
+ VSS VSS gf180mcu_fd_sc_mcu7t5v0__aoi22_1
X_09483_ _09890_/A1 _09491_/A2 _09491_/B1 VDD VDD VSS VSS gf180mcu_fd_sc_mcu7t5v0__nand2_4
X_06695_ _10001_/Q _06823_/A1 _06749_/A1 VDD VDD VSS VSS gf180mcu_fd_sc_mcu7t5v0__nand2_1
X_08434_ _10181_/Q _08589_/A2 _08576_/B1 _10929_/Q _08591_/B1 _10993_/Q _08435_/A3
+ VDD VDD VSS VSS gf180mcu_fd_sc_mcu7t5v0__aoi222_2
X_05646_ _10584_/Q _09049_/B2 VDD VDD VSS VSS gf180mcu_fd_sc_mcu7t5v0__clkinv_1
X_05577_ _11122_/Q _09857_/B2 VDD VDD VSS VSS gf180mcu_fd_sc_mcu7t5v0__clkinv_1
X_08365_ _10212_/Q _08528_/A2 _08586_/A2 _10103_/Q _08532_/A2 _10095_/Q _08367_/A2
+ VDD VDD VSS VSS gf180mcu_fd_sc_mcu7t5v0__aoi222_2
X_07316_ _10241_/Q _08675_/A2 _08674_/B _07317_/B VDD VDD VSS VSS
+ gf180mcu_fd_sc_mcu7t5v0__oai21_1
X_08296_ _08296_/I _08346_/B1 VDD VDD VSS VSS gf180mcu_fd_sc_mcu7t5v0__inv_1
X_07247_ _07247_/I0 _07247_/I1 _07247_/S _07247_/Z VDD VDD VSS VSS
+ gf180mcu_fd_sc_mcu7t5v0__mux2_1
X_07178_ _07178_/I _07232_/A1 VDD VDD VSS VSS gf180mcu_fd_sc_mcu7t5v0__clkinv_1
X_06129_ _09979_/Q _06143_/A2 _06130_/B VDD VDD VSS VSS gf180mcu_fd_sc_mcu7t5v0__nand2_1
X_09819_ _11100_/Q _09816_/I _09819_/Z VDD VDD VSS VSS gf180mcu_fd_sc_mcu7t5v0__xor2_1
X_10525_ _10525_/D _11109_/CLK _10525_/Q VDD VDD VSS VSS gf180mcu_fd_sc_mcu7t5v0__dffq_1
X_10456_ _10456_/D _11101_/CLK _10456_/Q VDD VDD VSS VSS gf180mcu_fd_sc_mcu7t5v0__dffq_1
X_10387_ _10387_/D _11018_/CLK _10387_/Q VDD VDD VSS VSS gf180mcu_fd_sc_mcu7t5v0__dffq_1
X_11008_ _11008_/D _11039_/CLK _11008_/Q VDD VDD VSS VSS gf180mcu_fd_sc_mcu7t5v0__dffq_1
X_05500_ _10798_/Q _09317_/B2 VDD VDD VSS VSS gf180mcu_fd_sc_mcu7t5v0__clkinv_1
X_06480_ _06480_/A1 _06482_/A1 _06480_/B1 _06480_/B2 _06492_/A2 VDD VDD
+ VSS VSS gf180mcu_fd_sc_mcu7t5v0__oai22_1
X_05431_ _10558_/Q _09017_/B2 VDD VDD VSS VSS gf180mcu_fd_sc_mcu7t5v0__clkinv_1
X_08150_ _08150_/A1 _08150_/A2 _08150_/A3 _08151_/B1 VDD VDD VSS VSS
+ gf180mcu_fd_sc_mcu7t5v0__nand3_1
X_07101_ _07019_/C _07100_/Z _07116_/B VDD VDD VSS VSS gf180mcu_fd_sc_mcu7t5v0__nor2_1
X_05362_ _09965_/Q _06104_/B2 VDD VDD VSS VSS gf180mcu_fd_sc_mcu7t5v0__clkinv_1
X_05293_ _10836_/Q _09365_/B2 VDD VDD VSS VSS gf180mcu_fd_sc_mcu7t5v0__clkinv_1
X_08081_ _11036_/Q _06112_/I _08877_/A2 _11020_/Q _09872_/A1 _09980_/Q _08082_/A3
+ VDD VDD VSS VSS gf180mcu_fd_sc_mcu7t5v0__aoi222_4
X_07032_ _06998_/Z _07001_/Z _07043_/A2 VDD VDD VSS VSS gf180mcu_fd_sc_mcu7t5v0__nand2_1
X_08983_ _09824_/A1 _08991_/A2 _08991_/B1 VDD VDD VSS VSS gf180mcu_fd_sc_mcu7t5v0__nand2_2
X_07934_ _10739_/Q _08590_/A2 _08590_/B1 _11011_/Q _08589_/B1 _10731_/Q _07935_/A3
+ VDD VDD VSS VSS gf180mcu_fd_sc_mcu7t5v0__aoi222_2
X_07865_ _07865_/A1 _07865_/A2 bus_addr[2] _07831_/I _07874_/S VDD VDD
+ VSS VSS gf180mcu_fd_sc_mcu7t5v0__or4_2
X_09604_ _06061_/Z _09607_/A2 _09607_/B1 _09604_/B2 _11015_/D VDD VDD
+ VSS VSS gf180mcu_fd_sc_mcu7t5v0__oai22_1
X_07796_ _09897_/A1 _07797_/A2 _07797_/B1 _07796_/B2 _10221_/D VDD VDD
+ VSS VSS gf180mcu_fd_sc_mcu7t5v0__oai22_1
X_06816_ _06816_/A1 _06814_/Z _06816_/Z VDD VDD VSS VSS gf180mcu_fd_sc_mcu7t5v0__xor2_1
X_09535_ _09944_/A1 _09539_/A2 _09535_/B _10968_/D VDD VDD VSS VSS
+ gf180mcu_fd_sc_mcu7t5v0__oai21_1
X_06747_ _10002_/Q _06823_/A1 _06799_/A2 VDD VDD VSS VSS gf180mcu_fd_sc_mcu7t5v0__nand2_1
X_09466_ _09893_/A1 _09471_/A2 _09471_/B1 _09466_/B2 _10917_/D VDD VDD
+ VSS VSS gf180mcu_fd_sc_mcu7t5v0__oai22_1
X_06678_ _06678_/A1 _06678_/A2 _06677_/B _06678_/Z VDD VDD VSS VSS
+ gf180mcu_fd_sc_mcu7t5v0__and3_1
X_05629_ _10384_/Q _08757_/B2 VDD VDD VSS VSS gf180mcu_fd_sc_mcu7t5v0__clkinv_1
X_08417_ _08417_/A1 _08417_/A2 _08417_/A3 _08418_/B1 VDD VDD VSS VSS
+ gf180mcu_fd_sc_mcu7t5v0__nand3_1
X_09397_ _06058_/Z _09401_/A2 _09401_/B1 _09397_/B2 _10862_/D VDD VDD
+ VSS VSS gf180mcu_fd_sc_mcu7t5v0__oai22_1
X_08348_ _08534_/B2 _08348_/A2 _08348_/B1 _08533_/B2 _08348_/C _08349_/A2 VDD
+ VDD VSS VSS gf180mcu_fd_sc_mcu7t5v0__oai221_1
X_08279_ _10791_/Q _06112_/I _08589_/B1 _10767_/Q _08279_/C _08348_/A2 VDD VDD
+ VSS VSS gf180mcu_fd_sc_mcu7t5v0__aoi221_4
X_10310_ _10310_/D _11018_/CLK _10310_/Q VDD VDD VSS VSS gf180mcu_fd_sc_mcu7t5v0__dffq_1
X_10241_ _10241_/D _10327_/CLK _10241_/Q VDD VDD VSS VSS gf180mcu_fd_sc_mcu7t5v0__dffq_1
X_10172_ _10172_/D _11101_/CLK _10172_/Q VDD VDD VSS VSS gf180mcu_fd_sc_mcu7t5v0__dffq_1
X_10508_ _10508_/D _11109_/CLK _10508_/Q VDD VDD VSS VSS gf180mcu_fd_sc_mcu7t5v0__dffq_1
X_10439_ _10439_/D _11017_/CLK _10439_/Q VDD VDD VSS VSS gf180mcu_fd_sc_mcu7t5v0__dffq_1
Xrepeater7 _09834_/A2 _07255_/I VDD VDD VSS VSS gf180mcu_fd_sc_mcu7t5v0__buf_16
X_05980_ _09732_/A1 _05983_/B1 _05980_/Z VDD VDD VSS VSS gf180mcu_fd_sc_mcu7t5v0__or2_1
X_07650_ _10131_/Q _07656_/A2 _07651_/B VDD VDD VSS VSS gf180mcu_fd_sc_mcu7t5v0__nand2_1
X_07581_ _07582_/A1 _07580_/Z _07622_/A2 VDD VDD VSS VSS gf180mcu_fd_sc_mcu7t5v0__nor2_1
X_06601_ _06700_/A2 _06700_/A3 _06823_/B _06604_/A3 VDD VDD VSS VSS
+ gf180mcu_fd_sc_mcu7t5v0__nand3_1
X_09320_ _09925_/A1 _09321_/A2 _09321_/B1 _09320_/B2 _10801_/D VDD VDD
+ VSS VSS gf180mcu_fd_sc_mcu7t5v0__oai22_1
X_06532_ _09502_/A1 _09937_/A1 _06541_/A2 VDD VDD VSS VSS gf180mcu_fd_sc_mcu7t5v0__nand2_4
X_09251_ _09832_/A1 _09251_/A2 _09251_/B1 _09251_/B2 _10746_/D VDD VDD
+ VSS VSS gf180mcu_fd_sc_mcu7t5v0__oai22_1
X_08202_ _10226_/Q _07680_/I _08202_/B _08203_/B1 VDD VDD VSS VSS
+ gf180mcu_fd_sc_mcu7t5v0__aoi21_2
X_06463_ _06502_/A1 _06502_/A2 _06501_/A2 VDD VDD VSS VSS gf180mcu_fd_sc_mcu7t5v0__xnor2_1
X_05414_ _10398_/Q _08775_/B2 VDD VDD VSS VSS gf180mcu_fd_sc_mcu7t5v0__clkinv_1
X_06394_ _06395_/A1 _06480_/A1 _06394_/Z VDD VDD VSS VSS gf180mcu_fd_sc_mcu7t5v0__and2_1
X_09182_ _09871_/A1 _08588_/B _09191_/A2 VDD VDD VSS VSS gf180mcu_fd_sc_mcu7t5v0__nand2_4
X_08133_ _10741_/Q _08547_/A2 _08591_/A2 _10421_/Q _08133_/C _08136_/A1 VDD
+ VDD VSS VSS gf180mcu_fd_sc_mcu7t5v0__aoi221_1
X_05345_ _10709_/Q _09206_/B2 VDD VDD VSS VSS gf180mcu_fd_sc_mcu7t5v0__clkinv_1
X_08064_ _10062_/Q _08530_/A2 _08528_/B1 _09972_/Q _06877_/Z _10054_/Q _08066_/A2
+ VDD VDD VSS VSS gf180mcu_fd_sc_mcu7t5v0__aoi222_4
X_05276_ _10956_/Q _09515_/B2 VDD VDD VSS VSS gf180mcu_fd_sc_mcu7t5v0__clkinv_1
X_07015_ _10002_/Q _07221_/A2 _07085_/A1 VDD VDD VSS VSS gf180mcu_fd_sc_mcu7t5v0__nand2_1
X_08966_ _09921_/A1 _08971_/A2 _08971_/B1 _08966_/B2 _10517_/D VDD VDD
+ VSS VSS gf180mcu_fd_sc_mcu7t5v0__oai22_1
X_08897_ _09920_/A1 _08903_/A2 _08903_/B1 _08897_/B2 _10468_/D VDD VDD
+ VSS VSS gf180mcu_fd_sc_mcu7t5v0__oai22_1
X_07917_ bus_wdata[5] _07920_/A2 rst_n _07918_/B VDD VDD VSS VSS gf180mcu_fd_sc_mcu7t5v0__oai21_1
X_07848_ _10246_/Q _07853_/A2 _07849_/B VDD VDD VSS VSS gf180mcu_fd_sc_mcu7t5v0__nor2_1
X_09518_ _06061_/Z _09521_/A2 _09521_/B1 _09518_/B2 _10959_/D VDD VDD
+ VSS VSS gf180mcu_fd_sc_mcu7t5v0__oai22_1
X_07779_ _06058_/Z _07787_/A2 _07779_/B _10210_/D VDD VDD VSS VSS
+ gf180mcu_fd_sc_mcu7t5v0__oai21_1
X_10790_ _10790_/D _11164_/CLK _10790_/Q VDD VDD VSS VSS gf180mcu_fd_sc_mcu7t5v0__dffq_1
X_09449_ _09944_/A1 _09451_/A2 _09451_/B1 _09449_/B2 _10904_/D VDD VDD
+ VSS VSS gf180mcu_fd_sc_mcu7t5v0__oai22_1
X_10224_ _10224_/D _11147_/CLK _10224_/Q VDD VDD VSS VSS gf180mcu_fd_sc_mcu7t5v0__dffq_1
X_10155_ _10155_/D _11181_/CLK _10155_/Q VDD VDD VSS VSS gf180mcu_fd_sc_mcu7t5v0__dffq_1
X_10086_ _10086_/D _11039_/CLK _10086_/Q VDD VDD VSS VSS gf180mcu_fd_sc_mcu7t5v0__dffq_2
X_10988_ _10988_/D _11017_/CLK _10988_/Q VDD VDD VSS VSS gf180mcu_fd_sc_mcu7t5v0__dffq_1
Xclkbuf_leaf_10_clk clkbuf_1_1_0_clk/Z _11017_/CLK VDD VDD VSS VSS
+ gf180mcu_fd_sc_mcu7t5v0__clkbuf_16
X_05130_ _10691_/Q _09184_/B2 VDD VDD VSS VSS gf180mcu_fd_sc_mcu7t5v0__clkinv_1
X_05061_ _10003_/Q _07470_/B2 VDD VDD VSS VSS gf180mcu_fd_sc_mcu7t5v0__clkinv_4
X_08820_ _09645_/A2 _09917_/A2 _08829_/A2 VDD VDD VSS VSS gf180mcu_fd_sc_mcu7t5v0__nand2_4
X_08751_ _09918_/A1 _08759_/A2 _08759_/B1 VDD VDD VSS VSS gf180mcu_fd_sc_mcu7t5v0__nand2_2
X_05963_ _11076_/Q _11075_/Q _11078_/Q _11077_/Q _05964_/A2 VDD VDD VSS
+ VSS gf180mcu_fd_sc_mcu7t5v0__nor4_1
X_05894_ _11149_/Q _09898_/B2 VDD VDD VSS VSS gf180mcu_fd_sc_mcu7t5v0__clkinv_1
X_08682_ _10282_/Q _08621_/I _08684_/A1 VDD VDD VSS VSS gf180mcu_fd_sc_mcu7t5v0__nand2_1
X_07702_ _06047_/Z _07709_/A2 _07709_/B1 _07702_/B2 _10159_/D VDD VDD
+ VSS VSS gf180mcu_fd_sc_mcu7t5v0__oai22_1
X_07633_ _10007_/Q _07633_/A2 _07633_/B _07633_/C _07634_/A2 VDD VDD VSS
+ VSS gf180mcu_fd_sc_mcu7t5v0__aoi211_1
X_07564_ _07564_/A1 _07564_/A2 _07525_/Z _07527_/Z _07564_/B2 _07579_/A1 VDD
+ VDD VSS VSS gf180mcu_fd_sc_mcu7t5v0__oai32_1
X_09303_ _09433_/A1 _09311_/A2 _09311_/B1 VDD VDD VSS VSS gf180mcu_fd_sc_mcu7t5v0__nand2_4
X_06515_ _09940_/A1 _06521_/A2 _06521_/B1 _06515_/B2 _10017_/D VDD VDD
+ VSS VSS gf180mcu_fd_sc_mcu7t5v0__oai22_1
X_07495_ _07632_/I0 _07463_/Z _07496_/A2 VDD VDD VSS VSS gf180mcu_fd_sc_mcu7t5v0__nand2_1
X_09234_ _06047_/Z _09241_/A2 _09241_/B1 _09234_/B2 _10731_/D VDD VDD
+ VSS VSS gf180mcu_fd_sc_mcu7t5v0__oai22_1
X_06446_ _10005_/Q _06446_/A2 _06446_/B _06480_/B1 VDD VDD VSS VSS
+ gf180mcu_fd_sc_mcu7t5v0__aoi21_1
X_09165_ _09940_/A1 _09171_/A2 _09171_/B1 _09165_/B2 _10676_/D VDD VDD
+ VSS VSS gf180mcu_fd_sc_mcu7t5v0__oai22_1
X_08116_ _10177_/Q _08589_/A2 _08591_/B1 _10989_/Q _08117_/A3 VDD VDD
+ VSS VSS gf180mcu_fd_sc_mcu7t5v0__aoi22_1
X_06377_ _06377_/A1 _07601_/B _06377_/B _10012_/D VDD VDD VSS VSS
+ gf180mcu_fd_sc_mcu7t5v0__aoi21_1
X_09096_ _09893_/A1 _09101_/A2 _09101_/B1 _09096_/B2 _10621_/D VDD VDD
+ VSS VSS gf180mcu_fd_sc_mcu7t5v0__oai22_1
X_05328_ _10581_/Q _09046_/B2 VDD VDD VSS VSS gf180mcu_fd_sc_mcu7t5v0__clkinv_1
X_05259_ _11119_/Q _09854_/B2 VDD VDD VSS VSS gf180mcu_fd_sc_mcu7t5v0__clkinv_1
X_08047_ _10756_/Q _08559_/A2 _09872_/A1 _10780_/Q _08877_/A2 _10796_/Q _08048_/C
+ VDD VDD VSS VSS gf180mcu_fd_sc_mcu7t5v0__aoi222_2
X_09998_ _09998_/D _10327_/CLK _09998_/Q VDD VDD VSS VSS gf180mcu_fd_sc_mcu7t5v0__dffq_4
X_08949_ _09924_/A1 _08951_/A2 _08951_/B1 _08949_/B2 _10504_/D VDD VDD
+ VSS VSS gf180mcu_fd_sc_mcu7t5v0__oai22_1
X_10911_ _10911_/D _10978_/CLK _10911_/Q VDD VDD VSS VSS gf180mcu_fd_sc_mcu7t5v0__dffq_1
X_10842_ _10842_/D _11142_/CLK _10842_/Q VDD VDD VSS VSS gf180mcu_fd_sc_mcu7t5v0__dffq_1
X_10773_ _10773_/D _11164_/CLK _10773_/Q VDD VDD VSS VSS gf180mcu_fd_sc_mcu7t5v0__dffq_1
X_11187_ cgra_status[7] VDD VDD VSS VSS gf180mcu_fd_sc_mcu7t5v0__tiel
X_10207_ _10207_/D _11097_/CLK _10207_/Q VDD VDD VSS VSS gf180mcu_fd_sc_mcu7t5v0__dffq_1
X_10138_ _10138_/D _11176_/CLK _10138_/Q VDD VDD VSS VSS gf180mcu_fd_sc_mcu7t5v0__dffq_1
X_10069_ _10069_/D _11150_/CLK _10069_/Q VDD VDD VSS VSS gf180mcu_fd_sc_mcu7t5v0__dffq_1
X_06300_ _06300_/A1 _06307_/A1 _06268_/Z _06300_/B2 _06310_/A2 VDD VDD
+ VSS VSS gf180mcu_fd_sc_mcu7t5v0__oai22_2
X_07280_ _10099_/Q _07292_/A2 _07281_/B VDD VDD VSS VSS gf180mcu_fd_sc_mcu7t5v0__nand2_1
X_06231_ _06553_/A3 _07601_/B _06231_/B1 _06231_/B2 _07603_/B _10008_/D VDD
+ VDD VSS VSS gf180mcu_fd_sc_mcu7t5v0__aoi221_1
X_06162_ _09992_/Q _06166_/A2 _06163_/B VDD VDD VSS VSS gf180mcu_fd_sc_mcu7t5v0__nand2_1
X_05113_ _10555_/Q _09014_/B2 VDD VDD VSS VSS gf180mcu_fd_sc_mcu7t5v0__clkinv_1
X_06093_ _09946_/A1 _06093_/A2 _06093_/B1 _06093_/B2 _09962_/D VDD VDD
+ VSS VSS gf180mcu_fd_sc_mcu7t5v0__oai22_1
X_09921_ _09921_/A1 _09926_/A2 _09926_/B1 _09921_/B2 _11160_/D VDD VDD
+ VSS VSS gf180mcu_fd_sc_mcu7t5v0__oai22_1
X_05044_ _10046_/Q _07362_/A3 VDD VDD VSS VSS gf180mcu_fd_sc_mcu7t5v0__clkinv_2
X_09852_ _09852_/A1 _09860_/A2 _09860_/B1 VDD VDD VSS VSS gf180mcu_fd_sc_mcu7t5v0__nand2_2
X_08803_ _09920_/A1 _08809_/A2 _08809_/B1 _08803_/B2 _10420_/D VDD VDD
+ VSS VSS gf180mcu_fd_sc_mcu7t5v0__oai22_1
X_09783_ _09783_/A1 _09795_/A2 _09783_/B _11084_/D VDD VDD VSS VSS
+ gf180mcu_fd_sc_mcu7t5v0__aoi21_1
X_08734_ _09941_/A1 _08739_/A2 _08739_/B1 _08734_/B2 _10365_/D VDD VDD
+ VSS VSS gf180mcu_fd_sc_mcu7t5v0__oai22_1
X_06995_ _10000_/Q _07221_/A2 _07000_/B VDD VDD VSS VSS gf180mcu_fd_sc_mcu7t5v0__nand2_1
X_05946_ _09722_/B2 _09721_/A1 _09718_/A1 _09722_/A1 _09717_/A1 VDD VDD
+ VSS VSS gf180mcu_fd_sc_mcu7t5v0__nor4_1
X_05877_ _10730_/Q _09231_/B2 VDD VDD VSS VSS gf180mcu_fd_sc_mcu7t5v0__clkinv_1
X_08665_ _08665_/A1 _08675_/A2 _08665_/B _10325_/D VDD VDD VSS VSS
+ gf180mcu_fd_sc_mcu7t5v0__aoi21_1
X_08596_ _09861_/A2 _08596_/A2 _08596_/B1 _09412_/A2 _08596_/C1 _09900_/A2 _08597_/A4
+ VDD VDD VSS VSS gf180mcu_fd_sc_mcu7t5v0__aoi222_1
X_07616_ _10002_/Q _07508_/Z _07618_/A1 VDD VDD VSS VSS gf180mcu_fd_sc_mcu7t5v0__nand2_1
X_07547_ _07594_/A1 _07541_/Z _07593_/A2 _07547_/B _07548_/B VDD VDD VSS
+ VSS gf180mcu_fd_sc_mcu7t5v0__oai31_1
X_07478_ _07478_/I _07583_/A2 VDD VDD VSS VSS gf180mcu_fd_sc_mcu7t5v0__clkinv_1
Xclkbuf_opt_1_1_clk clkbuf_opt_1_1_clk/I clkbuf_opt_1_1_clk/Z VDD VDD
+ VSS VSS gf180mcu_fd_sc_mcu7t5v0__clkbuf_16
X_09217_ _06058_/Z _09221_/A2 _09221_/B1 _09217_/B2 _10718_/D VDD VDD
+ VSS VSS gf180mcu_fd_sc_mcu7t5v0__oai22_1
X_06429_ _06429_/A1 _06402_/Z _06429_/B _06455_/A1 VDD VDD VSS VSS
+ gf180mcu_fd_sc_mcu7t5v0__aoi21_1
X_09148_ _06061_/Z _09151_/A2 _09151_/B1 _09148_/B2 _10663_/D VDD VDD
+ VSS VSS gf180mcu_fd_sc_mcu7t5v0__oai22_1
X_09079_ _09944_/A1 _09081_/A2 _09081_/B1 _09079_/B2 _10608_/D VDD VDD
+ VSS VSS gf180mcu_fd_sc_mcu7t5v0__oai22_1
X_11110_ _11110_/D _11150_/CLK _11110_/Q VDD VDD VSS VSS gf180mcu_fd_sc_mcu7t5v0__dffq_1
X_11041_ _11041_/D _11164_/CLK _11041_/Q VDD VDD VSS VSS gf180mcu_fd_sc_mcu7t5v0__dffq_1
X_10825_ _10825_/D _11142_/CLK _10825_/Q VDD VDD VSS VSS gf180mcu_fd_sc_mcu7t5v0__dffq_1
X_10756_ _10756_/D _11010_/CLK _10756_/Q VDD VDD VSS VSS gf180mcu_fd_sc_mcu7t5v0__dffq_1
X_10687_ _10687_/D _10905_/CLK _10687_/Q VDD VDD VSS VSS gf180mcu_fd_sc_mcu7t5v0__dffq_1
X_05800_ _10905_/Q _09450_/B2 VDD VDD VSS VSS gf180mcu_fd_sc_mcu7t5v0__clkinv_1
X_06780_ _10005_/Q _06873_/A2 _06781_/A2 _06872_/I1 _06873_/B _06781_/B VDD
+ VDD VSS VSS gf180mcu_fd_sc_mcu7t5v0__aoi221_1
X_05731_ _10181_/Q _07737_/B2 VDD VDD VSS VSS gf180mcu_fd_sc_mcu7t5v0__clkinv_1
X_08450_ _10745_/Q _08547_/A2 _06125_/I _11049_/Q _08452_/A2 VDD VDD VSS
+ VSS gf180mcu_fd_sc_mcu7t5v0__aoi22_1
X_05662_ _10408_/Q _08787_/B2 VDD VDD VSS VSS gf180mcu_fd_sc_mcu7t5v0__clkinv_1
X_08381_ _10712_/Q _08582_/A2 _08532_/A2 _10720_/Q _08381_/C _08382_/A3 VDD
+ VDD VSS VSS gf180mcu_fd_sc_mcu7t5v0__aoi221_1
X_07401_ _07401_/A1 _07401_/A2 _07403_/A2 VDD VDD VSS VSS gf180mcu_fd_sc_mcu7t5v0__xnor2_1
X_05593_ _10975_/Q _09546_/B2 VDD VDD VSS VSS gf180mcu_fd_sc_mcu7t5v0__clkinv_1
X_07332_ _07557_/B2 _10082_/Q _07328_/Z _10331_/Q _07332_/C _07368_/A2 VDD VDD
+ VSS VSS gf180mcu_fd_sc_mcu7t5v0__aoi221_4
X_07263_ _09940_/A1 _07275_/A2 _07263_/B _10091_/D VDD VDD VSS VSS
+ gf180mcu_fd_sc_mcu7t5v0__oai21_1
X_09002_ _09851_/A1 _09062_/A2 _09011_/A2 VDD VDD VSS VSS gf180mcu_fd_sc_mcu7t5v0__nand2_4
X_06214_ _06257_/A2 _06372_/B2 _06212_/Z _06221_/A1 VDD VDD VSS VSS
+ gf180mcu_fd_sc_mcu7t5v0__nor3_1
X_07194_ _07194_/A1 _07214_/A1 _07193_/B _07194_/Z VDD VDD VSS VSS
+ gf180mcu_fd_sc_mcu7t5v0__xor3_2
X_06145_ _06145_/A1 _06040_/I _08345_/B2 VDD VDD VSS VSS gf180mcu_fd_sc_mcu7t5v0__nor2_2
X_06076_ _06038_/I _06040_/I _08533_/A1 VDD VDD VSS VSS gf180mcu_fd_sc_mcu7t5v0__nand2_4
X_09904_ _09904_/A1 _09916_/A2 _09904_/B _11151_/D VDD VDD VSS VSS
+ gf180mcu_fd_sc_mcu7t5v0__oai21_1
X_05027_ _10119_/Q _07358_/A1 VDD VDD VSS VSS gf180mcu_fd_sc_mcu7t5v0__inv_1
X_09835_ _11110_/Q _09849_/A2 _09836_/B VDD VDD VSS VSS gf180mcu_fd_sc_mcu7t5v0__nand2_1
X_09766_ _11078_/Q _09763_/Z _09766_/Z VDD VDD VSS VSS gf180mcu_fd_sc_mcu7t5v0__and2_1
X_06978_ _10001_/Q _07222_/A2 _07181_/A2 _10000_/Q _06979_/A2 VDD VDD
+ VSS VSS gf180mcu_fd_sc_mcu7t5v0__aoi22_1
X_08717_ _09896_/A1 _08719_/A2 _08719_/B1 _08717_/B2 _10352_/D VDD VDD
+ VSS VSS gf180mcu_fd_sc_mcu7t5v0__oai22_1
X_05929_ _10842_/Q _09371_/B2 VDD VDD VSS VSS gf180mcu_fd_sc_mcu7t5v0__clkinv_1
X_09697_ _09697_/A1 _09697_/A2 _11055_/D VDD VDD VSS VSS gf180mcu_fd_sc_mcu7t5v0__nor2_1
X_08648_ _10277_/Q _07636_/B _08649_/C VDD VDD VSS VSS gf180mcu_fd_sc_mcu7t5v0__and2_1
X_08579_ _10842_/Q _08590_/A2 _06125_/I _10850_/Q _08583_/A1 VDD VDD VSS
+ VSS gf180mcu_fd_sc_mcu7t5v0__aoi22_1
X_10610_ _10610_/D _11176_/CLK _10610_/Q VDD VDD VSS VSS gf180mcu_fd_sc_mcu7t5v0__dffq_1
X_10541_ _10541_/D _11138_/CLK _10541_/Q VDD VDD VSS VSS gf180mcu_fd_sc_mcu7t5v0__dffq_1
X_10472_ _10472_/D _11017_/CLK _10472_/Q VDD VDD VSS VSS gf180mcu_fd_sc_mcu7t5v0__dffq_1
X_11024_ _11024_/D _11039_/CLK _11024_/Q VDD VDD VSS VSS gf180mcu_fd_sc_mcu7t5v0__dffq_1
X_10808_ _10808_/D _11010_/CLK _10808_/Q VDD VDD VSS VSS gf180mcu_fd_sc_mcu7t5v0__dffq_1
X_10739_ _10739_/D _11017_/CLK _10739_/Q VDD VDD VSS VSS gf180mcu_fd_sc_mcu7t5v0__dffq_1
X_07950_ _07950_/I _07951_/C VDD VDD VSS VSS gf180mcu_fd_sc_mcu7t5v0__clkinv_1
X_06901_ _09900_/A2 _09851_/A1 _09900_/B _06916_/A2 VDD VDD VSS VSS
+ gf180mcu_fd_sc_mcu7t5v0__aoi21_4
X_07881_ bus_wdata[2] _07890_/A2 _08654_/B _07882_/B VDD VDD VSS VSS
+ gf180mcu_fd_sc_mcu7t5v0__oai21_1
X_09620_ _11024_/Q _09624_/A2 _09621_/B VDD VDD VSS VSS gf180mcu_fd_sc_mcu7t5v0__nand2_1
X_06832_ _06832_/A1 _06832_/A2 _06832_/B _06833_/B VDD VDD VSS VSS
+ gf180mcu_fd_sc_mcu7t5v0__oai21_1
X_09551_ _09645_/A1 _09927_/A2 _09900_/B _09566_/A2 VDD VDD VSS VSS
+ gf180mcu_fd_sc_mcu7t5v0__aoi21_4
X_06763_ _06817_/A1 _06762_/Z _06819_/A1 VDD VDD VSS VSS gf180mcu_fd_sc_mcu7t5v0__nand2_1
X_05714_ _10816_/Q _09339_/B2 VDD VDD VSS VSS gf180mcu_fd_sc_mcu7t5v0__clkinv_1
X_08502_ _08502_/A1 _08502_/A2 _08502_/A3 _08503_/B1 VDD VDD VSS VSS
+ gf180mcu_fd_sc_mcu7t5v0__nand3_1
X_09482_ _09871_/A1 _09861_/A2 _09491_/A2 VDD VDD VSS VSS gf180mcu_fd_sc_mcu7t5v0__nand2_4
X_06694_ _10001_/Q _06854_/A2 _06697_/A2 VDD VDD VSS VSS gf180mcu_fd_sc_mcu7t5v0__nand2_1
X_08433_ _10385_/Q _08591_/A2 _08591_/C1 _10393_/Q _10401_/Q _08589_/B1 _08435_/A2
+ VDD VDD VSS VSS gf180mcu_fd_sc_mcu7t5v0__aoi222_2
X_05645_ _10576_/Q _09039_/B2 VDD VDD VSS VSS gf180mcu_fd_sc_mcu7t5v0__clkinv_1
X_05576_ _11146_/Q _09895_/B2 VDD VDD VSS VSS gf180mcu_fd_sc_mcu7t5v0__clkinv_1
X_08364_ _10968_/Q _08530_/A2 _08563_/C1 _10156_/Q _08367_/A1 VDD VDD
+ VSS VSS gf180mcu_fd_sc_mcu7t5v0__aoi22_1
X_07315_ _07341_/A2 _08675_/A2 _07315_/B _10115_/D VDD VDD VSS VSS
+ gf180mcu_fd_sc_mcu7t5v0__aoi21_1
X_08295_ _10503_/Q _08591_/C1 _08591_/B1 _10519_/Q _08295_/C _08296_/I VDD VDD
+ VSS VSS gf180mcu_fd_sc_mcu7t5v0__aoi221_2
X_07246_ _07246_/A1 _07245_/Z _07250_/B VDD VDD VSS VSS gf180mcu_fd_sc_mcu7t5v0__nand2_1
X_07177_ _07177_/A1 _07183_/A1 _07177_/B1 _07177_/B2 _07178_/I VDD VDD
+ VSS VSS gf180mcu_fd_sc_mcu7t5v0__oai22_1
X_06128_ _09645_/A1 _09871_/A1 _09900_/B _06143_/A2 VDD VDD VSS VSS
+ gf180mcu_fd_sc_mcu7t5v0__aoi21_4
X_06059_ _06074_/A1 _06058_/Z _06059_/B _09950_/D VDD VDD VSS VSS
+ gf180mcu_fd_sc_mcu7t5v0__oai21_1
X_09818_ _09811_/B _09814_/B _09822_/A1 VDD VDD VSS VSS gf180mcu_fd_sc_mcu7t5v0__nand2_1
X_09749_ _11072_/Q _11073_/Q _09750_/A2 _09749_/Z VDD VDD VSS VSS
+ gf180mcu_fd_sc_mcu7t5v0__and3_1
X_10524_ _10524_/D _11109_/CLK _10524_/Q VDD VDD VSS VSS gf180mcu_fd_sc_mcu7t5v0__dffq_1
X_10455_ _10455_/D _11101_/CLK _10455_/Q VDD VDD VSS VSS gf180mcu_fd_sc_mcu7t5v0__dffq_1
X_10386_ _10386_/D _11018_/CLK _10386_/Q VDD VDD VSS VSS gf180mcu_fd_sc_mcu7t5v0__dffq_1
X_11007_ _11007_/D _11039_/CLK _11007_/Q VDD VDD VSS VSS gf180mcu_fd_sc_mcu7t5v0__dffq_1
X_05430_ _10550_/Q _09007_/B2 VDD VDD VSS VSS gf180mcu_fd_sc_mcu7t5v0__clkinv_1
X_05361_ _11176_/Q _09941_/B2 VDD VDD VSS VSS gf180mcu_fd_sc_mcu7t5v0__clkinv_1
X_07100_ _10086_/Q _07120_/A1 _07097_/Z _07100_/Z VDD VDD VSS VSS
+ gf180mcu_fd_sc_mcu7t5v0__xor3_1
X_05292_ _10828_/Q _09355_/B2 VDD VDD VSS VSS gf180mcu_fd_sc_mcu7t5v0__clkinv_1
X_08080_ _09948_/Q _08560_/A2 _08560_/B1 _11004_/Q _07255_/I _10980_/Q _08082_/A2
+ VDD VDD VSS VSS gf180mcu_fd_sc_mcu7t5v0__aoi222_4
X_07031_ _07031_/I _07075_/A2 VDD VDD VSS VSS gf180mcu_fd_sc_mcu7t5v0__clkinv_1
X_08982_ _09927_/A2 _09823_/A2 _08991_/A2 VDD VDD VSS VSS gf180mcu_fd_sc_mcu7t5v0__nand2_4
X_07933_ _10419_/Q _08591_/A2 _07680_/I _10371_/Q _06125_/I _11043_/Q _07935_/A2 VDD
+ VDD VSS VSS gf180mcu_fd_sc_mcu7t5v0__aoi222_1
X_07864_ _09698_/A1 _07864_/A2 _07864_/B _09900_/B _10253_/D VDD VDD VSS
+ VSS gf180mcu_fd_sc_mcu7t5v0__aoi211_1
X_09603_ _06058_/Z _09607_/A2 _09607_/B1 _09603_/B2 _11014_/D VDD VDD
+ VSS VSS gf180mcu_fd_sc_mcu7t5v0__oai22_1
X_06815_ _06816_/A1 _06814_/Z _06860_/A2 VDD VDD VSS VSS gf180mcu_fd_sc_mcu7t5v0__nand2_1
X_07795_ _09896_/A1 _07797_/A2 _07797_/B1 _07795_/B2 _10220_/D VDD VDD
+ VSS VSS gf180mcu_fd_sc_mcu7t5v0__oai22_1
X_09534_ _10968_/Q _09538_/A2 _09535_/B VDD VDD VSS VSS gf180mcu_fd_sc_mcu7t5v0__nand2_1
X_06746_ _10002_/Q _06854_/A2 _06848_/A1 VDD VDD VSS VSS gf180mcu_fd_sc_mcu7t5v0__nand2_1
X_09465_ _09940_/A1 _09471_/A2 _09471_/B1 _09465_/B2 _10916_/D VDD VDD
+ VSS VSS gf180mcu_fd_sc_mcu7t5v0__oai22_1
X_06677_ _06678_/A1 _06678_/A2 _06677_/B _06728_/A2 VDD VDD VSS VSS
+ gf180mcu_fd_sc_mcu7t5v0__aoi21_1
X_05628_ _10392_/Q _08767_/B2 VDD VDD VSS VSS gf180mcu_fd_sc_mcu7t5v0__clkinv_1
X_08416_ _10440_/Q _08591_/A2 _08591_/B1 _10432_/Q _08591_/C1 _10472_/Q _08417_/A3
+ VDD VDD VSS VSS gf180mcu_fd_sc_mcu7t5v0__aoi222_2
X_09396_ _09893_/A1 _09401_/A2 _09401_/B1 _09396_/B2 _10861_/D VDD VDD
+ VSS VSS gf180mcu_fd_sc_mcu7t5v0__oai22_1
X_05559_ _10727_/Q _09228_/B2 VDD VDD VSS VSS gf180mcu_fd_sc_mcu7t5v0__clkinv_1
X_08347_ _08347_/A1 _08347_/A2 _08347_/B _08349_/B VDD VDD VSS VSS
+ gf180mcu_fd_sc_mcu7t5v0__oai21_1
X_08278_ _08278_/A1 _08278_/A2 _08279_/C VDD VDD VSS VSS gf180mcu_fd_sc_mcu7t5v0__nand2_1
X_07229_ _07229_/A1 _07225_/Z _07228_/Z _07229_/Z VDD VDD VSS VSS
+ gf180mcu_fd_sc_mcu7t5v0__xor3_1
X_10240_ _10240_/D _10327_/CLK _10240_/Q VDD VDD VSS VSS gf180mcu_fd_sc_mcu7t5v0__dffq_1
X_10171_ _10171_/D _11097_/CLK _10171_/Q VDD VDD VSS VSS gf180mcu_fd_sc_mcu7t5v0__dffq_1
X_10507_ _10507_/D _11109_/CLK _10507_/Q VDD VDD VSS VSS gf180mcu_fd_sc_mcu7t5v0__dffq_1
X_10438_ _10438_/D _11164_/CLK _10438_/Q VDD VDD VSS VSS gf180mcu_fd_sc_mcu7t5v0__dffq_1
Xrepeater8 _09834_/A2 _08532_/A2 VDD VDD VSS VSS gf180mcu_fd_sc_mcu7t5v0__buf_12
X_10369_ _10369_/D _10905_/CLK _10369_/Q VDD VDD VSS VSS gf180mcu_fd_sc_mcu7t5v0__dffq_1
X_07580_ _07563_/I _07579_/Z _07580_/Z VDD VDD VSS VSS gf180mcu_fd_sc_mcu7t5v0__xor2_1
X_06600_ _10040_/Q _06633_/A2 _06823_/B VDD VDD VSS VSS gf180mcu_fd_sc_mcu7t5v0__nand2_2
X_06531_ _09946_/A1 _06531_/A2 _06531_/B1 _06531_/B2 _10031_/D VDD VDD
+ VSS VSS gf180mcu_fd_sc_mcu7t5v0__oai22_1
X_09250_ _09897_/A1 _09251_/A2 _09251_/B1 _09250_/B2 _10745_/D VDD VDD
+ VSS VSS gf180mcu_fd_sc_mcu7t5v0__oai22_1
X_08201_ _08201_/A1 _08201_/A2 _08201_/A3 _08202_/B VDD VDD VSS VSS
+ gf180mcu_fd_sc_mcu7t5v0__nand3_1
X_06462_ _06462_/A1 _06462_/A2 _06502_/A2 VDD VDD VSS VSS gf180mcu_fd_sc_mcu7t5v0__nand2_1
X_05413_ _10178_/Q _07734_/B2 VDD VDD VSS VSS gf180mcu_fd_sc_mcu7t5v0__clkinv_1
X_09181_ _09926_/A1 _09181_/A2 _09181_/B1 _09181_/B2 _10690_/D VDD VDD
+ VSS VSS gf180mcu_fd_sc_mcu7t5v0__oai22_1
X_06393_ _10005_/Q _06446_/A2 _06447_/A1 VDD VDD VSS VSS gf180mcu_fd_sc_mcu7t5v0__nand2_1
X_08132_ _09236_/B2 _08581_/A2 _08585_/B1 _08744_/B2 _08133_/C VDD VDD
+ VSS VSS gf180mcu_fd_sc_mcu7t5v0__oai22_1
X_05344_ _10405_/Q _08784_/B2 VDD VDD VSS VSS gf180mcu_fd_sc_mcu7t5v0__clkinv_1
X_05275_ _10972_/Q _09543_/B2 VDD VDD VSS VSS gf180mcu_fd_sc_mcu7t5v0__clkinv_1
X_08063_ _11167_/Q _08532_/A2 _08563_/C1 _11175_/Q _08066_/A1 VDD VDD
+ VSS VSS gf180mcu_fd_sc_mcu7t5v0__aoi22_1
X_07014_ _07014_/A1 _07247_/I0 _06951_/B _07014_/A4 _07020_/B2 VDD VDD
+ VSS VSS gf180mcu_fd_sc_mcu7t5v0__nor4_1
X_08965_ _09904_/A1 _08971_/A2 _08971_/B1 _08965_/B2 _10516_/D VDD VDD
+ VSS VSS gf180mcu_fd_sc_mcu7t5v0__oai22_1
X_07916_ _09698_/A1 _07920_/A2 _07916_/B _08658_/B _10277_/D VDD VDD VSS
+ VSS gf180mcu_fd_sc_mcu7t5v0__oai211_1
X_08896_ _06047_/Z _08903_/A2 _08903_/B1 _08896_/B2 _10467_/D VDD VDD
+ VSS VSS gf180mcu_fd_sc_mcu7t5v0__oai22_1
X_07847_ _07858_/A1 _07853_/A2 _07847_/B _09900_/B _10245_/D VDD VDD VSS
+ VSS gf180mcu_fd_sc_mcu7t5v0__aoi211_1
X_07778_ _10210_/Q _07786_/A2 _07779_/B VDD VDD VSS VSS gf180mcu_fd_sc_mcu7t5v0__nand2_1
X_09517_ _06058_/Z _09521_/A2 _09521_/B1 _09517_/B2 _10958_/D VDD VDD
+ VSS VSS gf180mcu_fd_sc_mcu7t5v0__oai22_1
X_06729_ _06871_/C _06776_/A2 _06735_/A2 VDD VDD VSS VSS gf180mcu_fd_sc_mcu7t5v0__nand2_1
X_09448_ _06061_/Z _09451_/A2 _09451_/B1 _09448_/B2 _10903_/D VDD VDD
+ VSS VSS gf180mcu_fd_sc_mcu7t5v0__oai22_1
X_09379_ _09896_/A1 _09381_/A2 _09381_/B1 _09379_/B2 _10848_/D VDD VDD
+ VSS VSS gf180mcu_fd_sc_mcu7t5v0__oai22_1
X_10223_ _10223_/D _11149_/CLK _10223_/Q VDD VDD VSS VSS gf180mcu_fd_sc_mcu7t5v0__dffq_1
X_10154_ _10154_/D _11181_/CLK _10154_/Q VDD VDD VSS VSS gf180mcu_fd_sc_mcu7t5v0__dffq_1
X_10085_ _10085_/D _11039_/CLK _10085_/Q VDD VDD VSS VSS gf180mcu_fd_sc_mcu7t5v0__dffq_2
X_10987_ _10987_/D _11018_/CLK _10987_/Q VDD VDD VSS VSS gf180mcu_fd_sc_mcu7t5v0__dffq_1
X_05060_ _10004_/Q _07470_/A1 VDD VDD VSS VSS gf180mcu_fd_sc_mcu7t5v0__clkinv_2
X_08750_ _09645_/A2 _09568_/A2 _08759_/A2 VDD VDD VSS VSS gf180mcu_fd_sc_mcu7t5v0__nand2_4
X_05962_ _11080_/Q _11079_/Q _11082_/Q _11081_/Q _05964_/A1 VDD VDD VSS
+ VSS gf180mcu_fd_sc_mcu7t5v0__nor4_1
X_08681_ _08681_/A1 _08681_/A2 _09900_/B _10332_/D VDD VDD VSS VSS
+ gf180mcu_fd_sc_mcu7t5v0__aoi21_1
X_05893_ _11173_/Q _09936_/B2 VDD VDD VSS VSS gf180mcu_fd_sc_mcu7t5v0__clkinv_1
X_07701_ _08658_/B _07709_/A2 _07709_/B1 VDD VDD VSS VSS gf180mcu_fd_sc_mcu7t5v0__nand2_2
X_07632_ _07632_/I0 _07632_/I1 _07632_/S _07633_/B VDD VDD VSS VSS
+ gf180mcu_fd_sc_mcu7t5v0__mux2_1
X_09302_ _09645_/A2 _09332_/A2 _09311_/A2 VDD VDD VSS VSS gf180mcu_fd_sc_mcu7t5v0__nand2_4
X_07563_ _07563_/I _07605_/A1 VDD VDD VSS VSS gf180mcu_fd_sc_mcu7t5v0__clkinv_1
X_06514_ _06047_/Z _06521_/A2 _06521_/B1 _06514_/B2 _10016_/D VDD VDD
+ VSS VSS gf180mcu_fd_sc_mcu7t5v0__oai22_1
X_07494_ _10004_/Q _07463_/Z _07499_/B1 VDD VDD VSS VSS gf180mcu_fd_sc_mcu7t5v0__nor2_1
X_09233_ _09599_/A1 _09241_/A2 _09241_/B1 VDD VDD VSS VSS gf180mcu_fd_sc_mcu7t5v0__nand2_2
X_06445_ _10006_/Q _06446_/A2 _06482_/A1 VDD VDD VSS VSS gf180mcu_fd_sc_mcu7t5v0__nand2_1
X_09164_ _06047_/Z _09171_/A2 _09171_/B1 _09164_/B2 _10675_/D VDD VDD
+ VSS VSS gf180mcu_fd_sc_mcu7t5v0__oai22_1
X_08115_ _10306_/Q _08590_/A2 _08590_/B1 _10941_/Q _08591_/C1 _10389_/Q _08117_/A2
+ VDD VDD VSS VSS gf180mcu_fd_sc_mcu7t5v0__aoi222_2
X_06376_ _08672_/B _08675_/A2 _06376_/A3 _06377_/B VDD VDD VSS VSS
+ gf180mcu_fd_sc_mcu7t5v0__nand3_1
X_09095_ _09940_/A1 _09101_/A2 _09101_/B1 _09095_/B2 _10620_/D VDD VDD
+ VSS VSS gf180mcu_fd_sc_mcu7t5v0__oai22_1
X_05327_ _10573_/Q _09036_/B2 VDD VDD VSS VSS gf180mcu_fd_sc_mcu7t5v0__clkinv_1
X_05258_ _11143_/Q _09892_/B2 VDD VDD VSS VSS gf180mcu_fd_sc_mcu7t5v0__clkinv_1
X_08046_ _08533_/B2 _08329_/B _09062_/A2 VDD VDD VSS VSS gf180mcu_fd_sc_mcu7t5v0__nor2_4
X_05189_ _10851_/Q _09384_/B2 VDD VDD VSS VSS gf180mcu_fd_sc_mcu7t5v0__clkinv_1
X_09997_ _09997_/D _10327_/CLK _09997_/Q VDD VDD VSS VSS gf180mcu_fd_sc_mcu7t5v0__dffq_2
X_08948_ _06061_/Z _08951_/A2 _08951_/B1 _08948_/B2 _10503_/D VDD VDD
+ VSS VSS gf180mcu_fd_sc_mcu7t5v0__oai22_1
X_08879_ _06047_/Z _08893_/A2 _08879_/B _10459_/D VDD VDD VSS VSS
+ gf180mcu_fd_sc_mcu7t5v0__oai21_1
X_10910_ _10910_/D _11149_/CLK _10910_/Q VDD VDD VSS VSS gf180mcu_fd_sc_mcu7t5v0__dffq_1
X_10841_ _10841_/D _11142_/CLK _10841_/Q VDD VDD VSS VSS gf180mcu_fd_sc_mcu7t5v0__dffq_1
X_10772_ _10772_/D _11164_/CLK _10772_/Q VDD VDD VSS VSS gf180mcu_fd_sc_mcu7t5v0__dffq_1
X_10206_ _10206_/D _11147_/CLK _10206_/Q VDD VDD VSS VSS gf180mcu_fd_sc_mcu7t5v0__dffq_1
X_11186_ cgra_status[6] VDD VDD VSS VSS gf180mcu_fd_sc_mcu7t5v0__tiel
X_10137_ _10137_/D _11176_/CLK _10137_/Q VDD VDD VSS VSS gf180mcu_fd_sc_mcu7t5v0__dffq_1
X_10068_ _10068_/D _11181_/CLK _10068_/Q VDD VDD VSS VSS gf180mcu_fd_sc_mcu7t5v0__dffq_1
X_06230_ _08674_/B _08675_/A2 _07603_/B VDD VDD VSS VSS gf180mcu_fd_sc_mcu7t5v0__nand2_4
X_06161_ _06061_/Z _06167_/A2 _06161_/B _09991_/D VDD VDD VSS VSS
+ gf180mcu_fd_sc_mcu7t5v0__oai21_1
X_05112_ _10547_/Q _09004_/B2 VDD VDD VSS VSS gf180mcu_fd_sc_mcu7t5v0__clkinv_1
X_06092_ _09945_/A1 _06093_/A2 _06093_/B1 _06092_/B2 _09961_/D VDD VDD
+ VSS VSS gf180mcu_fd_sc_mcu7t5v0__oai22_1
X_09920_ _09920_/A1 _09926_/A2 _09926_/B1 _09920_/B2 _11159_/D VDD VDD
+ VSS VSS gf180mcu_fd_sc_mcu7t5v0__oai22_1
X_05043_ _10049_/Q _06737_/A1 VDD VDD VSS VSS gf180mcu_fd_sc_mcu7t5v0__clkinv_1
X_09851_ _09851_/A1 _09889_/A2 _09860_/A2 VDD VDD VSS VSS gf180mcu_fd_sc_mcu7t5v0__nand2_4
X_08802_ _06047_/Z _08809_/A2 _08809_/B1 _08802_/B2 _10419_/D VDD VDD
+ VSS VSS gf180mcu_fd_sc_mcu7t5v0__oai22_1
X_09782_ _11092_/Q _09795_/A2 _09809_/B _09783_/B VDD VDD VSS VSS
+ gf180mcu_fd_sc_mcu7t5v0__oai21_1
X_06994_ _06994_/A1 _07216_/A2 _06994_/B1 _06994_/B2 _07221_/A2 VDD VDD
+ VSS VSS gf180mcu_fd_sc_mcu7t5v0__aoi22_4
X_08733_ _09940_/A1 _08739_/A2 _08739_/B1 _08733_/B2 _10364_/D VDD VDD
+ VSS VSS gf180mcu_fd_sc_mcu7t5v0__oai22_1
X_05945_ _11062_/Q _11061_/Q _11060_/Q _05942_/Z _05956_/A3 VDD VDD VSS
+ VSS gf180mcu_fd_sc_mcu7t5v0__nand4_1
X_05876_ _10722_/Q _09221_/B2 VDD VDD VSS VSS gf180mcu_fd_sc_mcu7t5v0__clkinv_1
X_08664_ _10282_/Q _08675_/A2 _08674_/B _08665_/B VDD VDD VSS VSS
+ gf180mcu_fd_sc_mcu7t5v0__oai21_1
X_08595_ _09332_/A2 _08595_/A2 _08595_/B1 _09917_/A2 _08595_/C _08598_/A1 VDD
+ VDD VSS VSS gf180mcu_fd_sc_mcu7t5v0__aoi221_2
X_07615_ _07568_/Z _07576_/Z _07615_/B _07621_/A2 VDD VDD VSS VSS
+ gf180mcu_fd_sc_mcu7t5v0__oai21_1
X_07546_ _10005_/Q _07508_/Z _07546_/B _07547_/B VDD VDD VSS VSS gf180mcu_fd_sc_mcu7t5v0__oai21_1
X_07477_ _07480_/A2 _07475_/Z _07478_/I VDD VDD VSS VSS gf180mcu_fd_sc_mcu7t5v0__xor2_1
X_09216_ _09941_/A1 _09221_/A2 _09221_/B1 _09216_/B2 _10717_/D VDD VDD
+ VSS VSS gf180mcu_fd_sc_mcu7t5v0__oai22_1
X_06428_ _06428_/A1 _06428_/A2 _06428_/B _06476_/A1 VDD VDD VSS VSS
+ gf180mcu_fd_sc_mcu7t5v0__aoi21_1
X_09147_ _06058_/Z _09151_/A2 _09151_/B1 _09147_/B2 _10662_/D VDD VDD
+ VSS VSS gf180mcu_fd_sc_mcu7t5v0__oai22_1
X_06359_ _06379_/A1 _06358_/Z _06375_/A1 VDD VDD VSS VSS gf180mcu_fd_sc_mcu7t5v0__nor2_1
X_09078_ _06061_/Z _09081_/A2 _09081_/B1 _09078_/B2 _10607_/D VDD VDD
+ VSS VSS gf180mcu_fd_sc_mcu7t5v0__oai22_1
X_08029_ _08029_/A1 _08029_/A2 _08029_/A3 _08029_/A4 _08030_/C1 VDD VDD
+ VSS VSS gf180mcu_fd_sc_mcu7t5v0__nand4_2
X_11040_ _11040_/D _11163_/CLK _11040_/Q VDD VDD VSS VSS gf180mcu_fd_sc_mcu7t5v0__dffq_1
X_10824_ _10824_/D _11142_/CLK _10824_/Q VDD VDD VSS VSS gf180mcu_fd_sc_mcu7t5v0__dffq_1
X_10755_ _10755_/D _11010_/CLK _10755_/Q VDD VDD VSS VSS gf180mcu_fd_sc_mcu7t5v0__dffq_1
X_10686_ _10686_/D _10905_/CLK _10686_/Q VDD VDD VSS VSS gf180mcu_fd_sc_mcu7t5v0__dffq_1
X_11169_ _11169_/D _11176_/CLK _11169_/Q VDD VDD VSS VSS gf180mcu_fd_sc_mcu7t5v0__dffq_1
X_05730_ _11164_/Q _09925_/B2 VDD VDD VSS VSS gf180mcu_fd_sc_mcu7t5v0__clkinv_1
X_05661_ _10704_/Q _09199_/B2 VDD VDD VSS VSS gf180mcu_fd_sc_mcu7t5v0__clkinv_1
X_08380_ _09169_/B2 _08581_/A2 _08585_/B1 _08787_/B2 _08381_/C VDD VDD
+ VSS VSS gf180mcu_fd_sc_mcu7t5v0__oai22_1
X_07400_ _07401_/A1 _07401_/A2 _07430_/A2 VDD VDD VSS VSS gf180mcu_fd_sc_mcu7t5v0__nand2_1
X_05592_ _11007_/Q _09594_/B2 VDD VDD VSS VSS gf180mcu_fd_sc_mcu7t5v0__clkinv_1
X_07331_ _10118_/Q _10117_/Q _07333_/C VDD VDD VSS VSS gf180mcu_fd_sc_mcu7t5v0__or2_1
X_07262_ _10091_/Q _07274_/A2 _07263_/B VDD VDD VSS VSS gf180mcu_fd_sc_mcu7t5v0__nand2_1
X_09001_ _09926_/A1 _09001_/A2 _09001_/B1 _09001_/B2 _10546_/D VDD VDD
+ VSS VSS gf180mcu_fd_sc_mcu7t5v0__oai22_1
X_06213_ _06215_/A2 _06328_/A1 _06470_/A1 _06509_/B2 VDD VDD VSS VSS
+ gf180mcu_fd_sc_mcu7t5v0__nand3_2
X_07193_ _07093_/I _07141_/Z _07193_/B _07214_/A2 VDD VDD VSS VSS
+ gf180mcu_fd_sc_mcu7t5v0__aoi21_1
X_06144_ _09916_/A1 _06144_/A2 _06144_/B _09986_/D VDD VDD VSS VSS
+ gf180mcu_fd_sc_mcu7t5v0__oai21_1
X_06075_ _06145_/A1 _06146_/A2 _08327_/A1 VDD VDD VSS VSS gf180mcu_fd_sc_mcu7t5v0__nor2_2
X_09903_ _11151_/Q _09915_/A2 _09904_/B VDD VDD VSS VSS gf180mcu_fd_sc_mcu7t5v0__nand2_1
X_05026_ _10122_/Q _07444_/A1 VDD VDD VSS VSS gf180mcu_fd_sc_mcu7t5v0__inv_2
X_09834_ _09872_/A2 _09834_/A2 _09900_/B _09849_/A2 VDD VDD VSS VSS
+ gf180mcu_fd_sc_mcu7t5v0__aoi21_4
X_09765_ _09763_/Z _09765_/A2 _11077_/D VDD VDD VSS VSS gf180mcu_fd_sc_mcu7t5v0__nor2_1
X_06977_ _07003_/A1 _07003_/A2 _07004_/A1 VDD VDD VSS VSS gf180mcu_fd_sc_mcu7t5v0__nor2_1
X_08716_ _06061_/Z _08719_/A2 _08719_/B1 _08716_/B2 _10351_/D VDD VDD
+ VSS VSS gf180mcu_fd_sc_mcu7t5v0__oai22_1
X_05928_ _10834_/Q _09361_/B2 VDD VDD VSS VSS gf180mcu_fd_sc_mcu7t5v0__clkinv_1
X_09696_ bus_wdata[3] _09722_/A1 _09696_/B _09697_/A2 VDD VDD VSS VSS
+ gf180mcu_fd_sc_mcu7t5v0__aoi21_1
X_05859_ _10594_/Q _09061_/B2 VDD VDD VSS VSS gf180mcu_fd_sc_mcu7t5v0__clkinv_1
X_08647_ _08659_/A1 _08647_/A2 _08647_/B _10319_/D VDD VDD VSS VSS
+ gf180mcu_fd_sc_mcu7t5v0__aoi21_1
X_08578_ _08578_/A1 _08578_/A2 _08578_/A3 _08593_/B1 VDD VDD VSS VSS
+ gf180mcu_fd_sc_mcu7t5v0__nand3_1
X_07529_ _07530_/A1 _07528_/Z _07554_/B VDD VDD VSS VSS gf180mcu_fd_sc_mcu7t5v0__and2_1
X_10540_ _10540_/D _11138_/CLK _10540_/Q VDD VDD VSS VSS gf180mcu_fd_sc_mcu7t5v0__dffq_1
X_10471_ _10471_/D _11017_/CLK _10471_/Q VDD VDD VSS VSS gf180mcu_fd_sc_mcu7t5v0__dffq_1
X_11023_ _11023_/D _11039_/CLK _11023_/Q VDD VDD VSS VSS gf180mcu_fd_sc_mcu7t5v0__dffq_1
X_10807_ _10807_/D _11010_/CLK _10807_/Q VDD VDD VSS VSS gf180mcu_fd_sc_mcu7t5v0__dffq_1
X_10738_ _10738_/D _11017_/CLK _10738_/Q VDD VDD VSS VSS gf180mcu_fd_sc_mcu7t5v0__dffq_1
X_10669_ _10669_/D _11139_/CLK _10669_/Q VDD VDD VSS VSS gf180mcu_fd_sc_mcu7t5v0__dffq_1
X_06900_ _09872_/A2 _08589_/B1 _06917_/A2 VDD VDD VSS VSS gf180mcu_fd_sc_mcu7t5v0__nand2_4
X_07880_ _07880_/A1 _07890_/A2 _07880_/B _10260_/D VDD VDD VSS VSS
+ gf180mcu_fd_sc_mcu7t5v0__aoi21_1
X_06831_ _10006_/Q _06873_/A2 _06832_/A2 _06872_/I1 _06873_/B _06832_/B VDD
+ VDD VSS VSS gf180mcu_fd_sc_mcu7t5v0__aoi221_1
X_09550_ _09645_/A1 _09927_/A2 _09567_/A2 VDD VDD VSS VSS gf180mcu_fd_sc_mcu7t5v0__nand2_2
X_06762_ _06787_/A1 _06761_/Z _06762_/Z VDD VDD VSS VSS gf180mcu_fd_sc_mcu7t5v0__xor2_1
X_09481_ _09832_/A1 _09481_/A2 _09481_/B1 _09481_/B2 _10930_/D VDD VDD
+ VSS VSS gf180mcu_fd_sc_mcu7t5v0__oai22_1
X_08501_ _10625_/Q _06023_/I _08582_/A2 _10657_/Q _08564_/C1 _10633_/Q _08502_/A3
+ VDD VDD VSS VSS gf180mcu_fd_sc_mcu7t5v0__aoi222_2
X_05713_ _10808_/Q _09329_/B2 VDD VDD VSS VSS gf180mcu_fd_sc_mcu7t5v0__clkinv_1
X_08432_ _10310_/Q _08590_/A2 _08590_/B1 _10945_/Q _08435_/A1 VDD VDD
+ VSS VSS gf180mcu_fd_sc_mcu7t5v0__aoi22_1
X_06693_ _10000_/Q _06823_/A1 _06697_/A1 VDD VDD VSS VSS gf180mcu_fd_sc_mcu7t5v0__nand2_1
X_05644_ _10568_/Q _09029_/B2 VDD VDD VSS VSS gf180mcu_fd_sc_mcu7t5v0__clkinv_1
X_08363_ _08363_/A1 _08363_/A2 _08363_/A3 _08368_/A2 VDD VDD VSS VSS
+ gf180mcu_fd_sc_mcu7t5v0__nand3_1
X_05575_ _11170_/Q _09933_/B2 VDD VDD VSS VSS gf180mcu_fd_sc_mcu7t5v0__clkinv_1
X_08294_ _08294_/A1 _08294_/A2 _08295_/C VDD VDD VSS VSS gf180mcu_fd_sc_mcu7t5v0__nand2_1
X_07314_ _10240_/Q _08675_/A2 _08674_/B _07315_/B VDD VDD VSS VSS
+ gf180mcu_fd_sc_mcu7t5v0__oai21_1
X_07245_ _07245_/A1 _07245_/A2 _07245_/A3 _07245_/Z VDD VDD VSS VSS
+ gf180mcu_fd_sc_mcu7t5v0__xor3_1
X_07176_ _07176_/A1 _07174_/Z _07186_/A1 VDD VDD VSS VSS gf180mcu_fd_sc_mcu7t5v0__xnor2_1
X_06127_ _09645_/A1 _09871_/A1 _06144_/A2 VDD VDD VSS VSS gf180mcu_fd_sc_mcu7t5v0__nand2_2
X_06058_ _07862_/A1 _07444_/A1 cgra_status[0] _06058_/Z VDD VDD VSS
+ VSS gf180mcu_fd_sc_mcu7t5v0__mux2_4
X_05009_ bus_wdata[1] _07858_/A1 VDD VDD VSS VSS gf180mcu_fd_sc_mcu7t5v0__inv_1
X_09817_ _09817_/A1 _09817_/A2 _09817_/B _09900_/B _11099_/D VDD VDD VSS
+ VSS gf180mcu_fd_sc_mcu7t5v0__aoi211_1
X_09748_ _09811_/B _09748_/A2 _09747_/Z _11072_/D VDD VDD VSS VSS
+ gf180mcu_fd_sc_mcu7t5v0__and3_1
X_09679_ _09679_/A1 _10289_/Q _09680_/B VDD VDD VSS VSS gf180mcu_fd_sc_mcu7t5v0__nor2_1
X_10523_ _10523_/D _11018_/CLK _10523_/Q VDD VDD VSS VSS gf180mcu_fd_sc_mcu7t5v0__dffq_1
X_10454_ _10454_/D _11101_/CLK _10454_/Q VDD VDD VSS VSS gf180mcu_fd_sc_mcu7t5v0__dffq_1
X_10385_ _10385_/D _11017_/CLK _10385_/Q VDD VDD VSS VSS gf180mcu_fd_sc_mcu7t5v0__dffq_1
X_11006_ _11006_/D _11039_/CLK _11006_/Q VDD VDD VSS VSS gf180mcu_fd_sc_mcu7t5v0__dffq_1
X_05360_ _09973_/Q _06118_/B2 VDD VDD VSS VSS gf180mcu_fd_sc_mcu7t5v0__clkinv_1
X_05291_ _10820_/Q _09345_/B2 VDD VDD VSS VSS gf180mcu_fd_sc_mcu7t5v0__clkinv_1
X_07030_ _10000_/Q _07223_/A2 _07031_/I VDD VDD VSS VSS gf180mcu_fd_sc_mcu7t5v0__nand2_1
X_08981_ _09832_/A1 _08981_/A2 _08981_/B1 _08981_/B2 _10530_/D VDD VDD
+ VSS VSS gf180mcu_fd_sc_mcu7t5v0__oai22_1
X_07932_ _10723_/Q _08580_/A2 _08576_/B1 _10995_/Q _07935_/A1 VDD VDD
+ VSS VSS gf180mcu_fd_sc_mcu7t5v0__aoi22_1
X_07863_ _10253_/Q _07864_/A2 _07864_/B VDD VDD VSS VSS gf180mcu_fd_sc_mcu7t5v0__nor2_1
X_09602_ _09893_/A1 _09607_/A2 _09607_/B1 _09602_/B2 _11013_/D VDD VDD
+ VSS VSS gf180mcu_fd_sc_mcu7t5v0__oai22_1
X_06814_ _06841_/A1 _06841_/A2 _06814_/Z VDD VDD VSS VSS gf180mcu_fd_sc_mcu7t5v0__xor2_1
X_07794_ _06061_/Z _07797_/A2 _07797_/B1 _07794_/B2 _10219_/D VDD VDD
+ VSS VSS gf180mcu_fd_sc_mcu7t5v0__oai22_1
X_09533_ _06061_/Z _09539_/A2 _09533_/B _10967_/D VDD VDD VSS VSS
+ gf180mcu_fd_sc_mcu7t5v0__oai21_1
X_06745_ _06745_/I _06792_/A1 VDD VDD VSS VSS gf180mcu_fd_sc_mcu7t5v0__clkinv_1
X_09464_ _06047_/Z _09471_/A2 _09471_/B1 _09464_/B2 _10915_/D VDD VDD
+ VSS VSS gf180mcu_fd_sc_mcu7t5v0__oai22_1
X_06676_ _07470_/B2 _06674_/Z _06677_/B VDD VDD VSS VSS gf180mcu_fd_sc_mcu7t5v0__xor2_1
X_05627_ _10309_/Q _08616_/B2 VDD VDD VSS VSS gf180mcu_fd_sc_mcu7t5v0__clkinv_1
X_09395_ _09920_/A1 _09401_/A2 _09401_/B1 _09395_/B2 _10860_/D VDD VDD
+ VSS VSS gf180mcu_fd_sc_mcu7t5v0__oai22_1
X_08415_ _10488_/Q _08540_/A2 _08560_/B1 _10148_/Q _07255_/I _11163_/Q _08417_/A2
+ VDD VDD VSS VSS gf180mcu_fd_sc_mcu7t5v0__aoi222_2
X_08346_ _09917_/A2 _08346_/A2 _08346_/B1 _09823_/A2 _08346_/C1 _09568_/A2 _08347_/B
+ VDD VDD VSS VSS gf180mcu_fd_sc_mcu7t5v0__aoi222_4
X_05558_ _10719_/Q _09218_/B2 VDD VDD VSS VSS gf180mcu_fd_sc_mcu7t5v0__clkinv_1
X_05489_ _10950_/Q _09507_/B2 VDD VDD VSS VSS gf180mcu_fd_sc_mcu7t5v0__clkinv_1
X_08277_ _10759_/Q _08559_/A2 _09872_/A1 _10783_/Q _08877_/A2 _10799_/Q _08278_/A2
+ VDD VDD VSS VSS gf180mcu_fd_sc_mcu7t5v0__aoi222_1
X_07228_ _07228_/A1 _07228_/A2 _07228_/Z VDD VDD VSS VSS gf180mcu_fd_sc_mcu7t5v0__xor2_1
X_07159_ _07019_/C _07159_/A2 _07160_/B VDD VDD VSS VSS gf180mcu_fd_sc_mcu7t5v0__nand2_1
X_10170_ _10170_/D _11097_/CLK _10170_/Q VDD VDD VSS VSS gf180mcu_fd_sc_mcu7t5v0__dffq_1
X_10506_ _10506_/D _11109_/CLK _10506_/Q VDD VDD VSS VSS gf180mcu_fd_sc_mcu7t5v0__dffq_1
X_10437_ _10437_/D _11017_/CLK _10437_/Q VDD VDD VSS VSS gf180mcu_fd_sc_mcu7t5v0__dffq_1
Xrepeater9 _08529_/B1 _08564_/C1 VDD VDD VSS VSS gf180mcu_fd_sc_mcu7t5v0__buf_16
X_10368_ _10368_/D _11176_/CLK _10368_/Q VDD VDD VSS VSS gf180mcu_fd_sc_mcu7t5v0__dffq_1
X_10299_ _10299_/D _11176_/CLK _10299_/Q VDD VDD VSS VSS gf180mcu_fd_sc_mcu7t5v0__dffq_1
X_06530_ _09945_/A1 _06531_/A2 _06531_/B1 _06530_/B2 _10030_/D VDD VDD
+ VSS VSS gf180mcu_fd_sc_mcu7t5v0__oai22_1
X_06461_ _06502_/B _06483_/A2 _06462_/A2 VDD VDD VSS VSS gf180mcu_fd_sc_mcu7t5v0__nand2_1
X_08200_ _11145_/Q _08555_/A2 _08591_/A2 _10342_/Q _06125_/I _10350_/Q _08201_/A3
+ VDD VDD VSS VSS gf180mcu_fd_sc_mcu7t5v0__aoi222_1
X_05412_ _11161_/Q _09922_/B2 VDD VDD VSS VSS gf180mcu_fd_sc_mcu7t5v0__clkinv_1
X_09180_ _09897_/A1 _09181_/A2 _09181_/B1 _09180_/B2 _10689_/D VDD VDD
+ VSS VSS gf180mcu_fd_sc_mcu7t5v0__oai22_1
X_06392_ _10005_/Q _06481_/A2 _06480_/A1 VDD VDD VSS VSS gf180mcu_fd_sc_mcu7t5v0__nand2_1
X_05343_ _10701_/Q _09196_/B2 VDD VDD VSS VSS gf180mcu_fd_sc_mcu7t5v0__clkinv_1
X_08131_ _09937_/A1 _08131_/A2 _08131_/B1 _09442_/A1 _08142_/A3 VDD VDD
+ VSS VSS gf180mcu_fd_sc_mcu7t5v0__aoi22_2
X_08062_ _08062_/A1 _08062_/A2 _08062_/A3 _08101_/A2 VDD VDD VSS VSS
+ gf180mcu_fd_sc_mcu7t5v0__nand3_2
X_05274_ _11004_/Q _09591_/B2 VDD VDD VSS VSS gf180mcu_fd_sc_mcu7t5v0__clkinv_1
X_07013_ _07013_/A1 _06971_/Z _07012_/B _07014_/A4 VDD VDD VSS VSS
+ gf180mcu_fd_sc_mcu7t5v0__nor3_1
X_08964_ _06047_/Z _08971_/A2 _08971_/B1 _08964_/B2 _10515_/D VDD VDD
+ VSS VSS gf180mcu_fd_sc_mcu7t5v0__oai22_1
X_07915_ _10277_/Q _07920_/A2 _07916_/B VDD VDD VSS VSS gf180mcu_fd_sc_mcu7t5v0__nand2_1
X_08895_ _09599_/A1 _08903_/A2 _08903_/B1 VDD VDD VSS VSS gf180mcu_fd_sc_mcu7t5v0__nand2_4
X_07846_ _10245_/Q _07853_/A2 _07847_/B VDD VDD VSS VSS gf180mcu_fd_sc_mcu7t5v0__nor2_1
X_04989_ _11060_/Q _09718_/A1 VDD VDD VSS VSS gf180mcu_fd_sc_mcu7t5v0__clkinv_1
X_07777_ _09941_/A1 _07787_/A2 _07777_/B _10209_/D VDD VDD VSS VSS
+ gf180mcu_fd_sc_mcu7t5v0__oai21_1
X_09516_ _09893_/A1 _09521_/A2 _09521_/B1 _09516_/B2 _10957_/D VDD VDD
+ VSS VSS gf180mcu_fd_sc_mcu7t5v0__oai22_1
X_06728_ _06675_/Z _06728_/A2 _06728_/B _06776_/A2 VDD VDD VSS VSS
+ gf180mcu_fd_sc_mcu7t5v0__oai21_1
X_09447_ _06058_/Z _09451_/A2 _09451_/B1 _09447_/B2 _10902_/D VDD VDD
+ VSS VSS gf180mcu_fd_sc_mcu7t5v0__oai22_1
X_06659_ _10001_/Q _06850_/A2 _06659_/Z VDD VDD VSS VSS gf180mcu_fd_sc_mcu7t5v0__and2_1
X_09378_ _06061_/Z _09381_/A2 _09381_/B1 _09378_/B2 _10847_/D VDD VDD
+ VSS VSS gf180mcu_fd_sc_mcu7t5v0__oai22_1
X_08329_ _08329_/A1 _08329_/A2 _08329_/B _08349_/C VDD VDD VSS VSS
+ gf180mcu_fd_sc_mcu7t5v0__aoi21_1
X_10222_ _10222_/D _11147_/CLK _10222_/Q VDD VDD VSS VSS gf180mcu_fd_sc_mcu7t5v0__dffq_1
X_10153_ _10153_/D _11101_/CLK _10153_/Q VDD VDD VSS VSS gf180mcu_fd_sc_mcu7t5v0__dffq_1
X_10084_ _10084_/D _11039_/CLK _10084_/Q VDD VDD VSS VSS gf180mcu_fd_sc_mcu7t5v0__dffq_2
X_10986_ _10986_/D _11010_/CLK _10986_/Q VDD VDD VSS VSS gf180mcu_fd_sc_mcu7t5v0__dffq_1
X_05961_ _09809_/B _09678_/A1 _09673_/A2 _10288_/D VDD VDD VSS VSS
+ gf180mcu_fd_sc_mcu7t5v0__nand3_1
X_07700_ _09502_/A1 _09442_/A1 _07709_/A2 VDD VDD VSS VSS gf180mcu_fd_sc_mcu7t5v0__nand2_4
X_05892_ _09970_/Q _06109_/B2 VDD VDD VSS VSS gf180mcu_fd_sc_mcu7t5v0__clkinv_1
X_08680_ _10332_/Q _08698_/A2 _08681_/A2 VDD VDD VSS VSS gf180mcu_fd_sc_mcu7t5v0__nand2_1
X_07631_ _07631_/A1 _07628_/Z _07631_/A3 _07631_/Z VDD VDD VSS VSS
+ gf180mcu_fd_sc_mcu7t5v0__xor3_1
X_07562_ _07562_/A1 _07562_/A2 _07563_/I VDD VDD VSS VSS gf180mcu_fd_sc_mcu7t5v0__xnor2_1
X_09301_ _09916_/A1 _09301_/A2 _09301_/B1 _09301_/B2 _10786_/D VDD VDD
+ VSS VSS gf180mcu_fd_sc_mcu7t5v0__oai22_1
X_06513_ _08658_/B _06521_/A2 _06521_/B1 VDD VDD VSS VSS gf180mcu_fd_sc_mcu7t5v0__nand2_4
X_07493_ _07346_/Z _07542_/A2 _07499_/A2 VDD VDD VSS VSS gf180mcu_fd_sc_mcu7t5v0__nand2_1
X_09232_ _09851_/A1 _09662_/A2 _09241_/A2 VDD VDD VSS VSS gf180mcu_fd_sc_mcu7t5v0__nand2_4
X_06444_ _06470_/B _06444_/A2 _06446_/B VDD VDD VSS VSS gf180mcu_fd_sc_mcu7t5v0__nor2_1
X_09163_ _09193_/A1 _09171_/A2 _09171_/B1 VDD VDD VSS VSS gf180mcu_fd_sc_mcu7t5v0__nand2_4
X_06375_ _06375_/A1 _06375_/A2 _06375_/B1 _06327_/B _07636_/B _06376_/A3 VDD
+ VDD VSS VSS gf180mcu_fd_sc_mcu7t5v0__oai221_1
X_08114_ _10381_/Q _08591_/A2 _08576_/B1 _10925_/Q _08589_/B1 _10397_/Q _08117_/A1
+ VDD VDD VSS VSS gf180mcu_fd_sc_mcu7t5v0__aoi222_2
X_05326_ _10565_/Q _09026_/B2 VDD VDD VSS VSS gf180mcu_fd_sc_mcu7t5v0__clkinv_1
X_09094_ _06047_/Z _09101_/A2 _09101_/B1 _09094_/B2 _10619_/D VDD VDD
+ VSS VSS gf180mcu_fd_sc_mcu7t5v0__oai22_1
X_08045_ _08045_/A1 _08045_/A2 _08045_/A3 _08095_/A1 VDD VDD VSS VSS
+ gf180mcu_fd_sc_mcu7t5v0__nand3_1
X_05257_ _11167_/Q _09930_/B2 VDD VDD VSS VSS gf180mcu_fd_sc_mcu7t5v0__clkinv_1
X_05188_ _10843_/Q _09374_/B2 VDD VDD VSS VSS gf180mcu_fd_sc_mcu7t5v0__clkinv_1
X_09996_ _09996_/D _10327_/CLK _09996_/Q VDD VDD VSS VSS gf180mcu_fd_sc_mcu7t5v0__dffq_2
X_08947_ _06058_/Z _08951_/A2 _08951_/B1 _08947_/B2 _10502_/D VDD VDD
+ VSS VSS gf180mcu_fd_sc_mcu7t5v0__oai22_1
X_08878_ _10459_/Q _08892_/A2 _08879_/B VDD VDD VSS VSS gf180mcu_fd_sc_mcu7t5v0__nand2_1
X_07829_ bus_addr[3] _07829_/A2 bus_addr[6] _07829_/C _07830_/A4 VDD VDD
+ VSS VSS gf180mcu_fd_sc_mcu7t5v0__aoi211_2
X_10840_ _10840_/D _11142_/CLK _10840_/Q VDD VDD VSS VSS gf180mcu_fd_sc_mcu7t5v0__dffq_1
X_10771_ _10771_/D _11164_/CLK _10771_/Q VDD VDD VSS VSS gf180mcu_fd_sc_mcu7t5v0__dffq_1
X_10205_ _10205_/D _11147_/CLK _10205_/Q VDD VDD VSS VSS gf180mcu_fd_sc_mcu7t5v0__dffq_1
X_11185_ cgra_status[5] VDD VDD VSS VSS gf180mcu_fd_sc_mcu7t5v0__tiel
X_10136_ _10136_/D _11176_/CLK _10136_/Q VDD VDD VSS VSS gf180mcu_fd_sc_mcu7t5v0__dffq_1
X_10067_ _10067_/D _11101_/CLK _10067_/Q VDD VDD VSS VSS gf180mcu_fd_sc_mcu7t5v0__dffq_1
X_10969_ _10969_/D _11101_/CLK _10969_/Q VDD VDD VSS VSS gf180mcu_fd_sc_mcu7t5v0__dffq_1
X_06160_ _09991_/Q _06166_/A2 _06161_/B VDD VDD VSS VSS gf180mcu_fd_sc_mcu7t5v0__nand2_1
X_05111_ _10539_/Q _08994_/B2 VDD VDD VSS VSS gf180mcu_fd_sc_mcu7t5v0__clkinv_1
X_06091_ _09944_/A1 _06093_/A2 _06093_/B1 _06091_/B2 _09960_/D VDD VDD
+ VSS VSS gf180mcu_fd_sc_mcu7t5v0__oai22_1
X_05042_ _10052_/Q _06876_/A1 VDD VDD VSS VSS gf180mcu_fd_sc_mcu7t5v0__clkinv_1
X_09850_ _09916_/A1 _09850_/A2 _09850_/B _11117_/D VDD VDD VSS VSS
+ gf180mcu_fd_sc_mcu7t5v0__oai21_1
X_08801_ _09852_/A1 _08809_/A2 _08809_/B1 VDD VDD VSS VSS gf180mcu_fd_sc_mcu7t5v0__nand2_2
X_09781_ _09781_/A1 _09795_/A2 _09781_/B _11083_/D VDD VDD VSS VSS
+ gf180mcu_fd_sc_mcu7t5v0__aoi21_1
X_06993_ _10121_/Q _10080_/Q _06994_/B2 VDD VDD VSS VSS gf180mcu_fd_sc_mcu7t5v0__nand2_1
X_08732_ _06047_/Z _08739_/A2 _08739_/B1 _08732_/B2 _10363_/D VDD VDD
+ VSS VSS gf180mcu_fd_sc_mcu7t5v0__oai22_1
X_05944_ _10291_/Q _08830_/B _05947_/B VDD VDD VSS VSS gf180mcu_fd_sc_mcu7t5v0__nand2_1
X_08663_ _08663_/A1 _08675_/A2 _08663_/B _10324_/D VDD VDD VSS VSS
+ gf180mcu_fd_sc_mcu7t5v0__aoi21_1
X_05875_ _10714_/Q _09211_/B2 VDD VDD VSS VSS gf180mcu_fd_sc_mcu7t5v0__clkinv_1
X_08594_ _08594_/A1 _08594_/A2 _08595_/C VDD VDD VSS VSS gf180mcu_fd_sc_mcu7t5v0__nand2_1
X_07614_ _07614_/A1 _07614_/A2 _07567_/Z _07614_/B2 _07619_/A3 VDD VDD
+ VSS VSS gf180mcu_fd_sc_mcu7t5v0__oai22_1
X_07545_ _07545_/A1 _07545_/A2 _07545_/B _07546_/B VDD VDD VSS VSS
+ gf180mcu_fd_sc_mcu7t5v0__oai21_1
X_07476_ _07480_/A2 _07475_/Z _07583_/B2 VDD VDD VSS VSS gf180mcu_fd_sc_mcu7t5v0__nand2_1
X_09215_ _09940_/A1 _09221_/A2 _09221_/B1 _09215_/B2 _10716_/D VDD VDD
+ VSS VSS gf180mcu_fd_sc_mcu7t5v0__oai22_1
X_06427_ _10014_/Q _07601_/B _06475_/A1 VDD VDD VSS VSS gf180mcu_fd_sc_mcu7t5v0__nand2_1
X_09146_ _09941_/A1 _09151_/A2 _09151_/B1 _09146_/B2 _10661_/D VDD VDD
+ VSS VSS gf180mcu_fd_sc_mcu7t5v0__oai22_1
X_06358_ _06377_/A1 _06356_/Z _06358_/Z VDD VDD VSS VSS gf180mcu_fd_sc_mcu7t5v0__xor2_1
X_05309_ _10306_/Q _08613_/B2 VDD VDD VSS VSS gf180mcu_fd_sc_mcu7t5v0__clkinv_1
X_09077_ _06058_/Z _09081_/A2 _09081_/B1 _09077_/B2 _10606_/D VDD VDD
+ VSS VSS gf180mcu_fd_sc_mcu7t5v0__oai22_1
X_06289_ _06509_/A1 _06271_/Z _06289_/B1 _06289_/B2 _06289_/C _06290_/B VDD
+ VDD VSS VSS gf180mcu_fd_sc_mcu7t5v0__oai221_1
X_08028_ _10476_/Q _08528_/B1 _09834_/A2 _11111_/Q _08589_/B1 _10070_/Q _08029_/A4
+ VDD VDD VSS VSS gf180mcu_fd_sc_mcu7t5v0__aoi222_4
X_09979_ _09979_/D _11164_/CLK _09979_/Q VDD VDD VSS VSS gf180mcu_fd_sc_mcu7t5v0__dffq_1
X_10823_ _10823_/D _11138_/CLK _10823_/Q VDD VDD VSS VSS gf180mcu_fd_sc_mcu7t5v0__dffq_1
X_10754_ _10754_/D _10978_/CLK _10754_/Q VDD VDD VSS VSS gf180mcu_fd_sc_mcu7t5v0__dffq_1
X_10685_ _10685_/D _10905_/CLK _10685_/Q VDD VDD VSS VSS gf180mcu_fd_sc_mcu7t5v0__dffq_1
X_11168_ _11168_/D _11176_/CLK _11168_/Q VDD VDD VSS VSS gf180mcu_fd_sc_mcu7t5v0__dffq_1
X_10119_ _10119_/D _11150_/CLK _10119_/Q VDD VDD VSS VSS gf180mcu_fd_sc_mcu7t5v0__dffq_1
X_11099_ _11099_/D _11101_/CLK _11099_/Q VDD VDD VSS VSS gf180mcu_fd_sc_mcu7t5v0__dffq_1
X_05660_ _10696_/Q _09189_/B2 VDD VDD VSS VSS gf180mcu_fd_sc_mcu7t5v0__clkinv_1
X_05591_ _10367_/Q _08736_/B2 VDD VDD VSS VSS gf180mcu_fd_sc_mcu7t5v0__clkinv_1
X_07330_ _10118_/Q _10117_/Q _07332_/C VDD VDD VSS VSS gf180mcu_fd_sc_mcu7t5v0__nor2_4
X_09000_ _09945_/A1 _09001_/A2 _09001_/B1 _09000_/B2 _10545_/D VDD VDD
+ VSS VSS gf180mcu_fd_sc_mcu7t5v0__oai22_1
X_07261_ _06047_/Z _07275_/A2 _07261_/B _10090_/D VDD VDD VSS VSS
+ gf180mcu_fd_sc_mcu7t5v0__oai21_1
X_06212_ _06215_/A2 _06328_/A1 _06470_/A1 _06212_/Z VDD VDD VSS VSS
+ gf180mcu_fd_sc_mcu7t5v0__and3_1
X_07192_ _07093_/I _07141_/Z _07193_/B _07214_/B VDD VDD VSS VSS gf180mcu_fd_sc_mcu7t5v0__nand3_1
X_06143_ _09986_/Q _06143_/A2 _06144_/B VDD VDD VSS VSS gf180mcu_fd_sc_mcu7t5v0__nand2_1
X_06074_ _06074_/A1 _09916_/A1 _06074_/B _09954_/D VDD VDD VSS VSS
+ gf180mcu_fd_sc_mcu7t5v0__oai21_1
X_05025_ _10123_/Q _07503_/A1 VDD VDD VSS VSS gf180mcu_fd_sc_mcu7t5v0__clkinv_2
X_09902_ _06047_/Z _09916_/A2 _09902_/B _11150_/D VDD VDD VSS VSS
+ gf180mcu_fd_sc_mcu7t5v0__oai21_1
X_09833_ _09872_/A2 _09834_/A2 _09850_/A2 VDD VDD VSS VSS gf180mcu_fd_sc_mcu7t5v0__nand2_2
X_09764_ _11077_/Q _09760_/Z _09776_/B _09765_/A2 VDD VDD VSS VSS
+ gf180mcu_fd_sc_mcu7t5v0__oai21_1
X_06976_ _10001_/Q _07222_/A2 _06998_/A1 VDD VDD VSS VSS gf180mcu_fd_sc_mcu7t5v0__nand2_1
X_08715_ _06058_/Z _08719_/A2 _08719_/B1 _08715_/B2 _10350_/D VDD VDD
+ VSS VSS gf180mcu_fd_sc_mcu7t5v0__oai22_1
X_05927_ _10826_/Q _09351_/B2 VDD VDD VSS VSS gf180mcu_fd_sc_mcu7t5v0__clkinv_1
X_09695_ _09678_/Z _09695_/A2 _09696_/B VDD VDD VSS VSS gf180mcu_fd_sc_mcu7t5v0__nand2_1
X_05858_ _10586_/Q _09051_/B2 VDD VDD VSS VSS gf180mcu_fd_sc_mcu7t5v0__clkinv_1
X_08646_ _10319_/Q _08659_/A1 _08654_/B _08647_/B VDD VDD VSS VSS
+ gf180mcu_fd_sc_mcu7t5v0__oai21_1
X_05789_ _11124_/Q _09859_/B2 VDD VDD VSS VSS gf180mcu_fd_sc_mcu7t5v0__clkinv_1
X_08577_ _10426_/Q _08591_/A2 _08589_/B1 _10738_/Q _08578_/A3 VDD VDD
+ VSS VSS gf180mcu_fd_sc_mcu7t5v0__aoi22_1
X_07528_ _07564_/B2 _07527_/Z _07528_/Z VDD VDD VSS VSS gf180mcu_fd_sc_mcu7t5v0__xor2_1
X_07459_ _07602_/A1 _07445_/Z _07459_/B _07636_/B _07460_/A2 VDD VDD VSS
+ VSS gf180mcu_fd_sc_mcu7t5v0__oai211_1
X_10470_ _10470_/D _11165_/CLK _10470_/Q VDD VDD VSS VSS gf180mcu_fd_sc_mcu7t5v0__dffq_1
X_09129_ _09944_/A1 _09131_/A2 _09131_/B1 _09129_/B2 _10648_/D VDD VDD
+ VSS VSS gf180mcu_fd_sc_mcu7t5v0__oai22_1
X_11022_ _11022_/D _11039_/CLK _11022_/Q VDD VDD VSS VSS gf180mcu_fd_sc_mcu7t5v0__dffq_1
X_10806_ _10806_/D _11010_/CLK _10806_/Q VDD VDD VSS VSS gf180mcu_fd_sc_mcu7t5v0__dffq_1
X_10737_ _10737_/D _11142_/CLK _10737_/Q VDD VDD VSS VSS gf180mcu_fd_sc_mcu7t5v0__dffq_1
X_10668_ _10668_/D _11139_/CLK _10668_/Q VDD VDD VSS VSS gf180mcu_fd_sc_mcu7t5v0__dffq_1
X_10599_ _10599_/D _10666_/CLK _10599_/Q VDD VDD VSS VSS gf180mcu_fd_sc_mcu7t5v0__dffq_1
X_06830_ _10006_/Q _06867_/A2 _06832_/A2 VDD VDD VSS VSS gf180mcu_fd_sc_mcu7t5v0__nand2_1
X_06761_ _06761_/A1 _06760_/B _06761_/Z VDD VDD VSS VSS gf180mcu_fd_sc_mcu7t5v0__xor2_1
X_09480_ _09897_/A1 _09481_/A2 _09481_/B1 _09480_/B2 _10929_/D VDD VDD
+ VSS VSS gf180mcu_fd_sc_mcu7t5v0__oai22_1
X_05712_ _10800_/Q _09319_/B2 VDD VDD VSS VSS gf180mcu_fd_sc_mcu7t5v0__clkinv_1
X_08500_ _10617_/Q _06877_/Z _08584_/B1 _10665_/Q _08563_/C1 _10649_/Q _08502_/A2
+ VDD VDD VSS VSS gf180mcu_fd_sc_mcu7t5v0__aoi222_1
X_06692_ _07503_/A1 _06843_/B1 _06692_/B1 _06692_/B2 _06823_/A1 VDD VDD
+ VSS VSS gf180mcu_fd_sc_mcu7t5v0__aoi22_4
X_05643_ _10560_/Q _09019_/B2 VDD VDD VSS VSS gf180mcu_fd_sc_mcu7t5v0__clkinv_1
X_08431_ _08431_/I _10285_/D VDD VDD VSS VSS gf180mcu_fd_sc_mcu7t5v0__clkinv_1
X_08362_ _10037_/Q _08528_/A2 _08586_/A2 _09968_/Q _08564_/C1 _10029_/Q _08363_/A3
+ VDD VDD VSS VSS gf180mcu_fd_sc_mcu7t5v0__aoi222_1
X_05574_ _09967_/Q _06106_/B2 VDD VDD VSS VSS gf180mcu_fd_sc_mcu7t5v0__clkinv_1
X_08293_ _10359_/Q _08540_/A2 _08590_/B1 _10527_/Q _08591_/A2 _10511_/Q _08294_/A2
+ VDD VDD VSS VSS gf180mcu_fd_sc_mcu7t5v0__aoi222_1
X_07313_ _07353_/A3 _08675_/A2 _07313_/B _10114_/D VDD VDD VSS VSS
+ gf180mcu_fd_sc_mcu7t5v0__aoi21_1
X_07244_ _07244_/A1 _07244_/A2 _07245_/A3 VDD VDD VSS VSS gf180mcu_fd_sc_mcu7t5v0__nand2_1
X_07175_ _10001_/Q _07226_/A2 _07174_/Z _07231_/B VDD VDD VSS VSS
+ gf180mcu_fd_sc_mcu7t5v0__nand3_1
X_06126_ _07682_/A1 _08587_/B1 _09871_/A1 VDD VDD VSS VSS gf180mcu_fd_sc_mcu7t5v0__nor2_4
X_06057_ _09950_/Q _06071_/A2 _06059_/B VDD VDD VSS VSS gf180mcu_fd_sc_mcu7t5v0__nand2_1
X_05008_ _10274_/Q _08636_/A1 VDD VDD VSS VSS gf180mcu_fd_sc_mcu7t5v0__clkinv_1
X_09816_ _09816_/I _09817_/B VDD VDD VSS VSS gf180mcu_fd_sc_mcu7t5v0__clkinv_1
X_09747_ _11072_/Q _09750_/A2 _09747_/Z VDD VDD VSS VSS gf180mcu_fd_sc_mcu7t5v0__xor2_1
X_06959_ _07601_/B _06959_/A2 _06959_/A3 _06960_/C VDD VDD VSS VSS
+ gf180mcu_fd_sc_mcu7t5v0__nor3_1
X_09678_ _09678_/A1 _09716_/A2 _09678_/Z VDD VDD VSS VSS gf180mcu_fd_sc_mcu7t5v0__and2_4
X_08629_ _10314_/Q _08629_/A2 _08657_/A2 VDD VDD VSS VSS gf180mcu_fd_sc_mcu7t5v0__nor2_4
X_10522_ _10522_/D _11109_/CLK _10522_/Q VDD VDD VSS VSS gf180mcu_fd_sc_mcu7t5v0__dffq_1
X_10453_ _10453_/D _11101_/CLK _10453_/Q VDD VDD VSS VSS gf180mcu_fd_sc_mcu7t5v0__dffq_1
X_10384_ _10384_/D _11017_/CLK _10384_/Q VDD VDD VSS VSS gf180mcu_fd_sc_mcu7t5v0__dffq_1
X_11005_ _11005_/D _11010_/CLK _11005_/Q VDD VDD VSS VSS gf180mcu_fd_sc_mcu7t5v0__dffq_1
X_05290_ _10812_/Q _09335_/B2 VDD VDD VSS VSS gf180mcu_fd_sc_mcu7t5v0__clkinv_1
X_08980_ _09925_/A1 _08981_/A2 _08981_/B1 _08980_/B2 _10529_/D VDD VDD
+ VSS VSS gf180mcu_fd_sc_mcu7t5v0__oai22_1
X_07931_ _07931_/A1 _07931_/A2 _07931_/A3 _07936_/A2 VDD VDD VSS VSS
+ gf180mcu_fd_sc_mcu7t5v0__nand3_1
X_07862_ _07862_/A1 _07864_/A2 _07862_/B _09900_/B _10252_/D VDD VDD VSS
+ VSS gf180mcu_fd_sc_mcu7t5v0__aoi211_1
X_09601_ _09920_/A1 _09607_/A2 _09607_/B1 _09601_/B2 _11012_/D VDD VDD
+ VSS VSS gf180mcu_fd_sc_mcu7t5v0__oai22_1
X_06813_ _06813_/A1 _06813_/A2 _06841_/A2 VDD VDD VSS VSS gf180mcu_fd_sc_mcu7t5v0__xnor2_1
X_07793_ _06058_/Z _07797_/A2 _07797_/B1 _07793_/B2 _10218_/D VDD VDD
+ VSS VSS gf180mcu_fd_sc_mcu7t5v0__oai22_1
X_09532_ _10967_/Q _09538_/A2 _09533_/B VDD VDD VSS VSS gf180mcu_fd_sc_mcu7t5v0__nand2_1
X_06744_ _10000_/Q _06847_/A2 _06745_/I VDD VDD VSS VSS gf180mcu_fd_sc_mcu7t5v0__nand2_1
X_09463_ _09890_/A1 _09471_/A2 _09471_/B1 VDD VDD VSS VSS gf180mcu_fd_sc_mcu7t5v0__nand2_2
X_06675_ _10003_/Q _06674_/Z _06675_/Z VDD VDD VSS VSS gf180mcu_fd_sc_mcu7t5v0__and2_1
X_05626_ _10400_/Q _08777_/B2 VDD VDD VSS VSS gf180mcu_fd_sc_mcu7t5v0__clkinv_1
X_09394_ _06047_/Z _09401_/A2 _09401_/B1 _09394_/B2 _10859_/D VDD VDD
+ VSS VSS gf180mcu_fd_sc_mcu7t5v0__oai22_1
X_08414_ _10416_/Q _08559_/A2 _08589_/B1 _10496_/Q _08417_/A1 VDD VDD
+ VSS VSS gf180mcu_fd_sc_mcu7t5v0__aoi22_1
X_08345_ _08345_/A1 _08345_/A2 _08345_/B1 _08345_/B2 _08345_/C _08347_/A2 VDD
+ VDD VSS VSS gf180mcu_fd_sc_mcu7t5v0__aoi221_2
X_05557_ _10711_/Q _09208_/B2 VDD VDD VSS VSS gf180mcu_fd_sc_mcu7t5v0__clkinv_1
X_05488_ _10958_/Q _09517_/B2 VDD VDD VSS VSS gf180mcu_fd_sc_mcu7t5v0__clkinv_1
X_08276_ _10775_/Q _08560_/A2 _08560_/B1 _10807_/Q _07255_/I _10815_/Q _08278_/A1
+ VDD VDD VSS VSS gf180mcu_fd_sc_mcu7t5v0__aoi222_2
X_07227_ _07227_/A1 _07227_/A2 _07182_/Z _07227_/B2 _07228_/A2 VDD VDD
+ VSS VSS gf180mcu_fd_sc_mcu7t5v0__oai22_1
X_07158_ _07208_/A1 _07144_/Z _07154_/Z _07158_/B2 _07158_/C1 _07246_/A1 _07159_/A2
+ VDD VDD VSS VSS gf180mcu_fd_sc_mcu7t5v0__aoi222_1
X_06109_ _09946_/A1 _06109_/A2 _06109_/B1 _06109_/B2 _09970_/D VDD VDD
+ VSS VSS gf180mcu_fd_sc_mcu7t5v0__oai22_1
X_07089_ _07077_/I _07088_/Z _07139_/A2 VDD VDD VSS VSS gf180mcu_fd_sc_mcu7t5v0__nor2_1
Xclkbuf_leaf_22_clk clkbuf_1_0_0_clk/Z _11101_/CLK VDD VDD VSS VSS
+ gf180mcu_fd_sc_mcu7t5v0__clkbuf_16
X_10505_ _10505_/D _11109_/CLK _10505_/Q VDD VDD VSS VSS gf180mcu_fd_sc_mcu7t5v0__dffq_1
X_10436_ _10436_/D _11017_/CLK _10436_/Q VDD VDD VSS VSS gf180mcu_fd_sc_mcu7t5v0__dffq_1
X_10367_ _10367_/D _11176_/CLK _10367_/Q VDD VDD VSS VSS gf180mcu_fd_sc_mcu7t5v0__dffq_1
X_10298_ _10298_/D _11176_/CLK _10298_/Q VDD VDD VSS VSS gf180mcu_fd_sc_mcu7t5v0__dffq_1
X_06460_ _06460_/A1 _06456_/Z _06473_/A2 VDD VDD VSS VSS gf180mcu_fd_sc_mcu7t5v0__nand2_1
X_05411_ _10146_/Q _07674_/B2 VDD VDD VSS VSS gf180mcu_fd_sc_mcu7t5v0__clkinv_1
Xclkbuf_leaf_13_clk clkbuf_1_1_0_clk/Z _11010_/CLK VDD VDD VSS VSS
+ gf180mcu_fd_sc_mcu7t5v0__clkbuf_16
X_06391_ _10003_/Q _06479_/A2 _06442_/B2 VDD VDD VSS VSS gf180mcu_fd_sc_mcu7t5v0__nand2_1
X_08130_ _08130_/A1 _08130_/A2 _08130_/A3 _08131_/B1 VDD VDD VSS VSS
+ gf180mcu_fd_sc_mcu7t5v0__nand3_1
X_05342_ _10693_/Q _09186_/B2 VDD VDD VSS VSS gf180mcu_fd_sc_mcu7t5v0__clkinv_1
X_08061_ _10356_/Q _08540_/A2 _08590_/B1 _10524_/Q _08591_/C1 _10500_/Q _08062_/A3
+ VDD VDD VSS VSS gf180mcu_fd_sc_mcu7t5v0__aoi222_2
X_05273_ _10364_/Q _08733_/B2 VDD VDD VSS VSS gf180mcu_fd_sc_mcu7t5v0__clkinv_1
X_07012_ _07013_/A1 _06971_/Z _07012_/B _07055_/A2 VDD VDD VSS VSS
+ gf180mcu_fd_sc_mcu7t5v0__oai21_1
X_08963_ _09824_/A1 _08971_/A2 _08971_/B1 VDD VDD VSS VSS gf180mcu_fd_sc_mcu7t5v0__nand2_4
X_07914_ _08644_/A1 _07920_/A2 _07914_/B _10276_/D VDD VDD VSS VSS
+ gf180mcu_fd_sc_mcu7t5v0__aoi21_1
X_08894_ _09871_/A1 _09917_/A2 _08903_/A2 VDD VDD VSS VSS gf180mcu_fd_sc_mcu7t5v0__nand2_4
X_07845_ _09679_/A1 _07853_/A2 _07845_/B _09900_/B _10244_/D VDD VDD VSS
+ VSS gf180mcu_fd_sc_mcu7t5v0__aoi211_1
X_04988_ _11061_/Q _09721_/A1 VDD VDD VSS VSS gf180mcu_fd_sc_mcu7t5v0__clkinv_1
X_07776_ _10209_/Q _07786_/A2 _07777_/B VDD VDD VSS VSS gf180mcu_fd_sc_mcu7t5v0__nand2_1
X_09515_ _09940_/A1 _09521_/A2 _09521_/B1 _09515_/B2 _10956_/D VDD VDD
+ VSS VSS gf180mcu_fd_sc_mcu7t5v0__oai22_1
X_06727_ _06675_/Z _06728_/A2 _06728_/B _06735_/A1 VDD VDD VSS VSS
+ gf180mcu_fd_sc_mcu7t5v0__nor3_1
X_09446_ _09941_/A1 _09451_/A2 _09451_/B1 _09446_/B2 _10901_/D VDD VDD
+ VSS VSS gf180mcu_fd_sc_mcu7t5v0__oai22_1
X_06658_ _06622_/Z _06658_/A2 _06658_/B _06667_/A2 VDD VDD VSS VSS
+ gf180mcu_fd_sc_mcu7t5v0__aoi21_2
X_05609_ _10823_/Q _09348_/B2 VDD VDD VSS VSS gf180mcu_fd_sc_mcu7t5v0__clkinv_1
X_09377_ _06058_/Z _09381_/A2 _09381_/B1 _09377_/B2 _10846_/D VDD VDD
+ VSS VSS gf180mcu_fd_sc_mcu7t5v0__oai22_1
X_06589_ _10043_/Q _06589_/A2 _06589_/B _06661_/A3 VDD VDD VSS VSS
+ gf180mcu_fd_sc_mcu7t5v0__oai21_4
X_08328_ _08345_/A1 _08328_/A2 _08328_/B1 _08345_/B2 _08329_/A2 VDD VDD
+ VSS VSS gf180mcu_fd_sc_mcu7t5v0__aoi22_1
X_08259_ _08259_/A1 _08259_/A2 _08259_/A3 _08269_/B1 VDD VDD VSS VSS
+ gf180mcu_fd_sc_mcu7t5v0__nand3_1
X_10221_ _10221_/D _11147_/CLK _10221_/Q VDD VDD VSS VSS gf180mcu_fd_sc_mcu7t5v0__dffq_1
X_10152_ _10152_/D _11181_/CLK _10152_/Q VDD VDD VSS VSS gf180mcu_fd_sc_mcu7t5v0__dffq_1
X_10083_ _10083_/D _11039_/CLK _10083_/Q VDD VDD VSS VSS gf180mcu_fd_sc_mcu7t5v0__dffq_1
X_10985_ _10985_/D _11010_/CLK _10985_/Q VDD VDD VSS VSS gf180mcu_fd_sc_mcu7t5v0__dffq_1
X_10419_ _10419_/D _11142_/CLK _10419_/Q VDD VDD VSS VSS gf180mcu_fd_sc_mcu7t5v0__dffq_1
X_05960_ _10291_/Q _05942_/Z _09673_/A2 VDD VDD VSS VSS gf180mcu_fd_sc_mcu7t5v0__nand2_1
Xclkbuf_leaf_2_clk clkbuf_1_0_0_clk/Z _10905_/CLK VDD VDD VSS VSS
+ gf180mcu_fd_sc_mcu7t5v0__clkbuf_16
X_05891_ _11181_/Q _09946_/B2 VDD VDD VSS VSS gf180mcu_fd_sc_mcu7t5v0__clkinv_1
X_07630_ _07630_/A1 _07630_/A2 _07631_/A3 VDD VDD VSS VSS gf180mcu_fd_sc_mcu7t5v0__nand2_1
X_07561_ _07562_/A1 _07562_/A2 _07622_/A1 VDD VDD VSS VSS gf180mcu_fd_sc_mcu7t5v0__nor2_1
X_09300_ _09925_/A1 _09301_/A2 _09301_/B1 _09300_/B2 _10785_/D VDD VDD
+ VSS VSS gf180mcu_fd_sc_mcu7t5v0__oai22_1
X_06512_ _09442_/A1 _09861_/A1 _06521_/A2 VDD VDD VSS VSS gf180mcu_fd_sc_mcu7t5v0__nand2_4
X_07492_ _07492_/A1 _07492_/A2 _07492_/B _07542_/A2 VDD VDD VSS VSS
+ gf180mcu_fd_sc_mcu7t5v0__oai21_1
X_09231_ _09832_/A1 _09231_/A2 _09231_/B1 _09231_/B2 _10730_/D VDD VDD
+ VSS VSS gf180mcu_fd_sc_mcu7t5v0__oai22_1
X_06443_ _10004_/Q _06479_/A2 _06480_/B2 VDD VDD VSS VSS gf180mcu_fd_sc_mcu7t5v0__nand2_1
X_06374_ _06460_/A1 _06356_/Z _06374_/B1 _06374_/B2 _06374_/C _06375_/B1 VDD
+ VDD VSS VSS gf180mcu_fd_sc_mcu7t5v0__aoi221_2
X_09162_ _09851_/A1 _08588_/B _09171_/A2 VDD VDD VSS VSS gf180mcu_fd_sc_mcu7t5v0__nand2_4
X_05325_ _10557_/Q _09016_/B2 VDD VDD VSS VSS gf180mcu_fd_sc_mcu7t5v0__clkinv_1
X_08113_ _09900_/A2 _08113_/A2 _08113_/B1 _09332_/A2 _08142_/A1 VDD VDD
+ VSS VSS gf180mcu_fd_sc_mcu7t5v0__aoi22_1
X_09093_ _09413_/A1 _09101_/A2 _09101_/B1 VDD VDD VSS VSS gf180mcu_fd_sc_mcu7t5v0__nand2_4
X_08044_ _10540_/Q _08555_/A2 _08584_/A2 _10572_/Q _08044_/C _08045_/A3 VDD
+ VDD VSS VSS gf180mcu_fd_sc_mcu7t5v0__aoi221_1
X_05256_ _09964_/Q _06103_/B2 VDD VDD VSS VSS gf180mcu_fd_sc_mcu7t5v0__clkinv_1
X_05187_ _10835_/Q _09364_/B2 VDD VDD VSS VSS gf180mcu_fd_sc_mcu7t5v0__clkinv_1
X_09995_ _09995_/D _10327_/CLK _09995_/Q VDD VDD VSS VSS gf180mcu_fd_sc_mcu7t5v0__dffq_2
X_08946_ _09921_/A1 _08951_/A2 _08951_/B1 _08946_/B2 _10501_/D VDD VDD
+ VSS VSS gf180mcu_fd_sc_mcu7t5v0__oai22_1
X_08877_ _09872_/A2 _08877_/A2 _09900_/B _08892_/A2 VDD VDD VSS VSS
+ gf180mcu_fd_sc_mcu7t5v0__aoi21_4
X_07828_ _07829_/C _07828_/A2 _07828_/Z VDD VDD VSS VSS gf180mcu_fd_sc_mcu7t5v0__or2_1
X_07759_ _08347_/A1 _08534_/B2 _09889_/A2 VDD VDD VSS VSS gf180mcu_fd_sc_mcu7t5v0__nor2_4
X_10770_ _10770_/D _11010_/CLK _10770_/Q VDD VDD VSS VSS gf180mcu_fd_sc_mcu7t5v0__dffq_1
X_09429_ _09896_/A1 _09431_/A2 _09431_/B1 _09429_/B2 _10888_/D VDD VDD
+ VSS VSS gf180mcu_fd_sc_mcu7t5v0__oai22_1
X_10204_ _10204_/D _11147_/CLK _10204_/Q VDD VDD VSS VSS gf180mcu_fd_sc_mcu7t5v0__dffq_1
X_11184_ cgra_status[4] VDD VDD VSS VSS gf180mcu_fd_sc_mcu7t5v0__tiel
X_10135_ _10135_/D _11176_/CLK _10135_/Q VDD VDD VSS VSS gf180mcu_fd_sc_mcu7t5v0__dffq_1
X_10066_ _10066_/D _11101_/CLK _10066_/Q VDD VDD VSS VSS gf180mcu_fd_sc_mcu7t5v0__dffq_1
X_10968_ _10968_/D _11181_/CLK _10968_/Q VDD VDD VSS VSS gf180mcu_fd_sc_mcu7t5v0__dffq_1
X_10899_ _10899_/D _11181_/CLK _10899_/Q VDD VDD VSS VSS gf180mcu_fd_sc_mcu7t5v0__dffq_1
X_05110_ _10531_/Q _08984_/B2 VDD VDD VSS VSS gf180mcu_fd_sc_mcu7t5v0__clkinv_1
X_06090_ _06061_/Z _06093_/A2 _06093_/B1 _06090_/B2 _09959_/D VDD VDD
+ VSS VSS gf180mcu_fd_sc_mcu7t5v0__oai22_1
X_05041_ _10077_/Q _06953_/A3 VDD VDD VSS VSS gf180mcu_fd_sc_mcu7t5v0__inv_3
X_08800_ _09645_/A2 _09662_/A2 _08809_/A2 VDD VDD VSS VSS gf180mcu_fd_sc_mcu7t5v0__nand2_4
X_09780_ _11091_/Q _09795_/A2 _09809_/B _09781_/B VDD VDD VSS VSS
+ gf180mcu_fd_sc_mcu7t5v0__oai21_1
X_06992_ _10325_/Q _10080_/Q _07122_/B _06994_/B1 VDD VDD VSS VSS
+ gf180mcu_fd_sc_mcu7t5v0__oai21_2
X_08731_ _09193_/A1 _08739_/A2 _08739_/B1 VDD VDD VSS VSS gf180mcu_fd_sc_mcu7t5v0__nand2_2
X_05943_ _09900_/B _05942_/Z _08830_/B VDD VDD VSS VSS gf180mcu_fd_sc_mcu7t5v0__nor2_2
X_08662_ _10281_/Q _08675_/A2 _08672_/B _08663_/B VDD VDD VSS VSS
+ gf180mcu_fd_sc_mcu7t5v0__oai21_1
X_05874_ _10410_/Q _08789_/B2 VDD VDD VSS VSS gf180mcu_fd_sc_mcu7t5v0__clkinv_1
X_07613_ _07617_/A2 _07613_/A2 _07613_/A3 _07613_/Z VDD VDD VSS VSS
+ gf180mcu_fd_sc_mcu7t5v0__xor3_1
X_08593_ _09823_/A2 _08593_/A2 _08593_/B1 _09662_/A2 _08594_/A2 VDD VDD
+ VSS VSS gf180mcu_fd_sc_mcu7t5v0__aoi22_1
X_07544_ _10005_/Q _07325_/B _07632_/I1 _07545_/A2 _07633_/C _07545_/B VDD VDD
+ VSS VSS gf180mcu_fd_sc_mcu7t5v0__aoi221_1
X_07475_ _07467_/Z _07507_/A3 _07475_/Z VDD VDD VSS VSS gf180mcu_fd_sc_mcu7t5v0__xor2_1
X_06426_ _06426_/A1 _06426_/A2 _07603_/B _10013_/D VDD VDD VSS VSS
+ gf180mcu_fd_sc_mcu7t5v0__aoi21_1
X_09214_ _06047_/Z _09221_/A2 _09221_/B1 _09214_/B2 _10715_/D VDD VDD
+ VSS VSS gf180mcu_fd_sc_mcu7t5v0__oai22_1
X_09145_ _09940_/A1 _09151_/A2 _09151_/B1 _09145_/B2 _10660_/D VDD VDD
+ VSS VSS gf180mcu_fd_sc_mcu7t5v0__oai22_1
X_06357_ _10012_/Q _06356_/Z _06379_/B VDD VDD VSS VSS gf180mcu_fd_sc_mcu7t5v0__nand2_1
X_05308_ _10397_/Q _08774_/B2 VDD VDD VSS VSS gf180mcu_fd_sc_mcu7t5v0__clkinv_1
X_09076_ _09941_/A1 _09081_/A2 _09081_/B1 _09076_/B2 _10605_/D VDD VDD
+ VSS VSS gf180mcu_fd_sc_mcu7t5v0__oai22_1
X_06288_ _10002_/Q _06505_/B _06288_/B1 _06505_/A1 _06327_/B _06289_/C VDD VDD
+ VSS VSS gf180mcu_fd_sc_mcu7t5v0__aoi221_1
X_08027_ _09988_/Q _08540_/A2 _08877_/A2 _10460_/Q _08029_/A3 VDD VDD
+ VSS VSS gf180mcu_fd_sc_mcu7t5v0__aoi22_1
X_05239_ _10708_/Q _09205_/B2 VDD VDD VSS VSS gf180mcu_fd_sc_mcu7t5v0__clkinv_1
X_09978_ _09978_/D _11082_/CLK _09978_/Q VDD VDD VSS VSS gf180mcu_fd_sc_mcu7t5v0__dffq_1
X_08929_ _09924_/A1 _08931_/A2 _08931_/B1 _08929_/B2 _10488_/D VDD VDD
+ VSS VSS gf180mcu_fd_sc_mcu7t5v0__oai22_1
X_10822_ _10822_/D _11142_/CLK _10822_/Q VDD VDD VSS VSS gf180mcu_fd_sc_mcu7t5v0__dffq_1
X_10753_ _10753_/D _11149_/CLK _10753_/Q VDD VDD VSS VSS gf180mcu_fd_sc_mcu7t5v0__dffq_1
X_10684_ _10684_/D _10905_/CLK _10684_/Q VDD VDD VSS VSS gf180mcu_fd_sc_mcu7t5v0__dffq_1
X_11167_ _11167_/D _11181_/CLK _11167_/Q VDD VDD VSS VSS gf180mcu_fd_sc_mcu7t5v0__dffq_1
X_10118_ _10118_/D _11150_/CLK _10118_/Q VDD VDD VSS VSS gf180mcu_fd_sc_mcu7t5v0__dffq_4
X_11098_ _11098_/D _11101_/CLK _11098_/Q VDD VDD VSS VSS gf180mcu_fd_sc_mcu7t5v0__dffq_1
X_10049_ _10049_/D _11150_/CLK _10049_/Q VDD VDD VSS VSS gf180mcu_fd_sc_mcu7t5v0__dffq_1
X_05590_ _10020_/Q _06518_/B2 VDD VDD VSS VSS gf180mcu_fd_sc_mcu7t5v0__clkinv_1
X_07260_ _10090_/Q _07274_/A2 _07261_/B VDD VDD VSS VSS gf180mcu_fd_sc_mcu7t5v0__nand2_1
X_06211_ _09996_/Q _09995_/Q _06470_/A1 VDD VDD VSS VSS gf180mcu_fd_sc_mcu7t5v0__nand2_4
X_07191_ _07191_/A1 _07189_/Z _07193_/B VDD VDD VSS VSS gf180mcu_fd_sc_mcu7t5v0__xor2_1
X_06142_ _09925_/A1 _06144_/A2 _06142_/B _09985_/D VDD VDD VSS VSS
+ gf180mcu_fd_sc_mcu7t5v0__oai21_1
X_06073_ _10126_/Q cgra_status[0] _06073_/B _09916_/A1 VDD VDD VSS VSS
+ gf180mcu_fd_sc_mcu7t5v0__aoi21_4
X_09901_ _11150_/Q _09915_/A2 _09902_/B VDD VDD VSS VSS gf180mcu_fd_sc_mcu7t5v0__nand2_1
X_05024_ _10259_/Q _07878_/A1 VDD VDD VSS VSS gf180mcu_fd_sc_mcu7t5v0__clkinv_1
X_09832_ _09832_/A1 _09832_/A2 _09832_/B1 _09832_/B2 _11109_/D VDD VDD
+ VSS VSS gf180mcu_fd_sc_mcu7t5v0__oai22_1
X_09763_ _11077_/Q _09760_/Z _09763_/Z VDD VDD VSS VSS gf180mcu_fd_sc_mcu7t5v0__and2_1
X_08714_ _09893_/A1 _08719_/A2 _08719_/B1 _08714_/B2 _10349_/D VDD VDD
+ VSS VSS gf180mcu_fd_sc_mcu7t5v0__oai22_1
X_06975_ _07247_/I1 _07003_/A2 _07206_/C _06981_/A2 VDD VDD VSS VSS
+ gf180mcu_fd_sc_mcu7t5v0__aoi21_1
X_05926_ _10818_/Q _09341_/B2 VDD VDD VSS VSS gf180mcu_fd_sc_mcu7t5v0__clkinv_1
X_09694_ _11055_/Q _09678_/Z rst_n _09697_/A1 VDD VDD VSS VSS gf180mcu_fd_sc_mcu7t5v0__oai21_1
X_05857_ _10578_/Q _09041_/B2 VDD VDD VSS VSS gf180mcu_fd_sc_mcu7t5v0__clkinv_1
X_08645_ _10269_/Q _08657_/A2 _08657_/B1 _10262_/Q _08645_/C _08647_/A2 VDD
+ VDD VSS VSS gf180mcu_fd_sc_mcu7t5v0__aoi221_1
X_08576_ _10746_/Q _08590_/A2 _08576_/B1 _11002_/Q _08578_/A2 VDD VDD
+ VSS VSS gf180mcu_fd_sc_mcu7t5v0__aoi22_1
X_05788_ _11148_/Q _09897_/B2 VDD VDD VSS VSS gf180mcu_fd_sc_mcu7t5v0__clkinv_1
X_07527_ _07564_/A1 _07526_/Z _07527_/Z VDD VDD VSS VSS gf180mcu_fd_sc_mcu7t5v0__xor2_1
X_07458_ _07594_/A1 _07450_/Z _07492_/A2 _07458_/B _07459_/B VDD VDD VSS
+ VSS gf180mcu_fd_sc_mcu7t5v0__oai31_1
X_07389_ _10120_/Q _07636_/B _07390_/B VDD VDD VSS VSS gf180mcu_fd_sc_mcu7t5v0__nor2_1
X_06409_ _07124_/A1 _06411_/A2 _06428_/B VDD VDD VSS VSS gf180mcu_fd_sc_mcu7t5v0__nor2_1
X_09128_ _06061_/Z _09131_/A2 _09131_/B1 _09128_/B2 _10647_/D VDD VDD
+ VSS VSS gf180mcu_fd_sc_mcu7t5v0__oai22_1
X_09059_ _09944_/A1 _09061_/A2 _09061_/B1 _09059_/B2 _10592_/D VDD VDD
+ VSS VSS gf180mcu_fd_sc_mcu7t5v0__oai22_1
X_11021_ _11021_/D _11164_/CLK _11021_/Q VDD VDD VSS VSS gf180mcu_fd_sc_mcu7t5v0__dffq_1
X_10805_ _10805_/D _11010_/CLK _10805_/Q VDD VDD VSS VSS gf180mcu_fd_sc_mcu7t5v0__dffq_1
X_10736_ _10736_/D _11142_/CLK _10736_/Q VDD VDD VSS VSS gf180mcu_fd_sc_mcu7t5v0__dffq_1
X_10667_ _10667_/D _11139_/CLK _10667_/Q VDD VDD VSS VSS gf180mcu_fd_sc_mcu7t5v0__dffq_1
X_10598_ _10598_/D _10666_/CLK _10598_/Q VDD VDD VSS VSS gf180mcu_fd_sc_mcu7t5v0__dffq_1
X_06760_ _06740_/B _06760_/A2 _06760_/B _06787_/B VDD VDD VSS VSS
+ gf180mcu_fd_sc_mcu7t5v0__oai21_1
X_05711_ _10792_/Q _09309_/B2 VDD VDD VSS VSS gf180mcu_fd_sc_mcu7t5v0__clkinv_1
X_06691_ _06691_/A1 _10012_/Q _06691_/B _06692_/B2 VDD VDD VSS VSS
+ gf180mcu_fd_sc_mcu7t5v0__oai21_2
X_05642_ _10552_/Q _09009_/B2 VDD VDD VSS VSS gf180mcu_fd_sc_mcu7t5v0__clkinv_1
X_08430_ _08430_/A1 _08430_/A2 _08514_/B _08431_/I VDD VDD VSS VSS
+ gf180mcu_fd_sc_mcu7t5v0__oai21_1
X_05573_ _11178_/Q _09943_/B2 VDD VDD VSS VSS gf180mcu_fd_sc_mcu7t5v0__clkinv_1
X_08361_ _10058_/Q _06877_/Z _08532_/A2 _11171_/Q _08563_/C1 _11179_/Q _08363_/A2
+ VDD VDD VSS VSS gf180mcu_fd_sc_mcu7t5v0__aoi222_2
X_08292_ _11106_/Q _08559_/A2 _08589_/B1 _10895_/Q _08576_/B1 _10535_/Q _08294_/A1
+ VDD VDD VSS VSS gf180mcu_fd_sc_mcu7t5v0__aoi222_2
X_07312_ _10239_/Q _08675_/A2 _08674_/B _07313_/B VDD VDD VSS VSS
+ gf180mcu_fd_sc_mcu7t5v0__oai21_1
X_07243_ _07199_/B _07243_/A2 _07244_/A2 VDD VDD VSS VSS gf180mcu_fd_sc_mcu7t5v0__nand2_1
X_07174_ _07231_/A1 _07231_/A2 _07174_/Z VDD VDD VSS VSS gf180mcu_fd_sc_mcu7t5v0__xor2_1
X_06125_ _06125_/I _08587_/B1 VDD VDD VSS VSS gf180mcu_fd_sc_mcu7t5v0__clkinv_3
X_06056_ _06074_/A1 _09921_/A1 _06056_/B _09949_/D VDD VDD VSS VSS
+ gf180mcu_fd_sc_mcu7t5v0__oai21_1
X_05007_ bus_wdata[2] _07860_/A1 VDD VDD VSS VSS gf180mcu_fd_sc_mcu7t5v0__inv_1
X_09815_ _11099_/Q _09815_/A2 _09816_/I VDD VDD VSS VSS gf180mcu_fd_sc_mcu7t5v0__nand2_1
X_09746_ _09751_/A1 _09745_/Z _11071_/D VDD VDD VSS VSS gf180mcu_fd_sc_mcu7t5v0__nor2_1
X_06958_ _06991_/A1 _06958_/A2 _06959_/A3 VDD VDD VSS VSS gf180mcu_fd_sc_mcu7t5v0__nor2_1
X_05909_ _10370_/Q _08739_/B2 VDD VDD VSS VSS gf180mcu_fd_sc_mcu7t5v0__clkinv_1
X_09677_ _09720_/A2 _09718_/A2 _09716_/A2 VDD VDD VSS VSS gf180mcu_fd_sc_mcu7t5v0__nand2_1
X_06889_ _09946_/A1 _06889_/A2 _06889_/B1 _06889_/B2 _10060_/D VDD VDD
+ VSS VSS gf180mcu_fd_sc_mcu7t5v0__oai22_1
X_08628_ _08628_/A1 _08628_/A2 _09900_/B _10315_/D VDD VDD VSS VSS
+ gf180mcu_fd_sc_mcu7t5v0__aoi21_1
X_08559_ _11034_/Q _08559_/A2 _08589_/B1 _10134_/Q _08562_/A1 VDD VDD
+ VSS VSS gf180mcu_fd_sc_mcu7t5v0__aoi22_1
X_10521_ _10521_/D _11109_/CLK _10521_/Q VDD VDD VSS VSS gf180mcu_fd_sc_mcu7t5v0__dffq_1
X_10452_ _10452_/D _11101_/CLK _10452_/Q VDD VDD VSS VSS gf180mcu_fd_sc_mcu7t5v0__dffq_1
X_10383_ _10383_/D _11017_/CLK _10383_/Q VDD VDD VSS VSS gf180mcu_fd_sc_mcu7t5v0__dffq_1
X_11004_ _11004_/D _11010_/CLK _11004_/Q VDD VDD VSS VSS gf180mcu_fd_sc_mcu7t5v0__dffq_1
X_10719_ _10719_/D _11052_/CLK _10719_/Q VDD VDD VSS VSS gf180mcu_fd_sc_mcu7t5v0__dffq_1
X_07930_ _10571_/Q _08584_/A2 _08563_/C1 _10579_/Q _08564_/C1 _10563_/Q _07931_/A3
+ VDD VDD VSS VSS gf180mcu_fd_sc_mcu7t5v0__aoi222_2
X_07861_ _10252_/Q _07864_/A2 _07862_/B VDD VDD VSS VSS gf180mcu_fd_sc_mcu7t5v0__nor2_1
X_07792_ _09893_/A1 _07797_/A2 _07797_/B1 _07792_/B2 _10217_/D VDD VDD
+ VSS VSS gf180mcu_fd_sc_mcu7t5v0__oai22_1
X_09600_ _06047_/Z _09607_/A2 _09607_/B1 _09600_/B2 _11011_/D VDD VDD
+ VSS VSS gf180mcu_fd_sc_mcu7t5v0__oai22_1
X_06812_ _06813_/A1 _06813_/A2 _06841_/B VDD VDD VSS VSS gf180mcu_fd_sc_mcu7t5v0__nand2_1
X_09531_ _06058_/Z _09539_/A2 _09531_/B _10966_/D VDD VDD VSS VSS
+ gf180mcu_fd_sc_mcu7t5v0__oai21_1
X_06743_ _06743_/A1 _06743_/A2 _06847_/A2 VDD VDD VSS VSS gf180mcu_fd_sc_mcu7t5v0__nand2_2
X_09462_ _09645_/A2 _09861_/A2 _09471_/A2 VDD VDD VSS VSS gf180mcu_fd_sc_mcu7t5v0__nand2_4
X_06674_ _06854_/A2 _06723_/A1 _06674_/Z VDD VDD VSS VSS gf180mcu_fd_sc_mcu7t5v0__xor2_1
X_05625_ _10180_/Q _07736_/B2 VDD VDD VSS VSS gf180mcu_fd_sc_mcu7t5v0__clkinv_1
X_09393_ _08514_/B _09401_/A2 _09401_/B1 VDD VDD VSS VSS gf180mcu_fd_sc_mcu7t5v0__nand2_4
X_08413_ _08413_/A1 _08413_/A2 _08413_/A3 _08413_/A4 _08418_/A2 VDD VDD
+ VSS VSS gf180mcu_fd_sc_mcu7t5v0__nand4_2
X_08344_ _08533_/B2 _08344_/A2 _08344_/B1 _08533_/A1 _08345_/C VDD VDD
+ VSS VSS gf180mcu_fd_sc_mcu7t5v0__oai22_1
X_05556_ _10407_/Q _08786_/B2 VDD VDD VSS VSS gf180mcu_fd_sc_mcu7t5v0__clkinv_1
X_05487_ _10974_/Q _09545_/B2 VDD VDD VSS VSS gf180mcu_fd_sc_mcu7t5v0__clkinv_1
X_08275_ _08327_/A1 _08275_/A2 _08348_/C VDD VDD VSS VSS gf180mcu_fd_sc_mcu7t5v0__nand2_1
X_07226_ _10002_/Q _07226_/A2 _07228_/A1 VDD VDD VSS VSS gf180mcu_fd_sc_mcu7t5v0__nand2_1
X_07157_ _07207_/A1 _07157_/A2 _07157_/B _07158_/B2 VDD VDD VSS VSS
+ gf180mcu_fd_sc_mcu7t5v0__oai21_1
X_06108_ _09945_/A1 _06109_/A2 _06109_/B1 _06108_/B2 _09969_/D VDD VDD
+ VSS VSS gf180mcu_fd_sc_mcu7t5v0__oai22_1
X_07088_ _07090_/A2 _07086_/B _07088_/Z VDD VDD VSS VSS gf180mcu_fd_sc_mcu7t5v0__xor2_1
X_06039_ _10319_/Q bus_addr[3] _08619_/B _06040_/I VDD VDD VSS VSS
+ gf180mcu_fd_sc_mcu7t5v0__mux2_4
X_09729_ _09795_/A2 _09729_/A2 _09900_/B _11066_/D VDD VDD VSS VSS
+ gf180mcu_fd_sc_mcu7t5v0__aoi21_1
X_10504_ _10504_/D _11109_/CLK _10504_/Q VDD VDD VSS VSS gf180mcu_fd_sc_mcu7t5v0__dffq_1
X_10435_ _10435_/D _11164_/CLK _10435_/Q VDD VDD VSS VSS gf180mcu_fd_sc_mcu7t5v0__dffq_1
X_10366_ _10366_/D _11176_/CLK _10366_/Q VDD VDD VSS VSS gf180mcu_fd_sc_mcu7t5v0__dffq_1
X_10297_ _10297_/D _11176_/CLK _10297_/Q VDD VDD VSS VSS gf180mcu_fd_sc_mcu7t5v0__dffq_1
X_05410_ _10430_/Q _08815_/B2 VDD VDD VSS VSS gf180mcu_fd_sc_mcu7t5v0__clkinv_1
X_06390_ _06286_/I _06390_/A2 _06395_/A1 _06390_/B2 _06398_/A1 VDD VDD
+ VSS VSS gf180mcu_fd_sc_mcu7t5v0__oai22_2
X_05341_ _10685_/Q _09176_/B2 VDD VDD VSS VSS gf180mcu_fd_sc_mcu7t5v0__clkinv_1
X_08060_ _10508_/Q _08591_/A2 _08576_/B1 _10532_/Q _08062_/A2 VDD VDD
+ VSS VSS gf180mcu_fd_sc_mcu7t5v0__aoi22_1
X_05272_ _10017_/Q _06515_/B2 VDD VDD VSS VSS gf180mcu_fd_sc_mcu7t5v0__clkinv_1
X_07011_ _10002_/Q _07221_/A2 _07011_/A3 _07012_/B VDD VDD VSS VSS
+ gf180mcu_fd_sc_mcu7t5v0__xor3_1
X_08962_ _09937_/A2 _09823_/A2 _08971_/A2 VDD VDD VSS VSS gf180mcu_fd_sc_mcu7t5v0__nand2_4
X_08893_ _09916_/A1 _08893_/A2 _08893_/B _10466_/D VDD VDD VSS VSS
+ gf180mcu_fd_sc_mcu7t5v0__oai21_1
X_07913_ bus_wdata[3] _07920_/A2 _08658_/B _07914_/B VDD VDD VSS VSS
+ gf180mcu_fd_sc_mcu7t5v0__oai21_1
X_07844_ _10244_/Q _07853_/A2 _07845_/B VDD VDD VSS VSS gf180mcu_fd_sc_mcu7t5v0__nor2_1
X_04987_ _11062_/Q _09722_/B2 VDD VDD VSS VSS gf180mcu_fd_sc_mcu7t5v0__clkinv_1
X_07775_ _09940_/A1 _07787_/A2 _07775_/B _10208_/D VDD VDD VSS VSS
+ gf180mcu_fd_sc_mcu7t5v0__oai21_1
X_09514_ _06047_/Z _09521_/A2 _09521_/B1 _09514_/B2 _10955_/D VDD VDD
+ VSS VSS gf180mcu_fd_sc_mcu7t5v0__oai22_1
X_06726_ _10004_/Q _06726_/A2 _06728_/B VDD VDD VSS VSS gf180mcu_fd_sc_mcu7t5v0__xor2_1
X_09445_ _09940_/A1 _09451_/A2 _09451_/B1 _09445_/B2 _10900_/D VDD VDD
+ VSS VSS gf180mcu_fd_sc_mcu7t5v0__oai22_1
X_06657_ _06657_/I _06696_/A2 VDD VDD VSS VSS gf180mcu_fd_sc_mcu7t5v0__inv_1
X_05608_ _10815_/Q _09338_/B2 VDD VDD VSS VSS gf180mcu_fd_sc_mcu7t5v0__clkinv_1
X_09376_ _09893_/A1 _09381_/A2 _09381_/B1 _09376_/B2 _10845_/D VDD VDD
+ VSS VSS gf180mcu_fd_sc_mcu7t5v0__oai22_1
X_06588_ _10332_/Q _10044_/Q _06589_/B VDD VDD VSS VSS gf180mcu_fd_sc_mcu7t5v0__nand2_1
X_05539_ _10575_/Q _09038_/B2 VDD VDD VSS VSS gf180mcu_fd_sc_mcu7t5v0__clkinv_1
X_08327_ _08327_/A1 _08327_/A2 _08327_/B1 _08327_/B2 _08329_/A1 VDD VDD
+ VSS VSS gf180mcu_fd_sc_mcu7t5v0__aoi22_1
X_08258_ _10670_/Q _08563_/A2 _08532_/A2 _10718_/Q _08259_/A3 VDD VDD
+ VSS VSS gf180mcu_fd_sc_mcu7t5v0__aoi22_1
X_07209_ _07019_/C _07209_/A2 _07211_/B1 VDD VDD VSS VSS gf180mcu_fd_sc_mcu7t5v0__nand2_1
X_10220_ _10220_/D _11147_/CLK _10220_/Q VDD VDD VSS VSS gf180mcu_fd_sc_mcu7t5v0__dffq_1
X_08189_ _10064_/Q _08530_/A2 _08528_/B1 _09974_/Q _08564_/C1 _10027_/Q _08190_/A2
+ VDD VDD VSS VSS gf180mcu_fd_sc_mcu7t5v0__aoi222_1
X_10151_ _10151_/D _10905_/CLK _10151_/Q VDD VDD VSS VSS gf180mcu_fd_sc_mcu7t5v0__dffq_1
X_10082_ _10082_/D _11039_/CLK _10082_/Q VDD VDD VSS VSS gf180mcu_fd_sc_mcu7t5v0__dffq_2
X_10984_ _10984_/D _11039_/CLK _10984_/Q VDD VDD VSS VSS gf180mcu_fd_sc_mcu7t5v0__dffq_1
X_10418_ _10418_/D _11165_/CLK _10418_/Q VDD VDD VSS VSS gf180mcu_fd_sc_mcu7t5v0__dffq_1
X_10349_ _10349_/D _11149_/CLK _10349_/Q VDD VDD VSS VSS gf180mcu_fd_sc_mcu7t5v0__dffq_1
X_05890_ _09978_/Q _06123_/B2 VDD VDD VSS VSS gf180mcu_fd_sc_mcu7t5v0__clkinv_1
X_07560_ _07560_/A1 _07560_/A2 _07562_/A2 VDD VDD VSS VSS gf180mcu_fd_sc_mcu7t5v0__nor2_1
X_06511_ _06511_/A1 _07601_/B _06511_/B1 _06511_/B2 _07603_/B _10015_/D VDD
+ VDD VSS VSS gf180mcu_fd_sc_mcu7t5v0__aoi221_1
X_09230_ _09897_/A1 _09231_/A2 _09231_/B1 _09230_/B2 _10729_/D VDD VDD
+ VSS VSS gf180mcu_fd_sc_mcu7t5v0__oai22_1
X_07491_ _07492_/A1 _07492_/A2 _07492_/B _07499_/A1 VDD VDD VSS VSS
+ gf180mcu_fd_sc_mcu7t5v0__nor3_1
X_06442_ _06442_/A1 _06447_/A1 _06394_/Z _06442_/B2 _06450_/A2 VDD VDD
+ VSS VSS gf180mcu_fd_sc_mcu7t5v0__oai22_2
X_06373_ _07470_/A1 _06338_/Z _06373_/B1 _06373_/B2 _06374_/C VDD VDD
+ VSS VSS gf180mcu_fd_sc_mcu7t5v0__aoi22_1
X_09161_ _09946_/A1 _09161_/A2 _09161_/B1 _09161_/B2 _10674_/D VDD VDD
+ VSS VSS gf180mcu_fd_sc_mcu7t5v0__oai22_1
X_05324_ _10549_/Q _09006_/B2 VDD VDD VSS VSS gf180mcu_fd_sc_mcu7t5v0__clkinv_1
X_09092_ _09502_/A1 _09142_/A2 _09101_/A2 VDD VDD VSS VSS gf180mcu_fd_sc_mcu7t5v0__nand2_4
X_08112_ _08112_/A1 _08112_/A2 _08112_/A3 _08113_/B1 VDD VDD VSS VSS
+ gf180mcu_fd_sc_mcu7t5v0__nand3_2
X_08043_ _09015_/B2 _08585_/A2 _08581_/A2 _09005_/B2 _08044_/C VDD VDD
+ VSS VSS gf180mcu_fd_sc_mcu7t5v0__oai22_1
X_05255_ _11175_/Q _09940_/B2 VDD VDD VSS VSS gf180mcu_fd_sc_mcu7t5v0__clkinv_1
X_05186_ _10827_/Q _09354_/B2 VDD VDD VSS VSS gf180mcu_fd_sc_mcu7t5v0__clkinv_1
X_09994_ _09994_/D _11163_/CLK _09994_/Q VDD VDD VSS VSS gf180mcu_fd_sc_mcu7t5v0__dffq_1
X_08945_ _09904_/A1 _08951_/A2 _08951_/B1 _08945_/B2 _10500_/D VDD VDD
+ VSS VSS gf180mcu_fd_sc_mcu7t5v0__oai22_1
X_08876_ _09872_/A2 _08877_/A2 _08893_/A2 VDD VDD VSS VSS gf180mcu_fd_sc_mcu7t5v0__nand2_4
X_07827_ bus_addr[6] _07827_/A2 bus_addr[5] _07828_/A2 VDD VDD VSS VSS
+ gf180mcu_fd_sc_mcu7t5v0__aoi21_1
X_07758_ _09946_/A1 _07758_/A2 _07758_/B1 _07758_/B2 _10198_/D VDD VDD
+ VSS VSS gf180mcu_fd_sc_mcu7t5v0__oai22_1
X_06709_ _06698_/I _06710_/A2 _06760_/A2 VDD VDD VSS VSS gf180mcu_fd_sc_mcu7t5v0__nor2_1
X_07689_ _09529_/A1 _07699_/A2 _07689_/B _10153_/D VDD VDD VSS VSS
+ gf180mcu_fd_sc_mcu7t5v0__oai21_1
X_09428_ _06061_/Z _09431_/A2 _09431_/B1 _09428_/B2 _10887_/D VDD VDD
+ VSS VSS gf180mcu_fd_sc_mcu7t5v0__oai22_1
X_09359_ _09896_/A1 _09361_/A2 _09361_/B1 _09359_/B2 _10832_/D VDD VDD
+ VSS VSS gf180mcu_fd_sc_mcu7t5v0__oai22_1
X_10203_ _10203_/D _11147_/CLK _10203_/Q VDD VDD VSS VSS gf180mcu_fd_sc_mcu7t5v0__dffq_1
X_11183_ cgra_status[3] VDD VDD VSS VSS gf180mcu_fd_sc_mcu7t5v0__tiel
X_10134_ _10134_/D _11164_/CLK _10134_/Q VDD VDD VSS VSS gf180mcu_fd_sc_mcu7t5v0__dffq_1
X_10065_ _10065_/D _11181_/CLK _10065_/Q VDD VDD VSS VSS gf180mcu_fd_sc_mcu7t5v0__dffq_1
X_10967_ _10967_/D _11181_/CLK _10967_/Q VDD VDD VSS VSS gf180mcu_fd_sc_mcu7t5v0__dffq_1
X_10898_ _10898_/D _11109_/CLK _10898_/Q VDD VDD VSS VSS gf180mcu_fd_sc_mcu7t5v0__dffq_1
X_05040_ _10078_/Q _06942_/A1 VDD VDD VSS VSS gf180mcu_fd_sc_mcu7t5v0__inv_1
X_06991_ _06991_/A1 _06985_/Z _06991_/B _07024_/A1 VDD VDD VSS VSS
+ gf180mcu_fd_sc_mcu7t5v0__aoi21_1
X_08730_ _09442_/A1 _09927_/A2 _08739_/A2 VDD VDD VSS VSS gf180mcu_fd_sc_mcu7t5v0__nand2_4
X_05942_ _05942_/A1 _05942_/A2 _05942_/A3 _05942_/A4 _05942_/Z VDD VDD
+ VSS VSS gf180mcu_fd_sc_mcu7t5v0__and4_1
X_05873_ _10706_/Q _09201_/B2 VDD VDD VSS VSS gf180mcu_fd_sc_mcu7t5v0__clkinv_1
X_08661_ _08661_/A1 _08675_/A2 _08661_/B _10323_/D VDD VDD VSS VSS
+ gf180mcu_fd_sc_mcu7t5v0__aoi21_1
X_07612_ _07614_/A2 _07612_/A2 _07612_/A3 _07613_/A3 VDD VDD VSS VSS
+ gf180mcu_fd_sc_mcu7t5v0__xnor3_1
X_08592_ _08592_/A1 _08592_/A2 _08592_/A3 _08595_/B1 VDD VDD VSS VSS
+ gf180mcu_fd_sc_mcu7t5v0__nand3_1
X_07543_ _10005_/Q _07508_/Z _07545_/A2 VDD VDD VSS VSS gf180mcu_fd_sc_mcu7t5v0__nand2_1
X_07474_ _07507_/B2 _07507_/B1 _07507_/A3 VDD VDD VSS VSS gf180mcu_fd_sc_mcu7t5v0__xnor2_1
X_06425_ _06327_/B _06425_/A2 _06425_/A3 _06425_/B _06426_/A2 VDD VDD
+ VSS VSS gf180mcu_fd_sc_mcu7t5v0__oai31_1
X_09213_ _08658_/B _09221_/A2 _09221_/B1 VDD VDD VSS VSS gf180mcu_fd_sc_mcu7t5v0__nand2_2
X_09144_ _06047_/Z _09151_/A2 _09151_/B1 _09144_/B2 _10659_/D VDD VDD
+ VSS VSS gf180mcu_fd_sc_mcu7t5v0__oai22_1
X_06356_ _06311_/Z _06354_/Z _06356_/Z VDD VDD VSS VSS gf180mcu_fd_sc_mcu7t5v0__xor2_2
X_05307_ _10177_/Q _07733_/B2 VDD VDD VSS VSS gf180mcu_fd_sc_mcu7t5v0__clkinv_1
X_09075_ _09940_/A1 _09081_/A2 _09081_/B1 _09075_/B2 _10604_/D VDD VDD
+ VSS VSS gf180mcu_fd_sc_mcu7t5v0__oai22_1
X_06287_ _06372_/B2 _06286_/I _06372_/C _06289_/B2 VDD VDD VSS VSS
+ gf180mcu_fd_sc_mcu7t5v0__aoi21_1
X_08026_ _11151_/Q _08560_/B1 _09872_/A1 _11135_/Q _08029_/A2 VDD VDD
+ VSS VSS gf180mcu_fd_sc_mcu7t5v0__aoi22_1
X_05238_ _10404_/Q _08783_/B2 VDD VDD VSS VSS gf180mcu_fd_sc_mcu7t5v0__clkinv_1
X_05169_ _10971_/Q _09542_/B2 VDD VDD VSS VSS gf180mcu_fd_sc_mcu7t5v0__clkinv_1
X_09977_ _09977_/D _11181_/CLK _09977_/Q VDD VDD VSS VSS gf180mcu_fd_sc_mcu7t5v0__dffq_1
X_08928_ _06061_/Z _08931_/A2 _08931_/B1 _08928_/B2 _10487_/D VDD VDD
+ VSS VSS gf180mcu_fd_sc_mcu7t5v0__oai22_1
X_08859_ _10453_/Q _08856_/Z _08859_/Z VDD VDD VSS VSS gf180mcu_fd_sc_mcu7t5v0__and2_1
X_10821_ _10821_/D _11142_/CLK _10821_/Q VDD VDD VSS VSS gf180mcu_fd_sc_mcu7t5v0__dffq_1
X_10752_ _10752_/D _10978_/CLK _10752_/Q VDD VDD VSS VSS gf180mcu_fd_sc_mcu7t5v0__dffq_1
X_10683_ _10683_/D _10905_/CLK _10683_/Q VDD VDD VSS VSS gf180mcu_fd_sc_mcu7t5v0__dffq_1
X_11166_ _11166_/D _11181_/CLK _11166_/Q VDD VDD VSS VSS gf180mcu_fd_sc_mcu7t5v0__dffq_1
X_11097_ _11097_/D _11097_/CLK _11097_/Q VDD VDD VSS VSS gf180mcu_fd_sc_mcu7t5v0__dffq_1
X_10117_ _10117_/D _10327_/CLK _10117_/Q VDD VDD VSS VSS gf180mcu_fd_sc_mcu7t5v0__dffq_4
X_10048_ _10048_/D _11150_/CLK _10048_/Q VDD VDD VSS VSS gf180mcu_fd_sc_mcu7t5v0__dffq_2
X_06210_ _09997_/Q _09996_/Q _06237_/A2 VDD VDD VSS VSS gf180mcu_fd_sc_mcu7t5v0__nor2_1
X_07190_ _07191_/A1 _07189_/Z _07235_/A2 VDD VDD VSS VSS gf180mcu_fd_sc_mcu7t5v0__nand2_1
X_06141_ _09985_/Q _06143_/A2 _06142_/B VDD VDD VSS VSS gf180mcu_fd_sc_mcu7t5v0__nand2_1
X_06072_ bus_wdata[7] _08619_/B _06073_/B VDD VDD VSS VSS gf180mcu_fd_sc_mcu7t5v0__and2_1
X_09900_ _09900_/A1 _09900_/A2 _09900_/B _09915_/A2 VDD VDD VSS VSS
+ gf180mcu_fd_sc_mcu7t5v0__aoi21_4
X_05023_ _10260_/Q _07880_/A1 VDD VDD VSS VSS gf180mcu_fd_sc_mcu7t5v0__clkinv_1
X_09831_ _09925_/A1 _09832_/A2 _09832_/B1 _09831_/B2 _11108_/D VDD VDD
+ VSS VSS gf180mcu_fd_sc_mcu7t5v0__oai22_1
X_09762_ _09760_/Z _09762_/A2 _11076_/D VDD VDD VSS VSS gf180mcu_fd_sc_mcu7t5v0__nor2_1
X_06974_ _10001_/Q _07181_/A2 _07003_/A2 VDD VDD VSS VSS gf180mcu_fd_sc_mcu7t5v0__nand2_2
X_08713_ _09920_/A1 _08719_/A2 _08719_/B1 _08713_/B2 _10348_/D VDD VDD
+ VSS VSS gf180mcu_fd_sc_mcu7t5v0__oai22_1
X_05925_ _10810_/Q _09331_/B2 VDD VDD VSS VSS gf180mcu_fd_sc_mcu7t5v0__clkinv_1
X_09693_ _11056_/Q _10289_/Q _09695_/A2 VDD VDD VSS VSS gf180mcu_fd_sc_mcu7t5v0__nand2_1
X_05856_ _10570_/Q _09031_/B2 VDD VDD VSS VSS gf180mcu_fd_sc_mcu7t5v0__clkinv_1
X_08644_ _08644_/A1 _07601_/B _08645_/C VDD VDD VSS VSS gf180mcu_fd_sc_mcu7t5v0__nor2_1
X_08575_ _11050_/Q _06125_/I _07680_/I _10378_/Q _08575_/C _08578_/A1 VDD VDD
+ VSS VSS gf180mcu_fd_sc_mcu7t5v0__aoi221_2
X_05787_ _11172_/Q _09935_/B2 VDD VDD VSS VSS gf180mcu_fd_sc_mcu7t5v0__clkinv_1
X_07526_ _07526_/A1 _07524_/B _07617_/A1 _07526_/Z VDD VDD VSS VSS
+ gf180mcu_fd_sc_mcu7t5v0__xor3_1
X_07457_ _07635_/A1 _07441_/Z _07457_/B _07548_/C _07458_/B VDD VDD VSS
+ VSS gf180mcu_fd_sc_mcu7t5v0__aoi211_1
X_07388_ _07388_/A1 _07388_/A2 _07387_/Z _07602_/A1 _07390_/A2 VDD VDD
+ VSS VSS gf180mcu_fd_sc_mcu7t5v0__oai22_1
X_06408_ _07124_/A1 _06411_/A2 _06428_/A2 VDD VDD VSS VSS gf180mcu_fd_sc_mcu7t5v0__nand2_1
X_09127_ _06058_/Z _09131_/A2 _09131_/B1 _09127_/B2 _10646_/D VDD VDD
+ VSS VSS gf180mcu_fd_sc_mcu7t5v0__oai22_1
X_06339_ _06339_/A1 _06339_/A2 _06439_/A2 VDD VDD VSS VSS gf180mcu_fd_sc_mcu7t5v0__nand2_2
X_09058_ _06061_/Z _09061_/A2 _09061_/B1 _09058_/B2 _10591_/D VDD VDD
+ VSS VSS gf180mcu_fd_sc_mcu7t5v0__oai22_1
X_08009_ _09523_/A2 _08009_/A2 _08009_/B1 _09937_/A1 _08011_/A2 VDD VDD
+ VSS VSS gf180mcu_fd_sc_mcu7t5v0__aoi22_2
X_11020_ _11020_/D _11039_/CLK _11020_/Q VDD VDD VSS VSS gf180mcu_fd_sc_mcu7t5v0__dffq_1
X_10804_ _10804_/D _11010_/CLK _10804_/Q VDD VDD VSS VSS gf180mcu_fd_sc_mcu7t5v0__dffq_1
X_10735_ _10735_/D _11017_/CLK _10735_/Q VDD VDD VSS VSS gf180mcu_fd_sc_mcu7t5v0__dffq_1
X_10666_ _10666_/D _10666_/CLK _10666_/Q VDD VDD VSS VSS gf180mcu_fd_sc_mcu7t5v0__dffq_1
X_10597_ _10597_/D _10666_/CLK _10597_/Q VDD VDD VSS VSS gf180mcu_fd_sc_mcu7t5v0__dffq_1
X_11149_ _11149_/D _11149_/CLK _11149_/Q VDD VDD VSS VSS gf180mcu_fd_sc_mcu7t5v0__dffq_1
X_05710_ _10784_/Q _09299_/B2 VDD VDD VSS VSS gf180mcu_fd_sc_mcu7t5v0__clkinv_1
X_06690_ _10335_/Q _06651_/Z _06692_/B1 VDD VDD VSS VSS gf180mcu_fd_sc_mcu7t5v0__nand2_1
X_05641_ _10544_/Q _08999_/B2 VDD VDD VSS VSS gf180mcu_fd_sc_mcu7t5v0__clkinv_1
X_08360_ _10066_/Q _08530_/A2 _08528_/B1 _09976_/Q _08363_/A1 VDD VDD
+ VSS VSS gf180mcu_fd_sc_mcu7t5v0__aoi22_1
X_07311_ _09926_/A1 _07311_/A2 _07311_/B _10113_/D VDD VDD VSS VSS
+ gf180mcu_fd_sc_mcu7t5v0__oai21_1
X_05572_ _09975_/Q _06120_/B2 VDD VDD VSS VSS gf180mcu_fd_sc_mcu7t5v0__clkinv_1
X_08291_ _08291_/A1 _08291_/A2 _08291_/A3 _08346_/A2 VDD VDD VSS VSS
+ gf180mcu_fd_sc_mcu7t5v0__nand3_2
X_07242_ _07249_/B _07247_/S _07245_/A2 VDD VDD VSS VSS gf180mcu_fd_sc_mcu7t5v0__nand2_1
X_07173_ _10003_/Q _07199_/A1 _07224_/A1 VDD VDD VSS VSS gf180mcu_fd_sc_mcu7t5v0__nand2_1
X_06124_ _06124_/A1 _07679_/A1 _08529_/B1 VDD VDD VSS VSS gf180mcu_fd_sc_mcu7t5v0__nor2_4
X_06055_ _10121_/Q cgra_status[0] _06055_/B _09529_/A1 VDD VDD VSS VSS
+ gf180mcu_fd_sc_mcu7t5v0__aoi21_4
X_05006_ _10275_/Q _08640_/A1 VDD VDD VSS VSS gf180mcu_fd_sc_mcu7t5v0__clkinv_1
X_09814_ _05972_/Z _09817_/A2 _09814_/B _09815_/A2 VDD VDD VSS VSS
+ gf180mcu_fd_sc_mcu7t5v0__oai21_1
X_09745_ _11071_/Q _09745_/A2 _09745_/Z VDD VDD VSS VSS gf180mcu_fd_sc_mcu7t5v0__xor2_1
X_06957_ _10082_/Q _06933_/Z _07063_/C _06958_/A2 VDD VDD VSS VSS
+ gf180mcu_fd_sc_mcu7t5v0__oai21_1
X_05908_ _10023_/Q _06521_/B2 VDD VDD VSS VSS gf180mcu_fd_sc_mcu7t5v0__clkinv_1
X_09676_ _10289_/Q _05942_/Z _09718_/A2 VDD VDD VSS VSS gf180mcu_fd_sc_mcu7t5v0__nand2_1
X_06888_ _09945_/A1 _06889_/A2 _06889_/B1 _06888_/B2 _10059_/D VDD VDD
+ VSS VSS gf180mcu_fd_sc_mcu7t5v0__oai22_1
X_05839_ _10311_/Q _08618_/B2 VDD VDD VSS VSS gf180mcu_fd_sc_mcu7t5v0__clkinv_1
X_08627_ cgra_status[1] _08626_/Z _08628_/A2 VDD VDD VSS VSS gf180mcu_fd_sc_mcu7t5v0__nand2_1
X_08558_ _08558_/A1 _08558_/A2 _08558_/A3 _08571_/A2 VDD VDD VSS VSS
+ gf180mcu_fd_sc_mcu7t5v0__nand3_1
X_08489_ _10489_/Q _08540_/A2 _08560_/B1 _10149_/Q _06112_/I _10441_/Q _08491_/A2
+ VDD VDD VSS VSS gf180mcu_fd_sc_mcu7t5v0__aoi222_1
X_07509_ _10000_/Q _07508_/Z _07515_/A1 VDD VDD VSS VSS gf180mcu_fd_sc_mcu7t5v0__nand2_1
X_10520_ _10520_/D _11109_/CLK _10520_/Q VDD VDD VSS VSS gf180mcu_fd_sc_mcu7t5v0__dffq_1
X_10451_ _10451_/D _11101_/CLK _10451_/Q VDD VDD VSS VSS gf180mcu_fd_sc_mcu7t5v0__dffq_1
X_10382_ _10382_/D _11017_/CLK _10382_/Q VDD VDD VSS VSS gf180mcu_fd_sc_mcu7t5v0__dffq_1
X_11003_ _11003_/D _11039_/CLK _11003_/Q VDD VDD VSS VSS gf180mcu_fd_sc_mcu7t5v0__dffq_1
X_10718_ _10718_/D _10905_/CLK _10718_/Q VDD VDD VSS VSS gf180mcu_fd_sc_mcu7t5v0__dffq_1
X_10649_ _10649_/D _10666_/CLK _10649_/Q VDD VDD VSS VSS gf180mcu_fd_sc_mcu7t5v0__dffq_1
X_07860_ _07860_/A1 _07864_/A2 _07860_/B _09900_/B _10251_/D VDD VDD VSS
+ VSS gf180mcu_fd_sc_mcu7t5v0__aoi211_1
X_07791_ _09920_/A1 _07797_/A2 _07797_/B1 _07791_/B2 _10216_/D VDD VDD
+ VSS VSS gf180mcu_fd_sc_mcu7t5v0__oai22_1
X_06811_ _06800_/I _06811_/A2 _06811_/A3 _06813_/A2 VDD VDD VSS VSS
+ gf180mcu_fd_sc_mcu7t5v0__xnor3_1
X_06742_ _10013_/Q _06843_/A2 _06843_/B1 _10124_/Q _06743_/A2 VDD VDD
+ VSS VSS gf180mcu_fd_sc_mcu7t5v0__aoi22_1
X_09530_ _10966_/Q _09538_/A2 _09531_/B VDD VDD VSS VSS gf180mcu_fd_sc_mcu7t5v0__nand2_1
X_09461_ _09946_/A1 _09461_/A2 _09461_/B1 _09461_/B2 _10914_/D VDD VDD
+ VSS VSS gf180mcu_fd_sc_mcu7t5v0__oai22_1
X_06673_ _06557_/Z _06590_/Z _06850_/A2 _06823_/B _06723_/A1 VDD VDD VSS
+ VSS gf180mcu_fd_sc_mcu7t5v0__oai31_1
X_09392_ _09937_/A2 _09412_/A2 _09401_/A2 VDD VDD VSS VSS gf180mcu_fd_sc_mcu7t5v0__nand2_4
X_05624_ _11163_/Q _09924_/B2 VDD VDD VSS VSS gf180mcu_fd_sc_mcu7t5v0__clkinv_1
X_08412_ _10480_/Q _08591_/A2 _08476_/C1 _10464_/Q _09872_/A1 _11139_/Q _08413_/A4
+ VDD VDD VSS VSS gf180mcu_fd_sc_mcu7t5v0__aoi222_4
X_08343_ _09900_/A2 _08343_/A2 _08343_/B1 _09861_/A2 _08350_/A1 VDD VDD
+ VSS VSS gf180mcu_fd_sc_mcu7t5v0__aoi22_1
X_05555_ _10703_/Q _09198_/B2 VDD VDD VSS VSS gf180mcu_fd_sc_mcu7t5v0__clkinv_1
X_08274_ _08274_/A1 _08274_/A2 _08274_/A3 _08275_/A2 VDD VDD VSS VSS
+ gf180mcu_fd_sc_mcu7t5v0__nand3_1
X_05486_ _11006_/Q _09593_/B2 VDD VDD VSS VSS gf180mcu_fd_sc_mcu7t5v0__clkinv_1
X_07225_ _07227_/A2 _07225_/A2 _07224_/Z _07225_/Z VDD VDD VSS VSS
+ gf180mcu_fd_sc_mcu7t5v0__xor3_1
X_07156_ _10005_/Q _07206_/A2 _07157_/A2 _07247_/I1 _07206_/C _07157_/B VDD
+ VDD VSS VSS gf180mcu_fd_sc_mcu7t5v0__aoi221_1
X_07087_ _07078_/B _07039_/Z _07086_/B _07121_/A2 VDD VDD VSS VSS
+ gf180mcu_fd_sc_mcu7t5v0__nand3_1
X_06107_ _09944_/A1 _06109_/A2 _06109_/B1 _06107_/B2 _09968_/D VDD VDD
+ VSS VSS gf180mcu_fd_sc_mcu7t5v0__oai22_1
X_06038_ _06038_/I _06145_/A1 VDD VDD VSS VSS gf180mcu_fd_sc_mcu7t5v0__clkinv_3
X_09728_ _09728_/A1 _09728_/A2 _11066_/Q _09729_/A2 VDD VDD VSS VSS
+ gf180mcu_fd_sc_mcu7t5v0__oai21_1
X_07989_ _07989_/I _07990_/C VDD VDD VSS VSS gf180mcu_fd_sc_mcu7t5v0__clkinv_1
X_09659_ _09925_/A1 _09661_/A2 _09659_/B _11041_/D VDD VDD VSS VSS
+ gf180mcu_fd_sc_mcu7t5v0__oai21_1
X_10503_ _10503_/D _11109_/CLK _10503_/Q VDD VDD VSS VSS gf180mcu_fd_sc_mcu7t5v0__dffq_1
X_10434_ _10434_/D _11017_/CLK _10434_/Q VDD VDD VSS VSS gf180mcu_fd_sc_mcu7t5v0__dffq_1
X_10365_ _10365_/D _10905_/CLK _10365_/Q VDD VDD VSS VSS gf180mcu_fd_sc_mcu7t5v0__dffq_1
X_10296_ _10296_/D _11176_/CLK _10296_/Q VDD VDD VSS VSS gf180mcu_fd_sc_mcu7t5v0__dffq_1
X_05340_ _10677_/Q _09166_/B2 VDD VDD VSS VSS gf180mcu_fd_sc_mcu7t5v0__clkinv_1
X_05271_ _10293_/Q _08602_/B2 VDD VDD VSS VSS gf180mcu_fd_sc_mcu7t5v0__clkinv_1
X_07010_ _10002_/Q _07009_/Z _07055_/A1 VDD VDD VSS VSS gf180mcu_fd_sc_mcu7t5v0__nand2_1
X_08961_ _09916_/A1 _08961_/A2 _08961_/B1 _08961_/B2 _10514_/D VDD VDD
+ VSS VSS gf180mcu_fd_sc_mcu7t5v0__oai22_1
X_08892_ _10466_/Q _08892_/A2 _08893_/B VDD VDD VSS VSS gf180mcu_fd_sc_mcu7t5v0__nand2_1
X_07912_ _08640_/A1 _07920_/A2 _07912_/B _10275_/D VDD VDD VSS VSS
+ gf180mcu_fd_sc_mcu7t5v0__aoi21_1
X_07843_ bus_addr[2] _07843_/A2 _07831_/I _07853_/A2 VDD VDD VSS VSS
+ gf180mcu_fd_sc_mcu7t5v0__nor3_4
X_04986_ _11083_/Q _09781_/A1 VDD VDD VSS VSS gf180mcu_fd_sc_mcu7t5v0__clkinv_1
X_07774_ _10208_/Q _07786_/A2 _07775_/B VDD VDD VSS VSS gf180mcu_fd_sc_mcu7t5v0__nand2_1
X_09513_ _09890_/A1 _09521_/A2 _09521_/B1 VDD VDD VSS VSS gf180mcu_fd_sc_mcu7t5v0__nand2_2
X_06725_ _10004_/Q _06726_/A2 _06776_/A1 VDD VDD VSS VSS gf180mcu_fd_sc_mcu7t5v0__nand2_1
X_09444_ _06047_/Z _09451_/A2 _09451_/B1 _09444_/B2 _10899_/D VDD VDD
+ VSS VSS gf180mcu_fd_sc_mcu7t5v0__oai22_1
X_06656_ _10000_/Q _06854_/A2 _06657_/I VDD VDD VSS VSS gf180mcu_fd_sc_mcu7t5v0__nand2_1
X_05607_ _10807_/Q _09328_/B2 VDD VDD VSS VSS gf180mcu_fd_sc_mcu7t5v0__clkinv_1
X_09375_ _09920_/A1 _09381_/A2 _09381_/B1 _09375_/B2 _10844_/D VDD VDD
+ VSS VSS gf180mcu_fd_sc_mcu7t5v0__oai22_1
X_06587_ _10120_/Q _10044_/Q _06589_/A2 VDD VDD VSS VSS gf180mcu_fd_sc_mcu7t5v0__nor2_1
X_08326_ _08326_/A1 _08326_/A2 _08326_/A3 _08327_/B1 VDD VDD VSS VSS
+ gf180mcu_fd_sc_mcu7t5v0__nand3_1
X_05538_ _10567_/Q _09028_/B2 VDD VDD VSS VSS gf180mcu_fd_sc_mcu7t5v0__clkinv_1
X_08257_ _10710_/Q _08586_/A2 _08529_/B1 _10694_/Q _08259_/A2 VDD VDD
+ VSS VSS gf180mcu_fd_sc_mcu7t5v0__aoi22_1
X_05469_ _11169_/Q _09932_/B2 VDD VDD VSS VSS gf180mcu_fd_sc_mcu7t5v0__clkinv_1
X_08188_ _10056_/Q _06877_/Z _08563_/C1 _11177_/Q _09966_/Q _08586_/A2 _08190_/A1
+ VDD VDD VSS VSS gf180mcu_fd_sc_mcu7t5v0__aoi222_2
X_07208_ _07208_/A1 _07194_/Z _07208_/B1 _07208_/B2 _07203_/Z _07246_/A1 _07209_/A2
+ VDD VDD VSS VSS gf180mcu_fd_sc_mcu7t5v0__aoi222_1
X_07139_ _07121_/B _07139_/A2 _07139_/B _07163_/B VDD VDD VSS VSS
+ gf180mcu_fd_sc_mcu7t5v0__oai21_1
X_10150_ _10150_/D _11165_/CLK _10150_/Q VDD VDD VSS VSS gf180mcu_fd_sc_mcu7t5v0__dffq_1
X_10081_ _10081_/D _11039_/CLK _10081_/Q VDD VDD VSS VSS gf180mcu_fd_sc_mcu7t5v0__dffq_4
X_10983_ _10983_/D _11039_/CLK _10983_/Q VDD VDD VSS VSS gf180mcu_fd_sc_mcu7t5v0__dffq_1
X_10417_ _10417_/D _11165_/CLK _10417_/Q VDD VDD VSS VSS gf180mcu_fd_sc_mcu7t5v0__dffq_1
X_10348_ _10348_/D _11147_/CLK _10348_/Q VDD VDD VSS VSS gf180mcu_fd_sc_mcu7t5v0__dffq_1
X_10279_ _10279_/D _11097_/CLK _10279_/Q VDD VDD VSS VSS gf180mcu_fd_sc_mcu7t5v0__dffq_1
X_07490_ _10004_/Q _07487_/Z _07492_/B VDD VDD VSS VSS gf180mcu_fd_sc_mcu7t5v0__xor2_1
X_06510_ _06228_/B _06510_/A2 _07601_/B _06511_/B2 VDD VDD VSS VSS
+ gf180mcu_fd_sc_mcu7t5v0__aoi21_1
X_06441_ _06441_/A1 _06441_/A2 _06493_/B2 _06441_/Z VDD VDD VSS VSS
+ gf180mcu_fd_sc_mcu7t5v0__xor3_1
X_06372_ _10004_/Q _06505_/B _06372_/B1 _06372_/B2 _06372_/C _06373_/B2 VDD
+ VDD VSS VSS gf180mcu_fd_sc_mcu7t5v0__aoi221_1
X_09160_ _09897_/A1 _09161_/A2 _09161_/B1 _09160_/B2 _10673_/D VDD VDD
+ VSS VSS gf180mcu_fd_sc_mcu7t5v0__oai22_1
X_08111_ _10757_/Q _08559_/A2 _06112_/I _10789_/Q _08111_/C _08112_/A3 VDD VDD
+ VSS VSS gf180mcu_fd_sc_mcu7t5v0__aoi221_2
X_05323_ _10541_/Q _08996_/B2 VDD VDD VSS VSS gf180mcu_fd_sc_mcu7t5v0__clkinv_1
X_09091_ _09946_/A1 _09091_/A2 _09091_/B1 _09091_/B2 _10618_/D VDD VDD
+ VSS VSS gf180mcu_fd_sc_mcu7t5v0__oai22_1
X_08042_ _10564_/Q _08564_/C1 _08584_/B1 _10596_/Q _08045_/A2 VDD VDD
+ VSS VSS gf180mcu_fd_sc_mcu7t5v0__aoi22_1
X_05254_ _09972_/Q _06117_/B2 VDD VDD VSS VSS gf180mcu_fd_sc_mcu7t5v0__clkinv_1
X_05185_ _10819_/Q _09344_/B2 VDD VDD VSS VSS gf180mcu_fd_sc_mcu7t5v0__clkinv_1
X_09993_ _09993_/D _11163_/CLK _09993_/Q VDD VDD VSS VSS gf180mcu_fd_sc_mcu7t5v0__dffq_1
X_08944_ _06047_/Z _08951_/A2 _08951_/B1 _08944_/B2 _10499_/D VDD VDD
+ VSS VSS gf180mcu_fd_sc_mcu7t5v0__oai22_1
X_08875_ _08831_/I _08874_/Z _10458_/D VDD VDD VSS VSS gf180mcu_fd_sc_mcu7t5v0__nor2_1
X_07826_ bus_addr[0] bus_addr[1] bus_addr[2] _07827_/A2 VDD VDD VSS
+ VSS gf180mcu_fd_sc_mcu7t5v0__nand3_1
X_04969_ _11099_/Q _09817_/A1 VDD VDD VSS VSS gf180mcu_fd_sc_mcu7t5v0__clkinv_1
X_07757_ _09537_/A1 _07758_/A2 _07758_/B1 _07757_/B2 _10197_/D VDD VDD
+ VSS VSS gf180mcu_fd_sc_mcu7t5v0__oai22_1
X_06708_ _06698_/I _06710_/A2 _06708_/Z VDD VDD VSS VSS gf180mcu_fd_sc_mcu7t5v0__and2_1
X_07688_ _10153_/Q _07698_/A2 _07689_/B VDD VDD VSS VSS gf180mcu_fd_sc_mcu7t5v0__nand2_1
X_09427_ _06058_/Z _09431_/A2 _09431_/B1 _09427_/B2 _10886_/D VDD VDD
+ VSS VSS gf180mcu_fd_sc_mcu7t5v0__oai22_1
X_06639_ _06871_/C _06678_/A2 _06638_/Z _06646_/A2 VDD VDD VSS VSS
+ gf180mcu_fd_sc_mcu7t5v0__nand3_1
X_09358_ _06061_/Z _09361_/A2 _09361_/B1 _09358_/B2 _10831_/D VDD VDD
+ VSS VSS gf180mcu_fd_sc_mcu7t5v0__oai22_1
X_08309_ _08309_/A1 _08309_/A2 _08309_/A3 _08345_/A2 VDD VDD VSS VSS
+ gf180mcu_fd_sc_mcu7t5v0__nand3_2
X_09289_ _09924_/A1 _09291_/A2 _09291_/B1 _09289_/B2 _10776_/D VDD VDD
+ VSS VSS gf180mcu_fd_sc_mcu7t5v0__oai22_1
X_10202_ _10202_/D _11147_/CLK _10202_/Q VDD VDD VSS VSS gf180mcu_fd_sc_mcu7t5v0__dffq_1
X_11182_ cgra_status[2] VDD VDD VSS VSS gf180mcu_fd_sc_mcu7t5v0__tiel
X_10133_ _10133_/D _11164_/CLK _10133_/Q VDD VDD VSS VSS gf180mcu_fd_sc_mcu7t5v0__dffq_1
X_10064_ _10064_/D _11181_/CLK _10064_/Q VDD VDD VSS VSS gf180mcu_fd_sc_mcu7t5v0__dffq_1
X_10966_ _10966_/D _11181_/CLK _10966_/Q VDD VDD VSS VSS gf180mcu_fd_sc_mcu7t5v0__dffq_1
X_10897_ _10897_/D _11109_/CLK _10897_/Q VDD VDD VSS VSS gf180mcu_fd_sc_mcu7t5v0__dffq_1
X_06990_ _07361_/A2 _07601_/B _07603_/B _06990_/C _10083_/D VDD VDD VSS
+ VSS gf180mcu_fd_sc_mcu7t5v0__aoi211_1
X_05941_ _10452_/Q _10451_/Q _10454_/Q _10453_/Q _05942_/A4 VDD VDD VSS
+ VSS gf180mcu_fd_sc_mcu7t5v0__nor4_1
X_08660_ _10280_/Q _08675_/A2 _08672_/B _08661_/B VDD VDD VSS VSS
+ gf180mcu_fd_sc_mcu7t5v0__oai21_1
X_05872_ _10698_/Q _09191_/B2 VDD VDD VSS VSS gf180mcu_fd_sc_mcu7t5v0__clkinv_1
X_07611_ _10004_/Q _07428_/I _07612_/A3 VDD VDD VSS VSS gf180mcu_fd_sc_mcu7t5v0__nand2_1
X_08591_ _10442_/Q _08591_/A2 _08591_/B1 _10434_/Q _08591_/C1 _10474_/Q _08592_/A3
+ VDD VDD VSS VSS gf180mcu_fd_sc_mcu7t5v0__aoi222_2
X_07542_ _07542_/A1 _07542_/A2 _07542_/B _07593_/A2 VDD VDD VSS VSS
+ gf180mcu_fd_sc_mcu7t5v0__aoi21_1
X_07473_ _07516_/A1 _07473_/A2 _07522_/A1 _07507_/B1 VDD VDD VSS VSS
+ gf180mcu_fd_sc_mcu7t5v0__xnor3_1
X_06424_ _06327_/B _06410_/Z _07601_/B _06425_/B VDD VDD VSS VSS gf180mcu_fd_sc_mcu7t5v0__aoi21_1
X_09212_ _09927_/A2 _08588_/B _09221_/A2 VDD VDD VSS VSS gf180mcu_fd_sc_mcu7t5v0__nand2_4
X_09143_ _09413_/A1 _09151_/A2 _09151_/B1 VDD VDD VSS VSS gf180mcu_fd_sc_mcu7t5v0__nand2_2
X_06355_ _06311_/Z _06354_/Z _06407_/A1 VDD VDD VSS VSS gf180mcu_fd_sc_mcu7t5v0__nand2_1
X_05306_ _11160_/Q _09921_/B2 VDD VDD VSS VSS gf180mcu_fd_sc_mcu7t5v0__clkinv_1
X_09074_ _06047_/Z _09081_/A2 _09081_/B1 _09074_/B2 _10603_/D VDD VDD
+ VSS VSS gf180mcu_fd_sc_mcu7t5v0__oai22_1
X_06286_ _06286_/I _06288_/B1 VDD VDD VSS VSS gf180mcu_fd_sc_mcu7t5v0__clkinv_1
X_08025_ _10107_/Q _08589_/A2 _08029_/A1 VDD VDD VSS VSS gf180mcu_fd_sc_mcu7t5v0__nand2_1
X_05237_ _10700_/Q _09195_/B2 VDD VDD VSS VSS gf180mcu_fd_sc_mcu7t5v0__clkinv_1
X_05168_ _11003_/Q _09590_/B2 VDD VDD VSS VSS gf180mcu_fd_sc_mcu7t5v0__clkinv_1
X_05099_ _10379_/Q _08752_/B2 VDD VDD VSS VSS gf180mcu_fd_sc_mcu7t5v0__clkinv_1
X_09976_ _09976_/D _11101_/CLK _09976_/Q VDD VDD VSS VSS gf180mcu_fd_sc_mcu7t5v0__dffq_1
X_08927_ _06058_/Z _08931_/A2 _08931_/B1 _08927_/B2 _10486_/D VDD VDD
+ VSS VSS gf180mcu_fd_sc_mcu7t5v0__oai22_1
X_08858_ _08856_/Z _08858_/A2 _10452_/D VDD VDD VSS VSS gf180mcu_fd_sc_mcu7t5v0__nor2_1
X_07809_ _06877_/Z _07809_/A2 _09900_/B _07824_/A2 VDD VDD VSS VSS
+ gf180mcu_fd_sc_mcu7t5v0__aoi21_4
X_08789_ _09926_/A1 _08789_/A2 _08789_/B1 _08789_/B2 _10410_/D VDD VDD
+ VSS VSS gf180mcu_fd_sc_mcu7t5v0__oai22_1
X_10820_ _10820_/D _11142_/CLK _10820_/Q VDD VDD VSS VSS gf180mcu_fd_sc_mcu7t5v0__dffq_1
X_10751_ _10751_/D _10978_/CLK _10751_/Q VDD VDD VSS VSS gf180mcu_fd_sc_mcu7t5v0__dffq_1
X_10682_ _10682_/D _11139_/CLK _10682_/Q VDD VDD VSS VSS gf180mcu_fd_sc_mcu7t5v0__dffq_1
X_11165_ _11165_/D _11165_/CLK _11165_/Q VDD VDD VSS VSS gf180mcu_fd_sc_mcu7t5v0__dffq_1
X_10116_ _10116_/D _10327_/CLK _10116_/Q VDD VDD VSS VSS gf180mcu_fd_sc_mcu7t5v0__dffq_2
X_11096_ _11096_/D _11101_/CLK _11096_/Q VDD VDD VSS VSS gf180mcu_fd_sc_mcu7t5v0__dffq_1
X_10047_ _10047_/D _11150_/CLK _10047_/Q VDD VDD VSS VSS gf180mcu_fd_sc_mcu7t5v0__dffq_2
X_10949_ _10949_/D _11149_/CLK _10949_/Q VDD VDD VSS VSS gf180mcu_fd_sc_mcu7t5v0__dffq_1
X_06140_ _09924_/A1 _06144_/A2 _06140_/B _09984_/D VDD VDD VSS VSS
+ gf180mcu_fd_sc_mcu7t5v0__oai21_1
X_06071_ _09954_/Q _06071_/A2 _06074_/B VDD VDD VSS VSS gf180mcu_fd_sc_mcu7t5v0__nand2_1
X_05022_ _10261_/Q _07882_/A1 VDD VDD VSS VSS gf180mcu_fd_sc_mcu7t5v0__clkinv_1
X_09830_ _09924_/A1 _09832_/A2 _09832_/B1 _09830_/B2 _11107_/D VDD VDD
+ VSS VSS gf180mcu_fd_sc_mcu7t5v0__oai22_1
X_09761_ _11076_/Q _09757_/Z _09776_/B _09762_/A2 VDD VDD VSS VSS
+ gf180mcu_fd_sc_mcu7t5v0__oai21_1
X_06973_ _10001_/Q _07181_/A2 _06981_/A1 VDD VDD VSS VSS gf180mcu_fd_sc_mcu7t5v0__nor2_1
X_08712_ _06047_/Z _08719_/A2 _08719_/B1 _08712_/B2 _10347_/D VDD VDD
+ VSS VSS gf180mcu_fd_sc_mcu7t5v0__oai22_1
X_05924_ _10802_/Q _09321_/B2 VDD VDD VSS VSS gf180mcu_fd_sc_mcu7t5v0__clkinv_1
X_09692_ _09692_/A1 _09692_/A2 _11054_/D VDD VDD VSS VSS gf180mcu_fd_sc_mcu7t5v0__nor2_1
X_05855_ _10562_/Q _09021_/B2 VDD VDD VSS VSS gf180mcu_fd_sc_mcu7t5v0__clkinv_1
X_08643_ _08659_/A1 _08643_/A2 _08643_/B _10318_/D VDD VDD VSS VSS
+ gf180mcu_fd_sc_mcu7t5v0__aoi21_1
X_08574_ _08574_/I _08575_/C VDD VDD VSS VSS gf180mcu_fd_sc_mcu7t5v0__clkinv_1
X_05786_ _09969_/Q _06108_/B2 VDD VDD VSS VSS gf180mcu_fd_sc_mcu7t5v0__clkinv_1
X_07525_ _07524_/B _07525_/A2 _07569_/A2 _07525_/Z VDD VDD VSS VSS
+ gf180mcu_fd_sc_mcu7t5v0__and3_1
X_07456_ _07545_/A1 _07568_/A1 _07456_/B1 _07456_/B2 _07456_/C _07457_/B VDD
+ VDD VSS VSS gf180mcu_fd_sc_mcu7t5v0__oai221_1
X_06407_ _06407_/A1 _06407_/A2 _06411_/A2 VDD VDD VSS VSS gf180mcu_fd_sc_mcu7t5v0__xnor2_2
X_07387_ _10120_/Q _07391_/A1 _07382_/Z _07387_/Z VDD VDD VSS VSS
+ gf180mcu_fd_sc_mcu7t5v0__xor3_1
X_09126_ _09941_/A1 _09131_/A2 _09131_/B1 _09126_/B2 _10645_/D VDD VDD
+ VSS VSS gf180mcu_fd_sc_mcu7t5v0__oai22_1
X_06338_ _06339_/A1 _06339_/A2 _06338_/Z VDD VDD VSS VSS gf180mcu_fd_sc_mcu7t5v0__and2_1
X_09057_ _06058_/Z _09061_/A2 _09061_/B1 _09057_/B2 _10590_/D VDD VDD
+ VSS VSS gf180mcu_fd_sc_mcu7t5v0__oai22_1
X_06269_ _06270_/A2 _06300_/B2 _06269_/A3 _06269_/Z VDD VDD VSS VSS
+ gf180mcu_fd_sc_mcu7t5v0__xor3_1
X_08008_ _09917_/A2 _08008_/A2 _08008_/B1 _09861_/A2 _08011_/A1 VDD VDD
+ VSS VSS gf180mcu_fd_sc_mcu7t5v0__aoi22_1
X_09959_ _09959_/D _10905_/CLK _09959_/Q VDD VDD VSS VSS gf180mcu_fd_sc_mcu7t5v0__dffq_1
X_10803_ _10803_/D _11164_/CLK _10803_/Q VDD VDD VSS VSS gf180mcu_fd_sc_mcu7t5v0__dffq_1
X_10734_ _10734_/D _11142_/CLK _10734_/Q VDD VDD VSS VSS gf180mcu_fd_sc_mcu7t5v0__dffq_1
X_10665_ _10665_/D _10666_/CLK _10665_/Q VDD VDD VSS VSS gf180mcu_fd_sc_mcu7t5v0__dffq_1
X_10596_ _10596_/D _11176_/CLK _10596_/Q VDD VDD VSS VSS gf180mcu_fd_sc_mcu7t5v0__dffq_1
X_11148_ _11148_/D _11149_/CLK _11148_/Q VDD VDD VSS VSS gf180mcu_fd_sc_mcu7t5v0__dffq_1
X_11079_ _11079_/D _11082_/CLK _11079_/Q VDD VDD VSS VSS gf180mcu_fd_sc_mcu7t5v0__dffq_1
X_05640_ _10536_/Q _08989_/B2 VDD VDD VSS VSS gf180mcu_fd_sc_mcu7t5v0__clkinv_1
X_05571_ _10028_/Q _06528_/B2 VDD VDD VSS VSS gf180mcu_fd_sc_mcu7t5v0__clkinv_1
X_07310_ _10113_/Q _07310_/A2 _07311_/B VDD VDD VSS VSS gf180mcu_fd_sc_mcu7t5v0__nand2_1
X_08290_ _10415_/Q _08589_/A2 _08591_/C1 _10471_/Q _08591_/B1 _10431_/Q _08291_/A3
+ VDD VDD VSS VSS gf180mcu_fd_sc_mcu7t5v0__aoi222_2
X_07241_ _10007_/Q _07241_/A2 _07247_/S VDD VDD VSS VSS gf180mcu_fd_sc_mcu7t5v0__nand2_1
X_07172_ _10001_/Q _07226_/A2 _07176_/A1 VDD VDD VSS VSS gf180mcu_fd_sc_mcu7t5v0__nand2_1
X_06123_ _09946_/A1 _06123_/A2 _06123_/B1 _06123_/B2 _09978_/D VDD VDD
+ VSS VSS gf180mcu_fd_sc_mcu7t5v0__oai22_1
X_06054_ _07860_/A1 cgra_status[0] _06055_/B VDD VDD VSS VSS gf180mcu_fd_sc_mcu7t5v0__nor2_1
X_05005_ bus_wdata[3] _07862_/A1 VDD VDD VSS VSS gf180mcu_fd_sc_mcu7t5v0__inv_1
X_09813_ _09813_/A1 _10300_/Q _09814_/B VDD VDD VSS VSS gf180mcu_fd_sc_mcu7t5v0__nand2_1
X_09744_ _09744_/A1 _09745_/A2 _09750_/A2 VDD VDD VSS VSS gf180mcu_fd_sc_mcu7t5v0__nor2_1
X_06956_ _07333_/A2 _07003_/A1 _06991_/A1 VDD VDD VSS VSS gf180mcu_fd_sc_mcu7t5v0__nor2_1
X_05907_ _10299_/Q _08608_/B2 VDD VDD VSS VSS gf180mcu_fd_sc_mcu7t5v0__clkinv_1
X_09675_ _09722_/A1 _10288_/Q _09720_/A2 VDD VDD VSS VSS gf180mcu_fd_sc_mcu7t5v0__nand2_1
X_06887_ _09944_/A1 _06889_/A2 _06889_/B1 _06887_/B2 _10058_/D VDD VDD
+ VSS VSS gf180mcu_fd_sc_mcu7t5v0__oai22_1
X_05838_ _10402_/Q _08779_/B2 VDD VDD VSS VSS gf180mcu_fd_sc_mcu7t5v0__clkinv_1
X_08626_ cgra_status[0] _08626_/A2 _08626_/A3 _08626_/Z VDD VDD VSS
+ VSS gf180mcu_fd_sc_mcu7t5v0__or3_1
X_08557_ _10578_/Q _08584_/A2 _08563_/C1 _10586_/Q _08564_/C1 _10570_/Q _08558_/A3
+ VDD VDD VSS VSS gf180mcu_fd_sc_mcu7t5v0__aoi222_1
X_05769_ _10713_/Q _09210_/B2 VDD VDD VSS VSS gf180mcu_fd_sc_mcu7t5v0__clkinv_1
X_08488_ _10417_/Q _08589_/A2 _08591_/C1 _10473_/Q _08491_/A1 VDD VDD
+ VSS VSS gf180mcu_fd_sc_mcu7t5v0__aoi22_1
X_07508_ _10328_/Q _10087_/Q _10050_/Q _10336_/Q _10118_/Q _10117_/Q _07508_/Z VDD
+ VDD VSS VSS gf180mcu_fd_sc_mcu7t5v0__mux4_4
X_07439_ _07404_/Z _07438_/Z _07439_/Z VDD VDD VSS VSS gf180mcu_fd_sc_mcu7t5v0__and2_1
X_10450_ _10450_/D _11101_/CLK _10450_/Q VDD VDD VSS VSS gf180mcu_fd_sc_mcu7t5v0__dffq_1
X_09109_ _09944_/A1 _09111_/A2 _09111_/B1 _09109_/B2 _10632_/D VDD VDD
+ VSS VSS gf180mcu_fd_sc_mcu7t5v0__oai22_1
X_10381_ _10381_/D _11018_/CLK _10381_/Q VDD VDD VSS VSS gf180mcu_fd_sc_mcu7t5v0__dffq_1
X_11002_ _11002_/D _11018_/CLK _11002_/Q VDD VDD VSS VSS gf180mcu_fd_sc_mcu7t5v0__dffq_1
X_10717_ _10717_/D _10905_/CLK _10717_/Q VDD VDD VSS VSS gf180mcu_fd_sc_mcu7t5v0__dffq_1
X_10648_ _10648_/D _11176_/CLK _10648_/Q VDD VDD VSS VSS gf180mcu_fd_sc_mcu7t5v0__dffq_1
X_10579_ _10579_/D _10978_/CLK _10579_/Q VDD VDD VSS VSS gf180mcu_fd_sc_mcu7t5v0__dffq_1
X_07790_ _06047_/Z _07797_/A2 _07797_/B1 _07790_/B2 _10215_/D VDD VDD
+ VSS VSS gf180mcu_fd_sc_mcu7t5v0__oai22_1
X_06810_ _06811_/A2 _06811_/A3 _06853_/A2 VDD VDD VSS VSS gf180mcu_fd_sc_mcu7t5v0__nand2_1
X_06741_ _10336_/Q _06651_/Z _06743_/A1 VDD VDD VSS VSS gf180mcu_fd_sc_mcu7t5v0__nand2_1
X_09460_ _09945_/A1 _09461_/A2 _09461_/B1 _09460_/B2 _10913_/D VDD VDD
+ VSS VSS gf180mcu_fd_sc_mcu7t5v0__oai22_1
X_08411_ _11155_/Q _08444_/B1 _09834_/A2 _11115_/Q _08413_/A3 VDD VDD
+ VSS VSS gf180mcu_fd_sc_mcu7t5v0__aoi22_1
X_06672_ _06688_/A1 _06671_/Z _06672_/Z VDD VDD VSS VSS gf180mcu_fd_sc_mcu7t5v0__xor2_1
X_09391_ _09926_/A1 _09391_/A2 _09391_/B1 _09391_/B2 _10858_/D VDD VDD
+ VSS VSS gf180mcu_fd_sc_mcu7t5v0__oai22_1
X_05623_ _10148_/Q _07676_/B2 VDD VDD VSS VSS gf180mcu_fd_sc_mcu7t5v0__clkinv_1
Xclkbuf_leaf_16_clk clkbuf_1_1_0_clk/Z _11039_/CLK VDD VDD VSS VSS
+ gf180mcu_fd_sc_mcu7t5v0__clkbuf_16
X_08342_ _08342_/A1 _08342_/A2 _08342_/A3 _08345_/B1 VDD VDD VSS VSS
+ gf180mcu_fd_sc_mcu7t5v0__nand3_2
X_05554_ _10695_/Q _09188_/B2 VDD VDD VSS VSS gf180mcu_fd_sc_mcu7t5v0__clkinv_1
X_08273_ _10839_/Q _08590_/A2 _08582_/A2 _10871_/Q _08589_/B1 _10831_/Q _08274_/A3
+ VDD VDD VSS VSS gf180mcu_fd_sc_mcu7t5v0__aoi222_1
X_05485_ _10366_/Q _08735_/B2 VDD VDD VSS VSS gf180mcu_fd_sc_mcu7t5v0__clkinv_1
X_07224_ _07224_/A1 _07224_/A2 _07224_/Z VDD VDD VSS VSS gf180mcu_fd_sc_mcu7t5v0__xor2_1
X_07155_ _10005_/Q _07226_/A2 _07157_/A2 VDD VDD VSS VSS gf180mcu_fd_sc_mcu7t5v0__nand2_1
X_07086_ _07078_/B _07039_/Z _07086_/B _07121_/B VDD VDD VSS VSS gf180mcu_fd_sc_mcu7t5v0__aoi21_1
X_06106_ _06061_/Z _06109_/A2 _06109_/B1 _06106_/B2 _09967_/D VDD VDD
+ VSS VSS gf180mcu_fd_sc_mcu7t5v0__oai22_1
X_06037_ _10320_/Q bus_addr[4] _08619_/B _06038_/I VDD VDD VSS VSS
+ gf180mcu_fd_sc_mcu7t5v0__mux2_4
X_07988_ _10899_/Q _08584_/A2 _06877_/Z _10183_/Q _07989_/I VDD VDD VSS
+ VSS gf180mcu_fd_sc_mcu7t5v0__aoi22_1
X_09727_ bus_re _05986_/I _09728_/A2 VDD VDD VSS VSS gf180mcu_fd_sc_mcu7t5v0__nand2_1
X_06939_ _10079_/Q _06952_/A2 _07247_/I0 VDD VDD VSS VSS gf180mcu_fd_sc_mcu7t5v0__nor2_2
X_09658_ _11041_/Q _09660_/A2 _09659_/B VDD VDD VSS VSS gf180mcu_fd_sc_mcu7t5v0__nand2_1
X_08609_ _09502_/A1 _09568_/A2 _08618_/A2 VDD VDD VSS VSS gf180mcu_fd_sc_mcu7t5v0__nand2_4
X_09589_ _08672_/B _09597_/A2 _09597_/B1 VDD VDD VSS VSS gf180mcu_fd_sc_mcu7t5v0__nand2_4
X_10502_ _10502_/D _11109_/CLK _10502_/Q VDD VDD VSS VSS gf180mcu_fd_sc_mcu7t5v0__dffq_1
X_10433_ _10433_/D _11165_/CLK _10433_/Q VDD VDD VSS VSS gf180mcu_fd_sc_mcu7t5v0__dffq_1
X_10364_ _10364_/D _11176_/CLK _10364_/Q VDD VDD VSS VSS gf180mcu_fd_sc_mcu7t5v0__dffq_1
X_10295_ _10295_/D _11176_/CLK _10295_/Q VDD VDD VSS VSS gf180mcu_fd_sc_mcu7t5v0__dffq_1
X_05270_ _10900_/Q _09445_/B2 VDD VDD VSS VSS gf180mcu_fd_sc_mcu7t5v0__clkinv_1
X_08960_ _09925_/A1 _08961_/A2 _08961_/B1 _08960_/B2 _10513_/D VDD VDD
+ VSS VSS gf180mcu_fd_sc_mcu7t5v0__oai22_1
Xclkbuf_leaf_5_clk clkbuf_1_0_0_clk/Z _10978_/CLK VDD VDD VSS VSS
+ gf180mcu_fd_sc_mcu7t5v0__clkbuf_16
X_08891_ _09897_/A1 _08893_/A2 _08891_/B _10465_/D VDD VDD VSS VSS
+ gf180mcu_fd_sc_mcu7t5v0__oai21_1
X_07911_ bus_wdata[2] _07920_/A2 _08654_/B _07912_/B VDD VDD VSS VSS
+ gf180mcu_fd_sc_mcu7t5v0__oai21_1
X_07842_ _09698_/A1 _07842_/A2 _07842_/B _09900_/B _10243_/D VDD VDD VSS
+ VSS gf180mcu_fd_sc_mcu7t5v0__aoi211_1
X_09512_ _09851_/A1 _09861_/A2 _09521_/A2 VDD VDD VSS VSS gf180mcu_fd_sc_mcu7t5v0__nand2_4
X_04985_ _11084_/Q _09783_/A1 VDD VDD VSS VSS gf180mcu_fd_sc_mcu7t5v0__clkinv_1
X_07773_ _06047_/Z _07787_/A2 _07773_/B _10207_/D VDD VDD VSS VSS
+ gf180mcu_fd_sc_mcu7t5v0__oai21_1
X_06724_ _06823_/A1 _06771_/B _06726_/A2 VDD VDD VSS VSS gf180mcu_fd_sc_mcu7t5v0__xnor2_1
X_06655_ _06655_/A1 _06655_/A2 _06843_/B1 _07444_/A1 _06854_/A2 VDD VDD
+ VSS VSS gf180mcu_fd_sc_mcu7t5v0__aoi22_4
X_09443_ _08658_/B _09451_/A2 _09451_/B1 VDD VDD VSS VSS gf180mcu_fd_sc_mcu7t5v0__nand2_2
X_05606_ _10799_/Q _09318_/B2 VDD VDD VSS VSS gf180mcu_fd_sc_mcu7t5v0__clkinv_1
X_09374_ _06047_/Z _09381_/A2 _09381_/B1 _09374_/B2 _10843_/D VDD VDD
+ VSS VSS gf180mcu_fd_sc_mcu7t5v0__oai22_1
X_08325_ _10543_/Q _08555_/A2 _08589_/B1 _10551_/Q _07680_/I _10583_/Q _08326_/A3
+ VDD VDD VSS VSS gf180mcu_fd_sc_mcu7t5v0__aoi222_2
X_06586_ _10044_/Q _06691_/B _06964_/A1 _06661_/A2 VDD VDD VSS VSS
+ gf180mcu_fd_sc_mcu7t5v0__nand3_4
X_05537_ _10559_/Q _09018_/B2 VDD VDD VSS VSS gf180mcu_fd_sc_mcu7t5v0__clkinv_1
X_08256_ _10686_/Q _06023_/I _08584_/A2 _10702_/Q _08256_/C _08259_/A1 VDD VDD
+ VSS VSS gf180mcu_fd_sc_mcu7t5v0__aoi221_1
X_05468_ _09966_/Q _06105_/B2 VDD VDD VSS VSS gf180mcu_fd_sc_mcu7t5v0__clkinv_1
X_08187_ _08187_/A1 _08187_/A2 _08187_/A3 _08204_/A2 VDD VDD VSS VSS
+ gf180mcu_fd_sc_mcu7t5v0__nand3_1
X_07207_ _07207_/A1 _07207_/A2 _07207_/B _07208_/B2 VDD VDD VSS VSS
+ gf180mcu_fd_sc_mcu7t5v0__oai21_1
X_05399_ _10837_/Q _09366_/B2 VDD VDD VSS VSS gf180mcu_fd_sc_mcu7t5v0__clkinv_1
X_07138_ _07129_/Z _07138_/A2 _07136_/B _07139_/B VDD VDD VSS VSS
+ gf180mcu_fd_sc_mcu7t5v0__xnor3_1
X_07069_ _10123_/Q _07025_/Z _07071_/B1 VDD VDD VSS VSS gf180mcu_fd_sc_mcu7t5v0__nand2_1
X_10080_ _10080_/D _11039_/CLK _10080_/Q VDD VDD VSS VSS gf180mcu_fd_sc_mcu7t5v0__dffq_4
X_10982_ _10982_/D _11039_/CLK _10982_/Q VDD VDD VSS VSS gf180mcu_fd_sc_mcu7t5v0__dffq_1
X_10416_ _10416_/D _11164_/CLK _10416_/Q VDD VDD VSS VSS gf180mcu_fd_sc_mcu7t5v0__dffq_1
X_10347_ _10347_/D _11142_/CLK _10347_/Q VDD VDD VSS VSS gf180mcu_fd_sc_mcu7t5v0__dffq_1
X_10278_ _10278_/D _11097_/CLK _10278_/Q VDD VDD VSS VSS gf180mcu_fd_sc_mcu7t5v0__dffq_1
X_06440_ _06441_/A1 _06441_/A2 _06440_/Z VDD VDD VSS VSS gf180mcu_fd_sc_mcu7t5v0__and2_1
X_06371_ _10004_/Q _06505_/A1 _06439_/A2 _06373_/B1 VDD VDD VSS VSS
+ gf180mcu_fd_sc_mcu7t5v0__nand3_1
X_05322_ _10533_/Q _08986_/B2 VDD VDD VSS VSS gf180mcu_fd_sc_mcu7t5v0__clkinv_1
X_08110_ _09286_/B2 _08585_/A2 _08581_/A2 _09276_/B2 _08111_/C VDD VDD
+ VSS VSS gf180mcu_fd_sc_mcu7t5v0__oai22_2
X_09090_ _09945_/A1 _09091_/A2 _09091_/B1 _09090_/B2 _10617_/D VDD VDD
+ VSS VSS gf180mcu_fd_sc_mcu7t5v0__oai22_1
X_08041_ _10588_/Q _08582_/A2 _07680_/I _10580_/Q _08045_/A1 VDD VDD VSS
+ VSS gf180mcu_fd_sc_mcu7t5v0__aoi22_1
X_05253_ _10025_/Q _06525_/B2 VDD VDD VSS VSS gf180mcu_fd_sc_mcu7t5v0__clkinv_1
X_05184_ _10811_/Q _09334_/B2 VDD VDD VSS VSS gf180mcu_fd_sc_mcu7t5v0__clkinv_1
X_09992_ _09992_/D _11163_/CLK _09992_/Q VDD VDD VSS VSS gf180mcu_fd_sc_mcu7t5v0__dffq_1
X_08943_ _09824_/A1 _08951_/A2 _08951_/B1 VDD VDD VSS VSS gf180mcu_fd_sc_mcu7t5v0__nand2_2
X_08874_ _10458_/Q _08874_/A2 _08874_/Z VDD VDD VSS VSS gf180mcu_fd_sc_mcu7t5v0__xor2_1
X_07825_ _09946_/A1 _07825_/A2 _07825_/B _10238_/D VDD VDD VSS VSS
+ gf180mcu_fd_sc_mcu7t5v0__oai21_1
X_07756_ _09884_/A1 _07758_/A2 _07758_/B1 _07756_/B2 _10196_/D VDD VDD
+ VSS VSS gf180mcu_fd_sc_mcu7t5v0__oai22_1
X_06707_ _06707_/A1 _06704_/Z _06710_/A2 VDD VDD VSS VSS gf180mcu_fd_sc_mcu7t5v0__xnor2_1
X_09426_ _09893_/A1 _09431_/A2 _09431_/B1 _09426_/B2 _10885_/D VDD VDD
+ VSS VSS gf180mcu_fd_sc_mcu7t5v0__oai22_1
X_07687_ _09940_/A1 _07699_/A2 _07687_/B _10152_/D VDD VDD VSS VSS
+ gf180mcu_fd_sc_mcu7t5v0__oai21_1
X_06638_ _06603_/Z _06638_/A2 _06637_/B _06638_/Z VDD VDD VSS VSS
+ gf180mcu_fd_sc_mcu7t5v0__or3_1
X_09357_ _06058_/Z _09361_/A2 _09361_/B1 _09357_/B2 _10830_/D VDD VDD
+ VSS VSS gf180mcu_fd_sc_mcu7t5v0__oai22_1
X_06569_ _06570_/A2 _06832_/A1 _06732_/A1 _06607_/B VDD VDD VSS VSS
+ gf180mcu_fd_sc_mcu7t5v0__nand3_2
X_09288_ _06061_/Z _09291_/A2 _09291_/B1 _09288_/B2 _10775_/D VDD VDD
+ VSS VSS gf180mcu_fd_sc_mcu7t5v0__oai22_1
X_08308_ _10036_/Q _08528_/A2 _08586_/A2 _09967_/Q _08309_/A3 VDD VDD
+ VSS VSS gf180mcu_fd_sc_mcu7t5v0__aoi22_1
X_08239_ _10510_/Q _06112_/I _08589_/B1 _10894_/Q _08240_/I VDD VDD VSS
+ VSS gf180mcu_fd_sc_mcu7t5v0__aoi22_1
X_10201_ _10201_/D _11149_/CLK _10201_/Q VDD VDD VSS VSS gf180mcu_fd_sc_mcu7t5v0__dffq_1
X_11181_ _11181_/D _11181_/CLK _11181_/Q VDD VDD VSS VSS gf180mcu_fd_sc_mcu7t5v0__dffq_1
X_10132_ _10132_/D _11163_/CLK _10132_/Q VDD VDD VSS VSS gf180mcu_fd_sc_mcu7t5v0__dffq_1
X_10063_ _10063_/D _11101_/CLK _10063_/Q VDD VDD VSS VSS gf180mcu_fd_sc_mcu7t5v0__dffq_1
X_10965_ _10965_/D _11181_/CLK _10965_/Q VDD VDD VSS VSS gf180mcu_fd_sc_mcu7t5v0__dffq_1
X_10896_ _10896_/D _11109_/CLK _10896_/Q VDD VDD VSS VSS gf180mcu_fd_sc_mcu7t5v0__dffq_1
X_05940_ _10456_/Q _10455_/Q _10458_/Q _10457_/Q _05942_/A3 VDD VDD VSS
+ VSS gf180mcu_fd_sc_mcu7t5v0__nor4_1
X_05871_ _10690_/Q _09181_/B2 VDD VDD VSS VSS gf180mcu_fd_sc_mcu7t5v0__clkinv_1
X_08590_ _10490_/Q _08590_/A2 _08590_/B1 _10150_/Q _07255_/I _11165_/Q _08592_/A2
+ VDD VDD VSS VSS gf180mcu_fd_sc_mcu7t5v0__aoi222_1
X_07610_ _10005_/Q _07393_/I _07612_/A2 VDD VDD VSS VSS gf180mcu_fd_sc_mcu7t5v0__nand2_1
X_07541_ _07542_/A1 _07542_/A2 _07542_/B _07541_/Z VDD VDD VSS VSS
+ gf180mcu_fd_sc_mcu7t5v0__and3_1
X_07472_ _07434_/B _07526_/A1 _07516_/B VDD VDD VSS VSS gf180mcu_fd_sc_mcu7t5v0__nor2_1
X_06423_ _06423_/A1 _06423_/A2 _06423_/B _06425_/A3 VDD VDD VSS VSS
+ gf180mcu_fd_sc_mcu7t5v0__oai21_1
X_09211_ _09946_/A1 _09211_/A2 _09211_/B1 _09211_/B2 _10714_/D VDD VDD
+ VSS VSS gf180mcu_fd_sc_mcu7t5v0__oai22_1
X_09142_ _09927_/A2 _09142_/A2 _09151_/A2 VDD VDD VSS VSS gf180mcu_fd_sc_mcu7t5v0__nand2_4
X_06354_ _06354_/A1 _06354_/A2 _06354_/Z VDD VDD VSS VSS gf180mcu_fd_sc_mcu7t5v0__xor2_1
X_05305_ _10145_/Q _07673_/B2 VDD VDD VSS VSS gf180mcu_fd_sc_mcu7t5v0__clkinv_1
X_09073_ _09193_/A1 _09081_/A2 _09081_/B1 VDD VDD VSS VSS gf180mcu_fd_sc_mcu7t5v0__nand2_2
X_06285_ _10002_/Q _06479_/A2 _06286_/I VDD VDD VSS VSS gf180mcu_fd_sc_mcu7t5v0__nand2_2
X_08024_ _08024_/A1 _08024_/A2 _08024_/A3 _08030_/B1 VDD VDD VSS VSS
+ gf180mcu_fd_sc_mcu7t5v0__nand3_2
X_05236_ _10692_/Q _09185_/B2 VDD VDD VSS VSS gf180mcu_fd_sc_mcu7t5v0__clkinv_1
X_05167_ _10363_/Q _08732_/B2 VDD VDD VSS VSS gf180mcu_fd_sc_mcu7t5v0__clkinv_1
X_05098_ _10387_/Q _08762_/B2 VDD VDD VSS VSS gf180mcu_fd_sc_mcu7t5v0__clkinv_1
X_09975_ _09975_/D _11082_/CLK _09975_/Q VDD VDD VSS VSS gf180mcu_fd_sc_mcu7t5v0__dffq_1
X_08926_ _09921_/A1 _08931_/A2 _08931_/B1 _08926_/B2 _10485_/D VDD VDD
+ VSS VSS gf180mcu_fd_sc_mcu7t5v0__oai22_1
X_08857_ _10452_/Q _08853_/Z _08872_/B _08858_/A2 VDD VDD VSS VSS
+ gf180mcu_fd_sc_mcu7t5v0__oai21_1
X_07808_ _06877_/Z _07809_/A2 _07825_/A2 VDD VDD VSS VSS gf180mcu_fd_sc_mcu7t5v0__nand2_2
X_08788_ _09897_/A1 _08789_/A2 _08789_/B1 _08788_/B2 _10409_/D VDD VDD
+ VSS VSS gf180mcu_fd_sc_mcu7t5v0__oai22_1
X_07739_ _09442_/A1 _09851_/A1 _07748_/A2 VDD VDD VSS VSS gf180mcu_fd_sc_mcu7t5v0__nand2_4
X_10750_ _10750_/D _11149_/CLK _10750_/Q VDD VDD VSS VSS gf180mcu_fd_sc_mcu7t5v0__dffq_1
X_09409_ _09896_/A1 _09411_/A2 _09411_/B1 _09409_/B2 _10872_/D VDD VDD
+ VSS VSS gf180mcu_fd_sc_mcu7t5v0__oai22_1
X_10681_ _10681_/D _11139_/CLK _10681_/Q VDD VDD VSS VSS gf180mcu_fd_sc_mcu7t5v0__dffq_1
X_11164_ _11164_/D _11164_/CLK _11164_/Q VDD VDD VSS VSS gf180mcu_fd_sc_mcu7t5v0__dffq_1
X_11095_ _11095_/D _11101_/CLK _11095_/Q VDD VDD VSS VSS gf180mcu_fd_sc_mcu7t5v0__dffq_1
X_10115_ _10115_/D _10327_/CLK _10115_/Q VDD VDD VSS VSS gf180mcu_fd_sc_mcu7t5v0__dffq_2
X_10046_ _10046_/D _10327_/CLK _10046_/Q VDD VDD VSS VSS gf180mcu_fd_sc_mcu7t5v0__dffq_1
X_10948_ _10948_/D _11149_/CLK _10948_/Q VDD VDD VSS VSS gf180mcu_fd_sc_mcu7t5v0__dffq_1
X_10879_ _10879_/D _11138_/CLK _10879_/Q VDD VDD VSS VSS gf180mcu_fd_sc_mcu7t5v0__dffq_1
X_06070_ _06074_/A1 _09925_/A1 _06070_/B _09953_/D VDD VDD VSS VSS
+ gf180mcu_fd_sc_mcu7t5v0__oai21_1
X_05021_ _10262_/Q _07884_/A1 VDD VDD VSS VSS gf180mcu_fd_sc_mcu7t5v0__clkinv_1
X_09760_ _11076_/Q _09757_/Z _09760_/Z VDD VDD VSS VSS gf180mcu_fd_sc_mcu7t5v0__and2_1
X_06972_ _06972_/A1 _06970_/Z _06972_/Z VDD VDD VSS VSS gf180mcu_fd_sc_mcu7t5v0__xor2_1
X_08711_ _09890_/A1 _08719_/A2 _08719_/B1 VDD VDD VSS VSS gf180mcu_fd_sc_mcu7t5v0__nand2_4
X_05923_ _10794_/Q _09311_/B2 VDD VDD VSS VSS gf180mcu_fd_sc_mcu7t5v0__clkinv_1
X_09691_ bus_wdata[2] _09722_/A1 _09691_/B _09692_/A2 VDD VDD VSS VSS
+ gf180mcu_fd_sc_mcu7t5v0__aoi21_1
X_08642_ _10318_/Q _08659_/A1 _08654_/B _08643_/B VDD VDD VSS VSS
+ gf180mcu_fd_sc_mcu7t5v0__oai21_1
X_05854_ _10554_/Q _09011_/B2 VDD VDD VSS VSS gf180mcu_fd_sc_mcu7t5v0__clkinv_1
X_08573_ _10730_/Q _08580_/A2 _08573_/B1 _11018_/Q _08574_/I VDD VDD VSS
+ VSS gf180mcu_fd_sc_mcu7t5v0__aoi22_1
X_05785_ _11180_/Q _09945_/B2 VDD VDD VSS VSS gf180mcu_fd_sc_mcu7t5v0__clkinv_1
X_07524_ _07525_/A2 _07569_/A2 _07524_/B _07564_/A2 VDD VDD VSS VSS
+ gf180mcu_fd_sc_mcu7t5v0__aoi21_1
X_07455_ _10003_/Q _07633_/A2 _07456_/C VDD VDD VSS VSS gf180mcu_fd_sc_mcu7t5v0__nand2_1
X_06406_ _06407_/A1 _06407_/A2 _06477_/A2 VDD VDD VSS VSS gf180mcu_fd_sc_mcu7t5v0__nor2_1
X_07386_ _10120_/Q _07382_/Z _07386_/Z VDD VDD VSS VSS gf180mcu_fd_sc_mcu7t5v0__or2_1
X_09125_ _09940_/A1 _09131_/A2 _09131_/B1 _09125_/B2 _10644_/D VDD VDD
+ VSS VSS gf180mcu_fd_sc_mcu7t5v0__oai22_1
X_06337_ _10086_/Q _06431_/A2 _06339_/A2 VDD VDD VSS VSS gf180mcu_fd_sc_mcu7t5v0__nand2_1
X_09056_ _09893_/A1 _09061_/A2 _09061_/B1 _09056_/B2 _10589_/D VDD VDD
+ VSS VSS gf180mcu_fd_sc_mcu7t5v0__oai22_1
X_06268_ _06270_/A2 _06269_/A3 _06268_/Z VDD VDD VSS VSS gf180mcu_fd_sc_mcu7t5v0__and2_1
X_05219_ _10556_/Q _09015_/B2 VDD VDD VSS VSS gf180mcu_fd_sc_mcu7t5v0__clkinv_1
X_08007_ _08007_/A1 _08007_/A2 _08007_/A3 _08010_/B1 VDD VDD VSS VSS
+ gf180mcu_fd_sc_mcu7t5v0__nand3_1
X_06199_ _10045_/Q _06195_/Z _06431_/A2 _10082_/Q _06444_/A2 VDD VDD VSS
+ VSS gf180mcu_fd_sc_mcu7t5v0__aoi22_4
X_09958_ _09958_/D _10905_/CLK _09958_/Q VDD VDD VSS VSS gf180mcu_fd_sc_mcu7t5v0__dffq_1
X_08909_ _09904_/A1 _08921_/A2 _08909_/B _10476_/D VDD VDD VSS VSS
+ gf180mcu_fd_sc_mcu7t5v0__oai21_1
X_09889_ _09889_/A1 _09889_/A2 _09898_/A2 VDD VDD VSS VSS gf180mcu_fd_sc_mcu7t5v0__nand2_4
X_10802_ _10802_/D _11109_/CLK _10802_/Q VDD VDD VSS VSS gf180mcu_fd_sc_mcu7t5v0__dffq_1
X_10733_ _10733_/D _11142_/CLK _10733_/Q VDD VDD VSS VSS gf180mcu_fd_sc_mcu7t5v0__dffq_1
X_10664_ _10664_/D _10666_/CLK _10664_/Q VDD VDD VSS VSS gf180mcu_fd_sc_mcu7t5v0__dffq_1
X_10595_ _10595_/D _11138_/CLK _10595_/Q VDD VDD VSS VSS gf180mcu_fd_sc_mcu7t5v0__dffq_1
X_11147_ _11147_/D _11147_/CLK _11147_/Q VDD VDD VSS VSS gf180mcu_fd_sc_mcu7t5v0__dffq_1
X_11078_ _11078_/D _11082_/CLK _11078_/Q VDD VDD VSS VSS gf180mcu_fd_sc_mcu7t5v0__dffq_1
X_10029_ _10029_/D _11181_/CLK _10029_/Q VDD VDD VSS VSS gf180mcu_fd_sc_mcu7t5v0__dffq_1
X_05570_ _10036_/Q _06538_/B2 VDD VDD VSS VSS gf180mcu_fd_sc_mcu7t5v0__clkinv_1
X_07240_ _07628_/A1 _07240_/A2 _07240_/A3 _07249_/B VDD VDD VSS VSS
+ gf180mcu_fd_sc_mcu7t5v0__nand3_1
X_07171_ _07129_/Z _07171_/A2 _07171_/B _07215_/A1 VDD VDD VSS VSS
+ gf180mcu_fd_sc_mcu7t5v0__aoi21_1
X_06122_ _09537_/A1 _06123_/A2 _06123_/B1 _06122_/B2 _09977_/D VDD VDD
+ VSS VSS gf180mcu_fd_sc_mcu7t5v0__oai22_1
X_06053_ _09949_/Q _06071_/A2 _06056_/B VDD VDD VSS VSS gf180mcu_fd_sc_mcu7t5v0__nand2_1
X_05004_ _10276_/Q _08644_/A1 VDD VDD VSS VSS gf180mcu_fd_sc_mcu7t5v0__clkinv_1
X_09812_ _09812_/A1 _09817_/A2 _09812_/B _11098_/D VDD VDD VSS VSS
+ gf180mcu_fd_sc_mcu7t5v0__aoi21_1
X_09743_ _05980_/Z _09743_/A2 _09743_/B _09743_/C _11070_/D VDD VDD VSS
+ VSS gf180mcu_fd_sc_mcu7t5v0__aoi211_1
X_06955_ _06955_/A1 _06955_/A2 _06955_/B _06959_/A2 VDD VDD VSS VSS
+ gf180mcu_fd_sc_mcu7t5v0__aoi21_1
X_09674_ _05954_/Z _09673_/B _09674_/B _09900_/B _11051_/D VDD VDD VSS
+ VSS gf180mcu_fd_sc_mcu7t5v0__aoi211_1
X_06886_ _06061_/Z _06889_/A2 _06889_/B1 _06886_/B2 _10057_/D VDD VDD
+ VSS VSS gf180mcu_fd_sc_mcu7t5v0__oai22_1
X_05906_ _10906_/Q _09451_/B2 VDD VDD VSS VSS gf180mcu_fd_sc_mcu7t5v0__clkinv_1
X_05837_ _10182_/Q _07738_/B2 VDD VDD VSS VSS gf180mcu_fd_sc_mcu7t5v0__clkinv_1
X_08625_ _08625_/A1 _08675_/A2 _09900_/B _10314_/D VDD VDD VSS VSS
+ gf180mcu_fd_sc_mcu7t5v0__aoi21_1
X_08556_ _10562_/Q _06023_/I _08582_/A2 _10594_/Q _08584_/B1 _10602_/Q _08558_/A2
+ VDD VDD VSS VSS gf180mcu_fd_sc_mcu7t5v0__aoi222_2
X_07507_ _07554_/A1 _07507_/A2 _07507_/A3 _07507_/B1 _07507_/B2 _07530_/A1 VDD
+ VDD VSS VSS gf180mcu_fd_sc_mcu7t5v0__oai32_1
X_05768_ _10409_/Q _08788_/B2 VDD VDD VSS VSS gf180mcu_fd_sc_mcu7t5v0__clkinv_1
X_05699_ _10976_/Q _09547_/B2 VDD VDD VSS VSS gf180mcu_fd_sc_mcu7t5v0__clkinv_1
X_08487_ _08487_/A1 _08487_/A2 _08487_/A3 _08492_/A2 VDD VDD VSS VSS
+ gf180mcu_fd_sc_mcu7t5v0__nand3_1
X_07438_ _07465_/A1 _07438_/A2 _07436_/B _07438_/Z VDD VDD VSS VSS
+ gf180mcu_fd_sc_mcu7t5v0__xor3_1
X_07369_ _07365_/I _07371_/A3 _07369_/Z VDD VDD VSS VSS gf180mcu_fd_sc_mcu7t5v0__xor2_1
X_09108_ _06061_/Z _09111_/A2 _09111_/B1 _09108_/B2 _10631_/D VDD VDD
+ VSS VSS gf180mcu_fd_sc_mcu7t5v0__oai22_1
X_10380_ _10380_/D _11017_/CLK _10380_/Q VDD VDD VSS VSS gf180mcu_fd_sc_mcu7t5v0__dffq_1
X_09039_ _09944_/A1 _09041_/A2 _09041_/B1 _09039_/B2 _10576_/D VDD VDD
+ VSS VSS gf180mcu_fd_sc_mcu7t5v0__oai22_1
X_11001_ _11001_/D _11147_/CLK _11001_/Q VDD VDD VSS VSS gf180mcu_fd_sc_mcu7t5v0__dffq_1
X_10716_ _10716_/D _10905_/CLK _10716_/Q VDD VDD VSS VSS gf180mcu_fd_sc_mcu7t5v0__dffq_1
X_10647_ _10647_/D _10666_/CLK _10647_/Q VDD VDD VSS VSS gf180mcu_fd_sc_mcu7t5v0__dffq_1
X_10578_ _10578_/D _10666_/CLK _10578_/Q VDD VDD VSS VSS gf180mcu_fd_sc_mcu7t5v0__dffq_1
X_06740_ _06740_/A1 _06740_/A2 _06740_/B _06761_/A1 VDD VDD VSS VSS
+ gf180mcu_fd_sc_mcu7t5v0__aoi21_1
X_06671_ _10048_/Q _06669_/Z _06671_/Z VDD VDD VSS VSS gf180mcu_fd_sc_mcu7t5v0__xor2_1
X_05622_ _10432_/Q _08817_/B2 VDD VDD VSS VSS gf180mcu_fd_sc_mcu7t5v0__clkinv_1
X_08410_ _10111_/Q _08589_/A2 _08589_/B1 _10074_/Q _08413_/A2 VDD VDD
+ VSS VSS gf180mcu_fd_sc_mcu7t5v0__aoi22_1
X_09390_ _09897_/A1 _09391_/A2 _09391_/B1 _09390_/B2 _10857_/D VDD VDD
+ VSS VSS gf180mcu_fd_sc_mcu7t5v0__oai22_1
X_08341_ _11146_/Q _08555_/A2 _06125_/I _10351_/Q _07680_/I _10227_/Q _08342_/A3 VDD
+ VDD VSS VSS gf180mcu_fd_sc_mcu7t5v0__aoi222_2
X_05553_ _10687_/Q _09178_/B2 VDD VDD VSS VSS gf180mcu_fd_sc_mcu7t5v0__clkinv_1
X_08272_ _10855_/Q _08591_/A2 _08877_/A2 _10863_/Q _06125_/I _10847_/Q _08274_/A2
+ VDD VDD VSS VSS gf180mcu_fd_sc_mcu7t5v0__aoi222_1
X_05484_ _10019_/Q _06517_/B2 VDD VDD VSS VSS gf180mcu_fd_sc_mcu7t5v0__clkinv_1
X_07223_ _10004_/Q _07223_/A2 _07224_/A2 VDD VDD VSS VSS gf180mcu_fd_sc_mcu7t5v0__nand2_1
X_07154_ _10005_/Q _07226_/A2 _07154_/Z VDD VDD VSS VSS gf180mcu_fd_sc_mcu7t5v0__or2_1
X_07085_ _07085_/A1 _07085_/A2 _07177_/A1 _07086_/B VDD VDD VSS VSS
+ gf180mcu_fd_sc_mcu7t5v0__xor3_1
X_06105_ _06058_/Z _06109_/A2 _06109_/B1 _06105_/B2 _09966_/D VDD VDD
+ VSS VSS gf180mcu_fd_sc_mcu7t5v0__oai22_1
X_06036_ _06032_/I _06034_/I _08268_/B2 VDD VDD VSS VSS gf180mcu_fd_sc_mcu7t5v0__nand2_4
X_07987_ _08534_/A1 _08329_/B _09142_/A2 VDD VDD VSS VSS gf180mcu_fd_sc_mcu7t5v0__nor2_4
X_09726_ _09900_/B uart_rx _11065_/D VDD VDD VSS VSS gf180mcu_fd_sc_mcu7t5v0__or2_1
X_06938_ _10078_/Q _06953_/A3 _06952_/A2 VDD VDD VSS VSS gf180mcu_fd_sc_mcu7t5v0__nand2_1
X_09657_ _09924_/A1 _09661_/A2 _09657_/B _11040_/D VDD VDD VSS VSS
+ gf180mcu_fd_sc_mcu7t5v0__oai21_1
X_06869_ _07628_/A1 _06869_/A2 _06869_/A3 _06869_/Z VDD VDD VSS VSS
+ gf180mcu_fd_sc_mcu7t5v0__xor3_1
X_09588_ _09645_/A1 _09900_/A1 _09597_/A2 VDD VDD VSS VSS gf180mcu_fd_sc_mcu7t5v0__nand2_4
X_08608_ _09946_/A1 _08608_/A2 _08608_/B1 _08608_/B2 _10299_/D VDD VDD
+ VSS VSS gf180mcu_fd_sc_mcu7t5v0__oai22_1
X_08539_ _08539_/A1 _08539_/A2 _08539_/A3 _08593_/A2 VDD VDD VSS VSS
+ gf180mcu_fd_sc_mcu7t5v0__nand3_1
X_10501_ _10501_/D _11109_/CLK _10501_/Q VDD VDD VSS VSS gf180mcu_fd_sc_mcu7t5v0__dffq_1
X_10432_ _10432_/D _11017_/CLK _10432_/Q VDD VDD VSS VSS gf180mcu_fd_sc_mcu7t5v0__dffq_1
X_10363_ _10363_/D _11176_/CLK _10363_/Q VDD VDD VSS VSS gf180mcu_fd_sc_mcu7t5v0__dffq_1
X_10294_ _10294_/D _11176_/CLK _10294_/Q VDD VDD VSS VSS gf180mcu_fd_sc_mcu7t5v0__dffq_1
X_08890_ _10465_/Q _08892_/A2 _08891_/B VDD VDD VSS VSS gf180mcu_fd_sc_mcu7t5v0__nand2_1
X_07910_ _08636_/A1 _07920_/A2 _07910_/B _10274_/D VDD VDD VSS VSS
+ gf180mcu_fd_sc_mcu7t5v0__aoi21_1
X_07841_ _10243_/Q _07842_/A2 _07842_/B VDD VDD VSS VSS gf180mcu_fd_sc_mcu7t5v0__nor2_1
X_07772_ _10207_/Q _07786_/A2 _07773_/B VDD VDD VSS VSS gf180mcu_fd_sc_mcu7t5v0__nand2_1
X_09511_ _09926_/A1 _09511_/A2 _09511_/B1 _09511_/B2 _10954_/D VDD VDD
+ VSS VSS gf180mcu_fd_sc_mcu7t5v0__oai22_1
X_04984_ _11085_/Q _09785_/A1 VDD VDD VSS VSS gf180mcu_fd_sc_mcu7t5v0__clkinv_1
X_06723_ _06723_/A1 _06723_/A2 _06771_/B VDD VDD VSS VSS gf180mcu_fd_sc_mcu7t5v0__nand2_1
X_06654_ _10044_/Q _10043_/Q _06843_/B1 VDD VDD VSS VSS gf180mcu_fd_sc_mcu7t5v0__nor2_4
X_09442_ _09442_/A1 _09645_/A2 _09451_/A2 VDD VDD VSS VSS gf180mcu_fd_sc_mcu7t5v0__nand2_4
X_05605_ _10791_/Q _09308_/B2 VDD VDD VSS VSS gf180mcu_fd_sc_mcu7t5v0__clkinv_1
X_09373_ _08514_/B _09381_/A2 _09381_/B1 VDD VDD VSS VSS gf180mcu_fd_sc_mcu7t5v0__nand2_2
X_06585_ _07326_/A3 _07601_/B _06585_/B1 _06585_/B2 _07603_/B _10045_/D VDD
+ VDD VSS VSS gf180mcu_fd_sc_mcu7t5v0__aoi221_1
X_05536_ _10551_/Q _09008_/B2 VDD VDD VSS VSS gf180mcu_fd_sc_mcu7t5v0__clkinv_1
X_08324_ _10559_/Q _06023_/I _08582_/A2 _10591_/Q _08584_/A2 _10575_/Q _08326_/A2
+ VDD VDD VSS VSS gf180mcu_fd_sc_mcu7t5v0__aoi222_1
X_08255_ _09167_/B2 _08581_/A2 _08585_/B1 _08785_/B2 _08256_/C VDD VDD
+ VSS VSS gf180mcu_fd_sc_mcu7t5v0__oai22_1
X_05467_ _11177_/Q _09942_/B2 VDD VDD VSS VSS gf180mcu_fd_sc_mcu7t5v0__clkinv_1
X_05398_ _10829_/Q _09356_/B2 VDD VDD VSS VSS gf180mcu_fd_sc_mcu7t5v0__clkinv_1
X_07206_ _10006_/Q _07206_/A2 _07207_/A2 _07247_/I1 _07206_/C _07207_/B VDD
+ VDD VSS VSS gf180mcu_fd_sc_mcu7t5v0__aoi221_1
X_08186_ _10162_/Q _06023_/I _08586_/A2 _10019_/Q _06877_/Z _10186_/Q _08187_/A3 VDD
+ VDD VSS VSS gf180mcu_fd_sc_mcu7t5v0__aoi222_2
X_07137_ _07083_/Z _07084_/Z _07136_/B _07171_/A2 VDD VDD VSS VSS
+ gf180mcu_fd_sc_mcu7t5v0__nand3_1
X_07068_ _07075_/A2 _07068_/A2 _07068_/B _07095_/A1 VDD VDD VSS VSS
+ gf180mcu_fd_sc_mcu7t5v0__aoi21_2
X_06019_ _07865_/A1 cgra_status[0] _06020_/B VDD VDD VSS VSS gf180mcu_fd_sc_mcu7t5v0__nor2_1
X_10981_ _10981_/D _11010_/CLK _10981_/Q VDD VDD VSS VSS gf180mcu_fd_sc_mcu7t5v0__dffq_1
X_09709_ _09678_/Z _09709_/A2 _09710_/B VDD VDD VSS VSS gf180mcu_fd_sc_mcu7t5v0__nand2_1
X_10415_ _10415_/D _11017_/CLK _10415_/Q VDD VDD VSS VSS gf180mcu_fd_sc_mcu7t5v0__dffq_1
X_10346_ _10346_/D _11142_/CLK _10346_/Q VDD VDD VSS VSS gf180mcu_fd_sc_mcu7t5v0__dffq_1
X_10277_ _10277_/D _11052_/CLK _10277_/Q VDD VDD VSS VSS gf180mcu_fd_sc_mcu7t5v0__dffq_1
X_06370_ _10004_/Q _06439_/A2 _06372_/B1 VDD VDD VSS VSS gf180mcu_fd_sc_mcu7t5v0__nand2_1
X_05321_ _10525_/Q _08976_/B2 VDD VDD VSS VSS gf180mcu_fd_sc_mcu7t5v0__clkinv_1
X_08040_ _08040_/A1 _08040_/A2 _08040_/A3 _08096_/A2 VDD VDD VSS VSS
+ gf180mcu_fd_sc_mcu7t5v0__nand3_1
X_05252_ _10033_/Q _06535_/B2 VDD VDD VSS VSS gf180mcu_fd_sc_mcu7t5v0__clkinv_1
X_05183_ _10803_/Q _09324_/B2 VDD VDD VSS VSS gf180mcu_fd_sc_mcu7t5v0__clkinv_1
X_09991_ _09991_/D _11163_/CLK _09991_/Q VDD VDD VSS VSS gf180mcu_fd_sc_mcu7t5v0__dffq_1
X_08942_ _09871_/A1 _09823_/A2 _08951_/A2 VDD VDD VSS VSS gf180mcu_fd_sc_mcu7t5v0__nand2_4
X_08873_ _10457_/Q _08868_/Z _08873_/B _10457_/D VDD VDD VSS VSS gf180mcu_fd_sc_mcu7t5v0__aoi21_1
X_07824_ _10238_/Q _07824_/A2 _07825_/B VDD VDD VSS VSS gf180mcu_fd_sc_mcu7t5v0__nand2_1
X_07755_ _06061_/Z _07758_/A2 _07758_/B1 _07755_/B2 _10195_/D VDD VDD
+ VSS VSS gf180mcu_fd_sc_mcu7t5v0__oai22_1
X_06706_ _06707_/A1 _06704_/Z _06740_/A2 VDD VDD VSS VSS gf180mcu_fd_sc_mcu7t5v0__nand2_1
X_07686_ _10152_/Q _07698_/A2 _07687_/B VDD VDD VSS VSS gf180mcu_fd_sc_mcu7t5v0__nand2_1
X_09425_ _09920_/A1 _09431_/A2 _09431_/B1 _09425_/B2 _10884_/D VDD VDD
+ VSS VSS gf180mcu_fd_sc_mcu7t5v0__oai22_1
X_06637_ _06603_/Z _06638_/A2 _06637_/B _06678_/A2 VDD VDD VSS VSS
+ gf180mcu_fd_sc_mcu7t5v0__oai21_1
X_09356_ _09893_/A1 _09361_/A2 _09361_/B1 _09356_/B2 _10829_/D VDD VDD
+ VSS VSS gf180mcu_fd_sc_mcu7t5v0__oai22_1
X_06568_ _06570_/A2 _06832_/A1 _06732_/A1 _06871_/C VDD VDD VSS VSS
+ gf180mcu_fd_sc_mcu7t5v0__and3_1
X_05519_ _10179_/Q _07735_/B2 VDD VDD VSS VSS gf180mcu_fd_sc_mcu7t5v0__clkinv_1
X_09287_ _06058_/Z _09291_/A2 _09291_/B1 _09287_/B2 _10774_/D VDD VDD
+ VSS VSS gf180mcu_fd_sc_mcu7t5v0__oai22_1
X_06499_ _06511_/A1 _06499_/A2 _06498_/Z _06499_/Z VDD VDD VSS VSS
+ gf180mcu_fd_sc_mcu7t5v0__xor3_1
X_08307_ _10065_/Q _08530_/A2 _08532_/A2 _11170_/Q _08563_/C1 _11178_/Q _08309_/A2
+ VDD VDD VSS VSS gf180mcu_fd_sc_mcu7t5v0__aoi222_2
X_08238_ _08238_/A1 _08238_/A2 _08238_/A3 _08265_/B1 VDD VDD VSS VSS
+ gf180mcu_fd_sc_mcu7t5v0__nand3_1
X_10200_ _10200_/D _11147_/CLK _10200_/Q VDD VDD VSS VSS gf180mcu_fd_sc_mcu7t5v0__dffq_1
X_08169_ _10669_/Q _08530_/A2 _08589_/B1 _10677_/Q _08476_/C1 _10405_/Q _08170_/A3
+ VDD VDD VSS VSS gf180mcu_fd_sc_mcu7t5v0__aoi222_2
X_11180_ _11180_/D _11181_/CLK _11180_/Q VDD VDD VSS VSS gf180mcu_fd_sc_mcu7t5v0__dffq_1
X_10131_ _10131_/D _11164_/CLK _10131_/Q VDD VDD VSS VSS gf180mcu_fd_sc_mcu7t5v0__dffq_1
X_10062_ _10062_/D _11082_/CLK _10062_/Q VDD VDD VSS VSS gf180mcu_fd_sc_mcu7t5v0__dffq_1
X_10964_ _10964_/D _11181_/CLK _10964_/Q VDD VDD VSS VSS gf180mcu_fd_sc_mcu7t5v0__dffq_1
X_10895_ _10895_/D _11109_/CLK _10895_/Q VDD VDD VSS VSS gf180mcu_fd_sc_mcu7t5v0__dffq_1
X_10329_ _10329_/D _11039_/CLK _10329_/Q VDD VDD VSS VSS gf180mcu_fd_sc_mcu7t5v0__dffq_1
X_05870_ _10682_/Q _09171_/B2 VDD VDD VSS VSS gf180mcu_fd_sc_mcu7t5v0__clkinv_1
X_07540_ _10005_/Q _07540_/A2 _07542_/B VDD VDD VSS VSS gf180mcu_fd_sc_mcu7t5v0__xor2_1
X_07471_ _07471_/A1 _07471_/A2 _07471_/B _10004_/Q _07526_/A1 VDD VDD
+ VSS VSS gf180mcu_fd_sc_mcu7t5v0__oai211_4
X_06422_ _06372_/C _06422_/A2 _06422_/A3 _06483_/A2 _10005_/Q _06423_/B VDD
+ VDD VSS VSS gf180mcu_fd_sc_mcu7t5v0__oai32_1
X_09210_ _09897_/A1 _09211_/A2 _09211_/B1 _09210_/B2 _10713_/D VDD VDD
+ VSS VSS gf180mcu_fd_sc_mcu7t5v0__oai22_1
X_09141_ _09946_/A1 _09141_/A2 _09141_/B1 _09141_/B2 _10658_/D VDD VDD
+ VSS VSS gf180mcu_fd_sc_mcu7t5v0__oai22_1
X_06353_ _06354_/A1 _06354_/A2 _06405_/A1 VDD VDD VSS VSS gf180mcu_fd_sc_mcu7t5v0__nand2_1
X_05304_ _10429_/Q _08814_/B2 VDD VDD VSS VSS gf180mcu_fd_sc_mcu7t5v0__clkinv_1
X_09072_ _09889_/A1 _09142_/A2 _09081_/A2 VDD VDD VSS VSS gf180mcu_fd_sc_mcu7t5v0__nand2_4
X_08023_ _10305_/Q _08590_/A2 _08591_/C1 _10388_/Q _08024_/A3 VDD VDD
+ VSS VSS gf180mcu_fd_sc_mcu7t5v0__aoi22_1
X_06284_ _10002_/Q _06479_/A2 _06289_/B1 VDD VDD VSS VSS gf180mcu_fd_sc_mcu7t5v0__nor2_1
X_05235_ _10684_/Q _09175_/B2 VDD VDD VSS VSS gf180mcu_fd_sc_mcu7t5v0__clkinv_1
X_05166_ _10016_/Q _06514_/B2 VDD VDD VSS VSS gf180mcu_fd_sc_mcu7t5v0__clkinv_1
X_05097_ _10304_/Q _08611_/B2 VDD VDD VSS VSS gf180mcu_fd_sc_mcu7t5v0__clkinv_1
X_09974_ _09974_/D _11082_/CLK _09974_/Q VDD VDD VSS VSS gf180mcu_fd_sc_mcu7t5v0__dffq_1
X_08925_ _09920_/A1 _08931_/A2 _08931_/B1 _08925_/B2 _10484_/D VDD VDD
+ VSS VSS gf180mcu_fd_sc_mcu7t5v0__oai22_1
X_08856_ _10452_/Q _08853_/Z _08856_/Z VDD VDD VSS VSS gf180mcu_fd_sc_mcu7t5v0__and2_1
X_07807_ _09926_/A1 _07807_/A2 _07807_/B1 _07807_/B2 _10230_/D VDD VDD
+ VSS VSS gf180mcu_fd_sc_mcu7t5v0__oai22_1
X_08787_ _09884_/A1 _08789_/A2 _08789_/B1 _08787_/B2 _10408_/D VDD VDD
+ VSS VSS gf180mcu_fd_sc_mcu7t5v0__oai22_1
X_05999_ _09728_/A1 _05999_/A2 _05999_/B bus_rdata[2] VDD VDD VSS VSS
+ gf180mcu_fd_sc_mcu7t5v0__oai21_4
X_07738_ _09832_/A1 _07738_/A2 _07738_/B1 _07738_/B2 _10182_/D VDD VDD
+ VSS VSS gf180mcu_fd_sc_mcu7t5v0__oai22_1
X_07669_ _09900_/A1 _09917_/A2 _07678_/A2 VDD VDD VSS VSS gf180mcu_fd_sc_mcu7t5v0__nand2_4
X_09408_ _06061_/Z _09411_/A2 _09411_/B1 _09408_/B2 _10871_/D VDD VDD
+ VSS VSS gf180mcu_fd_sc_mcu7t5v0__oai22_1
X_10680_ _10680_/D _11139_/CLK _10680_/Q VDD VDD VSS VSS gf180mcu_fd_sc_mcu7t5v0__dffq_1
X_09339_ _09924_/A1 _09341_/A2 _09341_/B1 _09339_/B2 _10816_/D VDD VDD
+ VSS VSS gf180mcu_fd_sc_mcu7t5v0__oai22_1
X_11163_ _11163_/D _11163_/CLK _11163_/Q VDD VDD VSS VSS gf180mcu_fd_sc_mcu7t5v0__dffq_1
X_10114_ _10114_/D _10327_/CLK _10114_/Q VDD VDD VSS VSS gf180mcu_fd_sc_mcu7t5v0__dffq_2
X_11094_ _11094_/D _11097_/CLK _11094_/Q VDD VDD VSS VSS gf180mcu_fd_sc_mcu7t5v0__dffq_1
X_10045_ _10045_/D _11039_/CLK _10045_/Q VDD VDD VSS VSS gf180mcu_fd_sc_mcu7t5v0__dffq_2
X_10947_ _10947_/D _11149_/CLK _10947_/Q VDD VDD VSS VSS gf180mcu_fd_sc_mcu7t5v0__dffq_1
X_10878_ _10878_/D _11165_/CLK _10878_/Q VDD VDD VSS VSS gf180mcu_fd_sc_mcu7t5v0__dffq_1
X_05020_ _10263_/Q _07886_/A1 VDD VDD VSS VSS gf180mcu_fd_sc_mcu7t5v0__clkinv_1
X_06971_ _06972_/A1 _06970_/Z _06971_/Z VDD VDD VSS VSS gf180mcu_fd_sc_mcu7t5v0__and2_1
X_08710_ _09871_/A1 _09889_/A2 _08719_/A2 VDD VDD VSS VSS gf180mcu_fd_sc_mcu7t5v0__nand2_4
X_05922_ _10786_/Q _09301_/B2 VDD VDD VSS VSS gf180mcu_fd_sc_mcu7t5v0__clkinv_1
X_09690_ _09678_/Z _09690_/A2 _09691_/B VDD VDD VSS VSS gf180mcu_fd_sc_mcu7t5v0__nand2_1
X_05853_ _10546_/Q _09001_/B2 VDD VDD VSS VSS gf180mcu_fd_sc_mcu7t5v0__clkinv_1
X_08641_ _10268_/Q _08657_/A2 _08657_/B1 _10261_/Q _08641_/C _08643_/A2 VDD
+ VDD VSS VSS gf180mcu_fd_sc_mcu7t5v0__aoi221_1
X_08572_ _09645_/A1 _08572_/A2 _08572_/B1 _09568_/A2 _08597_/A3 VDD VDD
+ VSS VSS gf180mcu_fd_sc_mcu7t5v0__aoi22_1
X_05784_ _09977_/Q _06122_/B2 VDD VDD VSS VSS gf180mcu_fd_sc_mcu7t5v0__clkinv_1
X_07523_ _07526_/A1 _07617_/A1 _07569_/A2 VDD VDD VSS VSS gf180mcu_fd_sc_mcu7t5v0__nand2_1
X_07454_ _07632_/I1 _07568_/A1 _07633_/C _07456_/B1 VDD VDD VSS VSS
+ gf180mcu_fd_sc_mcu7t5v0__aoi21_1
X_06405_ _06405_/A1 _06405_/A2 _06407_/A2 VDD VDD VSS VSS gf180mcu_fd_sc_mcu7t5v0__xnor2_1
X_07385_ _10120_/Q _07382_/Z _07391_/B VDD VDD VSS VSS gf180mcu_fd_sc_mcu7t5v0__and2_1
X_09124_ _06047_/Z _09131_/A2 _09131_/B1 _09124_/B2 _10643_/D VDD VDD
+ VSS VSS gf180mcu_fd_sc_mcu7t5v0__oai22_1
X_06336_ _10049_/Q _06195_/Z _06339_/A1 VDD VDD VSS VSS gf180mcu_fd_sc_mcu7t5v0__nand2_1
X_09055_ _09920_/A1 _09061_/A2 _09061_/B1 _09055_/B2 _10588_/D VDD VDD
+ VSS VSS gf180mcu_fd_sc_mcu7t5v0__oai22_1
X_06267_ _10002_/Q _06446_/A2 _06307_/A1 VDD VDD VSS VSS gf180mcu_fd_sc_mcu7t5v0__nand2_1
X_05218_ _10548_/Q _09005_/B2 VDD VDD VSS VSS gf180mcu_fd_sc_mcu7t5v0__clkinv_1
X_08006_ _11003_/Q _08444_/B1 _08877_/A2 _11019_/Q _08006_/C _08007_/A3 VDD
+ VDD VSS VSS gf180mcu_fd_sc_mcu7t5v0__aoi221_4
X_06198_ _09999_/Q _09998_/Q _06198_/Z VDD VDD VSS VSS gf180mcu_fd_sc_mcu7t5v0__or2_2
X_05149_ _11174_/Q _09939_/B2 VDD VDD VSS VSS gf180mcu_fd_sc_mcu7t5v0__clkinv_1
X_09957_ _09957_/D _11176_/CLK _09957_/Q VDD VDD VSS VSS gf180mcu_fd_sc_mcu7t5v0__dffq_1
X_08908_ _10476_/Q _08920_/A2 _08909_/B VDD VDD VSS VSS gf180mcu_fd_sc_mcu7t5v0__nand2_1
X_09888_ _09916_/A1 _09888_/A2 _09888_/B _11141_/D VDD VDD VSS VSS
+ gf180mcu_fd_sc_mcu7t5v0__oai21_1
X_08839_ _10446_/Q _08836_/Z _08839_/Z VDD VDD VSS VSS gf180mcu_fd_sc_mcu7t5v0__and2_1
X_10801_ _10801_/D _11109_/CLK _10801_/Q VDD VDD VSS VSS gf180mcu_fd_sc_mcu7t5v0__dffq_1
X_10732_ _10732_/D _11142_/CLK _10732_/Q VDD VDD VSS VSS gf180mcu_fd_sc_mcu7t5v0__dffq_1
X_10663_ _10663_/D _10666_/CLK _10663_/Q VDD VDD VSS VSS gf180mcu_fd_sc_mcu7t5v0__dffq_1
X_10594_ _10594_/D _11138_/CLK _10594_/Q VDD VDD VSS VSS gf180mcu_fd_sc_mcu7t5v0__dffq_1
X_11146_ _11146_/D _11149_/CLK _11146_/Q VDD VDD VSS VSS gf180mcu_fd_sc_mcu7t5v0__dffq_1
X_11077_ _11077_/D _11082_/CLK _11077_/Q VDD VDD VSS VSS gf180mcu_fd_sc_mcu7t5v0__dffq_1
X_10028_ _10028_/D _11082_/CLK _10028_/Q VDD VDD VSS VSS gf180mcu_fd_sc_mcu7t5v0__dffq_1
X_07170_ _07170_/A1 _07170_/A2 _07170_/Z VDD VDD VSS VSS gf180mcu_fd_sc_mcu7t5v0__xor2_1
X_06121_ _09944_/A1 _06123_/A2 _06123_/B1 _06121_/B2 _09976_/D VDD VDD
+ VSS VSS gf180mcu_fd_sc_mcu7t5v0__oai22_1
X_06052_ _06074_/A1 _09904_/A1 _06052_/B _09948_/D VDD VDD VSS VSS
+ gf180mcu_fd_sc_mcu7t5v0__oai21_1
X_05003_ bus_wdata[4] _09698_/A1 VDD VDD VSS VSS gf180mcu_fd_sc_mcu7t5v0__inv_2
X_09811_ _11064_/Q _09817_/A2 _09811_/B _09812_/B VDD VDD VSS VSS
+ gf180mcu_fd_sc_mcu7t5v0__oai21_1
X_09742_ _09754_/B _09745_/A2 _09743_/C VDD VDD VSS VSS gf180mcu_fd_sc_mcu7t5v0__nand2_1
X_06954_ _10000_/Q _07222_/A2 _07019_/C _06955_/B VDD VDD VSS VSS
+ gf180mcu_fd_sc_mcu7t5v0__oai21_1
X_05905_ _10142_/Q _07667_/B2 VDD VDD VSS VSS gf180mcu_fd_sc_mcu7t5v0__clkinv_1
X_09673_ _11051_/Q _09673_/A2 _09673_/B _09674_/B VDD VDD VSS VSS
+ gf180mcu_fd_sc_mcu7t5v0__aoi21_1
X_06885_ _06058_/Z _06889_/A2 _06889_/B1 _06885_/B2 _10056_/D VDD VDD
+ VSS VSS gf180mcu_fd_sc_mcu7t5v0__oai22_1
X_05836_ _11165_/Q _09926_/B2 VDD VDD VSS VSS gf180mcu_fd_sc_mcu7t5v0__clkinv_1
X_08624_ _08629_/A2 _08698_/A2 _09900_/B _10313_/D VDD VDD VSS VSS
+ gf180mcu_fd_sc_mcu7t5v0__aoi21_1
X_08555_ _10546_/Q _08555_/A2 _08589_/B1 _10554_/Q _08558_/A1 VDD VDD
+ VSS VSS gf180mcu_fd_sc_mcu7t5v0__aoi22_1
X_05767_ _10705_/Q _09200_/B2 VDD VDD VSS VSS gf180mcu_fd_sc_mcu7t5v0__clkinv_1
X_07506_ _07506_/I _07553_/A1 VDD VDD VSS VSS gf180mcu_fd_sc_mcu7t5v0__clkinv_1
X_08486_ _09985_/Q _09872_/A1 _08877_/A2 _11025_/Q _08589_/B1 _10133_/Q _08487_/A3
+ VDD VDD VSS VSS gf180mcu_fd_sc_mcu7t5v0__aoi222_1
X_05698_ _11008_/Q _09595_/B2 VDD VDD VSS VSS gf180mcu_fd_sc_mcu7t5v0__clkinv_1
X_07437_ _07430_/B _07437_/A2 _07436_/B _07462_/A2 VDD VDD VSS VSS
+ gf180mcu_fd_sc_mcu7t5v0__nor3_1
X_07368_ _07368_/A1 _07368_/A2 _07368_/B _07409_/B _07371_/A3 VDD VDD
+ VSS VSS gf180mcu_fd_sc_mcu7t5v0__aoi211_4
X_09107_ _06058_/Z _09111_/A2 _09111_/B1 _09107_/B2 _10630_/D VDD VDD
+ VSS VSS gf180mcu_fd_sc_mcu7t5v0__oai22_1
X_06319_ _10003_/Q _06318_/Z _06368_/A1 VDD VDD VSS VSS gf180mcu_fd_sc_mcu7t5v0__nand2_1
X_07299_ _09920_/A1 _07311_/A2 _07299_/B _10107_/D VDD VDD VSS VSS
+ gf180mcu_fd_sc_mcu7t5v0__oai21_1
X_09038_ _06061_/Z _09041_/A2 _09041_/B1 _09038_/B2 _10575_/D VDD VDD
+ VSS VSS gf180mcu_fd_sc_mcu7t5v0__oai22_1
X_11000_ _11000_/D _11147_/CLK _11000_/Q VDD VDD VSS VSS gf180mcu_fd_sc_mcu7t5v0__dffq_1
X_10715_ _10715_/D _11139_/CLK _10715_/Q VDD VDD VSS VSS gf180mcu_fd_sc_mcu7t5v0__dffq_1
X_10646_ _10646_/D _10666_/CLK _10646_/Q VDD VDD VSS VSS gf180mcu_fd_sc_mcu7t5v0__dffq_1
X_10577_ _10577_/D _10666_/CLK _10577_/Q VDD VDD VSS VSS gf180mcu_fd_sc_mcu7t5v0__dffq_1
X_11129_ _11129_/D _11149_/CLK _11129_/Q VDD VDD VSS VSS gf180mcu_fd_sc_mcu7t5v0__dffq_1
X_06670_ _10048_/Q _06669_/Z _06688_/B VDD VDD VSS VSS gf180mcu_fd_sc_mcu7t5v0__and2_1
X_05621_ _10440_/Q _08827_/B2 VDD VDD VSS VSS gf180mcu_fd_sc_mcu7t5v0__clkinv_1
X_08340_ _10887_/Q _08547_/A2 _08573_/B1 _10219_/Q _08576_/B1 _10203_/Q _08342_/A2
+ VDD VDD VSS VSS gf180mcu_fd_sc_mcu7t5v0__aoi222_4
X_05552_ _10679_/Q _09168_/B2 VDD VDD VSS VSS gf180mcu_fd_sc_mcu7t5v0__clkinv_1
X_08271_ _10823_/Q _08555_/A2 _08584_/B1 _10879_/Q _08274_/A1 VDD VDD
+ VSS VSS gf180mcu_fd_sc_mcu7t5v0__aoi22_1
X_05483_ _10295_/Q _08604_/B2 VDD VDD VSS VSS gf180mcu_fd_sc_mcu7t5v0__clkinv_1
X_07222_ _10007_/Q _07222_/A2 _07225_/A2 VDD VDD VSS VSS gf180mcu_fd_sc_mcu7t5v0__nand2_1
X_07153_ _07151_/Z _07198_/B _07158_/C1 VDD VDD VSS VSS gf180mcu_fd_sc_mcu7t5v0__nor2_1
X_06104_ _09941_/A1 _06109_/A2 _06109_/B1 _06104_/B2 _09965_/D VDD VDD
+ VSS VSS gf180mcu_fd_sc_mcu7t5v0__oai22_1
X_07084_ _07085_/A1 _07084_/A2 _07082_/Z _07084_/Z VDD VDD VSS VSS
+ gf180mcu_fd_sc_mcu7t5v0__or3_1
X_06035_ _07921_/A1 _06147_/A2 _08349_/A1 VDD VDD VSS VSS gf180mcu_fd_sc_mcu7t5v0__nor2_1
X_07986_ _07986_/A1 _07986_/A2 _07986_/A3 _08015_/A1 VDD VDD VSS VSS
+ gf180mcu_fd_sc_mcu7t5v0__nand3_1
X_09725_ _09900_/B _11065_/Q _11064_/D VDD VDD VSS VSS gf180mcu_fd_sc_mcu7t5v0__or2_1
X_06937_ _10077_/Q _06945_/A2 _07247_/I1 VDD VDD VSS VSS gf180mcu_fd_sc_mcu7t5v0__nor2_4
X_09656_ _11040_/Q _09660_/A2 _09657_/B VDD VDD VSS VSS gf180mcu_fd_sc_mcu7t5v0__nand2_1
X_06868_ _06868_/A1 _06868_/A2 _06869_/A3 VDD VDD VSS VSS gf180mcu_fd_sc_mcu7t5v0__nand2_1
X_08607_ _09945_/A1 _08608_/A2 _08608_/B1 _08607_/B2 _10298_/D VDD VDD
+ VSS VSS gf180mcu_fd_sc_mcu7t5v0__oai22_1
X_09587_ _09832_/A1 _09587_/A2 _09587_/B1 _09587_/B2 _11002_/D VDD VDD
+ VSS VSS gf180mcu_fd_sc_mcu7t5v0__oai22_1
X_05819_ _10809_/Q _09330_/B2 VDD VDD VSS VSS gf180mcu_fd_sc_mcu7t5v0__clkinv_1
X_06799_ _06799_/A1 _06799_/A2 _06848_/B2 _06800_/I VDD VDD VSS VSS
+ gf180mcu_fd_sc_mcu7t5v0__xor3_1
X_08538_ _11109_/Q _08559_/A2 _08591_/C1 _10506_/Q _08591_/B1 _10522_/Q _08539_/A3
+ VDD VDD VSS VSS gf180mcu_fd_sc_mcu7t5v0__aoi222_2
X_08469_ _10873_/Q _08582_/A2 _06125_/I _10849_/Q _08471_/A2 VDD VDD VSS
+ VSS gf180mcu_fd_sc_mcu7t5v0__aoi22_1
X_10500_ _10500_/D _11109_/CLK _10500_/Q VDD VDD VSS VSS gf180mcu_fd_sc_mcu7t5v0__dffq_1
X_10431_ _10431_/D _11165_/CLK _10431_/Q VDD VDD VSS VSS gf180mcu_fd_sc_mcu7t5v0__dffq_1
X_10362_ _10362_/D _11109_/CLK _10362_/Q VDD VDD VSS VSS gf180mcu_fd_sc_mcu7t5v0__dffq_1
X_10293_ _10293_/D _11176_/CLK _10293_/Q VDD VDD VSS VSS gf180mcu_fd_sc_mcu7t5v0__dffq_1
X_10629_ _10629_/D _10978_/CLK _10629_/Q VDD VDD VSS VSS gf180mcu_fd_sc_mcu7t5v0__dffq_1
X_07840_ _07862_/A1 _07842_/A2 _07840_/B _09900_/B _10242_/D VDD VDD VSS
+ VSS gf180mcu_fd_sc_mcu7t5v0__aoi211_1
X_07771_ _08528_/A2 _07809_/A2 _09900_/B _07786_/A2 VDD VDD VSS VSS
+ gf180mcu_fd_sc_mcu7t5v0__aoi21_4
X_09510_ _09945_/A1 _09511_/A2 _09511_/B1 _09510_/B2 _10953_/D VDD VDD
+ VSS VSS gf180mcu_fd_sc_mcu7t5v0__oai22_1
X_04983_ _11086_/Q _09787_/A1 VDD VDD VSS VSS gf180mcu_fd_sc_mcu7t5v0__clkinv_1
X_06722_ _06823_/B _06854_/A2 _06723_/A2 VDD VDD VSS VSS gf180mcu_fd_sc_mcu7t5v0__nand2_1
X_09441_ _09916_/A1 _09441_/A2 _09441_/B1 _09441_/B2 _10898_/D VDD VDD
+ VSS VSS gf180mcu_fd_sc_mcu7t5v0__oai22_1
X_06653_ _06691_/A1 _10011_/Q _06691_/B _06655_/A2 VDD VDD VSS VSS
+ gf180mcu_fd_sc_mcu7t5v0__oai21_2
X_05604_ _10783_/Q _09298_/B2 VDD VDD VSS VSS gf180mcu_fd_sc_mcu7t5v0__clkinv_1
X_09372_ _09871_/A1 _09412_/A2 _09381_/A2 VDD VDD VSS VSS gf180mcu_fd_sc_mcu7t5v0__nand2_4
X_06584_ _06582_/I _06584_/A2 _07601_/B _06585_/B2 VDD VDD VSS VSS
+ gf180mcu_fd_sc_mcu7t5v0__aoi21_1
X_05535_ _10543_/Q _08998_/B2 VDD VDD VSS VSS gf180mcu_fd_sc_mcu7t5v0__clkinv_1
X_08323_ _10567_/Q _08564_/C1 _08584_/B1 _10599_/Q _08326_/A1 VDD VDD
+ VSS VSS gf180mcu_fd_sc_mcu7t5v0__aoi22_1
X_08254_ _09662_/A2 _08254_/A2 _08254_/B1 _09142_/A2 _08266_/A1 VDD VDD
+ VSS VSS gf180mcu_fd_sc_mcu7t5v0__aoi22_1
X_05466_ _09974_/Q _06119_/B2 VDD VDD VSS VSS gf180mcu_fd_sc_mcu7t5v0__clkinv_1
X_05397_ _10821_/Q _09346_/B2 VDD VDD VSS VSS gf180mcu_fd_sc_mcu7t5v0__clkinv_1
X_08185_ _09958_/Q _08563_/A2 _08584_/B1 _10366_/Q _08187_/A2 VDD VDD
+ VSS VSS gf180mcu_fd_sc_mcu7t5v0__aoi22_1
X_07205_ _10006_/Q _07243_/A2 _07207_/A2 VDD VDD VSS VSS gf180mcu_fd_sc_mcu7t5v0__nand2_1
X_07136_ _07083_/Z _07084_/Z _07136_/B _07171_/B VDD VDD VSS VSS gf180mcu_fd_sc_mcu7t5v0__aoi21_1
X_07067_ _07067_/A1 _07048_/Z _07067_/B _07120_/A1 VDD VDD VSS VSS
+ gf180mcu_fd_sc_mcu7t5v0__aoi21_1
X_06018_ _06110_/A1 _06017_/Z _06124_/A1 VDD VDD VSS VSS gf180mcu_fd_sc_mcu7t5v0__nand2_2
X_07969_ _10947_/Q _08547_/A2 _08573_/B1 _11126_/Q _06125_/I _10931_/Q _07970_/A3
+ VDD VDD VSS VSS gf180mcu_fd_sc_mcu7t5v0__aoi222_4
X_09708_ _11058_/Q _09678_/Z _09809_/B _09711_/A1 VDD VDD VSS VSS
+ gf180mcu_fd_sc_mcu7t5v0__oai21_1
X_10980_ _10980_/D _11010_/CLK _10980_/Q VDD VDD VSS VSS gf180mcu_fd_sc_mcu7t5v0__dffq_1
X_09639_ _09924_/A1 _09643_/A2 _09639_/B _11032_/D VDD VDD VSS VSS
+ gf180mcu_fd_sc_mcu7t5v0__oai21_1
X_10414_ _10414_/D _11164_/CLK _10414_/Q VDD VDD VSS VSS gf180mcu_fd_sc_mcu7t5v0__dffq_1
X_10345_ _10345_/D _11142_/CLK _10345_/Q VDD VDD VSS VSS gf180mcu_fd_sc_mcu7t5v0__dffq_1
X_10276_ _10276_/D _11052_/CLK _10276_/Q VDD VDD VSS VSS gf180mcu_fd_sc_mcu7t5v0__dffq_1
X_05320_ _10517_/Q _08966_/B2 VDD VDD VSS VSS gf180mcu_fd_sc_mcu7t5v0__clkinv_1
X_05251_ _10054_/Q _06883_/B2 VDD VDD VSS VSS gf180mcu_fd_sc_mcu7t5v0__clkinv_1
X_05182_ _10795_/Q _09314_/B2 VDD VDD VSS VSS gf180mcu_fd_sc_mcu7t5v0__clkinv_1
X_09990_ _09990_/D _11164_/CLK _09990_/Q VDD VDD VSS VSS gf180mcu_fd_sc_mcu7t5v0__dffq_1
X_08941_ _09832_/A1 _08941_/A2 _08941_/B1 _08941_/B2 _10498_/D VDD VDD
+ VSS VSS gf180mcu_fd_sc_mcu7t5v0__oai22_1
X_08872_ _10457_/Q _08868_/Z _08872_/B _08873_/B VDD VDD VSS VSS gf180mcu_fd_sc_mcu7t5v0__oai21_1
X_07823_ _09537_/A1 _07825_/A2 _07823_/B _10237_/D VDD VDD VSS VSS
+ gf180mcu_fd_sc_mcu7t5v0__oai21_1
X_07754_ _06058_/Z _07758_/A2 _07758_/B1 _07754_/B2 _10194_/D VDD VDD
+ VSS VSS gf180mcu_fd_sc_mcu7t5v0__oai22_1
X_06705_ _06707_/A1 _06704_/Z _06740_/B VDD VDD VSS VSS gf180mcu_fd_sc_mcu7t5v0__nor2_1
X_07685_ _06047_/Z _07699_/A2 _07685_/B _10151_/D VDD VDD VSS VSS
+ gf180mcu_fd_sc_mcu7t5v0__oai21_1
X_09424_ _06047_/Z _09431_/A2 _09431_/B1 _09424_/B2 _10883_/D VDD VDD
+ VSS VSS gf180mcu_fd_sc_mcu7t5v0__oai22_1
X_06636_ _07434_/A1 _06850_/A2 _06636_/A3 _06637_/B VDD VDD VSS VSS
+ gf180mcu_fd_sc_mcu7t5v0__xor3_1
X_09355_ _09920_/A1 _09361_/A2 _09361_/B1 _09355_/B2 _10828_/D VDD VDD
+ VSS VSS gf180mcu_fd_sc_mcu7t5v0__oai22_1
X_06567_ _10041_/Q _10040_/Q _06732_/A1 VDD VDD VSS VSS gf180mcu_fd_sc_mcu7t5v0__nand2_2
X_09286_ _09921_/A1 _09291_/A2 _09291_/B1 _09286_/B2 _10773_/D VDD VDD
+ VSS VSS gf180mcu_fd_sc_mcu7t5v0__oai22_1
X_05518_ _11162_/Q _09923_/B2 VDD VDD VSS VSS gf180mcu_fd_sc_mcu7t5v0__clkinv_1
X_06498_ _06498_/A1 _06496_/Z _06497_/Z _06498_/Z VDD VDD VSS VSS
+ gf180mcu_fd_sc_mcu7t5v0__xor3_1
X_08306_ _09975_/Q _08528_/B1 _08564_/C1 _10028_/Q _10057_/Q _06877_/Z _08309_/A1
+ VDD VDD VSS VSS gf180mcu_fd_sc_mcu7t5v0__aoi222_2
X_08237_ _10178_/Q _08589_/A2 _08591_/B1 _10990_/Q _08238_/A3 VDD VDD
+ VSS VSS gf180mcu_fd_sc_mcu7t5v0__aoi22_1
X_05449_ _10702_/Q _09197_/B2 VDD VDD VSS VSS gf180mcu_fd_sc_mcu7t5v0__clkinv_1
X_08168_ _10685_/Q _06023_/I _08586_/A2 _10709_/Q _08584_/A2 _10701_/Q _08170_/A2
+ VDD VDD VSS VSS gf180mcu_fd_sc_mcu7t5v0__aoi222_1
X_08099_ _09662_/A2 _08099_/A2 _08588_/B _08099_/B2 _08099_/C1 _09937_/A1 _08100_/A2
+ VDD VDD VSS VSS gf180mcu_fd_sc_mcu7t5v0__aoi222_1
X_07119_ _10087_/Q _07601_/B _07161_/A1 VDD VDD VSS VSS gf180mcu_fd_sc_mcu7t5v0__nand2_1
X_10130_ _10130_/D _11163_/CLK _10130_/Q VDD VDD VSS VSS gf180mcu_fd_sc_mcu7t5v0__dffq_1
X_10061_ _10061_/D _11181_/CLK _10061_/Q VDD VDD VSS VSS gf180mcu_fd_sc_mcu7t5v0__dffq_1
X_10963_ _10963_/D _11181_/CLK _10963_/Q VDD VDD VSS VSS gf180mcu_fd_sc_mcu7t5v0__dffq_1
X_10894_ _10894_/D _11109_/CLK _10894_/Q VDD VDD VSS VSS gf180mcu_fd_sc_mcu7t5v0__dffq_1
X_10328_ _10328_/D _11150_/CLK _10328_/Q VDD VDD VSS VSS gf180mcu_fd_sc_mcu7t5v0__dffq_1
X_10259_ _10259_/D _11052_/CLK _10259_/Q VDD VDD VSS VSS gf180mcu_fd_sc_mcu7t5v0__dffq_1
X_07470_ _07470_/A1 _07485_/A1 _07365_/I _07470_/B2 _07516_/A2 VDD VDD
+ VSS VSS gf180mcu_fd_sc_mcu7t5v0__oai22_1
X_06421_ _10005_/Q _06483_/A2 _06507_/B _06422_/A3 VDD VDD VSS VSS
+ gf180mcu_fd_sc_mcu7t5v0__aoi21_1
X_09140_ _09945_/A1 _09141_/A2 _09141_/B1 _09140_/B2 _10657_/D VDD VDD
+ VSS VSS gf180mcu_fd_sc_mcu7t5v0__oai22_1
X_06352_ _06352_/A1 _06352_/A2 _06350_/B _06354_/A2 VDD VDD VSS VSS
+ gf180mcu_fd_sc_mcu7t5v0__xnor3_1
X_05303_ _10437_/Q _08824_/B2 VDD VDD VSS VSS gf180mcu_fd_sc_mcu7t5v0__clkinv_1
X_09071_ _09946_/A1 _09071_/A2 _09071_/B1 _09071_/B2 _10602_/D VDD VDD
+ VSS VSS gf180mcu_fd_sc_mcu7t5v0__oai22_1
X_06283_ _06283_/A1 _06281_/Z _06283_/Z VDD VDD VSS VSS gf180mcu_fd_sc_mcu7t5v0__xor2_1
X_08022_ _10176_/Q _08589_/A2 _08591_/A2 _10380_/Q _08576_/B1 _10924_/Q _08024_/A2
+ VDD VDD VSS VSS gf180mcu_fd_sc_mcu7t5v0__aoi222_2
X_05234_ _10676_/Q _09165_/B2 VDD VDD VSS VSS gf180mcu_fd_sc_mcu7t5v0__clkinv_1
X_05165_ _10292_/Q _08601_/B2 VDD VDD VSS VSS gf180mcu_fd_sc_mcu7t5v0__clkinv_1
X_05096_ _10395_/Q _08772_/B2 VDD VDD VSS VSS gf180mcu_fd_sc_mcu7t5v0__clkinv_1
X_09973_ _09973_/D _11181_/CLK _09973_/Q VDD VDD VSS VSS gf180mcu_fd_sc_mcu7t5v0__dffq_1
X_08924_ _06047_/Z _08931_/A2 _08931_/B1 _08924_/B2 _10483_/D VDD VDD
+ VSS VSS gf180mcu_fd_sc_mcu7t5v0__oai22_1
X_08855_ _08853_/Z _08855_/A2 _10451_/D VDD VDD VSS VSS gf180mcu_fd_sc_mcu7t5v0__nor2_1
X_07806_ _09897_/A1 _07807_/A2 _07807_/B1 _07806_/B2 _10229_/D VDD VDD
+ VSS VSS gf180mcu_fd_sc_mcu7t5v0__oai22_1
X_08786_ _06061_/Z _08789_/A2 _08789_/B1 _08786_/B2 _10407_/D VDD VDD
+ VSS VSS gf180mcu_fd_sc_mcu7t5v0__oai22_1
X_07737_ _09897_/A1 _07738_/A2 _07738_/B1 _07737_/B2 _10181_/D VDD VDD
+ VSS VSS gf180mcu_fd_sc_mcu7t5v0__oai22_1
X_05998_ _11054_/Q _07876_/A2 _05986_/I _11085_/Q _05999_/A2 VDD VDD VSS
+ VSS gf180mcu_fd_sc_mcu7t5v0__aoi22_2
X_07668_ _08533_/B2 _08102_/A1 _09917_/A2 VDD VDD VSS VSS gf180mcu_fd_sc_mcu7t5v0__nor2_4
X_09407_ _06058_/Z _09411_/A2 _09411_/B1 _09407_/B2 _10870_/D VDD VDD
+ VSS VSS gf180mcu_fd_sc_mcu7t5v0__oai22_1
X_07599_ _07599_/A1 _07599_/A2 _07599_/B _07600_/C VDD VDD VSS VSS
+ gf180mcu_fd_sc_mcu7t5v0__aoi21_1
X_06619_ _10121_/Q _10044_/Q _06691_/B _06621_/B1 VDD VDD VSS VSS
+ gf180mcu_fd_sc_mcu7t5v0__oai21_2
X_09338_ _06061_/Z _09341_/A2 _09341_/B1 _09338_/B2 _10815_/D VDD VDD
+ VSS VSS gf180mcu_fd_sc_mcu7t5v0__oai22_1
X_09269_ _09924_/A1 _09271_/A2 _09271_/B1 _09269_/B2 _10760_/D VDD VDD
+ VSS VSS gf180mcu_fd_sc_mcu7t5v0__oai22_1
X_11162_ _11162_/D _11163_/CLK _11162_/Q VDD VDD VSS VSS gf180mcu_fd_sc_mcu7t5v0__dffq_1
X_10113_ _10113_/D _11139_/CLK _10113_/Q VDD VDD VSS VSS gf180mcu_fd_sc_mcu7t5v0__dffq_1
X_11093_ _11093_/D _11097_/CLK _11093_/Q VDD VDD VSS VSS gf180mcu_fd_sc_mcu7t5v0__dffq_1
X_10044_ _10044_/D _11150_/CLK _10044_/Q VDD VDD VSS VSS gf180mcu_fd_sc_mcu7t5v0__dffq_4
X_10946_ _10946_/D _11018_/CLK _10946_/Q VDD VDD VSS VSS gf180mcu_fd_sc_mcu7t5v0__dffq_1
X_10877_ _10877_/D _11165_/CLK _10877_/Q VDD VDD VSS VSS gf180mcu_fd_sc_mcu7t5v0__dffq_1
X_06970_ _07431_/A1 _07181_/A2 _06970_/A3 _06970_/Z VDD VDD VSS VSS
+ gf180mcu_fd_sc_mcu7t5v0__xor3_1
X_05921_ _10778_/Q _09291_/B2 VDD VDD VSS VSS gf180mcu_fd_sc_mcu7t5v0__clkinv_1
X_05852_ _10538_/Q _08991_/B2 VDD VDD VSS VSS gf180mcu_fd_sc_mcu7t5v0__clkinv_1
X_08640_ _08640_/A1 _07601_/B _08641_/C VDD VDD VSS VSS gf180mcu_fd_sc_mcu7t5v0__nor2_1
X_08571_ _09062_/A2 _08571_/A2 _08571_/B1 _09142_/A2 _08597_/A2 VDD VDD
+ VSS VSS gf180mcu_fd_sc_mcu7t5v0__aoi22_2
X_05783_ _10030_/Q _06530_/B2 VDD VDD VSS VSS gf180mcu_fd_sc_mcu7t5v0__clkinv_1
X_07522_ _07522_/A1 _07573_/B _07525_/A2 VDD VDD VSS VSS gf180mcu_fd_sc_mcu7t5v0__nand2_1
X_07453_ _10003_/Q _07428_/I _07568_/A1 VDD VDD VSS VSS gf180mcu_fd_sc_mcu7t5v0__nand2_1
X_06404_ _06405_/A1 _06405_/A2 _06477_/A1 VDD VDD VSS VSS gf180mcu_fd_sc_mcu7t5v0__nor2_1
X_09123_ _08658_/B _09131_/A2 _09131_/B1 VDD VDD VSS VSS gf180mcu_fd_sc_mcu7t5v0__nand2_2
X_07384_ _07384_/A1 _07384_/A2 _07388_/A2 VDD VDD VSS VSS gf180mcu_fd_sc_mcu7t5v0__nand2_1
X_06335_ _06342_/A1 _06335_/A2 _06335_/B _06354_/A1 VDD VDD VSS VSS
+ gf180mcu_fd_sc_mcu7t5v0__oai21_1
X_09054_ _06047_/Z _09061_/A2 _09061_/B1 _09054_/B2 _10587_/D VDD VDD
+ VSS VSS gf180mcu_fd_sc_mcu7t5v0__oai22_1
X_06266_ _10002_/Q _06481_/A2 _06269_/A3 VDD VDD VSS VSS gf180mcu_fd_sc_mcu7t5v0__nand2_1
X_05217_ _10540_/Q _08995_/B2 VDD VDD VSS VSS gf180mcu_fd_sc_mcu7t5v0__clkinv_1
X_08005_ _08005_/I _08006_/C VDD VDD VSS VSS gf180mcu_fd_sc_mcu7t5v0__clkinv_1
X_06197_ _09999_/Q _09998_/Q _06431_/A2 VDD VDD VSS VSS gf180mcu_fd_sc_mcu7t5v0__nor2_4
X_05148_ _09971_/Q _06116_/B2 VDD VDD VSS VSS gf180mcu_fd_sc_mcu7t5v0__clkinv_1
X_09956_ _09956_/D _11176_/CLK _09956_/Q VDD VDD VSS VSS gf180mcu_fd_sc_mcu7t5v0__dffq_1
X_05079_ _11074_/Q _05965_/A3 VDD VDD VSS VSS gf180mcu_fd_sc_mcu7t5v0__clkinv_1
X_09887_ _11141_/Q _09887_/A2 _09888_/B VDD VDD VSS VSS gf180mcu_fd_sc_mcu7t5v0__nand2_1
X_08907_ _06047_/Z _08921_/A2 _08907_/B _10475_/D VDD VDD VSS VSS
+ gf180mcu_fd_sc_mcu7t5v0__oai21_1
X_08838_ _10446_/Q _08836_/Z _08840_/A2 VDD VDD VSS VSS gf180mcu_fd_sc_mcu7t5v0__nor2_1
X_08769_ _09832_/A1 _08769_/A2 _08769_/B1 _08769_/B2 _10394_/D VDD VDD
+ VSS VSS gf180mcu_fd_sc_mcu7t5v0__oai22_1
X_10800_ _10800_/D _11010_/CLK _10800_/Q VDD VDD VSS VSS gf180mcu_fd_sc_mcu7t5v0__dffq_1
X_10731_ _10731_/D _11017_/CLK _10731_/Q VDD VDD VSS VSS gf180mcu_fd_sc_mcu7t5v0__dffq_1
X_10662_ _10662_/D _10666_/CLK _10662_/Q VDD VDD VSS VSS gf180mcu_fd_sc_mcu7t5v0__dffq_1
X_10593_ _10593_/D _11138_/CLK _10593_/Q VDD VDD VSS VSS gf180mcu_fd_sc_mcu7t5v0__dffq_1
X_11145_ _11145_/D _11149_/CLK _11145_/Q VDD VDD VSS VSS gf180mcu_fd_sc_mcu7t5v0__dffq_1
X_11076_ _11076_/D _11082_/CLK _11076_/Q VDD VDD VSS VSS gf180mcu_fd_sc_mcu7t5v0__dffq_1
X_10027_ _10027_/D _11181_/CLK _10027_/Q VDD VDD VSS VSS gf180mcu_fd_sc_mcu7t5v0__dffq_1
X_10929_ _10929_/D _11017_/CLK _10929_/Q VDD VDD VSS VSS gf180mcu_fd_sc_mcu7t5v0__dffq_1
X_06120_ _06061_/Z _06123_/A2 _06123_/B1 _06120_/B2 _09975_/D VDD VDD
+ VSS VSS gf180mcu_fd_sc_mcu7t5v0__oai22_1
X_06051_ _10120_/Q cgra_status[0] _06051_/B _09904_/A1 VDD VDD VSS VSS
+ gf180mcu_fd_sc_mcu7t5v0__aoi21_4
X_05002_ _10278_/Q _08652_/A1 VDD VDD VSS VSS gf180mcu_fd_sc_mcu7t5v0__clkinv_1
X_09810_ _09810_/A1 _09817_/A2 _09810_/B _11097_/D VDD VDD VSS VSS
+ gf180mcu_fd_sc_mcu7t5v0__aoi21_1
X_09741_ _11070_/Q _11069_/Q _05977_/Z _09745_/A2 VDD VDD VSS VSS
+ gf180mcu_fd_sc_mcu7t5v0__nand3_2
X_06953_ _10079_/Q _10078_/Q _06953_/A3 _07019_/C VDD VDD VSS VSS
+ gf180mcu_fd_sc_mcu7t5v0__nand3_4
X_05904_ _10166_/Q _07709_/B2 VDD VDD VSS VSS gf180mcu_fd_sc_mcu7t5v0__clkinv_1
X_09672_ _09724_/A2 _10291_/Q _09673_/B VDD VDD VSS VSS gf180mcu_fd_sc_mcu7t5v0__nor2_1
X_06884_ _09941_/A1 _06889_/A2 _06889_/B1 _06884_/B2 _10055_/D VDD VDD
+ VSS VSS gf180mcu_fd_sc_mcu7t5v0__oai22_1
X_05835_ _10150_/Q _07678_/B2 VDD VDD VSS VSS gf180mcu_fd_sc_mcu7t5v0__clkinv_1
X_08623_ _10314_/Q _10313_/Q _10312_/Q _08623_/C _10312_/D VDD VDD VSS
+ VSS gf180mcu_fd_sc_mcu7t5v0__aoi211_1
Xclkbuf_leaf_19_clk clkbuf_1_0_0_clk/Z _11139_/CLK VDD VDD VSS VSS
+ gf180mcu_fd_sc_mcu7t5v0__clkbuf_16
X_08554_ _08554_/A1 _08554_/A2 _08554_/A3 _08596_/C1 VDD VDD VSS VSS
+ gf180mcu_fd_sc_mcu7t5v0__nand3_1
X_05766_ _10697_/Q _09190_/B2 VDD VDD VSS VSS gf180mcu_fd_sc_mcu7t5v0__clkinv_1
X_07505_ _07505_/A1 _07505_/A2 _07505_/B _07506_/I VDD VDD VSS VSS
+ gf180mcu_fd_sc_mcu7t5v0__oai21_1
X_08485_ _09953_/Q _08560_/A2 _08560_/B1 _11009_/Q _07255_/I _10985_/Q _08487_/A2
+ VDD VDD VSS VSS gf180mcu_fd_sc_mcu7t5v0__aoi222_2
X_05697_ _10368_/Q _08737_/B2 VDD VDD VSS VSS gf180mcu_fd_sc_mcu7t5v0__clkinv_1
X_07436_ _07430_/B _07437_/A2 _07436_/B _07462_/B VDD VDD VSS VSS
+ gf180mcu_fd_sc_mcu7t5v0__oai21_1
X_07367_ _10114_/Q _07367_/A2 _07589_/B VDD VDD VSS VSS gf180mcu_fd_sc_mcu7t5v0__nand2_2
X_09106_ _09893_/A1 _09111_/A2 _09111_/B1 _09106_/B2 _10629_/D VDD VDD
+ VSS VSS gf180mcu_fd_sc_mcu7t5v0__oai22_1
X_06318_ _06297_/Z _06318_/A2 _06318_/Z VDD VDD VSS VSS gf180mcu_fd_sc_mcu7t5v0__xor2_1
X_09037_ _06058_/Z _09041_/A2 _09041_/B1 _09037_/B2 _10574_/D VDD VDD
+ VSS VSS gf180mcu_fd_sc_mcu7t5v0__oai22_1
X_07298_ _10107_/Q _07310_/A2 _07299_/B VDD VDD VSS VSS gf180mcu_fd_sc_mcu7t5v0__nand2_1
X_06249_ _10001_/Q _06481_/A2 _06446_/A2 _10000_/Q _06250_/A2 VDD VDD
+ VSS VSS gf180mcu_fd_sc_mcu7t5v0__aoi22_1
X_09939_ _06047_/Z _09946_/A2 _09946_/B1 _09939_/B2 _11174_/D VDD VDD
+ VSS VSS gf180mcu_fd_sc_mcu7t5v0__oai22_1
X_10714_ _10714_/D _11139_/CLK _10714_/Q VDD VDD VSS VSS gf180mcu_fd_sc_mcu7t5v0__dffq_1
X_10645_ _10645_/D _11176_/CLK _10645_/Q VDD VDD VSS VSS gf180mcu_fd_sc_mcu7t5v0__dffq_1
X_10576_ _10576_/D _10666_/CLK _10576_/Q VDD VDD VSS VSS gf180mcu_fd_sc_mcu7t5v0__dffq_1
X_11128_ _11128_/D _11149_/CLK _11128_/Q VDD VDD VSS VSS gf180mcu_fd_sc_mcu7t5v0__dffq_1
X_11059_ _11059_/D _11097_/CLK _11059_/Q VDD VDD VSS VSS gf180mcu_fd_sc_mcu7t5v0__dffq_1
X_05620_ _10472_/Q _08901_/B2 VDD VDD VSS VSS gf180mcu_fd_sc_mcu7t5v0__clkinv_1
X_05551_ _10671_/Q _09158_/B2 VDD VDD VSS VSS gf180mcu_fd_sc_mcu7t5v0__clkinv_1
X_08270_ _08270_/A1 _08270_/A2 _09900_/B _10283_/D VDD VDD VSS VSS
+ gf180mcu_fd_sc_mcu7t5v0__aoi21_1
X_05482_ _10902_/Q _09447_/B2 VDD VDD VSS VSS gf180mcu_fd_sc_mcu7t5v0__clkinv_1
X_07221_ _10005_/Q _07221_/A2 _07229_/A1 VDD VDD VSS VSS gf180mcu_fd_sc_mcu7t5v0__nand2_1
X_07152_ _07152_/A1 _07152_/A2 _07152_/B _07198_/B VDD VDD VSS VSS
+ gf180mcu_fd_sc_mcu7t5v0__aoi21_1
X_06103_ _09940_/A1 _06109_/A2 _06109_/B1 _06103_/B2 _09964_/D VDD VDD
+ VSS VSS gf180mcu_fd_sc_mcu7t5v0__oai22_1
Xclkbuf_leaf_8_clk clkbuf_1_0_0_clk/Z _11142_/CLK VDD VDD VSS VSS
+ gf180mcu_fd_sc_mcu7t5v0__clkbuf_16
X_07083_ _07085_/A2 _07177_/A1 _07083_/Z VDD VDD VSS VSS gf180mcu_fd_sc_mcu7t5v0__or2_1
X_06034_ _06034_/I _06147_/A2 VDD VDD VSS VSS gf180mcu_fd_sc_mcu7t5v0__inv_2
X_07985_ _10603_/Q _08563_/A2 _08584_/B1 _10659_/Q _08563_/C1 _10643_/Q _07986_/A3
+ VDD VDD VSS VSS gf180mcu_fd_sc_mcu7t5v0__aoi222_1
X_09724_ _09809_/B _09724_/A2 _09724_/A3 _09724_/A4 _11063_/D VDD VDD
+ VSS VSS gf180mcu_fd_sc_mcu7t5v0__nand4_1
X_06936_ _10079_/Q _06942_/A1 _06945_/A2 VDD VDD VSS VSS gf180mcu_fd_sc_mcu7t5v0__nand2_2
X_09655_ _06061_/Z _09661_/A2 _09655_/B _11039_/D VDD VDD VSS VSS
+ gf180mcu_fd_sc_mcu7t5v0__oai21_1
X_06867_ _06823_/B _06867_/A2 _06868_/A2 VDD VDD VSS VSS gf180mcu_fd_sc_mcu7t5v0__nand2_1
X_05818_ _10801_/Q _09320_/B2 VDD VDD VSS VSS gf180mcu_fd_sc_mcu7t5v0__clkinv_1
X_08606_ _09944_/A1 _08608_/A2 _08608_/B1 _08606_/B2 _10297_/D VDD VDD
+ VSS VSS gf180mcu_fd_sc_mcu7t5v0__oai22_1
X_09586_ _09897_/A1 _09587_/A2 _09587_/B1 _09586_/B2 _11001_/D VDD VDD
+ VSS VSS gf180mcu_fd_sc_mcu7t5v0__oai22_1
X_06798_ _06799_/A1 _06799_/A2 _06798_/Z VDD VDD VSS VSS gf180mcu_fd_sc_mcu7t5v0__and2_1
X_08537_ _10362_/Q _08540_/A2 _08590_/B1 _10530_/Q _08576_/B1 _10538_/Q _08539_/A2
+ VDD VDD VSS VSS gf180mcu_fd_sc_mcu7t5v0__aoi222_1
X_05749_ _10561_/Q _09020_/B2 VDD VDD VSS VSS gf180mcu_fd_sc_mcu7t5v0__clkinv_1
X_08468_ _10841_/Q _08590_/A2 _07680_/I _10865_/Q _08468_/C _08471_/A1 VDD VDD
+ VSS VSS gf180mcu_fd_sc_mcu7t5v0__aoi221_2
X_07419_ _10002_/Q _07633_/A2 _07516_/A1 _07632_/I0 _07548_/C _07420_/I VDD
+ VDD VSS VSS gf180mcu_fd_sc_mcu7t5v0__aoi221_1
X_10430_ _10430_/D _11165_/CLK _10430_/Q VDD VDD VSS VSS gf180mcu_fd_sc_mcu7t5v0__dffq_1
X_08399_ _10792_/Q _06112_/I _09872_/A1 _10784_/Q _08402_/A2 VDD VDD VSS
+ VSS gf180mcu_fd_sc_mcu7t5v0__aoi22_1
X_10361_ _10361_/D _11109_/CLK _10361_/Q VDD VDD VSS VSS gf180mcu_fd_sc_mcu7t5v0__dffq_1
X_10292_ _10292_/D _11176_/CLK _10292_/Q VDD VDD VSS VSS gf180mcu_fd_sc_mcu7t5v0__dffq_1
X_10628_ _10628_/D _10978_/CLK _10628_/Q VDD VDD VSS VSS gf180mcu_fd_sc_mcu7t5v0__dffq_1
X_10559_ _10559_/D _11138_/CLK _10559_/Q VDD VDD VSS VSS gf180mcu_fd_sc_mcu7t5v0__dffq_1
X_04982_ _11087_/Q _09789_/A1 VDD VDD VSS VSS gf180mcu_fd_sc_mcu7t5v0__clkinv_1
X_07770_ _09502_/A1 _09523_/A2 _07787_/A2 VDD VDD VSS VSS gf180mcu_fd_sc_mcu7t5v0__nand2_2
X_06721_ _06835_/A1 _06716_/Z _06735_/C VDD VDD VSS VSS gf180mcu_fd_sc_mcu7t5v0__nand2_1
X_09440_ _09925_/A1 _09441_/A2 _09441_/B1 _09440_/B2 _10897_/D VDD VDD
+ VSS VSS gf180mcu_fd_sc_mcu7t5v0__oai22_1
X_06652_ _10334_/Q _06651_/Z _06655_/A1 VDD VDD VSS VSS gf180mcu_fd_sc_mcu7t5v0__nand2_1
X_09371_ _09926_/A1 _09371_/A2 _09371_/B1 _09371_/B2 _10842_/D VDD VDD
+ VSS VSS gf180mcu_fd_sc_mcu7t5v0__oai22_1
X_05603_ _10775_/Q _09288_/B2 VDD VDD VSS VSS gf180mcu_fd_sc_mcu7t5v0__clkinv_1
X_06583_ _07326_/A3 _06583_/A2 _06834_/C _06584_/A2 VDD VDD VSS VSS
+ gf180mcu_fd_sc_mcu7t5v0__aoi21_1
X_05534_ _10535_/Q _08988_/B2 VDD VDD VSS VSS gf180mcu_fd_sc_mcu7t5v0__clkinv_1
X_08322_ _08322_/A1 _08322_/A2 _08322_/A3 _08328_/B1 VDD VDD VSS VSS
+ gf180mcu_fd_sc_mcu7t5v0__nand3_1
X_08253_ _08253_/A1 _08253_/A2 _08253_/A3 _08254_/B1 VDD VDD VSS VSS
+ gf180mcu_fd_sc_mcu7t5v0__nand3_2
X_05465_ _10027_/Q _06527_/B2 VDD VDD VSS VSS gf180mcu_fd_sc_mcu7t5v0__clkinv_1
X_07204_ _06470_/B _07204_/A2 _07204_/A3 _07208_/B1 VDD VDD VSS VSS
+ gf180mcu_fd_sc_mcu7t5v0__nand3_1
X_05396_ _10813_/Q _09336_/B2 VDD VDD VSS VSS gf180mcu_fd_sc_mcu7t5v0__clkinv_1
X_08184_ _10902_/Q _08584_/A2 _08563_/C1 _10295_/Q _08564_/C1 _10138_/Q _08187_/A1
+ VDD VDD VSS VSS gf180mcu_fd_sc_mcu7t5v0__aoi222_2
X_07135_ _07135_/A1 _07177_/B2 _07227_/A1 _07136_/B VDD VDD VSS VSS
+ gf180mcu_fd_sc_mcu7t5v0__xor3_1
X_07066_ _07603_/B _07066_/A2 _10085_/D VDD VDD VSS VSS gf180mcu_fd_sc_mcu7t5v0__nor2_1
X_06017_ _10317_/Q bus_addr[1] _08619_/B _06017_/Z VDD VDD VSS VSS
+ gf180mcu_fd_sc_mcu7t5v0__mux2_4
X_07968_ _10971_/Q _08555_/A2 _06877_/Z _10955_/Q _07680_/I _10907_/Q _07970_/A2 VDD
+ VDD VSS VSS gf180mcu_fd_sc_mcu7t5v0__aoi222_2
X_09707_ _11059_/Q _10289_/Q _09709_/A2 VDD VDD VSS VSS gf180mcu_fd_sc_mcu7t5v0__nand2_1
X_06919_ _06953_/A3 _08675_/A2 _06919_/B _10077_/D VDD VDD VSS VSS
+ gf180mcu_fd_sc_mcu7t5v0__aoi21_1
X_07899_ _07899_/A1 _07905_/A2 _07899_/B _10269_/D VDD VDD VSS VSS
+ gf180mcu_fd_sc_mcu7t5v0__aoi21_1
X_09638_ _11032_/Q _09642_/A2 _09639_/B VDD VDD VSS VSS gf180mcu_fd_sc_mcu7t5v0__nand2_1
X_09569_ _09918_/A1 _09577_/A2 _09577_/B1 VDD VDD VSS VSS gf180mcu_fd_sc_mcu7t5v0__nand2_2
X_10413_ _10413_/D _11165_/CLK _10413_/Q VDD VDD VSS VSS gf180mcu_fd_sc_mcu7t5v0__dffq_1
X_10344_ _10344_/D _11147_/CLK _10344_/Q VDD VDD VSS VSS gf180mcu_fd_sc_mcu7t5v0__dffq_1
X_10275_ _10275_/D _11052_/CLK _10275_/Q VDD VDD VSS VSS gf180mcu_fd_sc_mcu7t5v0__dffq_1
X_05250_ _10062_/Q _06893_/B2 VDD VDD VSS VSS gf180mcu_fd_sc_mcu7t5v0__clkinv_1
X_05181_ _10787_/Q _09304_/B2 VDD VDD VSS VSS gf180mcu_fd_sc_mcu7t5v0__clkinv_1
X_08940_ _09925_/A1 _08941_/A2 _08941_/B1 _08940_/B2 _10497_/D VDD VDD
+ VSS VSS gf180mcu_fd_sc_mcu7t5v0__oai22_1
X_08871_ _10457_/Q _08868_/Z _08874_/A2 VDD VDD VSS VSS gf180mcu_fd_sc_mcu7t5v0__nand2_1
X_07822_ _10237_/Q _07824_/A2 _07823_/B VDD VDD VSS VSS gf180mcu_fd_sc_mcu7t5v0__nand2_1
X_07753_ _09529_/A1 _07758_/A2 _07758_/B1 _07753_/B2 _10193_/D VDD VDD
+ VSS VSS gf180mcu_fd_sc_mcu7t5v0__oai22_1
X_07684_ _10151_/Q _07698_/A2 _07685_/B VDD VDD VSS VSS gf180mcu_fd_sc_mcu7t5v0__nand2_1
X_06704_ _06704_/A1 _06704_/A2 _06704_/A3 _06704_/Z VDD VDD VSS VSS
+ gf180mcu_fd_sc_mcu7t5v0__xor3_1
X_09423_ _09852_/A1 _09431_/A2 _09431_/B1 VDD VDD VSS VSS gf180mcu_fd_sc_mcu7t5v0__nand2_4
X_06635_ _10002_/Q _06635_/A2 _06678_/A1 VDD VDD VSS VSS gf180mcu_fd_sc_mcu7t5v0__nand2_1
X_09354_ _06047_/Z _09361_/A2 _09361_/B1 _09354_/B2 _10827_/D VDD VDD
+ VSS VSS gf180mcu_fd_sc_mcu7t5v0__oai22_1
X_08305_ _08305_/A1 _08305_/A2 _08305_/A3 _08346_/C1 VDD VDD VSS VSS
+ gf180mcu_fd_sc_mcu7t5v0__nand3_2
X_06566_ _10042_/Q _10041_/Q _06633_/A2 VDD VDD VSS VSS gf180mcu_fd_sc_mcu7t5v0__nor2_2
X_05517_ _10147_/Q _07675_/B2 VDD VDD VSS VSS gf180mcu_fd_sc_mcu7t5v0__clkinv_1
X_09285_ _09904_/A1 _09291_/A2 _09291_/B1 _09285_/B2 _10772_/D VDD VDD
+ VSS VSS gf180mcu_fd_sc_mcu7t5v0__oai22_1
X_06497_ _06497_/A1 _06497_/A2 _06497_/Z VDD VDD VSS VSS gf180mcu_fd_sc_mcu7t5v0__xor2_1
X_08236_ _10307_/Q _08590_/A2 _08590_/B1 _10942_/Q _08591_/C1 _10390_/Q _08238_/A2
+ VDD VDD VSS VSS gf180mcu_fd_sc_mcu7t5v0__aoi222_2
X_05448_ _10694_/Q _09187_/B2 VDD VDD VSS VSS gf180mcu_fd_sc_mcu7t5v0__clkinv_1
X_08167_ _10693_/Q _08564_/C1 _08584_/B1 _10717_/Q _08170_/A1 VDD VDD
+ VSS VSS gf180mcu_fd_sc_mcu7t5v0__aoi22_1
X_05379_ _10365_/Q _08734_/B2 VDD VDD VSS VSS gf180mcu_fd_sc_mcu7t5v0__clkinv_1
X_07118_ _07603_/B _07118_/A2 _07118_/A3 _10086_/D VDD VDD VSS VSS
+ gf180mcu_fd_sc_mcu7t5v0__nor3_1
X_08098_ _09332_/A2 _08098_/A2 _08098_/B1 _09861_/A2 _09442_/A1 _08098_/C2 _08100_/A1
+ VDD VDD VSS VSS gf180mcu_fd_sc_mcu7t5v0__aoi222_1
X_07049_ _07067_/A1 _07048_/Z _07064_/A2 VDD VDD VSS VSS gf180mcu_fd_sc_mcu7t5v0__xnor2_1
X_10060_ _10060_/D _11181_/CLK _10060_/Q VDD VDD VSS VSS gf180mcu_fd_sc_mcu7t5v0__dffq_1
X_10962_ _10962_/D _10978_/CLK _10962_/Q VDD VDD VSS VSS gf180mcu_fd_sc_mcu7t5v0__dffq_1
X_10893_ _10893_/D _11109_/CLK _10893_/Q VDD VDD VSS VSS gf180mcu_fd_sc_mcu7t5v0__dffq_1
X_10327_ _10327_/D _10327_/CLK _10327_/Q VDD VDD VSS VSS gf180mcu_fd_sc_mcu7t5v0__dffq_1
X_10258_ _10258_/D _10327_/CLK _10258_/Q VDD VDD VSS VSS gf180mcu_fd_sc_mcu7t5v0__dffq_1
X_10189_ _10189_/D _10905_/CLK _10189_/Q VDD VDD VSS VSS gf180mcu_fd_sc_mcu7t5v0__dffq_1
X_06420_ _06470_/A1 _06420_/A2 _06420_/B _06422_/A2 VDD VDD VSS VSS
+ gf180mcu_fd_sc_mcu7t5v0__aoi21_1
X_06351_ _06351_/A1 _06351_/A2 _06350_/B _06380_/A3 VDD VDD VSS VSS
+ gf180mcu_fd_sc_mcu7t5v0__nor3_1
X_05302_ _10469_/Q _08898_/B2 VDD VDD VSS VSS gf180mcu_fd_sc_mcu7t5v0__clkinv_1
X_09070_ _09945_/A1 _09071_/A2 _09071_/B1 _09070_/B2 _10601_/D VDD VDD
+ VSS VSS gf180mcu_fd_sc_mcu7t5v0__oai22_1
X_06282_ _06283_/A1 _06281_/Z _06282_/Z VDD VDD VSS VSS gf180mcu_fd_sc_mcu7t5v0__and2_1
X_08021_ _10396_/Q _08589_/B1 _08591_/B1 _10988_/Q _10940_/Q _08590_/B1 _08024_/A1
+ VDD VDD VSS VSS gf180mcu_fd_sc_mcu7t5v0__aoi222_2
X_05233_ _10668_/Q _09155_/B2 VDD VDD VSS VSS gf180mcu_fd_sc_mcu7t5v0__clkinv_1
X_05164_ _10899_/Q _09444_/B2 VDD VDD VSS VSS gf180mcu_fd_sc_mcu7t5v0__clkinv_1
X_05095_ _10175_/Q _07731_/B2 VDD VDD VSS VSS gf180mcu_fd_sc_mcu7t5v0__clkinv_1
X_09972_ _09972_/D _11082_/CLK _09972_/Q VDD VDD VSS VSS gf180mcu_fd_sc_mcu7t5v0__dffq_1
X_08923_ _09918_/A1 _08931_/A2 _08931_/B1 VDD VDD VSS VSS gf180mcu_fd_sc_mcu7t5v0__nand2_2
X_08854_ _10451_/Q _08850_/Z _08872_/B _08855_/A2 VDD VDD VSS VSS
+ gf180mcu_fd_sc_mcu7t5v0__oai21_1
X_07805_ _09896_/A1 _07807_/A2 _07807_/B1 _08405_/B2 _10228_/D VDD VDD
+ VSS VSS gf180mcu_fd_sc_mcu7t5v0__oai22_1
X_08785_ _06058_/Z _08789_/A2 _08789_/B1 _08785_/B2 _10406_/D VDD VDD
+ VSS VSS gf180mcu_fd_sc_mcu7t5v0__oai22_1
X_05997_ _10282_/Q _07829_/C _05999_/B VDD VDD VSS VSS gf180mcu_fd_sc_mcu7t5v0__nand2_1
X_07736_ _09896_/A1 _07738_/A2 _07738_/B1 _07736_/B2 _10180_/D VDD VDD
+ VSS VSS gf180mcu_fd_sc_mcu7t5v0__oai22_1
X_07667_ _09946_/A1 _07667_/A2 _07667_/B1 _07667_/B2 _10142_/D VDD VDD
+ VSS VSS gf180mcu_fd_sc_mcu7t5v0__oai22_1
X_09406_ _09893_/A1 _09411_/A2 _09411_/B1 _09406_/B2 _10869_/D VDD VDD
+ VSS VSS gf180mcu_fd_sc_mcu7t5v0__oai22_1
X_07598_ _10006_/Q _07325_/B _07632_/I1 _07598_/B2 _07633_/C _07599_/A2 VDD
+ VDD VSS VSS gf180mcu_fd_sc_mcu7t5v0__aoi221_1
X_06618_ _06618_/A1 _06618_/A2 _06618_/B _06650_/A1 VDD VDD VSS VSS
+ gf180mcu_fd_sc_mcu7t5v0__aoi21_2
X_09337_ _06058_/Z _09341_/A2 _09341_/B1 _09337_/B2 _10814_/D VDD VDD
+ VSS VSS gf180mcu_fd_sc_mcu7t5v0__oai22_1
X_06549_ _06691_/B _08675_/A2 _06549_/B _10043_/D VDD VDD VSS VSS
+ gf180mcu_fd_sc_mcu7t5v0__aoi21_1
X_09268_ _06061_/Z _09271_/A2 _09271_/B1 _09268_/B2 _10759_/D VDD VDD
+ VSS VSS gf180mcu_fd_sc_mcu7t5v0__oai22_1
X_08219_ _10822_/Q _08580_/A2 _08589_/B1 _10830_/Q _07680_/I _10862_/Q _08221_/A2
+ VDD VDD VSS VSS gf180mcu_fd_sc_mcu7t5v0__aoi222_2
X_09199_ _09884_/A1 _09201_/A2 _09201_/B1 _09199_/B2 _10704_/D VDD VDD
+ VSS VSS gf180mcu_fd_sc_mcu7t5v0__oai22_1
X_11161_ _11161_/D _11165_/CLK _11161_/Q VDD VDD VSS VSS gf180mcu_fd_sc_mcu7t5v0__dffq_1
X_10112_ _10112_/D _11163_/CLK _10112_/Q VDD VDD VSS VSS gf180mcu_fd_sc_mcu7t5v0__dffq_1
X_11092_ _11092_/D _11097_/CLK _11092_/Q VDD VDD VSS VSS gf180mcu_fd_sc_mcu7t5v0__dffq_1
X_10043_ _10043_/D _11150_/CLK _10043_/Q VDD VDD VSS VSS gf180mcu_fd_sc_mcu7t5v0__dffq_4
X_10945_ _10945_/D _11018_/CLK _10945_/Q VDD VDD VSS VSS gf180mcu_fd_sc_mcu7t5v0__dffq_1
X_10876_ _10876_/D _11138_/CLK _10876_/Q VDD VDD VSS VSS gf180mcu_fd_sc_mcu7t5v0__dffq_1
X_05920_ _10770_/Q _09281_/B2 VDD VDD VSS VSS gf180mcu_fd_sc_mcu7t5v0__clkinv_1
X_05851_ _10530_/Q _08981_/B2 VDD VDD VSS VSS gf180mcu_fd_sc_mcu7t5v0__clkinv_1
X_08570_ _08570_/A1 _08570_/A2 _08570_/A3 _08572_/B1 VDD VDD VSS VSS
+ gf180mcu_fd_sc_mcu7t5v0__nand3_1
X_07521_ _07526_/A1 _07617_/A1 _07569_/B VDD VDD VSS VSS gf180mcu_fd_sc_mcu7t5v0__nor2_1
X_05782_ _10038_/Q _06540_/B2 VDD VDD VSS VSS gf180mcu_fd_sc_mcu7t5v0__clkinv_1
X_07452_ _10003_/Q _07428_/I _07456_/B2 VDD VDD VSS VSS gf180mcu_fd_sc_mcu7t5v0__nor2_1
X_06403_ _06429_/A1 _06402_/Z _06405_/A2 VDD VDD VSS VSS gf180mcu_fd_sc_mcu7t5v0__xnor2_1
X_07383_ _10001_/Q _07633_/A2 _07382_/Z _07635_/A1 _07548_/C _07384_/A2 VDD
+ VDD VSS VSS gf180mcu_fd_sc_mcu7t5v0__aoi221_1
X_09122_ _09937_/A2 _09142_/A2 _09131_/A2 VDD VDD VSS VSS gf180mcu_fd_sc_mcu7t5v0__nand2_4
X_06334_ _06294_/Z _06313_/Z _06334_/B _06379_/A1 VDD VDD VSS VSS
+ gf180mcu_fd_sc_mcu7t5v0__aoi21_2
X_09053_ _09413_/A1 _09061_/A2 _09061_/B1 VDD VDD VSS VSS gf180mcu_fd_sc_mcu7t5v0__nand2_2
X_06265_ _10000_/Q _06479_/A2 _06300_/B2 VDD VDD VSS VSS gf180mcu_fd_sc_mcu7t5v0__nand2_1
X_05216_ _10532_/Q _08985_/B2 VDD VDD VSS VSS gf180mcu_fd_sc_mcu7t5v0__clkinv_1
X_08004_ _09947_/Q _08560_/A2 _07255_/I _10979_/Q _08005_/I VDD VDD VSS
+ VSS gf180mcu_fd_sc_mcu7t5v0__aoi22_1
X_06196_ _10045_/Q _09999_/Q _09998_/Q _06200_/B VDD VDD VSS VSS gf180mcu_fd_sc_mcu7t5v0__nand3_2
X_05147_ _10024_/Q _06524_/B2 VDD VDD VSS VSS gf180mcu_fd_sc_mcu7t5v0__clkinv_1
X_09955_ _09955_/D _11176_/CLK _09955_/Q VDD VDD VSS VSS gf180mcu_fd_sc_mcu7t5v0__dffq_1
X_05078_ _11071_/Q _09744_/A1 VDD VDD VSS VSS gf180mcu_fd_sc_mcu7t5v0__clkinv_1
X_09886_ _09897_/A1 _09888_/A2 _09886_/B _11140_/D VDD VDD VSS VSS
+ gf180mcu_fd_sc_mcu7t5v0__oai21_1
X_08906_ _10475_/Q _08920_/A2 _08907_/B VDD VDD VSS VSS gf180mcu_fd_sc_mcu7t5v0__nand2_1
X_08837_ _08831_/I _08837_/A2 _08836_/Z _10445_/D VDD VDD VSS VSS
+ gf180mcu_fd_sc_mcu7t5v0__nor3_1
X_08768_ _09897_/A1 _08769_/A2 _08769_/B1 _08768_/B2 _10393_/D VDD VDD
+ VSS VSS gf180mcu_fd_sc_mcu7t5v0__oai22_1
X_07719_ _06058_/Z _07727_/A2 _07719_/B _10170_/D VDD VDD VSS VSS
+ gf180mcu_fd_sc_mcu7t5v0__oai21_1
X_08699_ _08699_/A1 _08699_/A2 _09900_/B _10338_/D VDD VDD VSS VSS
+ gf180mcu_fd_sc_mcu7t5v0__aoi21_1
X_10730_ _10730_/D _11147_/CLK _10730_/Q VDD VDD VSS VSS gf180mcu_fd_sc_mcu7t5v0__dffq_1
X_10661_ _10661_/D _10666_/CLK _10661_/Q VDD VDD VSS VSS gf180mcu_fd_sc_mcu7t5v0__dffq_1
X_10592_ _10592_/D _11138_/CLK _10592_/Q VDD VDD VSS VSS gf180mcu_fd_sc_mcu7t5v0__dffq_1
X_11144_ _11144_/D _11147_/CLK _11144_/Q VDD VDD VSS VSS gf180mcu_fd_sc_mcu7t5v0__dffq_1
X_11075_ _11075_/D _11082_/CLK _11075_/Q VDD VDD VSS VSS gf180mcu_fd_sc_mcu7t5v0__dffq_1
X_10026_ _10026_/D _11181_/CLK _10026_/Q VDD VDD VSS VSS gf180mcu_fd_sc_mcu7t5v0__dffq_1
X_10928_ _10928_/D _11017_/CLK _10928_/Q VDD VDD VSS VSS gf180mcu_fd_sc_mcu7t5v0__dffq_1
X_10859_ _10859_/D _11142_/CLK _10859_/Q VDD VDD VSS VSS gf180mcu_fd_sc_mcu7t5v0__dffq_1
X_06050_ _07858_/A1 cgra_status[0] _06051_/B VDD VDD VSS VSS gf180mcu_fd_sc_mcu7t5v0__nor2_1
X_05001_ _10279_/Q _08656_/A1 VDD VDD VSS VSS gf180mcu_fd_sc_mcu7t5v0__clkinv_1
X_09740_ _11069_/Q _05977_/Z _11070_/Q _09743_/B VDD VDD VSS VSS gf180mcu_fd_sc_mcu7t5v0__aoi21_1
X_06952_ _06952_/A1 _06952_/A2 _07063_/C VDD VDD VSS VSS gf180mcu_fd_sc_mcu7t5v0__nor2_2
.ends
