* NGSPICE file created from NanoCGRA_Lite.ext - technology: gf180mcuD

.subckt gf180mcu_fd_sc_mcu7t5v0__and2_1 A1 A2 Z VDD VNW VPW VSS
X0 VDD A2 a_36_159# VNW pfet_05v0 ad=0.40575p pd=2.055u as=0.156p ps=1.12u w=0.6u l=0.5u
X1 Z a_36_159# VDD VNW pfet_05v0 ad=0.5346p pd=3.31u as=0.40575p ps=2.055u w=1.215u l=0.5u
X2 Z a_36_159# VSS VPW nfet_05v0 ad=0.3586p pd=2.51u as=0.23405p ps=1.555u w=0.815u l=0.6u
X3 VSS A2 a_244_159# VPW nfet_05v0 ad=0.23405p pd=1.555u as=58.399994f ps=0.685u w=0.365u l=0.6u
X4 a_244_159# A1 a_36_159# VPW nfet_05v0 ad=58.399994f pd=0.685u as=0.1606p ps=1.61u w=0.365u l=0.6u
X5 a_36_159# A1 VDD VNW pfet_05v0 ad=0.156p pd=1.12u as=0.264p ps=2.08u w=0.6u l=0.5u
.ends

.subckt gf180mcu_fd_sc_mcu7t5v0__dffq_1 D CLK Q VDD VNW VPW VSS
X0 VSS CLK a_36_151# VPW nfet_05v0 ad=0.1053p pd=0.925u as=0.1782p ps=1.69u w=0.405u l=0.6u
X1 Q a_2304_115# VSS VPW nfet_05v0 ad=0.3608p pd=2.52u as=0.3608p ps=2.52u w=0.82u l=0.6u
X2 a_2304_115# a_2011_527# VSS VPW nfet_05v0 ad=0.176p pd=1.68u as=0.142p ps=1.14u w=0.4u l=0.6u
X3 a_1004_159# D a_836_159# VPW nfet_05v0 ad=0.207p pd=1.51u as=43.199997f ps=0.6u w=0.36u l=0.6u
X4 a_1004_159# D a_880_527# VNW pfet_05v0 ad=0.1872p pd=1.4u as=53.999996f ps=0.66u w=0.36u l=0.5u
X5 a_2011_527# a_36_151# a_1376_115# VNW pfet_05v0 ad=0.1665p pd=1.285u as=0.1791p ps=1.355u w=0.36u l=0.5u
X6 a_2296_527# a_448_472# a_2011_527# VNW pfet_05v0 ad=50.399998f pd=0.64u as=0.1665p ps=1.285u w=0.36u l=0.5u
X7 a_1376_115# a_1004_159# VDD VNW pfet_05v0 ad=0.1791p pd=1.355u as=0.1044p ps=0.94u w=0.36u l=0.5u
X8 VDD CLK a_36_151# VNW pfet_05v0 ad=0.2249p pd=1.385u as=0.3806p ps=2.61u w=0.865u l=0.5u
X9 VSS a_1376_115# a_1328_159# VPW nfet_05v0 ad=0.2637p pd=1.825u as=43.199997f ps=0.6u w=0.36u l=0.6u
X10 a_2011_527# a_448_472# a_1376_115# VPW nfet_05v0 ad=93.59999f pd=0.88u as=93.59999f ps=0.88u w=0.36u l=0.6u
X11 a_448_472# a_36_151# VDD VNW pfet_05v0 ad=0.3806p pd=2.61u as=0.2249p ps=1.385u w=0.865u l=0.5u
X12 Q a_2304_115# VDD VNW pfet_05v0 ad=0.5368p pd=3.32u as=0.5368p ps=3.32u w=1.22u l=0.5u
X13 a_1376_115# a_1004_159# VSS VPW nfet_05v0 ad=93.59999f pd=0.88u as=0.2637p ps=1.825u w=0.36u l=0.6u
X14 VSS a_2304_115# a_2256_159# VPW nfet_05v0 ad=0.142p pd=1.14u as=43.199997f ps=0.6u w=0.36u l=0.6u
X15 a_836_159# a_36_151# VSS VPW nfet_05v0 ad=43.199997f pd=0.6u as=0.1584p ps=1.6u w=0.36u l=0.6u
X16 a_448_472# a_36_151# VSS VPW nfet_05v0 ad=0.1782p pd=1.69u as=0.1053p ps=0.925u w=0.405u l=0.6u
X17 a_2256_159# a_36_151# a_2011_527# VPW nfet_05v0 ad=43.199997f pd=0.6u as=93.59999f ps=0.88u w=0.36u l=0.6u
X18 a_880_527# a_448_472# VDD VNW pfet_05v0 ad=53.999996f pd=0.66u as=0.4554p ps=3.25u w=0.36u l=0.5u
X19 a_1348_527# a_36_151# a_1004_159# VNW pfet_05v0 ad=43.199997f pd=0.6u as=0.1872p ps=1.4u w=0.36u l=0.5u
X20 a_1328_159# a_448_472# a_1004_159# VPW nfet_05v0 ad=43.199997f pd=0.6u as=0.207p ps=1.51u w=0.36u l=0.6u
X21 VDD a_1376_115# a_1348_527# VNW pfet_05v0 ad=0.1044p pd=0.94u as=43.199997f ps=0.6u w=0.36u l=0.5u
X22 VDD a_2304_115# a_2296_527# VNW pfet_05v0 ad=0.23p pd=1.54u as=50.399998f ps=0.64u w=0.36u l=0.5u
X23 a_2304_115# a_2011_527# VDD VNW pfet_05v0 ad=0.352p pd=2.48u as=0.23p ps=1.54u w=0.8u l=0.5u
.ends

.subckt gf180mcu_fd_sc_mcu7t5v0__nand2_2 A1 A2 ZN VDD VNW VPW VSS
X0 a_244_68# A2 VSS VPW nfet_05v0 ad=0.1312p pd=1.14u as=0.3608p ps=2.52u w=0.82u l=0.6u
X1 ZN A1 a_244_68# VPW nfet_05v0 ad=0.2132p pd=1.34u as=0.1312p ps=1.14u w=0.82u l=0.6u
X2 ZN A2 VDD VNW pfet_05v0 ad=0.2938p pd=1.65u as=0.4972p ps=3.14u w=1.13u l=0.5u
X3 VDD A1 ZN VNW pfet_05v0 ad=0.2938p pd=1.65u as=0.2938p ps=1.65u w=1.13u l=0.5u
X4 a_652_68# A1 ZN VPW nfet_05v0 ad=0.1312p pd=1.14u as=0.2132p ps=1.34u w=0.82u l=0.6u
X5 VSS A2 a_652_68# VPW nfet_05v0 ad=0.3608p pd=2.52u as=0.1312p ps=1.14u w=0.82u l=0.6u
X6 ZN A1 VDD VNW pfet_05v0 ad=0.2938p pd=1.65u as=0.2938p ps=1.65u w=1.13u l=0.5u
X7 VDD A2 ZN VNW pfet_05v0 ad=0.4972p pd=3.14u as=0.2938p ps=1.65u w=1.13u l=0.5u
.ends

.subckt gf180mcu_fd_sc_mcu7t5v0__nand2_1 A1 A2 ZN VDD VNW VPW VSS
X0 ZN A2 VDD VNW pfet_05v0 ad=0.2938p pd=1.65u as=0.4972p ps=3.14u w=1.13u l=0.5u
X1 ZN A1 a_245_68# VPW nfet_05v0 ad=0.3608p pd=2.52u as=0.1312p ps=1.14u w=0.82u l=0.6u
X2 VDD A1 ZN VNW pfet_05v0 ad=0.4972p pd=3.14u as=0.2938p ps=1.65u w=1.13u l=0.5u
X3 a_245_68# A2 VSS VPW nfet_05v0 ad=0.1312p pd=1.14u as=0.3608p ps=2.52u w=0.82u l=0.6u
.ends

.subckt gf180mcu_fd_sc_mcu7t5v0__or2_1 A1 A2 Z VDD VNW VPW VSS
X0 a_255_603# A1 a_67_603# VNW pfet_05v0 ad=0.1469p pd=1.085u as=0.2486p ps=2.01u w=0.565u l=0.5u
X1 Z a_67_603# VSS VPW nfet_05v0 ad=0.3608p pd=2.52u as=0.2288p ps=1.58u w=0.82u l=0.6u
X2 VDD A2 a_255_603# VNW pfet_05v0 ad=0.38705p pd=2.08u as=0.1469p ps=1.085u w=0.565u l=0.5u
X3 VSS A2 a_67_603# VPW nfet_05v0 ad=0.2288p pd=1.58u as=93.59999f ps=0.88u w=0.36u l=0.6u
X4 Z a_67_603# VDD VNW pfet_05v0 ad=0.5368p pd=3.32u as=0.38705p ps=2.08u w=1.22u l=0.5u
X5 a_67_603# A1 VSS VPW nfet_05v0 ad=93.59999f pd=0.88u as=0.1584p ps=1.6u w=0.36u l=0.6u
.ends

.subckt gf180mcu_fd_sc_mcu7t5v0__oai22_1 A1 A2 B1 B2 ZN VDD VNW VPW VSS
X0 ZN A1 a_36_68# VPW nfet_05v0 ad=0.2132p pd=1.34u as=0.2132p ps=1.34u w=0.82u l=0.6u
X1 VSS B2 a_36_68# VPW nfet_05v0 ad=0.2132p pd=1.34u as=0.3608p ps=2.52u w=0.82u l=0.6u
X2 a_244_472# B2 VDD VNW pfet_05v0 ad=0.3782p pd=1.84u as=0.6588p ps=3.52u w=1.22u l=0.5u
X3 a_692_472# A1 ZN VNW pfet_05v0 ad=0.3172p pd=1.74u as=0.3782p ps=1.84u w=1.22u l=0.5u
X4 VDD A2 a_692_472# VNW pfet_05v0 ad=0.5368p pd=3.32u as=0.3172p ps=1.74u w=1.22u l=0.5u
X5 a_36_68# A2 ZN VPW nfet_05v0 ad=0.3608p pd=2.52u as=0.2132p ps=1.34u w=0.82u l=0.6u
X6 a_36_68# B1 VSS VPW nfet_05v0 ad=0.2132p pd=1.34u as=0.2132p ps=1.34u w=0.82u l=0.6u
X7 ZN B1 a_244_472# VNW pfet_05v0 ad=0.3782p pd=1.84u as=0.3782p ps=1.84u w=1.22u l=0.5u
.ends

.subckt gf180mcu_fd_sc_mcu7t5v0__nor2_1 A1 A2 ZN VDD VNW VPW VSS
X0 ZN A1 a_224_472# VNW pfet_05v0 ad=0.5368p pd=3.32u as=0.4087p ps=1.89u w=1.22u l=0.5u
X1 VSS A1 ZN VPW nfet_05v0 ad=0.2486p pd=2.01u as=0.1469p ps=1.085u w=0.565u l=0.6u
X2 a_224_472# A2 VDD VNW pfet_05v0 ad=0.4087p pd=1.89u as=0.5368p ps=3.32u w=1.22u l=0.5u
X3 ZN A2 VSS VPW nfet_05v0 ad=0.1469p pd=1.085u as=0.2486p ps=2.01u w=0.565u l=0.6u
.ends

.subckt gf180mcu_fd_sc_mcu7t5v0__nand3_4 A1 A2 A3 ZN VDD VNW VPW VSS
X0 VDD A1 ZN VNW pfet_05v0 ad=0.4334p pd=2.85u as=0.52205p ps=2.045u w=0.985u l=0.5u
X1 a_36_68# A1 ZN VPW nfet_05v0 ad=0.2132p pd=1.34u as=0.4161p ps=1.905u w=0.82u l=0.6u
X2 ZN A2 VDD VNW pfet_05v0 ad=0.2561p pd=1.505u as=0.30535p ps=1.605u w=0.985u l=0.5u
X3 a_36_68# A2 a_672_68# VPW nfet_05v0 ad=0.2132p pd=1.34u as=0.1722p ps=1.24u w=0.82u l=0.6u
X4 a_1732_68# A2 a_1528_68# VPW nfet_05v0 ad=0.1722p pd=1.24u as=0.1722p ps=1.24u w=0.82u l=0.6u
X5 ZN A3 VDD VNW pfet_05v0 ad=0.2561p pd=1.505u as=0.30535p ps=1.605u w=0.985u l=0.5u
X6 a_244_68# A2 a_36_68# VPW nfet_05v0 ad=0.1722p pd=1.24u as=0.3608p ps=2.52u w=0.82u l=0.6u
X7 a_1528_68# A3 VSS VPW nfet_05v0 ad=0.1722p pd=1.24u as=0.2132p ps=1.34u w=0.82u l=0.6u
X8 VDD A2 ZN VNW pfet_05v0 ad=0.2561p pd=1.505u as=0.2561p ps=1.505u w=0.985u l=0.5u
X9 ZN A1 a_36_68# VPW nfet_05v0 ad=0.4161p pd=1.905u as=0.2132p ps=1.34u w=0.82u l=0.6u
X10 VDD A3 ZN VNW pfet_05v0 ad=0.30535p pd=1.605u as=0.2561p ps=1.505u w=0.985u l=0.5u
X11 VDD A1 ZN VNW pfet_05v0 ad=0.30535p pd=1.605u as=0.52205p ps=2.045u w=0.985u l=0.5u
X12 a_1100_68# A2 a_36_68# VPW nfet_05v0 ad=0.1722p pd=1.24u as=0.2132p ps=1.34u w=0.82u l=0.6u
X13 ZN A1 VDD VNW pfet_05v0 ad=0.52205p pd=2.045u as=0.2561p ps=1.505u w=0.985u l=0.5u
X14 ZN A3 VDD VNW pfet_05v0 ad=0.2561p pd=1.505u as=0.30535p ps=1.605u w=0.985u l=0.5u
X15 ZN A1 a_1732_68# VPW nfet_05v0 ad=0.4161p pd=1.905u as=0.1722p ps=1.24u w=0.82u l=0.6u
X16 VSS A3 a_244_68# VPW nfet_05v0 ad=0.2132p pd=1.34u as=0.1722p ps=1.24u w=0.82u l=0.6u
X17 VDD A2 ZN VNW pfet_05v0 ad=0.30535p pd=1.605u as=0.2561p ps=1.505u w=0.985u l=0.5u
X18 VSS A3 a_1100_68# VPW nfet_05v0 ad=0.2132p pd=1.34u as=0.1722p ps=1.24u w=0.82u l=0.6u
X19 a_36_68# A1 ZN VPW nfet_05v0 ad=0.3608p pd=2.52u as=0.4161p ps=1.905u w=0.82u l=0.6u
X20 ZN A2 VDD VNW pfet_05v0 ad=0.2561p pd=1.505u as=0.4334p ps=2.85u w=0.985u l=0.5u
X21 a_672_68# A3 VSS VPW nfet_05v0 ad=0.1722p pd=1.24u as=0.2132p ps=1.34u w=0.82u l=0.6u
X22 VDD A3 ZN VNW pfet_05v0 ad=0.30535p pd=1.605u as=0.2561p ps=1.505u w=0.985u l=0.5u
X23 ZN A1 VDD VNW pfet_05v0 ad=0.52205p pd=2.045u as=0.30535p ps=1.605u w=0.985u l=0.5u
.ends

.subckt gf180mcu_fd_sc_mcu7t5v0__oai21_1 A1 A2 B ZN VDD VNW VPW VSS
X0 VSS B a_36_68# VPW nfet_05v0 ad=0.3608p pd=2.52u as=0.2132p ps=1.34u w=0.82u l=0.6u
X1 ZN A2 a_36_68# VPW nfet_05v0 ad=0.2132p pd=1.34u as=0.3608p ps=2.52u w=0.82u l=0.6u
X2 VDD B ZN VNW pfet_05v0 ad=0.4972p pd=3.14u as=0.4248p ps=1.94u w=1.13u l=0.5u
X3 a_244_472# A2 VDD VNW pfet_05v0 ad=0.3172p pd=1.74u as=0.5978p ps=3.42u w=1.22u l=0.5u
X4 ZN A1 a_244_472# VNW pfet_05v0 ad=0.4248p pd=1.94u as=0.3172p ps=1.74u w=1.22u l=0.5u
X5 a_36_68# A1 ZN VPW nfet_05v0 ad=0.2132p pd=1.34u as=0.2132p ps=1.34u w=0.82u l=0.6u
.ends

.subckt gf180mcu_fd_sc_mcu7t5v0__xor3_1 A1 A2 A3 Z VDD VNW VPW VSS
X0 a_952_93# A1 a_728_93# VPW nfet_05v0 ad=57.599995f pd=0.68u as=93.59999f ps=0.88u w=0.36u l=0.6u
X1 a_728_93# A1 a_718_524# VNW pfet_05v0 ad=0.1469p pd=1.085u as=0.161025p ps=1.135u w=0.565u l=0.5u
X2 a_1524_472# a_728_93# a_1336_472# VNW pfet_05v0 ad=90.4f pd=0.885u as=0.2486p ps=2.01u w=0.565u l=0.5u
X3 a_244_524# A2 a_56_524# VNW pfet_05v0 ad=93.59999f pd=0.88u as=0.1584p ps=1.6u w=0.36u l=0.5u
X4 a_718_524# a_56_524# VDD VNW pfet_05v0 ad=0.161025p pd=1.135u as=0.194p ps=1.415u w=0.565u l=0.5u
X5 a_718_524# A2 a_728_93# VNW pfet_05v0 ad=0.2486p pd=2.01u as=0.1469p ps=1.085u w=0.565u l=0.5u
X6 VSS A1 a_56_524# VPW nfet_05v0 ad=0.126p pd=1.06u as=93.59999f ps=0.88u w=0.36u l=0.6u
X7 a_1336_472# a_728_93# VSS VPW nfet_05v0 ad=93.59999f pd=0.88u as=0.1584p ps=1.6u w=0.36u l=0.6u
X8 VDD A1 a_244_524# VNW pfet_05v0 ad=0.194p pd=1.415u as=93.59999f ps=0.88u w=0.36u l=0.5u
X9 a_56_524# A2 VSS VPW nfet_05v0 ad=93.59999f pd=0.88u as=0.1584p ps=1.6u w=0.36u l=0.6u
X10 VSS A3 a_1336_472# VPW nfet_05v0 ad=0.218p pd=1.52u as=93.59999f ps=0.88u w=0.36u l=0.6u
X11 a_2215_68# A3 Z VPW nfet_05v0 ad=0.1312p pd=1.14u as=0.2132p ps=1.34u w=0.82u l=0.6u
X12 VSS a_728_93# a_2215_68# VPW nfet_05v0 ad=0.3608p pd=2.52u as=0.1312p ps=1.14u w=0.82u l=0.6u
X13 Z a_1336_472# VSS VPW nfet_05v0 ad=0.2132p pd=1.34u as=0.218p ps=1.52u w=0.82u l=0.6u
X14 Z A3 a_1936_472# VNW pfet_05v0 ad=0.3172p pd=1.74u as=0.3172p ps=1.74u w=1.22u l=0.5u
X15 a_728_93# a_56_524# VSS VPW nfet_05v0 ad=93.59999f pd=0.88u as=0.126p ps=1.06u w=0.36u l=0.6u
X16 a_1936_472# a_728_93# Z VNW pfet_05v0 ad=0.5368p pd=3.32u as=0.3172p ps=1.74u w=1.22u l=0.5u
X17 VSS A2 a_952_93# VPW nfet_05v0 ad=0.1584p pd=1.6u as=57.599995f ps=0.68u w=0.36u l=0.6u
X18 VDD A3 a_1524_472# VNW pfet_05v0 ad=0.35315p pd=1.96u as=90.4f ps=0.885u w=0.565u l=0.5u
X19 a_1936_472# a_1336_472# VDD VNW pfet_05v0 ad=0.3172p pd=1.74u as=0.35315p ps=1.96u w=1.22u l=0.5u
.ends

.subckt gf180mcu_fd_sc_mcu7t5v0__clkinv_1 I ZN VDD VNW VPW VSS
X0 ZN I VSS VPW nfet_05v0 ad=0.2112p pd=1.84u as=0.2112p ps=1.84u w=0.48u l=0.6u
X1 ZN I VDD VNW pfet_05v0 ad=0.5368p pd=3.32u as=0.5368p ps=3.32u w=1.22u l=0.5u
.ends

.subckt gf180mcu_fd_sc_mcu7t5v0__aoi21_1 A1 A2 B ZN VDD VNW VPW VSS
X0 a_244_68# A2 VSS VPW nfet_05v0 ad=0.1312p pd=1.14u as=0.3608p ps=2.52u w=0.82u l=0.6u
X1 ZN A1 a_244_68# VPW nfet_05v0 ad=0.2569p pd=1.56u as=0.1312p ps=1.14u w=0.82u l=0.6u
X2 VDD B a_36_472# VNW pfet_05v0 ad=0.5346p pd=3.31u as=0.44955p ps=1.955u w=1.215u l=0.5u
X3 ZN A2 a_36_472# VNW pfet_05v0 ad=0.3159p pd=1.735u as=0.5346p ps=3.31u w=1.215u l=0.5u
X4 a_36_472# A1 ZN VNW pfet_05v0 ad=0.44955p pd=1.955u as=0.3159p ps=1.735u w=1.215u l=0.5u
X5 VSS B ZN VPW nfet_05v0 ad=0.2244p pd=1.9u as=0.2569p ps=1.56u w=0.51u l=0.6u
.ends

.subckt gf180mcu_fd_sc_mcu7t5v0__and3_1 A1 A2 A3 Z VDD VNW VPW VSS
X0 Z a_36_148# VDD VNW pfet_05v0 ad=0.5346p pd=3.31u as=0.4268p ps=2.175u w=1.215u l=0.5u
X1 a_428_148# A2 a_244_148# VPW nfet_05v0 ad=79.799995f pd=0.8u as=60.8f ps=0.7u w=0.38u l=0.6u
X2 Z a_36_148# VSS VPW nfet_05v0 ad=0.341p pd=2.43u as=0.2424p ps=1.635u w=0.775u l=0.6u
X3 VSS A3 a_428_148# VPW nfet_05v0 ad=0.2424p pd=1.635u as=79.799995f ps=0.8u w=0.38u l=0.6u
X4 a_244_148# A1 a_36_148# VPW nfet_05v0 ad=60.8f pd=0.7u as=0.1672p ps=1.64u w=0.38u l=0.6u
X5 VDD A1 a_36_148# VNW pfet_05v0 ad=0.1391p pd=1.055u as=0.2354p ps=1.95u w=0.535u l=0.5u
X6 a_36_148# A2 VDD VNW pfet_05v0 ad=0.1391p pd=1.055u as=0.1391p ps=1.055u w=0.535u l=0.5u
X7 VDD A3 a_36_148# VNW pfet_05v0 ad=0.4268p pd=2.175u as=0.1391p ps=1.055u w=0.535u l=0.5u
.ends

.subckt gf180mcu_fd_sc_mcu7t5v0__aoi221_1 A1 A2 B1 B2 C ZN VDD VNW VPW VSS
X0 a_672_472# C a_56_472# VNW pfet_05v0 ad=0.3402p pd=1.775u as=0.37665p ps=1.835u w=1.215u l=0.5u
X1 VDD B2 a_56_472# VNW pfet_05v0 ad=0.3159p pd=1.735u as=0.5346p ps=3.31u w=1.215u l=0.5u
X2 ZN A1 a_940_90# VPW nfet_05v0 ad=0.3124p pd=2.3u as=85.2f ps=0.95u w=0.71u l=0.6u
X3 a_56_472# B1 VDD VNW pfet_05v0 ad=0.37665p pd=1.835u as=0.3159p ps=1.735u w=1.215u l=0.5u
X4 a_672_472# A1 ZN VNW pfet_05v0 ad=0.5346p pd=3.31u as=0.37665p ps=1.835u w=1.215u l=0.5u
X5 ZN A2 a_672_472# VNW pfet_05v0 ad=0.37665p pd=1.835u as=0.3402p ps=1.775u w=1.215u l=0.5u
X6 a_244_90# B2 VSS VPW nfet_05v0 ad=85.2f pd=0.95u as=0.3124p ps=2.3u w=0.71u l=0.6u
X7 ZN B1 a_244_90# VPW nfet_05v0 ad=0.21175p pd=1.41u as=85.2f ps=0.95u w=0.71u l=0.6u
X8 a_940_90# A2 VSS VPW nfet_05v0 ad=85.2f pd=0.95u as=0.22595p ps=1.45u w=0.71u l=0.6u
X9 VSS C ZN VPW nfet_05v0 ad=0.22595p pd=1.45u as=0.21175p ps=1.41u w=0.465u l=0.6u
.ends

.subckt gf180mcu_fd_sc_mcu7t5v0__xor2_1 A1 A2 Z VDD VNW VPW VSS
X0 a_728_472# a_56_604# VDD VNW pfet_05v0 ad=0.3172p pd=1.74u as=0.4005p ps=2.12u w=1.22u l=0.5u
X1 Z A1 a_728_472# VNW pfet_05v0 ad=0.3172p pd=1.74u as=0.3172p ps=1.74u w=1.22u l=0.5u
X2 VSS A1 a_56_604# VPW nfet_05v0 ad=0.218p pd=1.52u as=93.59999f ps=0.88u w=0.36u l=0.6u
X3 a_728_472# A2 Z VNW pfet_05v0 ad=0.5368p pd=3.32u as=0.3172p ps=1.74u w=1.22u l=0.5u
X4 Z a_56_604# VSS VPW nfet_05v0 ad=0.2132p pd=1.34u as=0.218p ps=1.52u w=0.82u l=0.6u
X5 VSS A2 a_952_68# VPW nfet_05v0 ad=0.3608p pd=2.52u as=0.1312p ps=1.14u w=0.82u l=0.6u
X6 a_244_604# A2 a_56_604# VNW pfet_05v0 ad=0.1456p pd=1.08u as=0.2464p ps=2u w=0.56u l=0.5u
X7 a_56_604# A2 VSS VPW nfet_05v0 ad=93.59999f pd=0.88u as=0.1584p ps=1.6u w=0.36u l=0.6u
X8 a_952_68# A1 Z VPW nfet_05v0 ad=0.1312p pd=1.14u as=0.2132p ps=1.34u w=0.82u l=0.6u
X9 VDD A1 a_244_604# VNW pfet_05v0 ad=0.4005p pd=2.12u as=0.1456p ps=1.08u w=0.56u l=0.5u
.ends

.subckt gf180mcu_fd_sc_mcu7t5v0__oai32_1 A1 A2 A3 B1 B2 ZN VDD VNW VPW VSS
X0 ZN A1 a_468_472# VNW pfet_05v0 ad=0.4392p pd=1.94u as=0.3172p ps=1.74u w=1.22u l=0.5u
X1 a_244_68# A1 VSS VPW nfet_05v0 ad=0.2132p pd=1.34u as=0.2132p ps=1.34u w=0.82u l=0.6u
X2 a_244_68# A3 VSS VPW nfet_05v0 ad=0.2132p pd=1.34u as=0.3608p ps=2.52u w=0.82u l=0.6u
X3 a_916_472# B1 ZN VNW pfet_05v0 ad=0.3172p pd=1.74u as=0.4392p ps=1.94u w=1.22u l=0.5u
X4 VDD B2 a_916_472# VNW pfet_05v0 ad=0.5368p pd=3.32u as=0.3172p ps=1.74u w=1.22u l=0.5u
X5 ZN B1 a_244_68# VPW nfet_05v0 ad=0.2132p pd=1.34u as=0.2132p ps=1.34u w=0.82u l=0.6u
X6 a_224_472# A3 VDD VNW pfet_05v0 ad=0.4392p pd=1.94u as=0.5368p ps=3.32u w=1.22u l=0.5u
X7 VSS A2 a_244_68# VPW nfet_05v0 ad=0.2132p pd=1.34u as=0.2132p ps=1.34u w=0.82u l=0.6u
X8 a_244_68# B2 ZN VPW nfet_05v0 ad=0.3608p pd=2.52u as=0.2132p ps=1.34u w=0.82u l=0.6u
X9 a_468_472# A2 a_224_472# VNW pfet_05v0 ad=0.3172p pd=1.74u as=0.4392p ps=1.94u w=1.22u l=0.5u
.ends

.subckt gf180mcu_fd_sc_mcu7t5v0__aoi22_4 A1 A2 B1 B2 ZN VDD VNW VPW VSS
X0 a_36_497# B1 VDD VNW pfet_05v0 ad=0.2847p pd=1.615u as=0.2847p ps=1.615u w=1.095u l=0.5u
X1 a_2356_68# A1 ZN VPW nfet_05v0 ad=0.1312p pd=1.14u as=0.2132p ps=1.34u w=0.82u l=0.6u
X2 VDD B1 a_36_497# VNW pfet_05v0 ad=0.2847p pd=1.615u as=0.2847p ps=1.615u w=1.095u l=0.5u
X3 a_244_68# B2 VSS VPW nfet_05v0 ad=0.1312p pd=1.14u as=0.3608p ps=2.52u w=0.82u l=0.6u
X4 ZN B1 a_244_68# VPW nfet_05v0 ad=0.2132p pd=1.34u as=0.1312p ps=1.14u w=0.82u l=0.6u
X5 a_1468_68# B1 ZN VPW nfet_05v0 ad=0.1312p pd=1.14u as=0.2132p ps=1.34u w=0.82u l=0.6u
X6 a_36_497# B2 VDD VNW pfet_05v0 ad=0.2847p pd=1.615u as=0.2847p ps=1.615u w=1.095u l=0.5u
X7 ZN A1 a_2764_68# VPW nfet_05v0 ad=0.4161p pd=1.905u as=0.1312p ps=1.14u w=0.82u l=0.6u
X8 a_2764_68# A2 VSS VPW nfet_05v0 ad=0.1312p pd=1.14u as=0.2132p ps=1.34u w=0.82u l=0.6u
X9 VDD B2 a_36_497# VNW pfet_05v0 ad=0.2847p pd=1.615u as=0.2847p ps=1.615u w=1.095u l=0.5u
X10 ZN A1 a_36_497# VNW pfet_05v0 ad=0.2847p pd=1.615u as=0.5256p ps=2.055u w=1.095u l=0.5u
X11 ZN A1 a_1948_68# VPW nfet_05v0 ad=0.2132p pd=1.34u as=0.1312p ps=1.14u w=0.82u l=0.6u
X12 a_652_68# B1 ZN VPW nfet_05v0 ad=0.1312p pd=1.14u as=0.2132p ps=1.34u w=0.82u l=0.6u
X13 VSS B2 a_652_68# VPW nfet_05v0 ad=0.2132p pd=1.34u as=0.1312p ps=1.14u w=0.82u l=0.6u
X14 VSS A2 a_3260_68# VPW nfet_05v0 ad=0.3608p pd=2.52u as=0.1312p ps=1.14u w=0.82u l=0.6u
X15 a_36_497# A2 ZN VNW pfet_05v0 ad=0.4818p pd=3.07u as=0.2847p ps=1.615u w=1.095u l=0.5u
X16 a_3260_68# A1 ZN VPW nfet_05v0 ad=0.1312p pd=1.14u as=0.4161p ps=1.905u w=0.82u l=0.6u
X17 a_36_497# A1 ZN VNW pfet_05v0 ad=0.2847p pd=1.615u as=0.2847p ps=1.615u w=1.095u l=0.5u
X18 a_36_497# B1 VDD VNW pfet_05v0 ad=0.2847p pd=1.615u as=0.2847p ps=1.615u w=1.095u l=0.5u
X19 ZN B1 a_1060_68# VPW nfet_05v0 ad=0.2132p pd=1.34u as=0.1312p ps=1.14u w=0.82u l=0.6u
X20 ZN A1 a_36_497# VNW pfet_05v0 ad=0.2847p pd=1.615u as=0.2847p ps=1.615u w=1.095u l=0.5u
X21 a_1948_68# A2 VSS VPW nfet_05v0 ad=0.1312p pd=1.14u as=0.3608p ps=1.7u w=0.82u l=0.6u
X22 VSS A2 a_2356_68# VPW nfet_05v0 ad=0.2132p pd=1.34u as=0.1312p ps=1.14u w=0.82u l=0.6u
X23 a_1060_68# B2 VSS VPW nfet_05v0 ad=0.1312p pd=1.14u as=0.2132p ps=1.34u w=0.82u l=0.6u
X24 VDD B1 a_36_497# VNW pfet_05v0 ad=0.2847p pd=1.615u as=0.2847p ps=1.615u w=1.095u l=0.5u
X25 ZN A2 a_36_497# VNW pfet_05v0 ad=0.2847p pd=1.615u as=0.4818p ps=1.975u w=1.095u l=0.5u
X26 a_36_497# A2 ZN VNW pfet_05v0 ad=0.2847p pd=1.615u as=0.2847p ps=1.615u w=1.095u l=0.5u
X27 a_36_497# B2 VDD VNW pfet_05v0 ad=0.4818p pd=1.975u as=0.2847p ps=1.615u w=1.095u l=0.5u
X28 VSS B2 a_1468_68# VPW nfet_05v0 ad=0.3608p pd=1.7u as=0.1312p ps=1.14u w=0.82u l=0.6u
X29 ZN A2 a_36_497# VNW pfet_05v0 ad=0.2847p pd=1.615u as=0.2847p ps=1.615u w=1.095u l=0.5u
X30 a_36_497# A1 ZN VNW pfet_05v0 ad=0.5256p pd=2.055u as=0.2847p ps=1.615u w=1.095u l=0.5u
X31 VDD B2 a_36_497# VNW pfet_05v0 ad=0.2847p pd=1.615u as=0.4818p ps=3.07u w=1.095u l=0.5u
.ends

.subckt gf180mcu_fd_sc_mcu7t5v0__aoi211_1 A1 A2 B C ZN VDD VNW VPW VSS
X0 ZN A2 a_37_472# VNW pfet_05v0 ad=0.3159p pd=1.735u as=0.5346p ps=3.31u w=1.215u l=0.5u
X1 VSS B ZN VPW nfet_05v0 ad=0.1209p pd=0.985u as=0.21175p ps=1.41u w=0.465u l=0.6u
X2 a_37_472# A1 ZN VNW pfet_05v0 ad=0.37665p pd=1.835u as=0.3159p ps=1.735u w=1.215u l=0.5u
X3 VDD C a_653_472# VNW pfet_05v0 ad=0.5346p pd=3.31u as=0.37665p ps=1.835u w=1.215u l=0.5u
X4 a_245_90# A2 VSS VPW nfet_05v0 ad=85.2f pd=0.95u as=0.3124p ps=2.3u w=0.71u l=0.6u
X5 ZN A1 a_245_90# VPW nfet_05v0 ad=0.21175p pd=1.41u as=85.2f ps=0.95u w=0.71u l=0.6u
X6 a_653_472# B a_37_472# VNW pfet_05v0 ad=0.37665p pd=1.835u as=0.37665p ps=1.835u w=1.215u l=0.5u
X7 ZN C VSS VPW nfet_05v0 ad=0.2046p pd=1.81u as=0.1209p ps=0.985u w=0.465u l=0.6u
.ends

.subckt gf180mcu_fd_sc_mcu7t5v0__dffq_2 D CLK Q VDD VNW VPW VSS
X0 VSS a_2304_115# Q VPW nfet_05v0 ad=0.3608p pd=2.52u as=0.2132p ps=1.34u w=0.82u l=0.6u
X1 VSS CLK a_36_151# VPW nfet_05v0 ad=0.1053p pd=0.925u as=0.1782p ps=1.69u w=0.405u l=0.6u
X2 Q a_2304_115# VSS VPW nfet_05v0 ad=0.2132p pd=1.34u as=0.3608p ps=2.52u w=0.82u l=0.6u
X3 a_2304_115# a_2011_527# VSS VPW nfet_05v0 ad=0.176p pd=1.68u as=0.142p ps=1.14u w=0.4u l=0.6u
X4 a_1004_159# D a_836_159# VPW nfet_05v0 ad=0.207p pd=1.51u as=43.199997f ps=0.6u w=0.36u l=0.6u
X5 a_1004_159# D a_880_527# VNW pfet_05v0 ad=0.1872p pd=1.4u as=53.999996f ps=0.66u w=0.36u l=0.5u
X6 a_2011_527# a_36_151# a_1376_115# VNW pfet_05v0 ad=0.1665p pd=1.285u as=0.1791p ps=1.355u w=0.36u l=0.5u
X7 a_2296_527# a_448_472# a_2011_527# VNW pfet_05v0 ad=50.399998f pd=0.64u as=0.1665p ps=1.285u w=0.36u l=0.5u
X8 a_1376_115# a_1004_159# VDD VNW pfet_05v0 ad=0.1791p pd=1.355u as=0.1044p ps=0.94u w=0.36u l=0.5u
X9 VDD CLK a_36_151# VNW pfet_05v0 ad=0.2249p pd=1.385u as=0.3806p ps=2.61u w=0.865u l=0.5u
X10 VDD a_2304_115# Q VNW pfet_05v0 ad=0.854p pd=3.84u as=0.3172p ps=1.74u w=1.22u l=0.5u
X11 VSS a_1376_115# a_1328_159# VPW nfet_05v0 ad=0.2637p pd=1.825u as=43.199997f ps=0.6u w=0.36u l=0.6u
X12 a_2011_527# a_448_472# a_1376_115# VPW nfet_05v0 ad=93.59999f pd=0.88u as=93.59999f ps=0.88u w=0.36u l=0.6u
X13 a_448_472# a_36_151# VDD VNW pfet_05v0 ad=0.3806p pd=2.61u as=0.2249p ps=1.385u w=0.865u l=0.5u
X14 Q a_2304_115# VDD VNW pfet_05v0 ad=0.3172p pd=1.74u as=0.5368p ps=3.32u w=1.22u l=0.5u
X15 a_1376_115# a_1004_159# VSS VPW nfet_05v0 ad=93.59999f pd=0.88u as=0.2637p ps=1.825u w=0.36u l=0.6u
X16 VSS a_2304_115# a_2256_159# VPW nfet_05v0 ad=0.142p pd=1.14u as=43.199997f ps=0.6u w=0.36u l=0.6u
X17 a_836_159# a_36_151# VSS VPW nfet_05v0 ad=43.199997f pd=0.6u as=0.1584p ps=1.6u w=0.36u l=0.6u
X18 a_448_472# a_36_151# VSS VPW nfet_05v0 ad=0.1782p pd=1.69u as=0.1053p ps=0.925u w=0.405u l=0.6u
X19 a_2256_159# a_36_151# a_2011_527# VPW nfet_05v0 ad=43.199997f pd=0.6u as=93.59999f ps=0.88u w=0.36u l=0.6u
X20 a_880_527# a_448_472# VDD VNW pfet_05v0 ad=53.999996f pd=0.66u as=0.4554p ps=3.25u w=0.36u l=0.5u
X21 a_1348_527# a_36_151# a_1004_159# VNW pfet_05v0 ad=43.199997f pd=0.6u as=0.1872p ps=1.4u w=0.36u l=0.5u
X22 a_1328_159# a_448_472# a_1004_159# VPW nfet_05v0 ad=43.199997f pd=0.6u as=0.207p ps=1.51u w=0.36u l=0.6u
X23 VDD a_1376_115# a_1348_527# VNW pfet_05v0 ad=0.1044p pd=0.94u as=43.199997f ps=0.6u w=0.36u l=0.5u
X24 VDD a_2304_115# a_2296_527# VNW pfet_05v0 ad=0.23p pd=1.54u as=50.399998f ps=0.64u w=0.36u l=0.5u
X25 a_2304_115# a_2011_527# VDD VNW pfet_05v0 ad=0.352p pd=2.48u as=0.23p ps=1.54u w=0.8u l=0.5u
.ends

.subckt gf180mcu_fd_sc_mcu7t5v0__oai21_2 A1 A2 B ZN VDD VNW VPW VSS
X0 ZN A1 a_692_497# VNW pfet_05v0 ad=0.2847p pd=1.615u as=0.4599p ps=1.935u w=1.095u l=0.5u
X1 ZN A2 a_36_68# VPW nfet_05v0 ad=0.30965p pd=1.685u as=0.2132p ps=1.34u w=0.82u l=0.6u
X2 VSS B a_36_68# VPW nfet_05v0 ad=0.2132p pd=1.34u as=0.3608p ps=2.52u w=0.82u l=0.6u
X3 a_36_68# A2 ZN VPW nfet_05v0 ad=0.3608p pd=2.52u as=0.31215p ps=1.685u w=0.82u l=0.6u
X4 a_36_68# A1 ZN VPW nfet_05v0 ad=0.2132p pd=1.34u as=0.30965p ps=1.685u w=0.82u l=0.6u
X5 a_1164_497# A1 ZN VNW pfet_05v0 ad=0.4599p pd=1.935u as=0.2847p ps=1.615u w=1.095u l=0.5u
X6 ZN B VDD VNW pfet_05v0 ad=0.2483p pd=1.475u as=0.4202p ps=2.79u w=0.955u l=0.5u
X7 a_692_497# A2 VDD VNW pfet_05v0 ad=0.4599p pd=1.935u as=0.3718p ps=1.815u w=1.095u l=0.5u
X8 VDD B ZN VNW pfet_05v0 ad=0.3718p pd=1.815u as=0.2483p ps=1.475u w=0.955u l=0.5u
X9 VDD A2 a_1164_497# VNW pfet_05v0 ad=0.4818p pd=3.07u as=0.4599p ps=1.935u w=1.095u l=0.5u
X10 a_36_68# B VSS VPW nfet_05v0 ad=0.2132p pd=1.34u as=0.2132p ps=1.34u w=0.82u l=0.6u
X11 ZN A1 a_36_68# VPW nfet_05v0 ad=0.31215p pd=1.685u as=0.2132p ps=1.34u w=0.82u l=0.6u
.ends

.subckt gf180mcu_fd_sc_mcu7t5v0__nand3_1 A1 A2 A3 ZN VDD VNW VPW VSS
X0 ZN A1 a_455_68# VPW nfet_05v0 ad=0.3608p pd=2.52u as=0.1722p ps=1.24u w=0.82u l=0.6u
X1 ZN A3 VDD VNW pfet_05v0 ad=0.2561p pd=1.505u as=0.4334p ps=2.85u w=0.985u l=0.5u
X2 VDD A2 ZN VNW pfet_05v0 ad=0.2561p pd=1.505u as=0.2561p ps=1.505u w=0.985u l=0.5u
X3 ZN A1 VDD VNW pfet_05v0 ad=0.4334p pd=2.85u as=0.2561p ps=1.505u w=0.985u l=0.5u
X4 a_271_68# A3 VSS VPW nfet_05v0 ad=0.1312p pd=1.14u as=0.3608p ps=2.52u w=0.82u l=0.6u
X5 a_455_68# A2 a_271_68# VPW nfet_05v0 ad=0.1722p pd=1.24u as=0.1312p ps=1.14u w=0.82u l=0.6u
.ends

.subckt gf180mcu_fd_sc_mcu7t5v0__mux4_4 I0 I1 I2 I3 S0 S1 Z VDD VNW VPW VSS
X0 a_2595_156# S0 a_3216_156# VPW nfet_05v0 ad=94.899994f pd=0.885u as=94.899994f ps=0.885u w=0.365u l=0.6u
X1 Z a_1108_112# VSS VPW nfet_05v0 ad=98.799995f pd=0.9u as=98.799995f ps=0.9u w=0.38u l=0.6u
X2 a_728_472# a_348_112# a_468_156# VNW pfet_05v0 ad=0.3042p pd=1.56u as=0.2028p ps=1.3u w=0.78u l=0.5u
X3 VSS I3 a_728_472# VPW nfet_05v0 ad=98.799995f pd=0.9u as=98.799995f ps=0.9u w=0.38u l=0.6u
X4 Z a_1108_112# VDD VNW pfet_05v0 ad=0.2028p pd=1.3u as=0.3198p ps=1.6u w=0.78u l=0.5u
X5 a_348_112# S0 VDD VNW pfet_05v0 ad=0.2618p pd=2.07u as=0.18445p ps=1.215u w=0.595u l=0.5u
X6 Z a_1108_112# VSS VPW nfet_05v0 ad=98.799995f pd=0.9u as=98.799995f ps=0.9u w=0.38u l=0.6u
X7 a_3216_156# I1 VSS VPW nfet_05v0 ad=94.899994f pd=0.885u as=94.899994f ps=0.885u w=0.365u l=0.6u
X8 VDD I3 a_728_472# VNW pfet_05v0 ad=0.3198p pd=1.6u as=0.3042p ps=1.56u w=0.78u l=0.5u
X9 VDD a_1108_112# Z VNW pfet_05v0 ad=0.2028p pd=1.3u as=0.2028p ps=1.3u w=0.78u l=0.5u
X10 VSS I0 a_3624_509# VPW nfet_05v0 ad=94.899994f pd=0.885u as=94.899994f ps=0.885u w=0.365u l=0.6u
X11 a_3216_156# I1 VDD VNW pfet_05v0 ad=0.1547p pd=1.115u as=0.18445p ps=1.215u w=0.595u l=0.5u
X12 Z a_1108_112# VDD VNW pfet_05v0 ad=0.2028p pd=1.3u as=0.2028p ps=1.3u w=0.78u l=0.5u
X13 a_468_156# a_348_112# a_224_472# VPW nfet_05v0 ad=0.1824p pd=1.34u as=98.799995f ps=0.9u w=0.38u l=0.6u
X14 a_2595_156# a_348_112# a_3216_156# VNW pfet_05v0 ad=0.1547p pd=1.115u as=0.1547p ps=1.115u w=0.595u l=0.5u
X15 VDD a_1108_112# Z VNW pfet_05v0 ad=0.4524p pd=2.72u as=0.2028p ps=1.3u w=0.78u l=0.5u
X16 a_3624_509# S0 a_2595_156# VNW pfet_05v0 ad=0.2142p pd=1.315u as=0.1547p ps=1.115u w=0.595u l=0.5u
X17 a_728_472# S0 a_468_156# VPW nfet_05v0 ad=98.799995f pd=0.9u as=0.1824p ps=1.34u w=0.38u l=0.6u
X18 a_2595_156# S1 a_1108_112# VNW pfet_05v0 ad=0.2618p pd=2.07u as=0.2618p ps=1.475u w=0.595u l=0.5u
X19 VDD I0 a_3624_509# VNW pfet_05v0 ad=0.18445p pd=1.215u as=0.2142p ps=1.315u w=0.595u l=0.5u
X20 a_2595_156# a_2220_369# a_1108_112# VPW nfet_05v0 ad=0.162425p pd=1.62u as=0.112225p ps=0.98u w=0.365u l=0.6u
X21 VSS a_1108_112# Z VPW nfet_05v0 ad=98.799995f pd=0.9u as=98.799995f ps=0.9u w=0.38u l=0.6u
X22 a_3624_509# a_348_112# a_2595_156# VPW nfet_05v0 ad=94.899994f pd=0.885u as=94.899994f ps=0.885u w=0.365u l=0.6u
X23 VDD S1 a_2220_369# VNW pfet_05v0 ad=0.18445p pd=1.215u as=0.2618p ps=2.07u w=0.595u l=0.5u
X24 a_1108_112# S1 a_468_156# VPW nfet_05v0 ad=0.112225p pd=0.98u as=0.27375p ps=2.23u w=0.365u l=0.6u
X25 a_224_472# I2 VSS VPW nfet_05v0 ad=98.799995f pd=0.9u as=0.1672p ps=1.64u w=0.38u l=0.6u
X26 VSS a_1108_112# Z VPW nfet_05v0 ad=0.1672p pd=1.64u as=98.799995f ps=0.9u w=0.38u l=0.6u
X27 a_348_112# S0 VSS VPW nfet_05v0 ad=0.1606p pd=1.61u as=94.899994f ps=0.885u w=0.365u l=0.6u
X28 VSS S1 a_2220_369# VPW nfet_05v0 ad=94.899994f pd=0.885u as=0.1606p ps=1.61u w=0.365u l=0.6u
X29 a_224_472# I2 VDD VNW pfet_05v0 ad=0.39p pd=1.78u as=0.3432p ps=2.44u w=0.78u l=0.5u
X30 a_1108_112# a_2220_369# a_468_156# VNW pfet_05v0 ad=0.2618p pd=1.475u as=0.401625p ps=2.54u w=0.595u l=0.5u
X31 a_468_156# S0 a_224_472# VNW pfet_05v0 ad=0.2028p pd=1.3u as=0.39p ps=1.78u w=0.78u l=0.5u
.ends

.subckt gf180mcu_fd_sc_mcu7t5v0__nand4_1 A1 A2 A3 A4 ZN VDD VNW VPW VSS
X0 ZN A4 VDD VNW pfet_05v0 ad=0.2197p pd=1.365u as=0.3718p ps=2.57u w=0.845u l=0.5u
X1 VDD A3 ZN VNW pfet_05v0 ad=0.2197p pd=1.365u as=0.2197p ps=1.365u w=0.845u l=0.5u
X2 ZN A2 VDD VNW pfet_05v0 ad=0.2197p pd=1.365u as=0.2197p ps=1.365u w=0.845u l=0.5u
X3 VDD A1 ZN VNW pfet_05v0 ad=0.3718p pd=2.57u as=0.2197p ps=1.365u w=0.845u l=0.5u
X4 a_275_68# A4 VSS VPW nfet_05v0 ad=0.1517p pd=1.19u as=0.3608p ps=2.52u w=0.82u l=0.6u
X5 a_673_68# A2 a_469_68# VPW nfet_05v0 ad=0.1517p pd=1.19u as=0.1722p ps=1.24u w=0.82u l=0.6u
X6 a_469_68# A3 a_275_68# VPW nfet_05v0 ad=0.1722p pd=1.24u as=0.1517p ps=1.19u w=0.82u l=0.6u
X7 ZN A1 a_673_68# VPW nfet_05v0 ad=0.3608p pd=2.52u as=0.1517p ps=1.19u w=0.82u l=0.6u
.ends

.subckt gf180mcu_fd_sc_mcu7t5v0__aoi22_1 A1 A2 B1 B2 ZN VDD VNW VPW VSS
X0 ZN B1 a_257_69# VPW nfet_05v0 ad=0.2119p pd=1.335u as=0.1304p ps=1.135u w=0.815u l=0.6u
X1 VDD B2 a_49_472# VNW pfet_05v0 ad=0.3159p pd=1.735u as=0.5346p ps=3.31u w=1.215u l=0.5u
X2 a_49_472# B1 VDD VNW pfet_05v0 ad=0.3159p pd=1.735u as=0.3159p ps=1.735u w=1.215u l=0.5u
X3 ZN A1 a_49_472# VNW pfet_05v0 ad=0.3159p pd=1.735u as=0.3159p ps=1.735u w=1.215u l=0.5u
X4 a_49_472# A2 ZN VNW pfet_05v0 ad=0.5346p pd=3.31u as=0.3159p ps=1.735u w=1.215u l=0.5u
X5 a_257_69# B2 VSS VPW nfet_05v0 ad=0.1304p pd=1.135u as=0.3586p ps=2.51u w=0.815u l=0.6u
X6 a_665_69# A1 ZN VPW nfet_05v0 ad=0.1304p pd=1.135u as=0.2119p ps=1.335u w=0.815u l=0.6u
X7 VSS A2 a_665_69# VPW nfet_05v0 ad=0.3586p pd=2.51u as=0.1304p ps=1.135u w=0.815u l=0.6u
.ends

.subckt gf180mcu_fd_sc_mcu7t5v0__nor4_1 A1 A2 A3 A4 ZN VDD VNW VPW VSS
X0 a_672_472# A2 a_448_472# VNW pfet_05v0 ad=0.3782p pd=1.84u as=0.3782p ps=1.84u w=1.22u l=0.5u
X1 VSS A1 ZN VPW nfet_05v0 ad=0.1584p pd=1.6u as=93.59999f ps=0.88u w=0.36u l=0.6u
X2 VSS A3 ZN VPW nfet_05v0 ad=93.59999f pd=0.88u as=93.59999f ps=0.88u w=0.36u l=0.6u
X3 a_244_472# A4 VDD VNW pfet_05v0 ad=0.3172p pd=1.74u as=0.5368p ps=3.32u w=1.22u l=0.5u
X4 a_448_472# A3 a_244_472# VNW pfet_05v0 ad=0.3782p pd=1.84u as=0.3172p ps=1.74u w=1.22u l=0.5u
X5 ZN A2 VSS VPW nfet_05v0 ad=93.59999f pd=0.88u as=93.59999f ps=0.88u w=0.36u l=0.6u
X6 ZN A4 VSS VPW nfet_05v0 ad=93.59999f pd=0.88u as=0.1584p ps=1.6u w=0.36u l=0.6u
X7 ZN A1 a_672_472# VNW pfet_05v0 ad=0.5368p pd=3.32u as=0.3782p ps=1.84u w=1.22u l=0.5u
.ends

.subckt gf180mcu_fd_sc_mcu7t5v0__nor4_2 A1 A2 A3 A4 ZN VDD VNW VPW VSS
X0 VSS A3 ZN VPW nfet_05v0 ad=0.126p pd=1.06u as=0.126p ps=1.06u w=0.36u l=0.6u
X1 a_1213_472# A2 a_943_472# VNW pfet_05v0 ad=0.3477p pd=1.79u as=0.5185p ps=2.07u w=1.22u l=0.5u
X2 VSS A2 ZN VPW nfet_05v0 ad=0.1584p pd=1.6u as=93.59999f ps=0.88u w=0.36u l=0.6u
X3 a_943_472# A3 a_683_472# VNW pfet_05v0 ad=0.5185p pd=2.07u as=0.488p ps=2.02u w=1.22u l=0.5u
X4 VSS A1 ZN VPW nfet_05v0 ad=93.59999f pd=0.88u as=93.59999f ps=0.88u w=0.36u l=0.6u
X5 a_1661_472# A1 ZN VNW pfet_05v0 ad=0.3172p pd=1.74u as=0.4087p ps=1.89u w=1.22u l=0.5u
X6 VSS A4 ZN VPW nfet_05v0 ad=93.59999f pd=0.88u as=93.59999f ps=0.88u w=0.36u l=0.6u
X7 a_57_472# A2 a_1661_472# VNW pfet_05v0 ad=0.5368p pd=3.32u as=0.3172p ps=1.74u w=1.22u l=0.5u
X8 ZN A1 VSS VPW nfet_05v0 ad=93.59999f pd=0.88u as=93.59999f ps=0.88u w=0.36u l=0.6u
X9 VDD A4 a_245_472# VNW pfet_05v0 ad=0.3782p pd=1.84u as=0.3477p ps=1.79u w=1.22u l=0.5u
X10 ZN A2 VSS VPW nfet_05v0 ad=93.59999f pd=0.88u as=0.126p ps=1.06u w=0.36u l=0.6u
X11 ZN A4 VSS VPW nfet_05v0 ad=0.126p pd=1.06u as=93.59999f ps=0.88u w=0.36u l=0.6u
X12 a_245_472# A3 a_57_472# VNW pfet_05v0 ad=0.3477p pd=1.79u as=0.5368p ps=3.32u w=1.22u l=0.5u
X13 ZN A3 VSS VPW nfet_05v0 ad=93.59999f pd=0.88u as=0.1584p ps=1.6u w=0.36u l=0.6u
X14 ZN A1 a_1213_472# VNW pfet_05v0 ad=0.4087p pd=1.89u as=0.3477p ps=1.79u w=1.22u l=0.5u
X15 a_683_472# A4 VDD VNW pfet_05v0 ad=0.488p pd=2.02u as=0.3782p ps=1.84u w=1.22u l=0.5u
.ends

.subckt gf180mcu_fd_sc_mcu7t5v0__nor2_2 A1 A2 ZN VDD VNW VPW VSS
X0 a_672_472# A1 ZN VNW pfet_05v0 ad=0.4087p pd=1.89u as=0.3477p ps=1.79u w=1.22u l=0.5u
X1 ZN A1 VSS VPW nfet_05v0 ad=0.1469p pd=1.085u as=0.1469p ps=1.085u w=0.565u l=0.6u
X2 ZN A1 a_234_472# VNW pfet_05v0 ad=0.3477p pd=1.79u as=0.3782p ps=1.84u w=1.22u l=0.5u
X3 VSS A1 ZN VPW nfet_05v0 ad=0.1469p pd=1.085u as=0.1469p ps=1.085u w=0.565u l=0.6u
X4 a_234_472# A2 VDD VNW pfet_05v0 ad=0.3782p pd=1.84u as=0.5368p ps=3.32u w=1.22u l=0.5u
X5 VDD A2 a_672_472# VNW pfet_05v0 ad=0.5368p pd=3.32u as=0.4087p ps=1.89u w=1.22u l=0.5u
X6 VSS A2 ZN VPW nfet_05v0 ad=0.2486p pd=2.01u as=0.1469p ps=1.085u w=0.565u l=0.6u
X7 ZN A2 VSS VPW nfet_05v0 ad=0.1469p pd=1.085u as=0.2486p ps=2.01u w=0.565u l=0.6u
.ends

.subckt gf180mcu_fd_sc_mcu7t5v0__clkinv_2 I ZN VDD VNW VPW VSS
X0 ZN I VSS VPW nfet_05v0 ad=0.1248p pd=1u as=0.2112p ps=1.84u w=0.48u l=0.6u
X1 VDD I ZN VNW pfet_05v0 ad=0.5368p pd=3.32u as=0.3782p ps=1.84u w=1.22u l=0.5u
X2 ZN I VDD VNW pfet_05v0 ad=0.3782p pd=1.84u as=0.5368p ps=3.32u w=1.22u l=0.5u
X3 VSS I ZN VPW nfet_05v0 ad=0.2112p pd=1.84u as=0.1248p ps=1u w=0.48u l=0.6u
.ends

.subckt gf180mcu_fd_sc_mcu7t5v0__xnor3_1 A1 A2 A3 ZN VDD VNW VPW VSS
X0 a_952_93# A1 a_728_93# VPW nfet_05v0 ad=57.599995f pd=0.68u as=93.59999f ps=0.88u w=0.36u l=0.6u
X1 a_244_567# A2 a_56_567# VNW pfet_05v0 ad=0.1026p pd=0.93u as=0.1584p ps=1.6u w=0.36u l=0.5u
X2 a_728_93# A1 a_718_527# VNW pfet_05v0 ad=0.1456p pd=1.08u as=0.1596p ps=1.13u w=0.56u l=0.5u
X3 ZN A3 a_1948_68# VPW nfet_05v0 ad=0.4161p pd=1.905u as=0.2132p ps=1.34u w=0.82u l=0.6u
X4 ZN a_1296_93# VDD VNW pfet_05v0 ad=0.33945p pd=1.715u as=0.352075p ps=1.895u w=1.095u l=0.5u
X5 VDD a_728_93# a_2172_497# VNW pfet_05v0 ad=0.4818p pd=3.07u as=0.5256p ps=2.055u w=1.095u l=0.5u
X6 a_718_527# a_56_567# VDD VNW pfet_05v0 ad=0.1596p pd=1.13u as=0.184p ps=1.36u w=0.56u l=0.5u
X7 a_718_527# A2 a_728_93# VNW pfet_05v0 ad=0.2464p pd=2u as=0.1456p ps=1.08u w=0.56u l=0.5u
X8 VSS A1 a_56_567# VPW nfet_05v0 ad=0.126p pd=1.06u as=93.59999f ps=0.88u w=0.36u l=0.6u
X9 VSS A3 a_1504_93# VPW nfet_05v0 ad=0.218p pd=1.52u as=57.599995f ps=0.68u w=0.36u l=0.6u
X10 a_1948_68# a_728_93# ZN VPW nfet_05v0 ad=0.3608p pd=2.52u as=0.4161p ps=1.905u w=0.82u l=0.6u
X11 a_2172_497# A3 ZN VNW pfet_05v0 ad=0.5256p pd=2.055u as=0.33945p ps=1.715u w=1.095u l=0.5u
X12 a_1504_93# a_728_93# a_1296_93# VPW nfet_05v0 ad=57.599995f pd=0.68u as=0.1584p ps=1.6u w=0.36u l=0.6u
X13 a_56_567# A2 VSS VPW nfet_05v0 ad=93.59999f pd=0.88u as=0.1584p ps=1.6u w=0.36u l=0.6u
X14 a_1948_68# a_1296_93# VSS VPW nfet_05v0 ad=0.2132p pd=1.34u as=0.218p ps=1.52u w=0.82u l=0.6u
X15 a_1296_93# a_728_93# VDD VNW pfet_05v0 ad=0.1456p pd=1.08u as=0.2464p ps=2u w=0.56u l=0.5u
X16 a_728_93# a_56_567# VSS VPW nfet_05v0 ad=93.59999f pd=0.88u as=0.126p ps=1.06u w=0.36u l=0.6u
X17 VDD A3 a_1296_93# VNW pfet_05v0 ad=0.352075p pd=1.895u as=0.1456p ps=1.08u w=0.56u l=0.5u
X18 VDD A1 a_244_567# VNW pfet_05v0 ad=0.184p pd=1.36u as=0.1026p ps=0.93u w=0.36u l=0.5u
X19 VSS A2 a_952_93# VPW nfet_05v0 ad=0.1584p pd=1.6u as=57.599995f ps=0.68u w=0.36u l=0.6u
.ends

.subckt gf180mcu_fd_sc_mcu7t5v0__xnor2_1 A1 A2 ZN VDD VNW VPW VSS
X0 ZN a_64_93# VDD VNW pfet_05v0 ad=0.312075p pd=1.665u as=0.344375p ps=1.895u w=1.095u l=0.5u
X1 a_272_93# A2 a_64_93# VPW nfet_05v0 ad=57.599995f pd=0.68u as=0.1584p ps=1.6u w=0.36u l=0.6u
X2 VSS A1 a_272_93# VPW nfet_05v0 ad=0.218p pd=1.52u as=57.599995f ps=0.68u w=0.36u l=0.6u
X3 a_716_68# a_64_93# VSS VPW nfet_05v0 ad=0.2132p pd=1.34u as=0.218p ps=1.52u w=0.82u l=0.6u
X4 VDD A2 a_930_497# VNW pfet_05v0 ad=0.4818p pd=3.07u as=0.552975p ps=2.105u w=1.095u l=0.5u
X5 ZN A1 a_716_68# VPW nfet_05v0 ad=0.4161p pd=1.905u as=0.2132p ps=1.34u w=0.82u l=0.6u
X6 a_64_93# A2 VDD VNW pfet_05v0 ad=0.1456p pd=1.08u as=0.2464p ps=2u w=0.56u l=0.5u
X7 a_716_68# A2 ZN VPW nfet_05v0 ad=0.3608p pd=2.52u as=0.4161p ps=1.905u w=0.82u l=0.6u
X8 VDD A1 a_64_93# VNW pfet_05v0 ad=0.344375p pd=1.895u as=0.1456p ps=1.08u w=0.56u l=0.5u
X9 a_930_497# A1 ZN VNW pfet_05v0 ad=0.552975p pd=2.105u as=0.312075p ps=1.665u w=1.095u l=0.5u
.ends

.subckt gf180mcu_fd_sc_mcu7t5v0__aoi21_2 A1 A2 B ZN VDD VNW VPW VSS
X0 VSS A2 a_1133_69# VPW nfet_05v0 ad=0.341p pd=2.43u as=92.99999f ps=1.015u w=0.775u l=0.6u
X1 VDD B a_49_472# VNW pfet_05v0 ad=0.37665p pd=1.835u as=0.5346p ps=3.31u w=1.215u l=0.5u
X2 ZN A1 a_49_472# VNW pfet_05v0 ad=0.3159p pd=1.735u as=0.32805p ps=1.755u w=1.215u l=0.5u
X3 a_741_69# A2 VSS VPW nfet_05v0 ad=92.99999f pd=1.015u as=0.23975p ps=1.475u w=0.775u l=0.6u
X4 a_49_472# A1 ZN VNW pfet_05v0 ad=0.32805p pd=1.755u as=0.37665p ps=1.835u w=1.215u l=0.5u
X5 ZN B VSS VPW nfet_05v0 ad=0.1469p pd=1.085u as=0.2486p ps=2.01u w=0.565u l=0.6u
X6 a_49_472# A2 ZN VNW pfet_05v0 ad=0.5346p pd=3.31u as=0.3159p ps=1.735u w=1.215u l=0.5u
X7 a_49_472# B VDD VNW pfet_05v0 ad=0.3159p pd=1.735u as=0.37665p ps=1.835u w=1.215u l=0.5u
X8 ZN A2 a_49_472# VNW pfet_05v0 ad=0.37665p pd=1.835u as=0.3159p ps=1.735u w=1.215u l=0.5u
X9 VSS B ZN VPW nfet_05v0 ad=0.23975p pd=1.475u as=0.1469p ps=1.085u w=0.565u l=0.6u
X10 ZN A1 a_741_69# VPW nfet_05v0 ad=0.2015p pd=1.295u as=92.99999f ps=1.015u w=0.775u l=0.6u
X11 a_1133_69# A1 ZN VPW nfet_05v0 ad=92.99999f pd=1.015u as=0.2015p ps=1.295u w=0.775u l=0.6u
.ends

.subckt gf180mcu_fd_sc_mcu7t5v0__nand2_4 A1 A2 ZN VDD VNW VPW VSS
X0 ZN A1 VDD VNW pfet_05v0 ad=0.2938p pd=1.65u as=0.2938p ps=1.65u w=1.13u l=0.5u
X1 VSS A2 a_661_68# VPW nfet_05v0 ad=0.22755p pd=1.375u as=98.399994f ps=1.06u w=0.82u l=0.6u
X2 VDD A2 ZN VNW pfet_05v0 ad=0.2938p pd=1.65u as=0.2938p ps=1.65u w=1.13u l=0.5u
X3 ZN A1 a_260_68# VPW nfet_05v0 ad=0.23165p pd=1.385u as=98.399994f ps=1.06u w=0.82u l=0.6u
X4 a_1468_68# A1 ZN VPW nfet_05v0 ad=0.1312p pd=1.14u as=0.2132p ps=1.34u w=0.82u l=0.6u
X5 ZN A2 VDD VNW pfet_05v0 ad=0.2938p pd=1.65u as=0.2938p ps=1.65u w=1.13u l=0.5u
X6 VDD A1 ZN VNW pfet_05v0 ad=0.2938p pd=1.65u as=0.2938p ps=1.65u w=1.13u l=0.5u
X7 ZN A1 a_1060_68# VPW nfet_05v0 ad=0.2132p pd=1.34u as=0.1312p ps=1.14u w=0.82u l=0.6u
X8 ZN A1 VDD VNW pfet_05v0 ad=0.2938p pd=1.65u as=0.2938p ps=1.65u w=1.13u l=0.5u
X9 a_661_68# A1 ZN VPW nfet_05v0 ad=98.399994f pd=1.06u as=0.23165p ps=1.385u w=0.82u l=0.6u
X10 a_1060_68# A2 VSS VPW nfet_05v0 ad=0.1312p pd=1.14u as=0.22755p ps=1.375u w=0.82u l=0.6u
X11 VDD A2 ZN VNW pfet_05v0 ad=0.4972p pd=3.14u as=0.2938p ps=1.65u w=1.13u l=0.5u
X12 a_260_68# A2 VSS VPW nfet_05v0 ad=98.399994f pd=1.06u as=0.3608p ps=2.52u w=0.82u l=0.6u
X13 VSS A2 a_1468_68# VPW nfet_05v0 ad=0.3608p pd=2.52u as=0.1312p ps=1.14u w=0.82u l=0.6u
X14 ZN A2 VDD VNW pfet_05v0 ad=0.2938p pd=1.65u as=0.4972p ps=3.14u w=1.13u l=0.5u
X15 VDD A1 ZN VNW pfet_05v0 ad=0.2938p pd=1.65u as=0.2938p ps=1.65u w=1.13u l=0.5u
.ends

.subckt gf180mcu_fd_sc_mcu7t5v0__aoi222_2 A1 A2 B1 B2 C1 C2 ZN VDD VNW VPW VSS
X0 VSS C2 a_251_68# VPW nfet_05v0 ad=0.316p pd=1.59u as=96f ps=1.04u w=0.8u l=0.6u
X1 ZN C1 a_697_68# VPW nfet_05v0 ad=0.384p pd=1.76u as=0.124p ps=1.11u w=0.8u l=0.6u
X2 a_231_472# C1 VDD VNW pfet_05v0 ad=0.3172p pd=1.74u as=0.5368p ps=3.32u w=1.22u l=0.5u
X3 a_1003_472# B2 a_231_472# VNW pfet_05v0 ad=0.3172p pd=1.74u as=0.3172p ps=1.74u w=1.22u l=0.5u
X4 ZN A2 a_1003_472# VNW pfet_05v0 ad=0.3172p pd=1.74u as=0.3172p ps=1.74u w=1.22u l=0.5u
X5 ZN A1 a_1003_472# VNW pfet_05v0 ad=0.3172p pd=1.74u as=0.32635p ps=1.755u w=1.22u l=0.5u
X6 VSS B2 a_1191_68# VPW nfet_05v0 ad=0.208p pd=1.32u as=0.168p ps=1.22u w=0.8u l=0.6u
X7 a_231_472# B2 a_1003_472# VNW pfet_05v0 ad=0.3172p pd=1.74u as=0.3172p ps=1.74u w=1.22u l=0.5u
X8 a_1003_472# A1 ZN VNW pfet_05v0 ad=0.5368p pd=3.32u as=0.3172p ps=1.74u w=1.22u l=0.5u
X9 VDD C2 a_231_472# VNW pfet_05v0 ad=0.3172p pd=1.74u as=0.3172p ps=1.74u w=1.22u l=0.5u
X10 a_231_472# C2 VDD VNW pfet_05v0 ad=0.3172p pd=1.74u as=0.3172p ps=1.74u w=1.22u l=0.5u
X11 ZN B1 a_1619_68# VPW nfet_05v0 ad=0.214p pd=1.335u as=0.128p ps=1.12u w=0.8u l=0.6u
X12 VDD C1 a_231_472# VNW pfet_05v0 ad=0.5368p pd=3.32u as=0.3172p ps=1.74u w=1.22u l=0.5u
X13 a_2438_68# A2 VSS VPW nfet_05v0 ad=0.128p pd=1.12u as=0.208p ps=1.32u w=0.8u l=0.6u
X14 a_2030_68# A1 ZN VPW nfet_05v0 ad=0.128p pd=1.12u as=0.214p ps=1.335u w=0.8u l=0.6u
X15 a_251_68# C1 ZN VPW nfet_05v0 ad=96f pd=1.04u as=0.352p ps=2.48u w=0.8u l=0.6u
X16 a_1003_472# B1 a_231_472# VNW pfet_05v0 ad=0.32635p pd=1.755u as=0.3172p ps=1.74u w=1.22u l=0.5u
X17 VSS A2 a_2030_68# VPW nfet_05v0 ad=0.208p pd=1.32u as=0.128p ps=1.12u w=0.8u l=0.6u
X18 a_1191_68# B1 ZN VPW nfet_05v0 ad=0.168p pd=1.22u as=0.384p ps=1.76u w=0.8u l=0.6u
X19 a_1619_68# B2 VSS VPW nfet_05v0 ad=0.128p pd=1.12u as=0.208p ps=1.32u w=0.8u l=0.6u
X20 ZN A1 a_2438_68# VPW nfet_05v0 ad=0.352p pd=2.48u as=0.128p ps=1.12u w=0.8u l=0.6u
X21 a_231_472# B1 a_1003_472# VNW pfet_05v0 ad=0.3172p pd=1.74u as=0.5368p ps=3.32u w=1.22u l=0.5u
X22 a_697_68# C2 VSS VPW nfet_05v0 ad=0.124p pd=1.11u as=0.316p ps=1.59u w=0.8u l=0.6u
X23 a_1003_472# A2 ZN VNW pfet_05v0 ad=0.3172p pd=1.74u as=0.3172p ps=1.74u w=1.22u l=0.5u
.ends

.subckt gf180mcu_fd_sc_mcu7t5v0__nor3_1 A1 A2 A3 ZN VDD VNW VPW VSS
X0 ZN A1 a_448_472# VNW pfet_05v0 ad=0.5368p pd=3.32u as=0.3782p ps=1.84u w=1.22u l=0.5u
X1 ZN A1 VSS VPW nfet_05v0 ad=0.2046p pd=1.81u as=0.1209p ps=0.985u w=0.465u l=0.6u
X2 a_244_472# A3 VDD VNW pfet_05v0 ad=0.3172p pd=1.74u as=0.5368p ps=3.32u w=1.22u l=0.5u
X3 a_448_472# A2 a_244_472# VNW pfet_05v0 ad=0.3782p pd=1.84u as=0.3172p ps=1.74u w=1.22u l=0.5u
X4 VSS A2 ZN VPW nfet_05v0 ad=0.1209p pd=0.985u as=0.1209p ps=0.985u w=0.465u l=0.6u
X5 ZN A3 VSS VPW nfet_05v0 ad=0.1209p pd=0.985u as=0.2046p ps=1.81u w=0.465u l=0.6u
.ends

.subckt gf180mcu_fd_sc_mcu7t5v0__dffq_4 D CLK Q VDD VNW VPW VSS
X0 VSS CLK a_36_151# VPW nfet_05v0 ad=0.1053p pd=0.925u as=0.1782p ps=1.69u w=0.405u l=0.6u
X1 VDD a_2011_527# a_2304_115# VNW pfet_05v0 ad=0.38575p pd=1.92u as=0.2457p ps=1.465u w=0.945u l=0.5u
X2 a_1004_159# D a_836_159# VPW nfet_05v0 ad=0.207p pd=1.51u as=43.199997f ps=0.6u w=0.36u l=0.6u
X3 VSS a_2304_115# Q VPW nfet_05v0 ad=0.3586p pd=2.51u as=0.2119p ps=1.335u w=0.815u l=0.6u
X4 a_2304_115# a_2011_527# VSS VPW nfet_05v0 ad=0.2119p pd=1.335u as=0.2333p ps=1.555u w=0.815u l=0.6u
X5 a_1004_159# D a_880_527# VNW pfet_05v0 ad=0.1872p pd=1.4u as=53.999996f ps=0.66u w=0.36u l=0.5u
X6 a_2011_527# a_36_151# a_1376_115# VNW pfet_05v0 ad=0.1665p pd=1.285u as=0.1791p ps=1.355u w=0.36u l=0.5u
X7 a_2296_527# a_448_472# a_2011_527# VNW pfet_05v0 ad=50.399998f pd=0.64u as=0.1665p ps=1.285u w=0.36u l=0.5u
X8 Q a_2304_115# VDD VNW pfet_05v0 ad=0.4392p pd=1.94u as=0.38575p ps=1.92u w=1.22u l=0.5u
X9 VSS a_2304_115# Q VPW nfet_05v0 ad=0.2119p pd=1.335u as=0.2119p ps=1.335u w=0.815u l=0.6u
X10 a_1376_115# a_1004_159# VDD VNW pfet_05v0 ad=0.1791p pd=1.355u as=0.1044p ps=0.94u w=0.36u l=0.5u
X11 VDD CLK a_36_151# VNW pfet_05v0 ad=0.2249p pd=1.385u as=0.3806p ps=2.61u w=0.865u l=0.5u
X12 VDD a_2304_115# Q VNW pfet_05v0 ad=0.3172p pd=1.74u as=0.4392p ps=1.94u w=1.22u l=0.5u
X13 VSS a_1376_115# a_1328_159# VPW nfet_05v0 ad=0.2637p pd=1.825u as=43.199997f ps=0.6u w=0.36u l=0.6u
X14 a_2011_527# a_448_472# a_1376_115# VPW nfet_05v0 ad=93.59999f pd=0.88u as=93.59999f ps=0.88u w=0.36u l=0.6u
X15 Q a_2304_115# VDD VNW pfet_05v0 ad=0.4392p pd=1.94u as=0.3172p ps=1.74u w=1.22u l=0.5u
X16 a_448_472# a_36_151# VDD VNW pfet_05v0 ad=0.3806p pd=2.61u as=0.2249p ps=1.385u w=0.865u l=0.5u
X17 Q a_2304_115# VSS VPW nfet_05v0 ad=0.2119p pd=1.335u as=0.2119p ps=1.335u w=0.815u l=0.6u
X18 a_1376_115# a_1004_159# VSS VPW nfet_05v0 ad=93.59999f pd=0.88u as=0.2637p ps=1.825u w=0.36u l=0.6u
X19 VSS a_2304_115# a_2256_159# VPW nfet_05v0 ad=0.2333p pd=1.555u as=43.199997f ps=0.6u w=0.36u l=0.6u
X20 Q a_2304_115# VSS VPW nfet_05v0 ad=0.2119p pd=1.335u as=0.2608p ps=1.455u w=0.815u l=0.6u
X21 a_836_159# a_36_151# VSS VPW nfet_05v0 ad=43.199997f pd=0.6u as=0.1584p ps=1.6u w=0.36u l=0.6u
X22 a_448_472# a_36_151# VSS VPW nfet_05v0 ad=0.1782p pd=1.69u as=0.1053p ps=0.925u w=0.405u l=0.6u
X23 a_2256_159# a_36_151# a_2011_527# VPW nfet_05v0 ad=43.199997f pd=0.6u as=93.59999f ps=0.88u w=0.36u l=0.6u
X24 a_880_527# a_448_472# VDD VNW pfet_05v0 ad=53.999996f pd=0.66u as=0.4554p ps=3.25u w=0.36u l=0.5u
X25 a_1348_527# a_36_151# a_1004_159# VNW pfet_05v0 ad=43.199997f pd=0.6u as=0.1872p ps=1.4u w=0.36u l=0.5u
X26 VDD a_2304_115# Q VNW pfet_05v0 ad=0.5368p pd=3.32u as=0.4392p ps=1.94u w=1.22u l=0.5u
X27 a_1328_159# a_448_472# a_1004_159# VPW nfet_05v0 ad=43.199997f pd=0.6u as=0.207p ps=1.51u w=0.36u l=0.6u
X28 VDD a_1376_115# a_1348_527# VNW pfet_05v0 ad=0.1044p pd=0.94u as=43.199997f ps=0.6u w=0.36u l=0.5u
X29 VSS a_2011_527# a_2304_115# VPW nfet_05v0 ad=0.2608p pd=1.455u as=0.2119p ps=1.335u w=0.815u l=0.6u
X30 VDD a_2304_115# a_2296_527# VNW pfet_05v0 ad=0.2619p pd=1.685u as=50.399998f ps=0.64u w=0.36u l=0.5u
X31 a_2304_115# a_2011_527# VDD VNW pfet_05v0 ad=0.2457p pd=1.465u as=0.2619p ps=1.685u w=0.945u l=0.5u
.ends

.subckt gf180mcu_fd_sc_mcu7t5v0__nand3_2 A1 A2 A3 ZN VDD VNW VPW VSS
X0 ZN A1 VDD VNW pfet_05v0 ad=0.2561p pd=1.505u as=0.2561p ps=1.505u w=0.985u l=0.5u
X1 VDD A1 ZN VNW pfet_05v0 ad=0.2561p pd=1.505u as=0.2561p ps=1.505u w=0.985u l=0.5u
X2 a_1044_68# A2 a_860_68# VPW nfet_05v0 ad=0.1722p pd=1.24u as=0.1312p ps=1.14u w=0.82u l=0.6u
X3 a_860_68# A1 ZN VPW nfet_05v0 ad=0.1312p pd=1.14u as=0.2132p ps=1.34u w=0.82u l=0.6u
X4 ZN A2 VDD VNW pfet_05v0 ad=0.2561p pd=1.505u as=0.2561p ps=1.505u w=0.985u l=0.5u
X5 VDD A3 ZN VNW pfet_05v0 ad=0.4334p pd=2.85u as=0.2561p ps=1.505u w=0.985u l=0.5u
X6 VSS A3 a_1044_68# VPW nfet_05v0 ad=0.3608p pd=2.52u as=0.1722p ps=1.24u w=0.82u l=0.6u
X7 a_276_68# A3 VSS VPW nfet_05v0 ad=0.1148p pd=1.1u as=0.3608p ps=2.52u w=0.82u l=0.6u
X8 ZN A3 VDD VNW pfet_05v0 ad=0.2561p pd=1.505u as=0.4334p ps=2.85u w=0.985u l=0.5u
X9 VDD A2 ZN VNW pfet_05v0 ad=0.2561p pd=1.505u as=0.2561p ps=1.505u w=0.985u l=0.5u
X10 a_452_68# A2 a_276_68# VPW nfet_05v0 ad=0.1312p pd=1.14u as=0.1148p ps=1.1u w=0.82u l=0.6u
X11 ZN A1 a_452_68# VPW nfet_05v0 ad=0.2132p pd=1.34u as=0.1312p ps=1.14u w=0.82u l=0.6u
.ends

.subckt gf180mcu_fd_sc_mcu7t5v0__aoi221_2 A1 A2 B1 B2 C ZN VDD VNW VPW VSS
X0 a_56_492# A2 ZN VNW pfet_05v0 ad=0.2912p pd=1.64u as=0.2912p ps=1.64u w=1.12u l=0.5u
X1 a_512_68# B2 VSS VPW nfet_05v0 ad=0.16445p pd=1.175u as=0.21805p ps=1.455u w=0.715u l=0.6u
X2 ZN C VSS VPW nfet_05v0 ad=0.23355p pd=1.43u as=0.6525p ps=2.695u w=0.575u l=0.6u
X3 a_244_492# B2 VDD VNW pfet_05v0 ad=0.7056p pd=2.38u as=0.5664p ps=2.24u w=1.12u l=0.5u
X4 a_948_68# B1 ZN VPW nfet_05v0 ad=0.10725p pd=1.015u as=0.1859p ps=1.235u w=0.715u l=0.6u
X5 VSS B2 a_948_68# VPW nfet_05v0 ad=0.6525p pd=2.695u as=0.10725p ps=1.015u w=0.715u l=0.6u
X6 a_56_492# C a_244_492# VNW pfet_05v0 ad=0.3108p pd=1.675u as=0.7056p ps=2.38u w=1.12u l=0.5u
X7 VSS C ZN VPW nfet_05v0 ad=0.21805p pd=1.455u as=0.1782p ps=1.69u w=0.405u l=0.6u
X8 VDD B1 a_244_492# VNW pfet_05v0 ad=0.5664p pd=2.24u as=0.3024p ps=1.66u w=1.12u l=0.5u
X9 a_2267_68# A2 VSS VPW nfet_05v0 ad=85.799995f pd=0.955u as=0.1859p ps=1.235u w=0.715u l=0.6u
X10 a_1875_68# A1 ZN VPW nfet_05v0 ad=85.799995f pd=0.955u as=0.23355p ps=1.43u w=0.715u l=0.6u
X11 VSS A2 a_1875_68# VPW nfet_05v0 ad=0.1859p pd=1.235u as=85.799995f ps=0.955u w=0.715u l=0.6u
X12 ZN A1 a_2267_68# VPW nfet_05v0 ad=0.3146p pd=2.31u as=85.799995f ps=0.955u w=0.715u l=0.6u
X13 a_244_492# B1 VDD VNW pfet_05v0 ad=0.3024p pd=1.66u as=0.5664p ps=2.24u w=1.12u l=0.5u
X14 ZN B1 a_512_68# VPW nfet_05v0 ad=0.1859p pd=1.235u as=0.16445p ps=1.175u w=0.715u l=0.6u
X15 a_244_492# C a_56_492# VNW pfet_05v0 ad=0.2912p pd=1.64u as=0.4928p ps=3.12u w=1.12u l=0.5u
X16 ZN A2 a_56_492# VNW pfet_05v0 ad=0.2912p pd=1.64u as=0.2912p ps=1.64u w=1.12u l=0.5u
X17 VDD B2 a_244_492# VNW pfet_05v0 ad=0.5664p pd=2.24u as=0.2912p ps=1.64u w=1.12u l=0.5u
X18 ZN A1 a_56_492# VNW pfet_05v0 ad=0.2912p pd=1.64u as=0.3108p ps=1.675u w=1.12u l=0.5u
X19 a_56_492# A1 ZN VNW pfet_05v0 ad=0.4928p pd=3.12u as=0.2912p ps=1.64u w=1.12u l=0.5u
.ends

.subckt gf180mcu_fd_sc_mcu7t5v0__nor2_4 A1 A2 ZN VDD VNW VPW VSS
X0 a_1140_472# A2 VDD VNW pfet_05v0 ad=0.3172p pd=1.74u as=0.4392p ps=1.94u w=1.22u l=0.5u
X1 ZN A1 VSS VPW nfet_05v0 ad=0.1469p pd=1.085u as=0.1469p ps=1.085u w=0.565u l=0.6u
X2 ZN A1 a_1140_472# VNW pfet_05v0 ad=0.4392p pd=1.94u as=0.3172p ps=1.74u w=1.22u l=0.5u
X3 ZN A2 VSS VPW nfet_05v0 ad=0.1469p pd=1.085u as=0.2486p ps=2.01u w=0.565u l=0.6u
X4 a_1588_472# A1 ZN VNW pfet_05v0 ad=0.3172p pd=1.74u as=0.4392p ps=1.94u w=1.22u l=0.5u
X5 VDD A2 a_1588_472# VNW pfet_05v0 ad=0.5978p pd=3.42u as=0.3172p ps=1.74u w=1.22u l=0.5u
X6 ZN A1 VSS VPW nfet_05v0 ad=0.1469p pd=1.085u as=0.1469p ps=1.085u w=0.565u l=0.6u
X7 a_244_472# A2 VDD VNW pfet_05v0 ad=0.3172p pd=1.74u as=0.5978p ps=3.42u w=1.22u l=0.5u
X8 ZN A1 a_244_472# VNW pfet_05v0 ad=0.4392p pd=1.94u as=0.3172p ps=1.74u w=1.22u l=0.5u
X9 a_692_472# A1 ZN VNW pfet_05v0 ad=0.3172p pd=1.74u as=0.4392p ps=1.94u w=1.22u l=0.5u
X10 VSS A2 ZN VPW nfet_05v0 ad=0.2486p pd=2.01u as=0.1469p ps=1.085u w=0.565u l=0.6u
X11 VDD A2 a_692_472# VNW pfet_05v0 ad=0.4392p pd=1.94u as=0.3172p ps=1.74u w=1.22u l=0.5u
X12 VSS A1 ZN VPW nfet_05v0 ad=0.1469p pd=1.085u as=0.1469p ps=1.085u w=0.565u l=0.6u
X13 VSS A2 ZN VPW nfet_05v0 ad=0.1469p pd=1.085u as=0.1469p ps=1.085u w=0.565u l=0.6u
X14 VSS A1 ZN VPW nfet_05v0 ad=0.1469p pd=1.085u as=0.1469p ps=1.085u w=0.565u l=0.6u
X15 ZN A2 VSS VPW nfet_05v0 ad=0.1469p pd=1.085u as=0.1469p ps=1.085u w=0.565u l=0.6u
.ends

.subckt gf180mcu_fd_sc_mcu7t5v0__and3_2 A1 A2 A3 Z VDD VNW VPW VSS
X0 Z a_47_69# VSS VPW nfet_05v0 ad=0.2119p pd=1.335u as=0.2119p ps=1.335u w=0.815u l=0.6u
X1 VDD A1 a_47_69# VNW pfet_05v0 ad=0.2561p pd=1.505u as=0.4334p ps=2.85u w=0.985u l=0.5u
X2 Z a_47_69# VDD VNW pfet_05v0 ad=0.3159p pd=1.735u as=0.39075p ps=1.915u w=1.215u l=0.5u
X3 a_47_69# A2 VDD VNW pfet_05v0 ad=0.2561p pd=1.505u as=0.2561p ps=1.505u w=0.985u l=0.5u
X4 VDD a_47_69# Z VNW pfet_05v0 ad=0.5346p pd=3.31u as=0.3159p ps=1.735u w=1.215u l=0.5u
X5 VSS a_47_69# Z VPW nfet_05v0 ad=0.3586p pd=2.51u as=0.2119p ps=1.335u w=0.815u l=0.6u
X6 VSS A3 a_439_69# VPW nfet_05v0 ad=0.2119p pd=1.335u as=0.17115p ps=1.235u w=0.815u l=0.6u
X7 VDD A3 a_47_69# VNW pfet_05v0 ad=0.39075p pd=1.915u as=0.2561p ps=1.505u w=0.985u l=0.5u
X8 a_255_69# A1 a_47_69# VPW nfet_05v0 ad=0.1304p pd=1.135u as=0.3586p ps=2.51u w=0.815u l=0.6u
X9 a_439_69# A2 a_255_69# VPW nfet_05v0 ad=0.17115p pd=1.235u as=0.1304p ps=1.135u w=0.815u l=0.6u
.ends

.subckt gf180mcu_fd_sc_mcu7t5v0__oai21_4 A1 A2 B ZN VDD VNW VPW VSS
X0 ZN A1 a_36_68# VPW nfet_05v0 ad=0.2132p pd=1.34u as=0.2132p ps=1.34u w=0.82u l=0.6u
X1 a_716_497# A1 ZN VNW pfet_05v0 ad=0.3942p pd=1.815u as=0.2847p ps=1.615u w=1.095u l=0.5u
X2 VDD B ZN VNW pfet_05v0 ad=0.4202p pd=2.79u as=0.2483p ps=1.475u w=0.955u l=0.5u
X3 VSS B a_36_68# VPW nfet_05v0 ad=0.2132p pd=1.34u as=0.2132p ps=1.34u w=0.82u l=0.6u
X4 VDD A2 a_716_497# VNW pfet_05v0 ad=0.2847p pd=1.615u as=0.3942p ps=1.815u w=1.095u l=0.5u
X5 VSS B a_36_68# VPW nfet_05v0 ad=0.2132p pd=1.34u as=0.30715p ps=1.685u w=0.82u l=0.6u
X6 ZN A2 a_36_68# VPW nfet_05v0 ad=0.30965p pd=1.685u as=0.3608p ps=2.52u w=0.82u l=0.6u
X7 a_36_68# A2 ZN VPW nfet_05v0 ad=0.2132p pd=1.34u as=0.2132p ps=1.34u w=0.82u l=0.6u
X8 a_1164_497# A2 VDD VNW pfet_05v0 ad=0.3942p pd=1.815u as=0.2847p ps=1.615u w=1.095u l=0.5u
X9 VDD A2 a_1612_497# VNW pfet_05v0 ad=0.5246p pd=2.135u as=0.33945p ps=1.715u w=1.095u l=0.5u
X10 a_36_68# A1 ZN VPW nfet_05v0 ad=0.2132p pd=1.34u as=0.30965p ps=1.685u w=0.82u l=0.6u
X11 a_36_68# A2 ZN VPW nfet_05v0 ad=0.30715p pd=1.685u as=0.2132p ps=1.34u w=0.82u l=0.6u
X12 a_36_68# A1 ZN VPW nfet_05v0 ad=0.2132p pd=1.34u as=0.2132p ps=1.34u w=0.82u l=0.6u
X13 ZN A1 a_1164_497# VNW pfet_05v0 ad=0.2847p pd=1.615u as=0.3942p ps=1.815u w=1.095u l=0.5u
X14 a_1612_497# A1 ZN VNW pfet_05v0 ad=0.33945p pd=1.715u as=0.2847p ps=1.615u w=1.095u l=0.5u
X15 ZN B VDD VNW pfet_05v0 ad=0.2483p pd=1.475u as=0.5246p ps=2.135u w=0.955u l=0.5u
X16 a_36_68# B VSS VPW nfet_05v0 ad=0.3608p pd=2.52u as=0.2132p ps=1.34u w=0.82u l=0.6u
X17 ZN A1 a_36_68# VPW nfet_05v0 ad=0.2132p pd=1.34u as=0.2132p ps=1.34u w=0.82u l=0.6u
X18 a_36_68# B VSS VPW nfet_05v0 ad=0.2132p pd=1.34u as=0.2132p ps=1.34u w=0.82u l=0.6u
X19 VDD B ZN VNW pfet_05v0 ad=0.2483p pd=1.475u as=0.2483p ps=1.475u w=0.955u l=0.5u
X20 ZN A2 a_36_68# VPW nfet_05v0 ad=0.2132p pd=1.34u as=0.2132p ps=1.34u w=0.82u l=0.6u
X21 a_224_497# A2 VDD VNW pfet_05v0 ad=0.51465p pd=2.035u as=0.4818p ps=3.07u w=1.095u l=0.5u
X22 ZN B VDD VNW pfet_05v0 ad=0.2483p pd=1.475u as=0.2483p ps=1.475u w=0.955u l=0.5u
X23 ZN A1 a_224_497# VNW pfet_05v0 ad=0.2847p pd=1.615u as=0.51465p ps=2.035u w=1.095u l=0.5u
.ends

.subckt gf180mcu_fd_sc_mcu7t5v0__inv_1 I ZN VDD VNW VPW VSS
X0 ZN I VSS VPW nfet_05v0 ad=0.3608p pd=2.52u as=0.3608p ps=2.52u w=0.82u l=0.6u
X1 ZN I VDD VNW pfet_05v0 ad=0.5368p pd=3.32u as=0.5368p ps=3.32u w=1.22u l=0.5u
.ends

.subckt gf180mcu_fd_sc_mcu7t5v0__oai211_1 A1 A2 B C ZN VDD VNW VPW VSS
X0 a_692_68# B a_36_68# VPW nfet_05v0 ad=0.2132p pd=1.34u as=0.2132p ps=1.34u w=0.82u l=0.6u
X1 ZN A2 a_36_68# VPW nfet_05v0 ad=0.2132p pd=1.34u as=0.3608p ps=2.52u w=0.82u l=0.6u
X2 a_244_472# A2 VDD VNW pfet_05v0 ad=0.3172p pd=1.74u as=0.5978p ps=3.42u w=1.22u l=0.5u
X3 VDD B ZN VNW pfet_05v0 ad=0.2561p pd=1.505u as=0.4016p ps=1.94u w=0.985u l=0.5u
X4 ZN A1 a_244_472# VNW pfet_05v0 ad=0.4016p pd=1.94u as=0.3172p ps=1.74u w=1.22u l=0.5u
X5 ZN C VDD VNW pfet_05v0 ad=0.44325p pd=2.87u as=0.2561p ps=1.505u w=0.985u l=0.5u
X6 VSS C a_692_68# VPW nfet_05v0 ad=0.3608p pd=2.52u as=0.2132p ps=1.34u w=0.82u l=0.6u
X7 a_36_68# A1 ZN VPW nfet_05v0 ad=0.2132p pd=1.34u as=0.2132p ps=1.34u w=0.82u l=0.6u
.ends

.subckt gf180mcu_fd_sc_mcu7t5v0__inv_2 I ZN VDD VNW VPW VSS
X0 VDD I ZN VNW pfet_05v0 ad=0.5368p pd=3.32u as=0.4575p ps=1.97u w=1.22u l=0.5u
X1 ZN I VSS VPW nfet_05v0 ad=0.2255p pd=1.37u as=0.3608p ps=2.52u w=0.82u l=0.6u
X2 VSS I ZN VPW nfet_05v0 ad=0.3608p pd=2.52u as=0.2255p ps=1.37u w=0.82u l=0.6u
X3 ZN I VDD VNW pfet_05v0 ad=0.4575p pd=1.97u as=0.5368p ps=3.32u w=1.22u l=0.5u
.ends

.subckt gf180mcu_fd_sc_mcu7t5v0__or3_1 A1 A2 A3 Z VDD VNW VPW VSS
X0 a_224_604# A1 a_36_88# VNW pfet_05v0 ad=0.1736p pd=1.18u as=0.2464p ps=2u w=0.56u l=0.5u
X1 a_36_88# A2 VSS VPW nfet_05v0 ad=0.14p pd=1.1u as=0.104p ps=0.92u w=0.4u l=0.6u
X2 Z a_36_88# VDD VNW pfet_05v0 ad=0.5368p pd=3.32u as=0.389p ps=2.02u w=1.22u l=0.5u
X3 VSS A1 a_36_88# VPW nfet_05v0 ad=0.104p pd=0.92u as=0.176p ps=1.68u w=0.4u l=0.6u
X4 a_448_604# A2 a_224_604# VNW pfet_05v0 ad=0.224p pd=1.36u as=0.1736p ps=1.18u w=0.56u l=0.5u
X5 VSS A3 a_36_88# VPW nfet_05v0 ad=0.224p pd=1.52u as=0.14p ps=1.1u w=0.4u l=0.6u
X6 VDD A3 a_448_604# VNW pfet_05v0 ad=0.389p pd=2.02u as=0.224p ps=1.36u w=0.56u l=0.5u
X7 Z a_36_88# VSS VPW nfet_05v0 ad=0.3608p pd=2.52u as=0.224p ps=1.52u w=0.82u l=0.6u
.ends

.subckt gf180mcu_fd_sc_mcu7t5v0__and4_1 A1 A2 A3 A4 Z VDD VNW VPW VSS
X0 a_48_148# A1 VDD VNW pfet_05v0 ad=0.156p pd=1.12u as=0.264p ps=2.08u w=0.6u l=0.5u
X1 a_440_148# A2 a_256_148# VPW nfet_05v0 ad=88.2f pd=0.84u as=67.2f ps=0.74u w=0.42u l=0.6u
X2 Z a_48_148# VSS VPW nfet_05v0 ad=0.3586p pd=2.51u as=0.226p ps=1.515u w=0.815u l=0.6u
X3 VDD A2 a_48_148# VNW pfet_05v0 ad=0.156p pd=1.12u as=0.156p ps=1.12u w=0.6u l=0.5u
X4 Z a_48_148# VDD VNW pfet_05v0 ad=0.5368p pd=3.32u as=0.395p ps=2.02u w=1.22u l=0.5u
X5 a_644_148# A3 a_440_148# VPW nfet_05v0 ad=88.2f pd=0.84u as=88.2f ps=0.84u w=0.42u l=0.6u
X6 a_48_148# A3 VDD VNW pfet_05v0 ad=0.156p pd=1.12u as=0.156p ps=1.12u w=0.6u l=0.5u
X7 VSS A4 a_644_148# VPW nfet_05v0 ad=0.226p pd=1.515u as=88.2f ps=0.84u w=0.42u l=0.6u
X8 VDD A4 a_48_148# VNW pfet_05v0 ad=0.395p pd=2.02u as=0.156p ps=1.12u w=0.6u l=0.5u
X9 a_256_148# A1 a_48_148# VPW nfet_05v0 ad=67.2f pd=0.74u as=0.1848p ps=1.72u w=0.42u l=0.6u
.ends

.subckt gf180mcu_fd_sc_mcu7t5v0__and2_4 A1 A2 Z VDD VNW VPW VSS
X0 Z a_224_490# VSS VPW nfet_05v0 ad=0.2015p pd=1.295u as=0.2015p ps=1.295u w=0.775u l=0.6u
X1 VSS a_224_490# Z VPW nfet_05v0 ad=0.341p pd=2.43u as=0.2015p ps=1.295u w=0.775u l=0.6u
X2 a_224_490# A1 a_244_69# VPW nfet_05v0 ad=0.21505p pd=1.33u as=0.124p ps=1.095u w=0.775u l=0.6u
X3 a_659_69# A1 a_224_490# VPW nfet_05v0 ad=0.110425p pd=1.06u as=0.21505p ps=1.33u w=0.775u l=0.6u
X4 a_244_69# A2 VSS VPW nfet_05v0 ad=0.124p pd=1.095u as=0.341p ps=2.43u w=0.775u l=0.6u
X5 a_224_490# A2 VDD VNW pfet_05v0 ad=0.2925p pd=1.645u as=0.495p ps=3.13u w=1.125u l=0.5u
X6 Z a_224_490# VDD VNW pfet_05v0 ad=0.3159p pd=1.735u as=0.41175p ps=1.915u w=1.215u l=0.5u
X7 VSS a_224_490# Z VPW nfet_05v0 ad=0.2015p pd=1.295u as=0.2015p ps=1.295u w=0.775u l=0.6u
X8 VDD A1 a_224_490# VNW pfet_05v0 ad=0.2925p pd=1.645u as=0.2925p ps=1.645u w=1.125u l=0.5u
X9 VDD a_224_490# Z VNW pfet_05v0 ad=0.3159p pd=1.735u as=0.3159p ps=1.735u w=1.215u l=0.5u
X10 VSS A2 a_659_69# VPW nfet_05v0 ad=0.2015p pd=1.295u as=0.110425p ps=1.06u w=0.775u l=0.6u
X11 a_224_490# A1 VDD VNW pfet_05v0 ad=0.2925p pd=1.645u as=0.2925p ps=1.645u w=1.125u l=0.5u
X12 Z a_224_490# VDD VNW pfet_05v0 ad=0.3159p pd=1.735u as=0.3159p ps=1.735u w=1.215u l=0.5u
X13 VDD A2 a_224_490# VNW pfet_05v0 ad=0.41175p pd=1.915u as=0.2925p ps=1.645u w=1.125u l=0.5u
X14 VDD a_224_490# Z VNW pfet_05v0 ad=0.5346p pd=3.31u as=0.3159p ps=1.735u w=1.215u l=0.5u
X15 Z a_224_490# VSS VPW nfet_05v0 ad=0.2015p pd=1.295u as=0.2015p ps=1.295u w=0.775u l=0.6u
.ends

.subckt gf180mcu_fd_sc_mcu7t5v0__aoi22_2 A1 A2 B1 B2 ZN VDD VNW VPW VSS
X0 VDD B1 a_36_472# VNW pfet_05v0 ad=0.3159p pd=1.735u as=0.3159p ps=1.735u w=1.215u l=0.5u
X1 VSS A2 a_1468_69# VPW nfet_05v0 ad=0.3586p pd=2.51u as=0.1304p ps=1.135u w=0.815u l=0.6u
X2 a_36_472# B2 VDD VNW pfet_05v0 ad=0.3159p pd=1.735u as=0.3159p ps=1.735u w=1.215u l=0.5u
X3 ZN A2 a_36_472# VNW pfet_05v0 ad=0.3159p pd=1.735u as=0.3159p ps=1.735u w=1.215u l=0.5u
X4 a_36_472# A1 ZN VNW pfet_05v0 ad=0.3159p pd=1.735u as=0.3159p ps=1.735u w=1.215u l=0.5u
X5 ZN B1 a_244_69# VPW nfet_05v0 ad=0.22615p pd=1.37u as=0.1304p ps=1.135u w=0.815u l=0.6u
X6 a_659_69# B1 ZN VPW nfet_05v0 ad=0.116125p pd=1.1u as=0.22615p ps=1.37u w=0.815u l=0.6u
X7 a_244_69# B2 VSS VPW nfet_05v0 ad=0.1304p pd=1.135u as=0.3586p ps=2.51u w=0.815u l=0.6u
X8 ZN A1 a_36_472# VNW pfet_05v0 ad=0.3159p pd=1.735u as=0.3159p ps=1.735u w=1.215u l=0.5u
X9 a_1468_69# A1 ZN VPW nfet_05v0 ad=0.1304p pd=1.135u as=0.2119p ps=1.335u w=0.815u l=0.6u
X10 a_36_472# A2 ZN VNW pfet_05v0 ad=0.5346p pd=3.31u as=0.3159p ps=1.735u w=1.215u l=0.5u
X11 VSS B2 a_659_69# VPW nfet_05v0 ad=0.2119p pd=1.335u as=0.116125p ps=1.1u w=0.815u l=0.6u
X12 VDD B2 a_36_472# VNW pfet_05v0 ad=0.3159p pd=1.735u as=0.5346p ps=3.31u w=1.215u l=0.5u
X13 ZN A1 a_1060_69# VPW nfet_05v0 ad=0.2119p pd=1.335u as=0.1304p ps=1.135u w=0.815u l=0.6u
X14 a_36_472# B1 VDD VNW pfet_05v0 ad=0.3159p pd=1.735u as=0.3159p ps=1.735u w=1.215u l=0.5u
X15 a_1060_69# A2 VSS VPW nfet_05v0 ad=0.1304p pd=1.135u as=0.2119p ps=1.335u w=0.815u l=0.6u
.ends

.subckt gf180mcu_fd_sc_mcu7t5v0__clkinv_3 I ZN VDD VNW VPW VSS
X0 ZN I VDD VNW pfet_05v0 ad=0.5368p pd=3.32u as=0.3782p ps=1.84u w=1.22u l=0.5u
X1 ZN I VSS VPW nfet_05v0 ad=0.1248p pd=1u as=0.2112p ps=1.84u w=0.48u l=0.6u
X2 VDD I ZN VNW pfet_05v0 ad=0.3782p pd=1.84u as=0.3782p ps=1.84u w=1.22u l=0.5u
X3 ZN I VSS VPW nfet_05v0 ad=0.2112p pd=1.84u as=0.1248p ps=1u w=0.48u l=0.6u
X4 ZN I VDD VNW pfet_05v0 ad=0.3782p pd=1.84u as=0.5368p ps=3.32u w=1.22u l=0.5u
X5 VSS I ZN VPW nfet_05v0 ad=0.1248p pd=1u as=0.1248p ps=1u w=0.48u l=0.6u
.ends

.subckt gf180mcu_fd_sc_mcu7t5v0__xor3_2 A1 A2 A3 Z VDD VNW VPW VSS
X0 VDD a_725_93# a_2153_497# VNW pfet_05v0 ad=0.5694p pd=3.23u as=0.312075p ps=1.665u w=1.095u l=0.5u
X1 a_89_534# A2 VSS VPW nfet_05v0 ad=93.59999f pd=0.88u as=0.1584p ps=1.6u w=0.36u l=0.6u
X2 VSS A2 a_949_93# VPW nfet_05v0 ad=0.1584p pd=1.6u as=57.599995f ps=0.68u w=0.36u l=0.6u
X3 a_1943_497# A3 a_1949_68# VPW nfet_05v0 ad=0.4161p pd=1.905u as=0.2132p ps=1.34u w=0.82u l=0.6u
X4 Z a_1943_497# VDD VNW pfet_05v0 ad=0.5368p pd=3.32u as=0.3782p ps=1.84u w=1.22u l=0.5u
X5 a_1297_93# a_725_93# VDD VNW pfet_05v0 ad=0.1456p pd=1.08u as=0.2464p ps=2u w=0.56u l=0.5u
X6 a_2153_497# A3 a_1943_497# VNW pfet_05v0 ad=0.312075p pd=1.665u as=0.301125p ps=1.645u w=1.095u l=0.5u
X7 VSS A1 a_89_534# VPW nfet_05v0 ad=93.59999f pd=0.88u as=93.59999f ps=0.88u w=0.36u l=0.6u
X8 VDD A3 a_1297_93# VNW pfet_05v0 ad=0.3249p pd=1.835u as=0.1456p ps=1.08u w=0.56u l=0.5u
X9 a_1943_497# a_1297_93# VDD VNW pfet_05v0 ad=0.301125p pd=1.645u as=0.3249p ps=1.835u w=1.095u l=0.5u
X10 a_1949_68# a_725_93# a_1943_497# VPW nfet_05v0 ad=0.3608p pd=2.52u as=0.4161p ps=1.905u w=0.82u l=0.6u
X11 VSS A3 a_1505_93# VPW nfet_05v0 ad=0.218p pd=1.52u as=57.599995f ps=0.68u w=0.36u l=0.6u
X12 a_1505_93# a_725_93# a_1297_93# VPW nfet_05v0 ad=57.599995f pd=0.68u as=0.1584p ps=1.6u w=0.36u l=0.6u
X13 VDD a_1943_497# Z VNW pfet_05v0 ad=0.3782p pd=1.84u as=0.5368p ps=3.32u w=1.22u l=0.5u
X14 VDD A1 a_277_534# VNW pfet_05v0 ad=0.166p pd=1.26u as=0.1026p ps=0.93u w=0.36u l=0.5u
X15 a_1949_68# a_1297_93# VSS VPW nfet_05v0 ad=0.2132p pd=1.34u as=0.218p ps=1.52u w=0.82u l=0.6u
X16 a_949_93# A1 a_725_93# VPW nfet_05v0 ad=57.599995f pd=0.68u as=93.59999f ps=0.88u w=0.36u l=0.6u
X17 Z a_1943_497# VSS VPW nfet_05v0 ad=0.3608p pd=2.52u as=0.2132p ps=1.34u w=0.82u l=0.6u
X18 a_731_494# a_89_534# VDD VNW pfet_05v0 ad=0.1456p pd=1.08u as=0.166p ps=1.26u w=0.56u l=0.5u
X19 a_277_534# A2 a_89_534# VNW pfet_05v0 ad=0.1026p pd=0.93u as=0.1584p ps=1.6u w=0.36u l=0.5u
X20 a_725_93# A1 a_731_494# VNW pfet_05v0 ad=0.1456p pd=1.08u as=0.1456p ps=1.08u w=0.56u l=0.5u
X21 a_725_93# a_89_534# VSS VPW nfet_05v0 ad=93.59999f pd=0.88u as=93.59999f ps=0.88u w=0.36u l=0.6u
X22 VSS a_1943_497# Z VPW nfet_05v0 ad=0.2132p pd=1.34u as=0.3608p ps=2.52u w=0.82u l=0.6u
X23 a_731_494# A2 a_725_93# VNW pfet_05v0 ad=0.2464p pd=2u as=0.1456p ps=1.08u w=0.56u l=0.5u
.ends

.subckt gf180mcu_fd_sc_mcu7t5v0__oai32_2 A1 A2 A3 B1 B2 ZN VDD VNW VPW VSS
X0 a_468_497# A2 a_244_497# VNW pfet_05v0 ad=0.33945p pd=1.715u as=0.33945p ps=1.715u w=1.095u l=0.5u
X1 VSS A1 a_36_68# VPW nfet_05v0 ad=0.2132p pd=1.34u as=0.2132p ps=1.34u w=0.82u l=0.6u
X2 VSS A3 a_36_68# VPW nfet_05v0 ad=0.2132p pd=1.34u as=0.3608p ps=2.52u w=0.82u l=0.6u
X3 VDD B2 a_2060_497# VNW pfet_05v0 ad=0.4818p pd=3.07u as=0.4599p ps=1.935u w=1.095u l=0.5u
X4 VDD A3 a_1120_497# VNW pfet_05v0 ad=0.3942p pd=1.815u as=0.33945p ps=1.715u w=1.095u l=0.5u
X5 a_1588_497# B2 VDD VNW pfet_05v0 ad=0.4599p pd=1.935u as=0.3942p ps=1.815u w=1.095u l=0.5u
X6 ZN B2 a_36_68# VPW nfet_05v0 ad=0.30965p pd=1.685u as=0.2132p ps=1.34u w=0.82u l=0.6u
X7 a_244_497# A3 VDD VNW pfet_05v0 ad=0.33945p pd=1.715u as=0.4818p ps=3.07u w=1.095u l=0.5u
X8 a_36_68# B1 ZN VPW nfet_05v0 ad=0.2132p pd=1.34u as=0.30965p ps=1.685u w=0.82u l=0.6u
X9 ZN A1 a_468_497# VNW pfet_05v0 ad=0.2847p pd=1.615u as=0.33945p ps=1.715u w=1.095u l=0.5u
X10 a_1120_497# A2 a_896_497# VNW pfet_05v0 ad=0.33945p pd=1.715u as=0.33945p ps=1.715u w=1.095u l=0.5u
X11 a_36_68# A3 VSS VPW nfet_05v0 ad=0.2132p pd=1.34u as=0.2132p ps=1.34u w=0.82u l=0.6u
X12 a_896_497# A1 ZN VNW pfet_05v0 ad=0.33945p pd=1.715u as=0.2847p ps=1.615u w=1.095u l=0.5u
X13 ZN B1 a_36_68# VPW nfet_05v0 ad=0.30965p pd=1.685u as=0.2132p ps=1.34u w=0.82u l=0.6u
X14 a_36_68# A1 VSS VPW nfet_05v0 ad=0.2132p pd=1.34u as=0.2132p ps=1.34u w=0.82u l=0.6u
X15 a_36_68# B2 ZN VPW nfet_05v0 ad=0.3608p pd=2.52u as=0.30965p ps=1.685u w=0.82u l=0.6u
X16 ZN B1 a_1588_497# VNW pfet_05v0 ad=0.2847p pd=1.615u as=0.4599p ps=1.935u w=1.095u l=0.5u
X17 a_36_68# A2 VSS VPW nfet_05v0 ad=0.2132p pd=1.34u as=0.2132p ps=1.34u w=0.82u l=0.6u
X18 a_2060_497# B1 ZN VNW pfet_05v0 ad=0.4599p pd=1.935u as=0.2847p ps=1.615u w=1.095u l=0.5u
X19 VSS A2 a_36_68# VPW nfet_05v0 ad=0.2132p pd=1.34u as=0.2132p ps=1.34u w=0.82u l=0.6u
.ends

.subckt gf180mcu_fd_sc_mcu7t5v0__mux2_4 I0 I1 S Z VDD VNW VPW VSS
X0 VSS a_135_24# Z VPW nfet_05v0 ad=0.2132p pd=1.34u as=0.2132p ps=1.34u w=0.82u l=0.6u
X1 a_1151_68# I1 VSS VPW nfet_05v0 ad=98.399994f pd=1.06u as=0.2132p ps=1.34u w=0.82u l=0.6u
X2 VDD a_135_24# Z VNW pfet_05v0 ad=0.3782p pd=1.84u as=0.3782p ps=1.84u w=1.22u l=0.5u
X3 VSS I0 a_1543_68# VPW nfet_05v0 ad=0.2132p pd=1.34u as=0.1968p ps=1.3u w=0.82u l=0.6u
X4 Z a_135_24# VSS VPW nfet_05v0 ad=0.2132p pd=1.34u as=0.2132p ps=1.34u w=0.82u l=0.6u
X5 Z a_135_24# VSS VPW nfet_05v0 ad=0.2132p pd=1.34u as=0.3608p ps=2.52u w=0.82u l=0.6u
X6 a_135_24# a_1307_380# a_1151_472# VNW pfet_05v0 ad=0.3172p pd=1.74u as=0.4758p ps=2u w=1.22u l=0.5u
X7 a_1307_380# S VSS VPW nfet_05v0 ad=0.3608p pd=2.52u as=0.2132p ps=1.34u w=0.82u l=0.6u
X8 a_1611_472# S a_135_24# VNW pfet_05v0 ad=0.1464p pd=1.46u as=0.3172p ps=1.74u w=1.22u l=0.5u
X9 Z a_135_24# VDD VNW pfet_05v0 ad=0.3782p pd=1.84u as=0.5368p ps=3.32u w=1.22u l=0.5u
X10 VDD I0 a_1611_472# VNW pfet_05v0 ad=0.3172p pd=1.74u as=0.1464p ps=1.46u w=1.22u l=0.5u
X11 a_135_24# S a_1151_68# VPW nfet_05v0 ad=0.2132p pd=1.34u as=98.399994f ps=1.06u w=0.82u l=0.6u
X12 a_1307_380# S VDD VNW pfet_05v0 ad=0.5368p pd=3.32u as=0.3172p ps=1.74u w=1.22u l=0.5u
X13 Z a_135_24# VDD VNW pfet_05v0 ad=0.3477p pd=1.79u as=0.3782p ps=1.84u w=1.22u l=0.5u
X14 a_1543_68# a_1307_380# a_135_24# VPW nfet_05v0 ad=0.1968p pd=1.3u as=0.2132p ps=1.34u w=0.82u l=0.6u
X15 VDD a_135_24# Z VNW pfet_05v0 ad=0.4392p pd=1.94u as=0.3477p ps=1.79u w=1.22u l=0.5u
X16 VSS a_135_24# Z VPW nfet_05v0 ad=0.2132p pd=1.34u as=0.2132p ps=1.34u w=0.82u l=0.6u
X17 a_1151_472# I1 VDD VNW pfet_05v0 ad=0.4758p pd=2u as=0.4392p ps=1.94u w=1.22u l=0.5u
.ends

.subckt gf180mcu_fd_sc_mcu7t5v0__aoi222_4 A1 A2 B1 B2 C1 C2 ZN VDD VNW VPW VSS
X0 ZN A2 a_1812_472# VNW pfet_05v0 ad=0.3172p pd=1.74u as=0.3172p ps=1.74u w=1.22u l=0.5u
X1 a_224_472# C2 VDD VNW pfet_05v0 ad=0.3172p pd=1.74u as=0.3172p ps=1.74u w=1.22u l=0.5u
X2 ZN A1 a_4876_68# VPW nfet_05v0 ad=0.3608p pd=2.52u as=0.1312p ps=1.14u w=0.82u l=0.6u
X3 a_1812_472# A1 ZN VNW pfet_05v0 ad=0.5368p pd=3.32u as=0.3172p ps=1.74u w=1.22u l=0.5u
X4 a_2010_68# B1 ZN VPW nfet_05v0 ad=0.1517p pd=1.19u as=0.4879p ps=2.01u w=0.82u l=0.6u
X5 VSS A2 a_3652_68# VPW nfet_05v0 ad=0.2132p pd=1.34u as=0.1312p ps=1.14u w=0.82u l=0.6u
X6 a_3652_68# A1 ZN VPW nfet_05v0 ad=0.1312p pd=1.14u as=0.2132p ps=1.34u w=0.82u l=0.6u
X7 VDD C1 a_224_472# VNW pfet_05v0 ad=0.3172p pd=1.74u as=0.3172p ps=1.74u w=1.22u l=0.5u
X8 a_244_68# C1 ZN VPW nfet_05v0 ad=0.1312p pd=1.14u as=0.3608p ps=2.52u w=0.82u l=0.6u
X9 VSS C2 a_244_68# VPW nfet_05v0 ad=0.2132p pd=1.34u as=0.1312p ps=1.14u w=0.82u l=0.6u
X10 a_1812_472# B2 a_224_472# VNW pfet_05v0 ad=0.3172p pd=1.74u as=0.3172p ps=1.74u w=1.22u l=0.5u
X11 a_1468_68# C2 VSS VPW nfet_05v0 ad=0.1312p pd=1.14u as=0.2132p ps=1.34u w=0.82u l=0.6u
X12 a_2428_68# B2 VSS VPW nfet_05v0 ad=0.1312p pd=1.14u as=0.2132p ps=1.34u w=0.82u l=0.6u
X13 a_224_472# C1 VDD VNW pfet_05v0 ad=0.3172p pd=1.74u as=0.3172p ps=1.74u w=1.22u l=0.5u
X14 a_4468_68# A1 ZN VPW nfet_05v0 ad=0.1312p pd=1.14u as=0.2132p ps=1.34u w=0.82u l=0.6u
X15 a_224_472# B2 a_1812_472# VNW pfet_05v0 ad=0.3172p pd=1.74u as=0.3172p ps=1.74u w=1.22u l=0.5u
X16 a_224_472# B1 a_1812_472# VNW pfet_05v0 ad=0.3172p pd=1.74u as=0.5368p ps=3.32u w=1.22u l=0.5u
X17 a_4060_68# A2 VSS VPW nfet_05v0 ad=0.1312p pd=1.14u as=0.2132p ps=1.34u w=0.82u l=0.6u
X18 a_1812_472# B1 a_224_472# VNW pfet_05v0 ad=0.3172p pd=1.74u as=0.3172p ps=1.74u w=1.22u l=0.5u
X19 a_652_68# C2 VSS VPW nfet_05v0 ad=0.1312p pd=1.14u as=0.2132p ps=1.34u w=0.82u l=0.6u
X20 ZN C1 a_652_68# VPW nfet_05v0 ad=0.2132p pd=1.34u as=0.1312p ps=1.14u w=0.82u l=0.6u
X21 VDD C2 a_224_472# VNW pfet_05v0 ad=0.3172p pd=1.74u as=0.3172p ps=1.74u w=1.22u l=0.5u
X22 a_2836_68# B1 ZN VPW nfet_05v0 ad=0.1312p pd=1.14u as=0.2132p ps=1.34u w=0.82u l=0.6u
X23 a_224_472# B2 a_1812_472# VNW pfet_05v0 ad=0.3172p pd=1.74u as=0.3172p ps=1.74u w=1.22u l=0.5u
X24 a_224_472# B1 a_1812_472# VNW pfet_05v0 ad=0.3172p pd=1.74u as=0.3172p ps=1.74u w=1.22u l=0.5u
X25 VSS C2 a_1060_68# VPW nfet_05v0 ad=0.2132p pd=1.34u as=0.1312p ps=1.14u w=0.82u l=0.6u
X26 a_224_472# C2 VDD VNW pfet_05v0 ad=0.3172p pd=1.74u as=0.3172p ps=1.74u w=1.22u l=0.5u
X27 VSS B2 a_2010_68# VPW nfet_05v0 ad=0.2132p pd=1.34u as=0.1517p ps=1.19u w=0.82u l=0.6u
X28 a_4876_68# A2 VSS VPW nfet_05v0 ad=0.1312p pd=1.14u as=0.2132p ps=1.34u w=0.82u l=0.6u
X29 a_1812_472# B1 a_224_472# VNW pfet_05v0 ad=0.3172p pd=1.74u as=0.3172p ps=1.74u w=1.22u l=0.5u
X30 a_1812_472# B2 a_224_472# VNW pfet_05v0 ad=0.3172p pd=1.74u as=0.3172p ps=1.74u w=1.22u l=0.5u
X31 a_1060_68# C1 ZN VPW nfet_05v0 ad=0.1312p pd=1.14u as=0.2132p ps=1.34u w=0.82u l=0.6u
X32 ZN A1 a_4060_68# VPW nfet_05v0 ad=0.2132p pd=1.34u as=0.1312p ps=1.14u w=0.82u l=0.6u
X33 VDD C1 a_224_472# VNW pfet_05v0 ad=0.5368p pd=3.32u as=0.3172p ps=1.74u w=1.22u l=0.5u
X34 ZN A1 a_1812_472# VNW pfet_05v0 ad=0.3172p pd=1.74u as=0.3172p ps=1.74u w=1.22u l=0.5u
X35 a_1812_472# A1 ZN VNW pfet_05v0 ad=0.3172p pd=1.74u as=0.3172p ps=1.74u w=1.22u l=0.5u
X36 ZN C1 a_1468_68# VPW nfet_05v0 ad=0.4879p pd=2.01u as=0.1312p ps=1.14u w=0.82u l=0.6u
X37 a_1812_472# A2 ZN VNW pfet_05v0 ad=0.3172p pd=1.74u as=0.3172p ps=1.74u w=1.22u l=0.5u
X38 ZN B1 a_2428_68# VPW nfet_05v0 ad=0.2132p pd=1.34u as=0.1312p ps=1.14u w=0.82u l=0.6u
X39 ZN A2 a_1812_472# VNW pfet_05v0 ad=0.3172p pd=1.74u as=0.3172p ps=1.74u w=1.22u l=0.5u
X40 ZN A1 a_1812_472# VNW pfet_05v0 ad=0.3172p pd=1.74u as=0.3172p ps=1.74u w=1.22u l=0.5u
X41 VSS A2 a_4468_68# VPW nfet_05v0 ad=0.2132p pd=1.34u as=0.1312p ps=1.14u w=0.82u l=0.6u
X42 a_224_472# C1 VDD VNW pfet_05v0 ad=0.3172p pd=1.74u as=0.5368p ps=3.32u w=1.22u l=0.5u
X43 a_1812_472# A2 ZN VNW pfet_05v0 ad=0.3172p pd=1.74u as=0.3172p ps=1.74u w=1.22u l=0.5u
X44 ZN B1 a_3244_68# VPW nfet_05v0 ad=0.2132p pd=1.34u as=0.1312p ps=1.14u w=0.82u l=0.6u
X45 a_3244_68# B2 VSS VPW nfet_05v0 ad=0.1312p pd=1.14u as=0.2132p ps=1.34u w=0.82u l=0.6u
X46 VDD C2 a_224_472# VNW pfet_05v0 ad=0.3172p pd=1.74u as=0.3172p ps=1.74u w=1.22u l=0.5u
X47 VSS B2 a_2836_68# VPW nfet_05v0 ad=0.2132p pd=1.34u as=0.1312p ps=1.14u w=0.82u l=0.6u
.ends

.subckt gf180mcu_fd_sc_mcu7t5v0__clkinv_4 I ZN VDD VNW VPW VSS
X0 ZN I VDD VNW pfet_05v0 ad=0.4392p pd=1.94u as=0.3172p ps=1.74u w=1.22u l=0.5u
X1 VSS I ZN VPW nfet_05v0 ad=0.2112p pd=1.84u as=0.1248p ps=1u w=0.48u l=0.6u
X2 ZN I VSS VPW nfet_05v0 ad=0.1248p pd=1u as=0.2112p ps=1.84u w=0.48u l=0.6u
X3 VDD I ZN VNW pfet_05v0 ad=0.5368p pd=3.32u as=0.4392p ps=1.94u w=1.22u l=0.5u
X4 ZN I VSS VPW nfet_05v0 ad=0.1248p pd=1u as=0.1248p ps=1u w=0.48u l=0.6u
X5 ZN I VDD VNW pfet_05v0 ad=0.4392p pd=1.94u as=0.5368p ps=3.32u w=1.22u l=0.5u
X6 VDD I ZN VNW pfet_05v0 ad=0.3172p pd=1.74u as=0.4392p ps=1.94u w=1.22u l=0.5u
X7 VSS I ZN VPW nfet_05v0 ad=0.1248p pd=1u as=0.1248p ps=1u w=0.48u l=0.6u
.ends

.subckt gf180mcu_fd_sc_mcu7t5v0__aoi21_4 A1 A2 B ZN VDD VNW VPW VSS
X0 VDD B a_76_476# VNW pfet_05v0 ad=0.312p pd=1.72u as=0.312p ps=1.72u w=1.2u l=0.5u
X1 a_680_68# A1 ZN VPW nfet_05v0 ad=98.399994f pd=1.06u as=0.2132p ps=1.34u w=0.82u l=0.6u
X2 VDD B a_76_476# VNW pfet_05v0 ad=0.312p pd=1.72u as=0.48p ps=2u w=1.2u l=0.5u
X3 a_76_476# B VDD VNW pfet_05v0 ad=0.528p pd=3.28u as=0.312p ps=1.72u w=1.2u l=0.5u
X4 ZN B VSS VPW nfet_05v0 ad=0.1326p pd=1.03u as=0.1326p ps=1.03u w=0.51u l=0.6u
X5 ZN A2 a_76_476# VNW pfet_05v0 ad=0.312p pd=1.72u as=0.528p ps=3.28u w=1.2u l=0.5u
X6 a_76_476# A1 ZN VNW pfet_05v0 ad=0.312p pd=1.72u as=0.312p ps=1.72u w=1.2u l=0.5u
X7 a_1464_68# A1 ZN VPW nfet_05v0 ad=98.399994f pd=1.06u as=0.2132p ps=1.34u w=0.82u l=0.6u
X8 ZN A1 a_76_476# VNW pfet_05v0 ad=0.312p pd=1.72u as=0.312p ps=1.72u w=1.2u l=0.5u
X9 VSS A2 a_1464_68# VPW nfet_05v0 ad=0.2405p pd=1.52u as=98.399994f ps=1.06u w=0.82u l=0.6u
X10 a_76_476# A2 ZN VNW pfet_05v0 ad=0.312p pd=1.72u as=0.312p ps=1.72u w=1.2u l=0.5u
X11 VSS A2 a_680_68# VPW nfet_05v0 ad=0.2132p pd=1.34u as=98.399994f ps=1.06u w=0.82u l=0.6u
X12 ZN A2 a_76_476# VNW pfet_05v0 ad=0.312p pd=1.72u as=0.312p ps=1.72u w=1.2u l=0.5u
X13 VSS B ZN VPW nfet_05v0 ad=0.1326p pd=1.03u as=0.1326p ps=1.03u w=0.51u l=0.6u
X14 ZN A1 a_1072_68# VPW nfet_05v0 ad=0.2132p pd=1.34u as=98.399994f ps=1.06u w=0.82u l=0.6u
X15 a_288_68# A2 VSS VPW nfet_05v0 ad=98.399994f pd=1.06u as=0.3608p ps=2.52u w=0.82u l=0.6u
X16 a_1072_68# A2 VSS VPW nfet_05v0 ad=98.399994f pd=1.06u as=0.2132p ps=1.34u w=0.82u l=0.6u
X17 VSS B ZN VPW nfet_05v0 ad=0.2244p pd=1.9u as=0.1326p ps=1.03u w=0.51u l=0.6u
X18 a_76_476# A1 ZN VNW pfet_05v0 ad=0.312p pd=1.72u as=0.312p ps=1.72u w=1.2u l=0.5u
X19 ZN A1 a_288_68# VPW nfet_05v0 ad=0.2132p pd=1.34u as=98.399994f ps=1.06u w=0.82u l=0.6u
X20 ZN A1 a_76_476# VNW pfet_05v0 ad=0.312p pd=1.72u as=0.312p ps=1.72u w=1.2u l=0.5u
X21 a_76_476# A2 ZN VNW pfet_05v0 ad=0.48p pd=2u as=0.312p ps=1.72u w=1.2u l=0.5u
X22 a_76_476# B VDD VNW pfet_05v0 ad=0.312p pd=1.72u as=0.312p ps=1.72u w=1.2u l=0.5u
X23 ZN B VSS VPW nfet_05v0 ad=0.1326p pd=1.03u as=0.2405p ps=1.52u w=0.51u l=0.6u
.ends

.subckt gf180mcu_fd_sc_mcu7t5v0__clkbuf_16 I Z VDD VNW VPW VSS
X0 VSS I a_224_552# VPW nfet_05v0 ad=0.1053p pd=0.925u as=0.1053p ps=0.925u w=0.405u l=0.6u
X1 VSS a_224_552# Z VPW nfet_05v0 ad=0.1261p pd=1.005u as=0.1261p ps=1.005u w=0.485u l=0.6u
X2 a_224_552# I VDD VNW pfet_05v0 ad=0.2542p pd=1.44u as=0.2542p ps=1.44u w=0.82u l=0.5u
X3 Z a_224_552# VDD VNW pfet_05v0 ad=0.3782p pd=1.84u as=0.3782p ps=1.84u w=1.22u l=0.5u
X4 Z a_224_552# VSS VPW nfet_05v0 ad=0.1261p pd=1.005u as=0.1261p ps=1.005u w=0.485u l=0.6u
X5 VDD a_224_552# Z VNW pfet_05v0 ad=0.3782p pd=1.84u as=0.3782p ps=1.84u w=1.22u l=0.5u
X6 VDD a_224_552# Z VNW pfet_05v0 ad=0.3782p pd=1.84u as=0.3782p ps=1.84u w=1.22u l=0.5u
X7 Z a_224_552# VDD VNW pfet_05v0 ad=0.3782p pd=1.84u as=0.3782p ps=1.84u w=1.22u l=0.5u
X8 a_224_552# I VDD VNW pfet_05v0 ad=0.2542p pd=1.44u as=0.3608p ps=2.52u w=0.82u l=0.5u
X9 VDD a_224_552# Z VNW pfet_05v0 ad=0.3782p pd=1.84u as=0.3782p ps=1.84u w=1.22u l=0.5u
X10 Z a_224_552# VSS VPW nfet_05v0 ad=0.1261p pd=1.005u as=0.1261p ps=1.005u w=0.485u l=0.6u
X11 VSS a_224_552# Z VPW nfet_05v0 ad=0.1261p pd=1.005u as=0.1261p ps=1.005u w=0.485u l=0.6u
X12 VSS a_224_552# Z VPW nfet_05v0 ad=0.1261p pd=1.005u as=0.1261p ps=1.005u w=0.485u l=0.6u
X13 VDD a_224_552# Z VNW pfet_05v0 ad=0.5368p pd=3.32u as=0.3782p ps=1.84u w=1.22u l=0.5u
X14 Z a_224_552# VSS VPW nfet_05v0 ad=0.1261p pd=1.005u as=0.1261p ps=1.005u w=0.485u l=0.6u
X15 VSS I a_224_552# VPW nfet_05v0 ad=0.1053p pd=0.925u as=0.1782p ps=1.69u w=0.405u l=0.6u
X16 a_224_552# I VDD VNW pfet_05v0 ad=0.2542p pd=1.44u as=0.2542p ps=1.44u w=0.82u l=0.5u
X17 a_224_552# I VSS VPW nfet_05v0 ad=0.1053p pd=0.925u as=0.1053p ps=0.925u w=0.405u l=0.6u
X18 VSS a_224_552# Z VPW nfet_05v0 ad=0.1261p pd=1.005u as=0.1261p ps=1.005u w=0.485u l=0.6u
X19 Z a_224_552# VDD VNW pfet_05v0 ad=0.3782p pd=1.84u as=0.428p ps=2.02u w=1.22u l=0.5u
X20 VDD I a_224_552# VNW pfet_05v0 ad=0.2542p pd=1.44u as=0.2542p ps=1.44u w=0.82u l=0.5u
X21 Z a_224_552# VDD VNW pfet_05v0 ad=0.3782p pd=1.84u as=0.3782p ps=1.84u w=1.22u l=0.5u
X22 Z a_224_552# VDD VNW pfet_05v0 ad=0.3782p pd=1.84u as=0.3782p ps=1.84u w=1.22u l=0.5u
X23 VSS I a_224_552# VPW nfet_05v0 ad=0.1053p pd=0.925u as=0.1053p ps=0.925u w=0.405u l=0.6u
X24 VDD a_224_552# Z VNW pfet_05v0 ad=0.3782p pd=1.84u as=0.3782p ps=1.84u w=1.22u l=0.5u
X25 Z a_224_552# VSS VPW nfet_05v0 ad=0.1261p pd=1.005u as=0.1261p ps=1.005u w=0.485u l=0.6u
X26 VSS a_224_552# Z VPW nfet_05v0 ad=0.1261p pd=1.005u as=0.1261p ps=1.005u w=0.485u l=0.6u
X27 VSS a_224_552# Z VPW nfet_05v0 ad=0.1261p pd=1.005u as=0.1261p ps=1.005u w=0.485u l=0.6u
X28 VDD I a_224_552# VNW pfet_05v0 ad=0.428p pd=2.02u as=0.2542p ps=1.44u w=0.82u l=0.5u
X29 Z a_224_552# VDD VNW pfet_05v0 ad=0.3782p pd=1.84u as=0.3782p ps=1.84u w=1.22u l=0.5u
X30 a_224_552# I VSS VPW nfet_05v0 ad=0.1782p pd=1.69u as=0.1053p ps=0.925u w=0.405u l=0.6u
X31 Z a_224_552# VSS VPW nfet_05v0 ad=0.1261p pd=1.005u as=0.1261p ps=1.005u w=0.485u l=0.6u
X32 VSS a_224_552# Z VPW nfet_05v0 ad=0.1261p pd=1.005u as=0.1261p ps=1.005u w=0.485u l=0.6u
X33 Z a_224_552# VDD VNW pfet_05v0 ad=0.3782p pd=1.84u as=0.3782p ps=1.84u w=1.22u l=0.5u
X34 VSS a_224_552# Z VPW nfet_05v0 ad=0.2134p pd=1.85u as=0.1261p ps=1.005u w=0.485u l=0.6u
X35 VDD I a_224_552# VNW pfet_05v0 ad=0.2542p pd=1.44u as=0.2542p ps=1.44u w=0.82u l=0.5u
X36 VDD a_224_552# Z VNW pfet_05v0 ad=0.3782p pd=1.84u as=0.3782p ps=1.84u w=1.22u l=0.5u
X37 VDD a_224_552# Z VNW pfet_05v0 ad=0.3782p pd=1.84u as=0.3782p ps=1.84u w=1.22u l=0.5u
X38 Z a_224_552# VDD VNW pfet_05v0 ad=0.3782p pd=1.84u as=0.3782p ps=1.84u w=1.22u l=0.5u
X39 a_224_552# I VDD VNW pfet_05v0 ad=0.2542p pd=1.44u as=0.2542p ps=1.44u w=0.82u l=0.5u
X40 a_224_552# I VSS VPW nfet_05v0 ad=0.1053p pd=0.925u as=0.1053p ps=0.925u w=0.405u l=0.6u
X41 Z a_224_552# VSS VPW nfet_05v0 ad=0.1261p pd=1.005u as=0.2134p ps=1.85u w=0.485u l=0.6u
X42 VDD I a_224_552# VNW pfet_05v0 ad=0.2542p pd=1.44u as=0.2542p ps=1.44u w=0.82u l=0.5u
X43 VDD a_224_552# Z VNW pfet_05v0 ad=0.3782p pd=1.84u as=0.3782p ps=1.84u w=1.22u l=0.5u
X44 Z a_224_552# VSS VPW nfet_05v0 ad=0.1261p pd=1.005u as=0.1261p ps=1.005u w=0.485u l=0.6u
X45 Z a_224_552# VSS VPW nfet_05v0 ad=0.1261p pd=1.005u as=0.1261p ps=1.005u w=0.485u l=0.6u
.ends

.subckt gf180mcu_fd_sc_mcu7t5v0__oai221_2 A1 A2 B1 B2 C ZN VDD VNW VPW VSS
X0 ZN B1 a_224_497# VNW pfet_05v0 ad=0.2847p pd=1.615u as=0.3942p ps=1.815u w=1.095u l=0.5u
X1 a_672_497# B1 ZN VNW pfet_05v0 ad=0.3942p pd=1.815u as=0.2847p ps=1.615u w=1.095u l=0.5u
X2 a_244_68# B1 VSS VPW nfet_05v0 ad=0.2132p pd=1.34u as=0.2132p ps=1.34u w=0.82u l=0.6u
X3 a_244_68# B2 VSS VPW nfet_05v0 ad=0.2132p pd=1.34u as=0.3608p ps=2.52u w=0.82u l=0.6u
X4 a_1076_93# A2 ZN VPW nfet_05v0 ad=0.2132p pd=1.34u as=0.2132p ps=1.34u w=0.82u l=0.6u
X5 a_1076_93# C a_244_68# VPW nfet_05v0 ad=0.2132p pd=1.34u as=0.2132p ps=1.34u w=0.82u l=0.6u
X6 VDD C ZN VNW pfet_05v0 ad=0.2561p pd=1.505u as=0.5319p ps=3.05u w=0.985u l=0.5u
X7 a_2160_497# A2 VDD VNW pfet_05v0 ad=0.4599p pd=1.935u as=0.2847p ps=1.615u w=1.095u l=0.5u
X8 ZN C VDD VNW pfet_05v0 ad=0.3766p pd=1.815u as=0.2561p ps=1.505u w=0.985u l=0.5u
X9 VDD B2 a_672_497# VNW pfet_05v0 ad=0.4818p pd=3.07u as=0.3942p ps=1.815u w=1.095u l=0.5u
X10 VDD A2 a_1732_497# VNW pfet_05v0 ad=0.2847p pd=1.615u as=0.33945p ps=1.715u w=1.095u l=0.5u
X11 ZN A1 a_1076_93# VPW nfet_05v0 ad=0.2132p pd=1.34u as=0.2132p ps=1.34u w=0.82u l=0.6u
X12 a_1076_93# A1 ZN VPW nfet_05v0 ad=0.3608p pd=2.52u as=0.30965p ps=1.685u w=0.82u l=0.6u
X13 a_244_68# C a_1076_93# VPW nfet_05v0 ad=0.2132p pd=1.34u as=0.3608p ps=2.52u w=0.82u l=0.6u
X14 ZN A2 a_1076_93# VPW nfet_05v0 ad=0.30965p pd=1.685u as=0.2132p ps=1.34u w=0.82u l=0.6u
X15 VSS B2 a_244_68# VPW nfet_05v0 ad=0.3608p pd=2.52u as=0.2132p ps=1.34u w=0.82u l=0.6u
X16 VSS B1 a_244_68# VPW nfet_05v0 ad=0.2132p pd=1.34u as=0.2132p ps=1.34u w=0.82u l=0.6u
X17 ZN A1 a_2160_497# VNW pfet_05v0 ad=0.4818p pd=3.07u as=0.4599p ps=1.935u w=1.095u l=0.5u
X18 a_224_497# B2 VDD VNW pfet_05v0 ad=0.3942p pd=1.815u as=0.4818p ps=3.07u w=1.095u l=0.5u
X19 a_1732_497# A1 ZN VNW pfet_05v0 ad=0.33945p pd=1.715u as=0.3766p ps=1.815u w=1.095u l=0.5u
.ends

.subckt gf180mcu_fd_sc_mcu7t5v0__nor3_2 A1 A2 A3 ZN VDD VNW VPW VSS
X0 VDD A3 a_1130_472# VNW pfet_05v0 ad=0.5368p pd=3.32u as=0.3477p ps=1.79u w=1.22u l=0.5u
X1 a_1130_472# A2 a_906_472# VNW pfet_05v0 ad=0.3477p pd=1.79u as=0.3782p ps=1.84u w=1.22u l=0.5u
X2 ZN A3 VSS VPW nfet_05v0 ad=0.2046p pd=1.81u as=0.1209p ps=0.985u w=0.465u l=0.6u
X3 a_244_472# A3 VDD VNW pfet_05v0 ad=0.3782p pd=1.84u as=0.5368p ps=3.32u w=1.22u l=0.5u
X4 ZN A1 VSS VPW nfet_05v0 ad=0.1209p pd=0.985u as=0.1209p ps=0.985u w=0.465u l=0.6u
X5 ZN A2 VSS VPW nfet_05v0 ad=0.1209p pd=0.985u as=0.1209p ps=0.985u w=0.465u l=0.6u
X6 VSS A2 ZN VPW nfet_05v0 ad=0.1209p pd=0.985u as=0.1209p ps=0.985u w=0.465u l=0.6u
X7 a_906_472# A1 ZN VNW pfet_05v0 ad=0.3782p pd=1.84u as=0.3782p ps=1.84u w=1.22u l=0.5u
X8 ZN A1 a_468_472# VNW pfet_05v0 ad=0.3782p pd=1.84u as=0.3477p ps=1.79u w=1.22u l=0.5u
X9 VSS A1 ZN VPW nfet_05v0 ad=0.1209p pd=0.985u as=0.1209p ps=0.985u w=0.465u l=0.6u
X10 VSS A3 ZN VPW nfet_05v0 ad=0.1209p pd=0.985u as=0.2046p ps=1.81u w=0.465u l=0.6u
X11 a_468_472# A2 a_244_472# VNW pfet_05v0 ad=0.3477p pd=1.79u as=0.3782p ps=1.84u w=1.22u l=0.5u
.ends

.subckt gf180mcu_fd_sc_mcu7t5v0__oai221_1 A1 A2 B1 B2 C ZN VDD VNW VPW VSS
X0 a_692_68# C a_36_68# VPW nfet_05v0 ad=0.246p pd=1.42u as=0.2132p ps=1.34u w=0.82u l=0.6u
X1 a_932_472# A2 VDD VNW pfet_05v0 ad=0.3172p pd=1.74u as=0.38575p ps=1.92u w=1.22u l=0.5u
X2 VSS B2 a_36_68# VPW nfet_05v0 ad=0.2132p pd=1.34u as=0.3608p ps=2.52u w=0.82u l=0.6u
X3 ZN A2 a_692_68# VPW nfet_05v0 ad=0.2132p pd=1.34u as=0.246p ps=1.42u w=0.82u l=0.6u
X4 a_244_472# B2 VDD VNW pfet_05v0 ad=0.3172p pd=1.74u as=0.6588p ps=3.52u w=1.22u l=0.5u
X5 ZN A1 a_932_472# VNW pfet_05v0 ad=0.5368p pd=3.32u as=0.3172p ps=1.74u w=1.22u l=0.5u
X6 VDD C ZN VNW pfet_05v0 ad=0.38575p pd=1.92u as=0.3952p ps=1.94u w=0.945u l=0.5u
X7 ZN B1 a_244_472# VNW pfet_05v0 ad=0.3952p pd=1.94u as=0.3172p ps=1.74u w=1.22u l=0.5u
X8 a_36_68# B1 VSS VPW nfet_05v0 ad=0.2132p pd=1.34u as=0.2132p ps=1.34u w=0.82u l=0.6u
X9 a_692_68# A1 ZN VPW nfet_05v0 ad=0.3608p pd=2.52u as=0.2132p ps=1.34u w=0.82u l=0.6u
.ends

.subckt gf180mcu_fd_sc_mcu7t5v0__mux2_1 I0 I1 S Z VDD VNW VPW VSS
X0 a_896_593# S a_124_24# VNW pfet_05v0 ad=73.799995f pd=0.855u as=0.1599p ps=1.135u w=0.615u l=0.5u
X1 VSS a_124_24# Z VPW nfet_05v0 ad=0.218p pd=1.52u as=0.3608p ps=2.52u w=0.82u l=0.6u
X2 a_124_24# S a_504_104# VPW nfet_05v0 ad=93.59999f pd=0.88u as=43.199997f ps=0.6u w=0.36u l=0.6u
X3 VDD a_124_24# Z VNW pfet_05v0 ad=0.429825p pd=2.185u as=0.5368p ps=3.32u w=1.22u l=0.5u
X4 VDD I0 a_896_593# VNW pfet_05v0 ad=0.1599p pd=1.135u as=73.799995f ps=0.855u w=0.615u l=0.5u
X5 a_592_407# S VSS VPW nfet_05v0 ad=0.1584p pd=1.6u as=93.59999f ps=0.88u w=0.36u l=0.6u
X6 a_504_104# I1 VSS VPW nfet_05v0 ad=43.199997f pd=0.6u as=0.218p ps=1.52u w=0.36u l=0.6u
X7 a_592_407# S VDD VNW pfet_05v0 ad=0.2706p pd=2.11u as=0.1599p ps=1.135u w=0.615u l=0.5u
X8 a_537_593# I1 VDD VNW pfet_05v0 ad=84.549995f pd=0.89u as=0.429825p ps=2.185u w=0.615u l=0.5u
X9 VSS I0 a_896_104# VPW nfet_05v0 ad=93.59999f pd=0.88u as=43.199997f ps=0.6u w=0.36u l=0.6u
X10 a_896_104# a_592_407# a_124_24# VPW nfet_05v0 ad=43.199997f pd=0.6u as=93.59999f ps=0.88u w=0.36u l=0.6u
X11 a_124_24# a_592_407# a_537_593# VNW pfet_05v0 ad=0.1599p pd=1.135u as=84.549995f ps=0.89u w=0.615u l=0.5u
.ends

.subckt gf180mcu_fd_sc_mcu7t5v0__oai22_4 A1 A2 B1 B2 ZN VDD VNW VPW VSS
X0 ZN A1 a_2036_497# VNW pfet_05v0 ad=0.2847p pd=1.615u as=0.4599p ps=1.935u w=1.095u l=0.5u
X1 ZN B1 a_244_497# VNW pfet_05v0 ad=0.2847p pd=1.615u as=0.33945p ps=1.715u w=1.095u l=0.5u
X2 a_672_497# B1 ZN VNW pfet_05v0 ad=0.3942p pd=1.815u as=0.2847p ps=1.615u w=1.095u l=0.5u
X3 a_2508_497# A1 ZN VNW pfet_05v0 ad=0.3942p pd=1.815u as=0.2847p ps=1.615u w=1.095u l=0.5u
X4 VSS B1 a_36_68# VPW nfet_05v0 ad=0.2132p pd=1.34u as=0.2132p ps=1.34u w=0.82u l=0.6u
X5 VDD A2 a_2508_497# VNW pfet_05v0 ad=0.2847p pd=1.615u as=0.3942p ps=1.815u w=1.095u l=0.5u
X6 VSS B2 a_36_68# VPW nfet_05v0 ad=0.2132p pd=1.34u as=0.3608p ps=2.52u w=0.82u l=0.6u
X7 ZN A2 a_36_68# VPW nfet_05v0 ad=0.30965p pd=1.685u as=0.2132p ps=1.34u w=0.82u l=0.6u
X8 ZN A2 a_36_68# VPW nfet_05v0 ad=0.2132p pd=1.34u as=0.2132p ps=1.34u w=0.82u l=0.6u
X9 a_2956_497# A2 VDD VNW pfet_05v0 ad=0.3942p pd=1.815u as=0.2847p ps=1.615u w=1.095u l=0.5u
X10 VSS B1 a_36_68# VPW nfet_05v0 ad=0.2132p pd=1.34u as=0.2132p ps=1.34u w=0.82u l=0.6u
X11 ZN A1 a_2956_497# VNW pfet_05v0 ad=0.2847p pd=1.615u as=0.3942p ps=1.815u w=1.095u l=0.5u
X12 ZN A1 a_36_68# VPW nfet_05v0 ad=0.2132p pd=1.34u as=0.2132p ps=1.34u w=0.82u l=0.6u
X13 VDD B2 a_1568_497# VNW pfet_05v0 ad=0.3942p pd=1.815u as=0.33945p ps=1.715u w=1.095u l=0.5u
X14 a_244_497# B2 VDD VNW pfet_05v0 ad=0.33945p pd=1.715u as=0.4818p ps=3.07u w=1.095u l=0.5u
X15 ZN A1 a_36_68# VPW nfet_05v0 ad=0.30965p pd=1.685u as=0.2132p ps=1.34u w=0.82u l=0.6u
X16 VDD B2 a_672_497# VNW pfet_05v0 ad=0.2847p pd=1.615u as=0.3942p ps=1.815u w=1.095u l=0.5u
X17 a_3404_497# A1 ZN VNW pfet_05v0 ad=0.4599p pd=1.935u as=0.2847p ps=1.615u w=1.095u l=0.5u
X18 a_36_68# B2 VSS VPW nfet_05v0 ad=0.2132p pd=1.34u as=0.2132p ps=1.34u w=0.82u l=0.6u
X19 a_36_68# A2 ZN VPW nfet_05v0 ad=0.2132p pd=1.34u as=0.2132p ps=1.34u w=0.82u l=0.6u
X20 a_1120_497# B2 VDD VNW pfet_05v0 ad=0.3942p pd=1.815u as=0.2847p ps=1.615u w=1.095u l=0.5u
X21 a_36_68# B1 VSS VPW nfet_05v0 ad=0.2132p pd=1.34u as=0.2132p ps=1.34u w=0.82u l=0.6u
X22 a_36_68# A1 ZN VPW nfet_05v0 ad=0.2132p pd=1.34u as=0.30965p ps=1.685u w=0.82u l=0.6u
X23 ZN B1 a_1120_497# VNW pfet_05v0 ad=0.2847p pd=1.615u as=0.3942p ps=1.815u w=1.095u l=0.5u
X24 VDD A2 a_3404_497# VNW pfet_05v0 ad=0.4818p pd=3.07u as=0.4599p ps=1.935u w=1.095u l=0.5u
X25 a_2036_497# A2 VDD VNW pfet_05v0 ad=0.4599p pd=1.935u as=0.3942p ps=1.815u w=1.095u l=0.5u
X26 a_36_68# A1 ZN VPW nfet_05v0 ad=0.2132p pd=1.34u as=0.2132p ps=1.34u w=0.82u l=0.6u
X27 a_36_68# B2 VSS VPW nfet_05v0 ad=0.2132p pd=1.34u as=0.2132p ps=1.34u w=0.82u l=0.6u
X28 a_1568_497# B1 ZN VNW pfet_05v0 ad=0.33945p pd=1.715u as=0.2847p ps=1.615u w=1.095u l=0.5u
X29 a_36_68# B1 VSS VPW nfet_05v0 ad=0.2132p pd=1.34u as=0.2132p ps=1.34u w=0.82u l=0.6u
X30 a_36_68# A2 ZN VPW nfet_05v0 ad=0.3608p pd=2.52u as=0.30965p ps=1.685u w=0.82u l=0.6u
X31 VSS B2 a_36_68# VPW nfet_05v0 ad=0.2132p pd=1.34u as=0.2132p ps=1.34u w=0.82u l=0.6u
.ends

.subckt gf180mcu_fd_sc_mcu7t5v0__and2_2 A1 A2 Z VDD VNW VPW VSS
X0 a_247_68# A1 a_39_68# VPW nfet_05v0 ad=0.1304p pd=1.135u as=0.3586p ps=2.51u w=0.815u l=0.6u
X1 Z a_39_68# VDD VNW pfet_05v0 ad=0.3159p pd=1.735u as=0.4278p ps=1.955u w=1.215u l=0.5u
X2 Z a_39_68# VSS VPW nfet_05v0 ad=0.22005p pd=1.355u as=0.2119p ps=1.335u w=0.815u l=0.6u
X3 VDD a_39_68# Z VNW pfet_05v0 ad=0.5346p pd=3.31u as=0.3159p ps=1.735u w=1.215u l=0.5u
X4 a_39_68# A1 VDD VNW pfet_05v0 ad=0.2782p pd=1.59u as=0.4708p ps=3.02u w=1.07u l=0.5u
X5 VSS a_39_68# Z VPW nfet_05v0 ad=0.3586p pd=2.51u as=0.22005p ps=1.355u w=0.815u l=0.6u
X6 VDD A2 a_39_68# VNW pfet_05v0 ad=0.4278p pd=1.955u as=0.2782p ps=1.59u w=1.07u l=0.5u
X7 VSS A2 a_247_68# VPW nfet_05v0 ad=0.2119p pd=1.335u as=0.1304p ps=1.135u w=0.815u l=0.6u
.ends

.subckt gf180mcu_fd_sc_mcu7t5v0__buf_8 I Z VDD VNW VPW VSS
X0 a_224_472# I VDD VNW pfet_05v0 ad=0.3782p pd=1.84u as=0.3782p ps=1.84u w=1.22u l=0.5u
X1 Z a_224_472# VDD VNW pfet_05v0 ad=0.3782p pd=1.84u as=0.3782p ps=1.84u w=1.22u l=0.5u
X2 a_224_472# I VSS VPW nfet_05v0 ad=0.2132p pd=1.34u as=0.2132p ps=1.34u w=0.82u l=0.6u
X3 VSS a_224_472# Z VPW nfet_05v0 ad=0.3608p pd=2.52u as=0.2132p ps=1.34u w=0.82u l=0.6u
X4 VDD a_224_472# Z VNW pfet_05v0 ad=0.3782p pd=1.84u as=0.3782p ps=1.84u w=1.22u l=0.5u
X5 Z a_224_472# VDD VNW pfet_05v0 ad=0.3782p pd=1.84u as=0.3782p ps=1.84u w=1.22u l=0.5u
X6 a_224_472# I VSS VPW nfet_05v0 ad=0.2132p pd=1.34u as=0.3608p ps=2.52u w=0.82u l=0.6u
X7 Z a_224_472# VSS VPW nfet_05v0 ad=0.2132p pd=1.34u as=0.2132p ps=1.34u w=0.82u l=0.6u
X8 VDD a_224_472# Z VNW pfet_05v0 ad=0.3782p pd=1.84u as=0.3782p ps=1.84u w=1.22u l=0.5u
X9 Z a_224_472# VSS VPW nfet_05v0 ad=0.2132p pd=1.34u as=0.2132p ps=1.34u w=0.82u l=0.6u
X10 Z a_224_472# VSS VPW nfet_05v0 ad=0.2132p pd=1.34u as=0.2132p ps=1.34u w=0.82u l=0.6u
X11 VDD I a_224_472# VNW pfet_05v0 ad=0.3782p pd=1.84u as=0.3782p ps=1.84u w=1.22u l=0.5u
X12 VDD a_224_472# Z VNW pfet_05v0 ad=0.3782p pd=1.84u as=0.3782p ps=1.84u w=1.22u l=0.5u
X13 Z a_224_472# VDD VNW pfet_05v0 ad=0.3782p pd=1.84u as=0.3782p ps=1.84u w=1.22u l=0.5u
X14 VSS a_224_472# Z VPW nfet_05v0 ad=0.2132p pd=1.34u as=0.2132p ps=1.34u w=0.82u l=0.6u
X15 VDD I a_224_472# VNW pfet_05v0 ad=0.3782p pd=1.84u as=0.3782p ps=1.84u w=1.22u l=0.5u
X16 VSS a_224_472# Z VPW nfet_05v0 ad=0.2132p pd=1.34u as=0.2132p ps=1.34u w=0.82u l=0.6u
X17 VDD a_224_472# Z VNW pfet_05v0 ad=0.5368p pd=3.32u as=0.3782p ps=1.84u w=1.22u l=0.5u
X18 VSS a_224_472# Z VPW nfet_05v0 ad=0.2132p pd=1.34u as=0.2132p ps=1.34u w=0.82u l=0.6u
X19 Z a_224_472# VDD VNW pfet_05v0 ad=0.3782p pd=1.84u as=0.3782p ps=1.84u w=1.22u l=0.5u
X20 VSS I a_224_472# VPW nfet_05v0 ad=0.2132p pd=1.34u as=0.2132p ps=1.34u w=0.82u l=0.6u
X21 a_224_472# I VDD VNW pfet_05v0 ad=0.3782p pd=1.84u as=0.5368p ps=3.32u w=1.22u l=0.5u
X22 VSS I a_224_472# VPW nfet_05v0 ad=0.2132p pd=1.34u as=0.2132p ps=1.34u w=0.82u l=0.6u
X23 Z a_224_472# VSS VPW nfet_05v0 ad=0.2132p pd=1.34u as=0.2132p ps=1.34u w=0.82u l=0.6u
.ends

.subckt gf180mcu_fd_sc_mcu7t5v0__nor3_4 A1 A2 A3 ZN VDD VNW VPW VSS
X0 a_672_472# A3 VDD VNW pfet_05v0 ad=0.3782p pd=1.84u as=0.3782p ps=1.84u w=1.22u l=0.5u
X1 ZN A1 a_36_472# VNW pfet_05v0 ad=0.3782p pd=1.84u as=0.3782p ps=1.84u w=1.22u l=0.5u
X2 ZN A1 VSS VPW nfet_05v0 ad=0.1209p pd=0.985u as=0.1209p ps=0.985u w=0.465u l=0.6u
X3 VDD A3 a_1120_472# VNW pfet_05v0 ad=0.3782p pd=1.84u as=0.3782p ps=1.84u w=1.22u l=0.5u
X4 ZN A1 a_1792_472# VNW pfet_05v0 ad=0.3782p pd=1.84u as=0.3782p ps=1.84u w=1.22u l=0.5u
X5 VSS A2 ZN VPW nfet_05v0 ad=0.1209p pd=0.985u as=0.1209p ps=0.985u w=0.465u l=0.6u
X6 VSS A3 ZN VPW nfet_05v0 ad=0.1209p pd=0.985u as=0.1209p ps=0.985u w=0.465u l=0.6u
X7 a_1792_472# A2 a_1568_472# VNW pfet_05v0 ad=0.3782p pd=1.84u as=0.3782p ps=1.84u w=1.22u l=0.5u
X8 VSS A1 ZN VPW nfet_05v0 ad=0.1209p pd=0.985u as=0.1209p ps=0.985u w=0.465u l=0.6u
X9 VDD A3 a_224_472# VNW pfet_05v0 ad=0.3782p pd=1.84u as=0.3782p ps=1.84u w=1.22u l=0.5u
X10 VSS A2 ZN VPW nfet_05v0 ad=0.1209p pd=0.985u as=0.1209p ps=0.985u w=0.465u l=0.6u
X11 a_36_472# A1 ZN VNW pfet_05v0 ad=0.3782p pd=1.84u as=0.3782p ps=1.84u w=1.22u l=0.5u
X12 VSS A3 ZN VPW nfet_05v0 ad=0.1209p pd=0.985u as=0.1209p ps=0.985u w=0.465u l=0.6u
X13 a_1120_472# A2 a_36_472# VNW pfet_05v0 ad=0.3782p pd=1.84u as=0.3782p ps=1.84u w=1.22u l=0.5u
X14 ZN A2 VSS VPW nfet_05v0 ad=0.1209p pd=0.985u as=0.1209p ps=0.985u w=0.465u l=0.6u
X15 a_36_472# A2 a_672_472# VNW pfet_05v0 ad=0.3782p pd=1.84u as=0.3782p ps=1.84u w=1.22u l=0.5u
X16 a_36_472# A1 ZN VNW pfet_05v0 ad=0.5368p pd=3.32u as=0.3782p ps=1.84u w=1.22u l=0.5u
X17 a_1568_472# A3 VDD VNW pfet_05v0 ad=0.3782p pd=1.84u as=0.3782p ps=1.84u w=1.22u l=0.5u
X18 ZN A3 VSS VPW nfet_05v0 ad=0.1209p pd=0.985u as=0.1209p ps=0.985u w=0.465u l=0.6u
X19 VSS A1 ZN VPW nfet_05v0 ad=0.2046p pd=1.81u as=0.1209p ps=0.985u w=0.465u l=0.6u
X20 ZN A2 VSS VPW nfet_05v0 ad=0.1209p pd=0.985u as=0.2046p ps=1.81u w=0.465u l=0.6u
X21 a_224_472# A2 a_36_472# VNW pfet_05v0 ad=0.3782p pd=1.84u as=0.5368p ps=3.32u w=1.22u l=0.5u
X22 ZN A1 VSS VPW nfet_05v0 ad=0.1209p pd=0.985u as=0.1209p ps=0.985u w=0.465u l=0.6u
X23 ZN A3 VSS VPW nfet_05v0 ad=0.1209p pd=0.985u as=0.1209p ps=0.985u w=0.465u l=0.6u
.ends

.subckt gf180mcu_fd_sc_mcu7t5v0__or2_2 A1 A2 Z VDD VNW VPW VSS
X0 Z a_56_472# VSS VPW nfet_05v0 ad=0.2132p pd=1.34u as=0.2132p ps=1.34u w=0.82u l=0.6u
X1 a_56_472# A1 VSS VPW nfet_05v0 ad=0.2132p pd=1.34u as=0.3608p ps=2.52u w=0.82u l=0.6u
X2 a_244_472# A1 a_56_472# VNW pfet_05v0 ad=0.3172p pd=1.74u as=0.5368p ps=3.32u w=1.22u l=0.5u
X3 VDD A2 a_244_472# VNW pfet_05v0 ad=0.4087p pd=1.89u as=0.3172p ps=1.74u w=1.22u l=0.5u
X4 VDD a_56_472# Z VNW pfet_05v0 ad=0.5368p pd=3.32u as=0.3477p ps=1.79u w=1.22u l=0.5u
X5 Z a_56_472# VDD VNW pfet_05v0 ad=0.3477p pd=1.79u as=0.4087p ps=1.89u w=1.22u l=0.5u
X6 VSS a_56_472# Z VPW nfet_05v0 ad=0.3608p pd=2.52u as=0.2132p ps=1.34u w=0.82u l=0.6u
X7 VSS A2 a_56_472# VPW nfet_05v0 ad=0.2132p pd=1.34u as=0.2132p ps=1.34u w=0.82u l=0.6u
.ends

.subckt gf180mcu_fd_sc_mcu7t5v0__or4_1 A1 A2 A3 A4 Z VDD VNW VPW VSS
X0 VSS A4 a_56_604# VPW nfet_05v0 ad=0.218p pd=1.52u as=93.59999f ps=0.88u w=0.36u l=0.6u
X1 Z a_56_604# VSS VPW nfet_05v0 ad=0.3608p pd=2.52u as=0.218p ps=1.52u w=0.82u l=0.6u
X2 Z a_56_604# VDD VNW pfet_05v0 ad=0.5368p pd=3.32u as=0.389p ps=2.02u w=1.22u l=0.5u
X3 VSS A2 a_56_604# VPW nfet_05v0 ad=93.59999f pd=0.88u as=0.126p ps=1.06u w=0.36u l=0.6u
X4 VDD A4 a_708_604# VNW pfet_05v0 ad=0.389p pd=2.02u as=0.1736p ps=1.18u w=0.56u l=0.5u
X5 a_244_604# A1 a_56_604# VNW pfet_05v0 ad=0.196p pd=1.26u as=0.2464p ps=2u w=0.56u l=0.5u
X6 a_56_604# A1 VSS VPW nfet_05v0 ad=0.126p pd=1.06u as=0.1584p ps=1.6u w=0.36u l=0.6u
X7 a_56_604# A3 VSS VPW nfet_05v0 ad=93.59999f pd=0.88u as=93.59999f ps=0.88u w=0.36u l=0.6u
X8 a_708_604# A3 a_484_604# VNW pfet_05v0 ad=0.1736p pd=1.18u as=0.1736p ps=1.18u w=0.56u l=0.5u
X9 a_484_604# A2 a_244_604# VNW pfet_05v0 ad=0.1736p pd=1.18u as=0.196p ps=1.26u w=0.56u l=0.5u
.ends

.subckt gf180mcu_fd_sc_mcu7t5v0__oai31_1 A1 A2 A3 B ZN VDD VNW VPW VSS
X0 a_468_497# A1 ZN VNW pfet_05v0 ad=0.58035p pd=2.155u as=0.4012p ps=1.85u w=1.095u l=0.5u
X1 a_244_69# A2 ZN VPW nfet_05v0 ad=0.2119p pd=1.335u as=0.4137p ps=1.9u w=0.815u l=0.6u
X2 a_780_497# A2 a_468_497# VNW pfet_05v0 ad=0.2847p pd=1.615u as=0.58035p ps=2.155u w=1.095u l=0.5u
X3 ZN A1 a_244_69# VPW nfet_05v0 ad=0.4137p pd=1.9u as=0.2119p ps=1.335u w=0.815u l=0.6u
X4 VDD A3 a_780_497# VNW pfet_05v0 ad=0.5913p pd=3.27u as=0.2847p ps=1.615u w=1.095u l=0.5u
X5 a_244_69# B VSS VPW nfet_05v0 ad=0.2119p pd=1.335u as=0.3586p ps=2.51u w=0.815u l=0.6u
X6 ZN B VDD VNW pfet_05v0 ad=0.4012p pd=1.85u as=0.4972p ps=3.14u w=1.13u l=0.5u
X7 ZN A3 a_244_69# VPW nfet_05v0 ad=0.3586p pd=2.51u as=0.2119p ps=1.335u w=0.815u l=0.6u
.ends

.subckt gf180mcu_fd_sc_mcu7t5v0__inv_3 I ZN VDD VNW VPW VSS
X0 ZN I VDD VNW pfet_05v0 ad=0.5368p pd=3.32u as=0.3172p ps=1.74u w=1.22u l=0.5u
X1 ZN I VSS VPW nfet_05v0 ad=0.3608p pd=2.52u as=0.2132p ps=1.34u w=0.82u l=0.6u
X2 ZN I VSS VPW nfet_05v0 ad=0.2132p pd=1.34u as=0.3608p ps=2.52u w=0.82u l=0.6u
X3 ZN I VDD VNW pfet_05v0 ad=0.4392p pd=1.94u as=0.5368p ps=3.32u w=1.22u l=0.5u
X4 VSS I ZN VPW nfet_05v0 ad=0.2132p pd=1.34u as=0.2132p ps=1.34u w=0.82u l=0.6u
X5 VDD I ZN VNW pfet_05v0 ad=0.3172p pd=1.74u as=0.4392p ps=1.94u w=1.22u l=0.5u
.ends

.subckt gf180mcu_fd_sc_mcu7t5v0__oai32_4 A1 A2 A3 B1 B2 ZN VDD VNW VPW VSS
X0 VDD B2 a_4401_497# VNW pfet_05v0 ad=0.49275p pd=3.09u as=0.4599p ps=1.935u w=1.095u l=0.5u
X1 ZN B2 a_77_68# VPW nfet_05v0 ad=0.2132p pd=1.34u as=0.43265p ps=1.985u w=0.82u l=0.6u
X2 VSS A1 a_77_68# VPW nfet_05v0 ad=0.2132p pd=1.34u as=0.2132p ps=1.34u w=0.82u l=0.6u
X3 a_77_68# B1 ZN VPW nfet_05v0 ad=0.2132p pd=1.34u as=0.2132p ps=1.34u w=0.82u l=0.6u
X4 ZN A1 a_87_497# VNW pfet_05v0 ad=0.2847p pd=1.615u as=0.3942p ps=1.815u w=1.095u l=0.5u
X5 ZN B2 a_77_68# VPW nfet_05v0 ad=0.2132p pd=1.34u as=0.2132p ps=1.34u w=0.82u l=0.6u
X6 VDD A3 a_1161_497# VNW pfet_05v0 ad=0.2847p pd=1.615u as=0.3942p ps=1.815u w=1.095u l=0.5u
X7 a_77_68# B2 ZN VPW nfet_05v0 ad=0.3608p pd=2.52u as=0.30965p ps=1.685u w=0.82u l=0.6u
X8 ZN B1 a_77_68# VPW nfet_05v0 ad=0.2132p pd=1.34u as=0.2132p ps=1.34u w=0.82u l=0.6u
X9 a_87_497# A1 ZN VNW pfet_05v0 ad=0.4818p pd=3.07u as=0.2847p ps=1.615u w=1.095u l=0.5u
X10 a_77_68# A2 VSS VPW nfet_05v0 ad=0.2132p pd=1.34u as=0.2132p ps=1.34u w=0.82u l=0.6u
X11 a_1609_497# A3 VDD VNW pfet_05v0 ad=0.3942p pd=1.815u as=0.2847p ps=1.615u w=1.095u l=0.5u
X12 ZN B1 a_3077_497# VNW pfet_05v0 ad=0.2847p pd=1.615u as=0.33945p ps=1.715u w=1.095u l=0.5u
X13 ZN B1 a_77_68# VPW nfet_05v0 ad=0.30965p pd=1.685u as=0.2132p ps=1.34u w=0.82u l=0.6u
X14 a_1853_497# A2 a_1609_497# VNW pfet_05v0 ad=0.33945p pd=1.715u as=0.3942p ps=1.815u w=1.095u l=0.5u
X15 a_77_68# A3 VSS VPW nfet_05v0 ad=0.2132p pd=1.34u as=0.2132p ps=1.34u w=0.82u l=0.6u
X16 a_3505_497# B1 ZN VNW pfet_05v0 ad=0.3942p pd=1.815u as=0.2847p ps=1.615u w=1.095u l=0.5u
X17 ZN B1 a_3953_497# VNW pfet_05v0 ad=0.2847p pd=1.615u as=0.3942p ps=1.815u w=1.095u l=0.5u
X18 a_77_68# A1 VSS VPW nfet_05v0 ad=0.2132p pd=1.34u as=0.2132p ps=1.34u w=0.82u l=0.6u
X19 VDD B2 a_3505_497# VNW pfet_05v0 ad=0.2847p pd=1.615u as=0.3942p ps=1.815u w=1.095u l=0.5u
X20 VDD A3 a_285_497# VNW pfet_05v0 ad=0.2847p pd=1.615u as=0.33945p ps=1.715u w=1.095u l=0.5u
X21 a_77_68# A2 VSS VPW nfet_05v0 ad=0.2132p pd=1.34u as=0.2132p ps=1.34u w=0.82u l=0.6u
X22 a_77_68# B1 ZN VPW nfet_05v0 ad=0.2132p pd=1.34u as=0.2132p ps=1.34u w=0.82u l=0.6u
X23 a_713_497# A3 VDD VNW pfet_05v0 ad=0.3942p pd=1.815u as=0.2847p ps=1.615u w=1.095u l=0.5u
X24 a_3953_497# B2 VDD VNW pfet_05v0 ad=0.3942p pd=1.815u as=0.2847p ps=1.615u w=1.095u l=0.5u
X25 a_77_68# A3 VSS VPW nfet_05v0 ad=0.2132p pd=1.34u as=0.2132p ps=1.34u w=0.82u l=0.6u
X26 a_285_497# A2 a_87_497# VNW pfet_05v0 ad=0.33945p pd=1.715u as=0.53655p ps=3.17u w=1.095u l=0.5u
X27 VSS A2 a_77_68# VPW nfet_05v0 ad=0.2132p pd=1.34u as=0.2132p ps=1.34u w=0.82u l=0.6u
X28 a_87_497# A2 a_713_497# VNW pfet_05v0 ad=0.2847p pd=1.615u as=0.3942p ps=1.815u w=1.095u l=0.5u
X29 a_3077_497# B2 VDD VNW pfet_05v0 ad=0.33945p pd=1.715u as=0.4818p ps=3.07u w=1.095u l=0.5u
X30 a_4401_497# B1 ZN VNW pfet_05v0 ad=0.4599p pd=1.935u as=0.2847p ps=1.615u w=1.095u l=0.5u
X31 a_87_497# A1 ZN VNW pfet_05v0 ad=0.3942p pd=1.815u as=0.2847p ps=1.615u w=1.095u l=0.5u
X32 VSS A3 a_77_68# VPW nfet_05v0 ad=0.2132p pd=1.34u as=0.2132p ps=1.34u w=0.82u l=0.6u
X33 a_1161_497# A2 a_87_497# VNW pfet_05v0 ad=0.3942p pd=1.815u as=0.2847p ps=1.615u w=1.095u l=0.5u
X34 a_77_68# A1 VSS VPW nfet_05v0 ad=0.43265p pd=1.985u as=0.2132p ps=1.34u w=0.82u l=0.6u
X35 a_77_68# B2 ZN VPW nfet_05v0 ad=0.2132p pd=1.34u as=0.2132p ps=1.34u w=0.82u l=0.6u
X36 VSS A2 a_77_68# VPW nfet_05v0 ad=0.2132p pd=1.34u as=0.3608p ps=2.52u w=0.82u l=0.6u
X37 ZN A1 a_1853_497# VNW pfet_05v0 ad=0.2847p pd=1.615u as=0.33945p ps=1.715u w=1.095u l=0.5u
X38 VSS A1 a_77_68# VPW nfet_05v0 ad=0.2132p pd=1.34u as=0.2132p ps=1.34u w=0.82u l=0.6u
X39 VSS A3 a_77_68# VPW nfet_05v0 ad=0.2132p pd=1.34u as=0.2132p ps=1.34u w=0.82u l=0.6u
.ends

.subckt gf180mcu_fd_sc_mcu7t5v0__nor4_4 A1 A2 A3 A4 ZN VDD VNW VPW VSS
X0 a_66_473# A3 a_692_473# VNW pfet_05v0 ad=0.486p pd=2.015u as=0.486p ps=2.015u w=1.215u l=0.5u
X1 VSS A3 ZN VPW nfet_05v0 ad=0.126p pd=1.06u as=0.126p ps=1.06u w=0.36u l=0.6u
X2 a_2180_473# A2 a_1920_473# VNW pfet_05v0 ad=0.486p pd=2.015u as=0.486p ps=2.015u w=1.215u l=0.5u
X3 a_3220_473# A2 a_66_473# VNW pfet_05v0 ad=0.486p pd=2.015u as=0.486p ps=2.015u w=1.215u l=0.5u
X4 a_3740_473# A1 ZN VNW pfet_05v0 ad=0.455625p pd=1.965u as=0.486p ps=2.015u w=1.215u l=0.5u
X5 a_1212_473# A3 a_66_473# VNW pfet_05v0 ad=0.37665p pd=1.835u as=0.486p ps=2.015u w=1.215u l=0.5u
X6 VSS A3 ZN VPW nfet_05v0 ad=0.126p pd=1.06u as=0.126p ps=1.06u w=0.36u l=0.6u
X7 a_66_473# A2 a_2700_473# VNW pfet_05v0 ad=0.486p pd=2.015u as=0.486p ps=2.015u w=1.215u l=0.5u
X8 a_66_473# A2 a_3740_473# VNW pfet_05v0 ad=0.5346p pd=3.31u as=0.455625p ps=1.965u w=1.215u l=0.5u
X9 ZN A1 a_2180_473# VNW pfet_05v0 ad=0.486p pd=2.015u as=0.486p ps=2.015u w=1.215u l=0.5u
X10 ZN A2 VSS VPW nfet_05v0 ad=0.126p pd=1.06u as=0.126p ps=1.06u w=0.36u l=0.6u
X11 VDD A4 a_254_473# VNW pfet_05v0 ad=0.37665p pd=1.835u as=0.346275p ps=1.785u w=1.215u l=0.5u
X12 VSS A4 ZN VPW nfet_05v0 ad=93.59999f pd=0.88u as=93.59999f ps=0.88u w=0.36u l=0.6u
X13 ZN A1 VSS VPW nfet_05v0 ad=0.126p pd=1.06u as=0.126p ps=1.06u w=0.36u l=0.6u
X14 a_1660_473# A4 VDD VNW pfet_05v0 ad=0.486p pd=2.015u as=0.37665p ps=1.835u w=1.215u l=0.5u
X15 a_2700_473# A1 ZN VNW pfet_05v0 ad=0.486p pd=2.015u as=0.486p ps=2.015u w=1.215u l=0.5u
X16 VSS A1 ZN VPW nfet_05v0 ad=0.126p pd=1.06u as=0.126p ps=1.06u w=0.36u l=0.6u
X17 a_254_473# A3 a_66_473# VNW pfet_05v0 ad=0.346275p pd=1.785u as=0.5346p ps=3.31u w=1.215u l=0.5u
X18 VSS A4 ZN VPW nfet_05v0 ad=93.59999f pd=0.88u as=93.59999f ps=0.88u w=0.36u l=0.6u
X19 a_1920_473# A3 a_1660_473# VNW pfet_05v0 ad=0.486p pd=2.015u as=0.486p ps=2.015u w=1.215u l=0.5u
X20 VSS A2 ZN VPW nfet_05v0 ad=0.126p pd=1.06u as=0.126p ps=1.06u w=0.36u l=0.6u
X21 ZN A4 VSS VPW nfet_05v0 ad=0.126p pd=1.06u as=93.59999f ps=0.88u w=0.36u l=0.6u
X22 ZN A3 VSS VPW nfet_05v0 ad=93.59999f pd=0.88u as=0.126p ps=1.06u w=0.36u l=0.6u
X23 ZN A4 VSS VPW nfet_05v0 ad=0.126p pd=1.06u as=93.59999f ps=0.88u w=0.36u l=0.6u
X24 ZN A3 VSS VPW nfet_05v0 ad=93.59999f pd=0.88u as=0.1584p ps=1.6u w=0.36u l=0.6u
X25 VDD A4 a_1212_473# VNW pfet_05v0 ad=0.37665p pd=1.835u as=0.37665p ps=1.835u w=1.215u l=0.5u
X26 VSS A1 ZN VPW nfet_05v0 ad=0.126p pd=1.06u as=0.126p ps=1.06u w=0.36u l=0.6u
X27 a_692_473# A4 VDD VNW pfet_05v0 ad=0.486p pd=2.015u as=0.37665p ps=1.835u w=1.215u l=0.5u
X28 ZN A2 VSS VPW nfet_05v0 ad=0.126p pd=1.06u as=0.126p ps=1.06u w=0.36u l=0.6u
X29 VSS A2 ZN VPW nfet_05v0 ad=0.1584p pd=1.6u as=0.126p ps=1.06u w=0.36u l=0.6u
X30 ZN A1 a_3220_473# VNW pfet_05v0 ad=0.486p pd=2.015u as=0.486p ps=2.015u w=1.215u l=0.5u
X31 ZN A1 VSS VPW nfet_05v0 ad=0.126p pd=1.06u as=0.126p ps=1.06u w=0.36u l=0.6u
.ends

.subckt gf180mcu_fd_sc_mcu7t5v0__aoi221_4 A1 A2 B1 B2 C ZN VDD VNW VPW VSS
X0 VSS B2 a_1070_69# VPW nfet_05v0 ad=0.2002p pd=1.29u as=0.1232p ps=1.09u w=0.77u l=0.6u
X1 VDD B2 a_234_508# VNW pfet_05v0 ad=0.2691p pd=1.555u as=0.2691p ps=1.555u w=1.035u l=0.5u
X2 VSS A2 a_3728_69# VPW nfet_05v0 ad=0.2002p pd=1.29u as=0.1232p ps=1.09u w=0.77u l=0.6u
X3 a_234_508# C a_1822_472# VNW pfet_05v0 ad=0.346275p pd=1.785u as=0.3159p ps=1.735u w=1.215u l=0.5u
X4 a_1822_472# A1 ZN VNW pfet_05v0 ad=0.3159p pd=1.735u as=0.3159p ps=1.735u w=1.215u l=0.5u
X5 a_234_508# C a_1822_472# VNW pfet_05v0 ad=0.3159p pd=1.735u as=0.5346p ps=3.31u w=1.215u l=0.5u
X6 ZN A2 a_1822_472# VNW pfet_05v0 ad=0.3159p pd=1.735u as=0.3159p ps=1.735u w=1.215u l=0.5u
X7 a_1070_69# B1 ZN VPW nfet_05v0 ad=0.1232p pd=1.09u as=0.2002p ps=1.29u w=0.77u l=0.6u
X8 a_234_508# B2 VDD VNW pfet_05v0 ad=0.2691p pd=1.555u as=0.2691p ps=1.555u w=1.035u l=0.5u
X9 ZN A1 a_1822_472# VNW pfet_05v0 ad=0.3159p pd=1.735u as=0.3159p ps=1.735u w=1.215u l=0.5u
X10 a_1822_472# A1 ZN VNW pfet_05v0 ad=0.5346p pd=3.31u as=0.3159p ps=1.735u w=1.215u l=0.5u
X11 VDD B1 a_234_508# VNW pfet_05v0 ad=0.4554p pd=2.95u as=0.2691p ps=1.555u w=1.035u l=0.5u
X12 a_1822_472# A2 ZN VNW pfet_05v0 ad=0.3159p pd=1.735u as=0.3159p ps=1.735u w=1.215u l=0.5u
X13 a_2912_69# A1 ZN VPW nfet_05v0 ad=0.1232p pd=1.09u as=0.226p ps=1.47u w=0.77u l=0.6u
X14 VSS A2 a_2912_69# VPW nfet_05v0 ad=0.2002p pd=1.29u as=0.1232p ps=1.09u w=0.77u l=0.6u
X15 a_234_508# B1 VDD VNW pfet_05v0 ad=0.2691p pd=1.555u as=0.4554p ps=2.95u w=1.035u l=0.5u
X16 a_3728_69# A1 ZN VPW nfet_05v0 ad=0.1232p pd=1.09u as=0.2002p ps=1.29u w=0.77u l=0.6u
X17 ZN A1 a_4136_69# VPW nfet_05v0 ad=0.3388p pd=2.42u as=0.1232p ps=1.09u w=0.77u l=0.6u
X18 a_244_69# B1 ZN VPW nfet_05v0 ad=0.14245p pd=1.14u as=0.3388p ps=2.42u w=0.77u l=0.6u
X19 VSS C ZN VPW nfet_05v0 ad=0.1248p pd=1u as=0.1248p ps=1u w=0.48u l=0.6u
X20 VDD B2 a_234_508# VNW pfet_05v0 ad=0.2691p pd=1.555u as=0.2691p ps=1.555u w=1.035u l=0.5u
X21 ZN B1 a_1478_69# VPW nfet_05v0 ad=0.29915p pd=1.66u as=0.1617p ps=1.19u w=0.77u l=0.6u
X22 a_234_508# B2 VDD VNW pfet_05v0 ad=0.2691p pd=1.555u as=0.2691p ps=1.555u w=1.035u l=0.5u
X23 VSS B2 a_244_69# VPW nfet_05v0 ad=0.2002p pd=1.29u as=0.14245p ps=1.14u w=0.77u l=0.6u
X24 a_1478_69# B2 VSS VPW nfet_05v0 ad=0.1617p pd=1.19u as=0.2002p ps=1.29u w=0.77u l=0.6u
X25 VDD B1 a_234_508# VNW pfet_05v0 ad=0.2691p pd=1.555u as=0.2691p ps=1.555u w=1.035u l=0.5u
X26 ZN A1 a_1822_472# VNW pfet_05v0 ad=0.3159p pd=1.735u as=0.486p ps=2.015u w=1.215u l=0.5u
X27 ZN C VSS VPW nfet_05v0 ad=0.226p pd=1.47u as=0.1248p ps=1u w=0.48u l=0.6u
X28 a_3320_69# A2 VSS VPW nfet_05v0 ad=0.1232p pd=1.09u as=0.2002p ps=1.29u w=0.77u l=0.6u
X29 ZN A1 a_3320_69# VPW nfet_05v0 ad=0.2002p pd=1.29u as=0.1232p ps=1.09u w=0.77u l=0.6u
X30 a_234_508# B1 VDD VNW pfet_05v0 ad=0.2691p pd=1.555u as=0.2691p ps=1.555u w=1.035u l=0.5u
X31 ZN C VSS VPW nfet_05v0 ad=0.1248p pd=1u as=0.1248p ps=1u w=0.48u l=0.6u
X32 a_1822_472# C a_234_508# VNW pfet_05v0 ad=0.486p pd=2.015u as=0.346275p ps=1.785u w=1.215u l=0.5u
X33 a_1822_472# A2 ZN VNW pfet_05v0 ad=0.3159p pd=1.735u as=0.3159p ps=1.735u w=1.215u l=0.5u
X34 ZN B1 a_662_69# VPW nfet_05v0 ad=0.2002p pd=1.29u as=0.1232p ps=1.09u w=0.77u l=0.6u
X35 a_662_69# B2 VSS VPW nfet_05v0 ad=0.1232p pd=1.09u as=0.2002p ps=1.29u w=0.77u l=0.6u
X36 VSS C ZN VPW nfet_05v0 ad=0.1248p pd=1u as=0.29915p ps=1.66u w=0.48u l=0.6u
X37 a_1822_472# C a_234_508# VNW pfet_05v0 ad=0.3159p pd=1.735u as=0.3159p ps=1.735u w=1.215u l=0.5u
X38 ZN A2 a_1822_472# VNW pfet_05v0 ad=0.3159p pd=1.735u as=0.3159p ps=1.735u w=1.215u l=0.5u
X39 a_4136_69# A2 VSS VPW nfet_05v0 ad=0.1232p pd=1.09u as=0.2002p ps=1.29u w=0.77u l=0.6u
.ends

.subckt gf180mcu_fd_sc_mcu7t5v0__inv_4 I ZN VDD VNW VPW VSS
X0 ZN I VDD VNW pfet_05v0 ad=0.4392p pd=1.94u as=0.3172p ps=1.74u w=1.22u l=0.5u
X1 ZN I VSS VPW nfet_05v0 ad=0.2132p pd=1.34u as=0.2132p ps=1.34u w=0.82u l=0.6u
X2 ZN I VSS VPW nfet_05v0 ad=0.2132p pd=1.34u as=0.3608p ps=2.52u w=0.82u l=0.6u
X3 VDD I ZN VNW pfet_05v0 ad=0.5368p pd=3.32u as=0.4392p ps=1.94u w=1.22u l=0.5u
X4 VSS I ZN VPW nfet_05v0 ad=0.3608p pd=2.52u as=0.2132p ps=1.34u w=0.82u l=0.6u
X5 ZN I VDD VNW pfet_05v0 ad=0.4392p pd=1.94u as=0.5368p ps=3.32u w=1.22u l=0.5u
X6 VSS I ZN VPW nfet_05v0 ad=0.2132p pd=1.34u as=0.2132p ps=1.34u w=0.82u l=0.6u
X7 VDD I ZN VNW pfet_05v0 ad=0.3172p pd=1.74u as=0.4392p ps=1.94u w=1.22u l=0.5u
.ends

.subckt gf180mcu_fd_sc_mcu7t5v0__oai31_2 A1 A2 A3 B ZN VDD VNW VPW VSS
X0 VDD A3 a_1612_497# VNW pfet_05v0 ad=0.4818p pd=3.07u as=0.4599p ps=1.935u w=1.095u l=0.5u
X1 a_960_497# A2 a_692_497# VNW pfet_05v0 ad=0.33945p pd=1.715u as=0.4599p ps=1.935u w=1.095u l=0.5u
X2 ZN A3 a_36_68# VPW nfet_05v0 ad=0.30965p pd=1.685u as=0.2132p ps=1.34u w=0.82u l=0.6u
X3 VSS B a_36_68# VPW nfet_05v0 ad=0.2132p pd=1.34u as=0.3608p ps=2.52u w=0.82u l=0.6u
X4 a_36_68# A3 ZN VPW nfet_05v0 ad=0.3608p pd=2.52u as=0.30965p ps=1.685u w=0.82u l=0.6u
X5 a_36_68# A2 ZN VPW nfet_05v0 ad=0.2132p pd=1.34u as=0.30965p ps=1.685u w=0.82u l=0.6u
X6 ZN B VDD VNW pfet_05v0 ad=0.2808p pd=1.6u as=0.5292p ps=3.14u w=1.08u l=0.5u
X7 a_36_68# A1 ZN VPW nfet_05v0 ad=0.2132p pd=1.34u as=0.2132p ps=1.34u w=0.82u l=0.6u
X8 a_692_497# A3 VDD VNW pfet_05v0 ad=0.4599p pd=1.935u as=0.3918p ps=1.815u w=1.095u l=0.5u
X9 VDD B ZN VNW pfet_05v0 ad=0.3918p pd=1.815u as=0.2808p ps=1.6u w=1.08u l=0.5u
X10 a_1612_497# A2 a_1388_497# VNW pfet_05v0 ad=0.4599p pd=1.935u as=0.33945p ps=1.715u w=1.095u l=0.5u
X11 ZN A2 a_36_68# VPW nfet_05v0 ad=0.30965p pd=1.685u as=0.2132p ps=1.34u w=0.82u l=0.6u
X12 ZN A1 a_960_497# VNW pfet_05v0 ad=0.2847p pd=1.615u as=0.33945p ps=1.715u w=1.095u l=0.5u
X13 a_36_68# B VSS VPW nfet_05v0 ad=0.2132p pd=1.34u as=0.2132p ps=1.34u w=0.82u l=0.6u
X14 ZN A1 a_36_68# VPW nfet_05v0 ad=0.2132p pd=1.34u as=0.2132p ps=1.34u w=0.82u l=0.6u
X15 a_1388_497# A1 ZN VNW pfet_05v0 ad=0.33945p pd=1.715u as=0.2847p ps=1.615u w=1.095u l=0.5u
.ends

.subckt gf180mcu_fd_sc_mcu7t5v0__oai33_2 A1 A2 A3 B1 B2 B3 ZN VDD VNW VPW VSS
X0 a_468_497# B2 a_244_497# VNW pfet_05v0 ad=0.33945p pd=1.715u as=0.33945p ps=1.715u w=1.095u l=0.5u
X1 a_2508_497# A2 a_2284_497# VNW pfet_05v0 ad=0.4599p pd=1.935u as=0.33945p ps=1.715u w=1.095u l=0.5u
X2 VSS B1 a_36_68# VPW nfet_05v0 ad=0.2132p pd=1.34u as=0.2132p ps=1.34u w=0.82u l=0.6u
X3 VSS B3 a_36_68# VPW nfet_05v0 ad=0.2132p pd=1.34u as=0.3608p ps=2.52u w=0.82u l=0.6u
X4 VDD B3 a_1120_497# VNW pfet_05v0 ad=0.3942p pd=1.815u as=0.33945p ps=1.715u w=1.095u l=0.5u
X5 a_2284_497# A1 ZN VNW pfet_05v0 ad=0.33945p pd=1.715u as=0.2847p ps=1.615u w=1.095u l=0.5u
X6 a_1588_497# A3 VDD VNW pfet_05v0 ad=0.4599p pd=1.935u as=0.3942p ps=1.815u w=1.095u l=0.5u
X7 ZN A3 a_36_68# VPW nfet_05v0 ad=0.30965p pd=1.685u as=0.2132p ps=1.34u w=0.82u l=0.6u
X8 ZN A2 a_36_68# VPW nfet_05v0 ad=0.30965p pd=1.685u as=0.2132p ps=1.34u w=0.82u l=0.6u
X9 VDD A3 a_2508_497# VNW pfet_05v0 ad=0.4818p pd=3.07u as=0.4599p ps=1.935u w=1.095u l=0.5u
X10 ZN A1 a_1856_497# VNW pfet_05v0 ad=0.2847p pd=1.615u as=0.33945p ps=1.715u w=1.095u l=0.5u
X11 a_244_497# B3 VDD VNW pfet_05v0 ad=0.33945p pd=1.715u as=0.4818p ps=3.07u w=1.095u l=0.5u
X12 a_36_68# A2 ZN VPW nfet_05v0 ad=0.2132p pd=1.34u as=0.30965p ps=1.685u w=0.82u l=0.6u
X13 ZN B1 a_468_497# VNW pfet_05v0 ad=0.2847p pd=1.615u as=0.33945p ps=1.715u w=1.095u l=0.5u
X14 a_1120_497# B2 a_896_497# VNW pfet_05v0 ad=0.33945p pd=1.715u as=0.33945p ps=1.715u w=1.095u l=0.5u
X15 a_36_68# B3 VSS VPW nfet_05v0 ad=0.2132p pd=1.34u as=0.2132p ps=1.34u w=0.82u l=0.6u
X16 a_36_68# A1 ZN VPW nfet_05v0 ad=0.2132p pd=1.34u as=0.2132p ps=1.34u w=0.82u l=0.6u
X17 a_896_497# B1 ZN VNW pfet_05v0 ad=0.33945p pd=1.715u as=0.2847p ps=1.615u w=1.095u l=0.5u
X18 ZN A1 a_36_68# VPW nfet_05v0 ad=0.2132p pd=1.34u as=0.2132p ps=1.34u w=0.82u l=0.6u
X19 a_36_68# A3 ZN VPW nfet_05v0 ad=0.3608p pd=2.52u as=0.30965p ps=1.685u w=0.82u l=0.6u
X20 a_36_68# B1 VSS VPW nfet_05v0 ad=0.2132p pd=1.34u as=0.2132p ps=1.34u w=0.82u l=0.6u
X21 a_1856_497# A2 a_1588_497# VNW pfet_05v0 ad=0.33945p pd=1.715u as=0.4599p ps=1.935u w=1.095u l=0.5u
X22 a_36_68# B2 VSS VPW nfet_05v0 ad=0.2132p pd=1.34u as=0.2132p ps=1.34u w=0.82u l=0.6u
X23 VSS B2 a_36_68# VPW nfet_05v0 ad=0.2132p pd=1.34u as=0.2132p ps=1.34u w=0.82u l=0.6u
.ends

.subckt gf180mcu_fd_sc_mcu7t5v0__oai211_4 A1 A2 B C ZN VDD VNW VPW VSS
X0 VDD A2 a_1612_497# VNW pfet_05v0 ad=0.3766p pd=1.815u as=0.4599p ps=1.935u w=1.095u l=0.5u
X1 VDD C ZN VNW pfet_05v0 ad=0.2561p pd=1.505u as=0.2561p ps=1.505u w=0.985u l=0.5u
X2 ZN A1 a_36_68# VPW nfet_05v0 ad=0.2132p pd=1.34u as=0.2132p ps=1.34u w=0.82u l=0.6u
X3 a_716_497# A1 ZN VNW pfet_05v0 ad=0.3942p pd=1.815u as=0.2847p ps=1.615u w=1.095u l=0.5u
X4 VDD A2 a_716_497# VNW pfet_05v0 ad=0.2847p pd=1.615u as=0.3942p ps=1.815u w=1.095u l=0.5u
X5 ZN C VDD VNW pfet_05v0 ad=0.2561p pd=1.505u as=0.2561p ps=1.505u w=0.985u l=0.5u
X6 a_2124_68# B a_36_68# VPW nfet_05v0 ad=0.1722p pd=1.24u as=0.2132p ps=1.34u w=0.82u l=0.6u
X7 VDD C ZN VNW pfet_05v0 ad=0.2561p pd=1.505u as=0.2561p ps=1.505u w=0.985u l=0.5u
X8 ZN A2 a_36_68# VPW nfet_05v0 ad=0.30965p pd=1.685u as=0.3608p ps=2.52u w=0.82u l=0.6u
X9 a_36_68# A2 ZN VPW nfet_05v0 ad=0.2132p pd=1.34u as=0.30965p ps=1.685u w=0.82u l=0.6u
X10 VSS C a_2960_68# VPW nfet_05v0 ad=0.2132p pd=1.34u as=0.1312p ps=1.14u w=0.82u l=0.6u
X11 VDD B ZN VNW pfet_05v0 ad=0.2561p pd=1.505u as=0.2561p ps=1.505u w=0.985u l=0.5u
X12 ZN C VDD VNW pfet_05v0 ad=0.2561p pd=1.505u as=0.2561p ps=1.505u w=0.985u l=0.5u
X13 a_36_68# A2 ZN VPW nfet_05v0 ad=0.2132p pd=1.34u as=0.2132p ps=1.34u w=0.82u l=0.6u
X14 a_1164_497# A2 VDD VNW pfet_05v0 ad=0.3942p pd=1.815u as=0.2847p ps=1.615u w=1.095u l=0.5u
X15 ZN B VDD VNW pfet_05v0 ad=0.2561p pd=1.505u as=0.2561p ps=1.505u w=0.985u l=0.5u
X16 VDD B ZN VNW pfet_05v0 ad=0.4334p pd=2.85u as=0.2561p ps=1.505u w=0.985u l=0.5u
X17 a_36_68# A1 ZN VPW nfet_05v0 ad=0.2132p pd=1.34u as=0.30965p ps=1.685u w=0.82u l=0.6u
X18 a_36_68# B a_3368_68# VPW nfet_05v0 ad=0.3608p pd=2.52u as=0.1312p ps=1.14u w=0.82u l=0.6u
X19 a_244_497# A2 VDD VNW pfet_05v0 ad=0.4599p pd=1.935u as=0.4818p ps=3.07u w=1.095u l=0.5u
X20 VSS C a_2124_68# VPW nfet_05v0 ad=0.2132p pd=1.34u as=0.1722p ps=1.24u w=0.82u l=0.6u
X21 a_36_68# A1 ZN VPW nfet_05v0 ad=0.2132p pd=1.34u as=0.2132p ps=1.34u w=0.82u l=0.6u
X22 ZN A1 a_1164_497# VNW pfet_05v0 ad=0.2847p pd=1.615u as=0.3942p ps=1.815u w=1.095u l=0.5u
X23 a_36_68# B a_2552_68# VPW nfet_05v0 ad=0.2132p pd=1.34u as=0.1312p ps=1.14u w=0.82u l=0.6u
X24 a_2552_68# C VSS VPW nfet_05v0 ad=0.1312p pd=1.14u as=0.2132p ps=1.34u w=0.82u l=0.6u
X25 a_1612_497# A1 ZN VNW pfet_05v0 ad=0.4599p pd=1.935u as=0.2847p ps=1.615u w=1.095u l=0.5u
X26 ZN A1 a_36_68# VPW nfet_05v0 ad=0.30965p pd=1.685u as=0.2132p ps=1.34u w=0.82u l=0.6u
X27 ZN A2 a_36_68# VPW nfet_05v0 ad=0.2132p pd=1.34u as=0.2132p ps=1.34u w=0.82u l=0.6u
X28 a_3368_68# C VSS VPW nfet_05v0 ad=0.1312p pd=1.14u as=0.2132p ps=1.34u w=0.82u l=0.6u
X29 ZN B VDD VNW pfet_05v0 ad=0.2561p pd=1.505u as=0.3766p ps=1.815u w=0.985u l=0.5u
X30 a_2960_68# B a_36_68# VPW nfet_05v0 ad=0.1312p pd=1.14u as=0.2132p ps=1.34u w=0.82u l=0.6u
X31 ZN A1 a_244_497# VNW pfet_05v0 ad=0.2847p pd=1.615u as=0.4599p ps=1.935u w=1.095u l=0.5u
.ends

.subckt gf180mcu_fd_sc_mcu7t5v0__and3_4 A1 A2 A3 Z VDD VNW VPW VSS
X0 a_260_69# A3 VSS VPW nfet_05v0 ad=91.2f pd=1u as=0.3344p ps=2.4u w=0.76u l=0.6u
X1 VSS A3 a_1040_69# VPW nfet_05v0 ad=0.1976p pd=1.28u as=91.2f ps=1u w=0.76u l=0.6u
X2 a_224_472# A1 VDD VNW pfet_05v0 ad=0.3172p pd=1.74u as=0.3172p ps=1.74u w=1.22u l=0.5u
X3 a_856_69# A1 a_224_472# VPW nfet_05v0 ad=0.1216p pd=1.08u as=0.1976p ps=1.28u w=0.76u l=0.6u
X4 VDD A1 a_224_472# VNW pfet_05v0 ad=0.3172p pd=1.74u as=0.3172p ps=1.74u w=1.22u l=0.5u
X5 Z a_224_472# VSS VPW nfet_05v0 ad=0.1976p pd=1.28u as=0.1976p ps=1.28u w=0.76u l=0.6u
X6 Z a_224_472# VDD VNW pfet_05v0 ad=0.3172p pd=1.74u as=0.4514p ps=1.96u w=1.22u l=0.5u
X7 a_224_472# A2 VDD VNW pfet_05v0 ad=0.3172p pd=1.74u as=0.3172p ps=1.74u w=1.22u l=0.5u
X8 Z a_224_472# VSS VPW nfet_05v0 ad=0.1976p pd=1.28u as=0.1976p ps=1.28u w=0.76u l=0.6u
X9 VDD a_224_472# Z VNW pfet_05v0 ad=0.3172p pd=1.74u as=0.3172p ps=1.74u w=1.22u l=0.5u
X10 a_224_472# A1 a_428_69# VPW nfet_05v0 ad=0.1976p pd=1.28u as=0.1596p ps=1.18u w=0.76u l=0.6u
X11 VDD A3 a_224_472# VNW pfet_05v0 ad=0.4514p pd=1.96u as=0.3172p ps=1.74u w=1.22u l=0.5u
X12 a_428_69# A2 a_260_69# VPW nfet_05v0 ad=0.1596p pd=1.18u as=91.2f ps=1u w=0.76u l=0.6u
X13 VDD a_224_472# Z VNW pfet_05v0 ad=0.5368p pd=3.32u as=0.3172p ps=1.74u w=1.22u l=0.5u
X14 a_1040_69# A2 a_856_69# VPW nfet_05v0 ad=91.2f pd=1u as=0.1216p ps=1.08u w=0.76u l=0.6u
X15 Z a_224_472# VDD VNW pfet_05v0 ad=0.3172p pd=1.74u as=0.3172p ps=1.74u w=1.22u l=0.5u
X16 a_224_472# A3 VDD VNW pfet_05v0 ad=0.3172p pd=1.74u as=0.5368p ps=3.32u w=1.22u l=0.5u
X17 VSS a_224_472# Z VPW nfet_05v0 ad=0.3344p pd=2.4u as=0.1976p ps=1.28u w=0.76u l=0.6u
X18 VSS a_224_472# Z VPW nfet_05v0 ad=0.1976p pd=1.28u as=0.1976p ps=1.28u w=0.76u l=0.6u
X19 VDD A2 a_224_472# VNW pfet_05v0 ad=0.3172p pd=1.74u as=0.3172p ps=1.74u w=1.22u l=0.5u
.ends

.subckt gf180mcu_fd_sc_mcu7t5v0__or3_2 A1 A2 A3 Z VDD VNW VPW VSS
X0 VDD A3 a_448_472# VNW pfet_05v0 ad=0.488p pd=2.02u as=0.3782p ps=1.84u w=1.22u l=0.5u
X1 VSS A3 a_36_68# VPW nfet_05v0 ad=0.26375p pd=1.52u as=0.1729p ps=1.185u w=0.665u l=0.6u
X2 Z a_36_68# VDD VNW pfet_05v0 ad=0.3782p pd=1.84u as=0.488p ps=2.02u w=1.22u l=0.5u
X3 VSS A1 a_36_68# VPW nfet_05v0 ad=0.1729p pd=1.185u as=0.2926p ps=2.21u w=0.665u l=0.6u
X4 VSS a_36_68# Z VPW nfet_05v0 ad=0.3608p pd=2.52u as=0.2132p ps=1.34u w=0.82u l=0.6u
X5 a_244_472# A1 a_36_68# VNW pfet_05v0 ad=0.3172p pd=1.74u as=0.5368p ps=3.32u w=1.22u l=0.5u
X6 a_448_472# A2 a_244_472# VNW pfet_05v0 ad=0.3782p pd=1.84u as=0.3172p ps=1.74u w=1.22u l=0.5u
X7 Z a_36_68# VSS VPW nfet_05v0 ad=0.2132p pd=1.34u as=0.26375p ps=1.52u w=0.82u l=0.6u
X8 VDD a_36_68# Z VNW pfet_05v0 ad=0.5368p pd=3.32u as=0.3782p ps=1.84u w=1.22u l=0.5u
X9 a_36_68# A2 VSS VPW nfet_05v0 ad=0.1729p pd=1.185u as=0.1729p ps=1.185u w=0.665u l=0.6u
.ends

.subckt gf180mcu_fd_sc_mcu7t5v0__or4_2 A1 A2 A3 A4 Z VDD VNW VPW VSS
X0 Z a_56_472# VSS VPW nfet_05v0 ad=0.2132p pd=1.34u as=0.23375p ps=1.52u w=0.82u l=0.6u
X1 a_244_472# A1 a_56_472# VNW pfet_05v0 ad=0.3782p pd=1.84u as=0.5368p ps=3.32u w=1.22u l=0.5u
X2 VDD A4 a_692_472# VNW pfet_05v0 ad=0.4575p pd=1.97u as=0.3782p ps=1.84u w=1.22u l=0.5u
X3 VDD a_56_472# Z VNW pfet_05v0 ad=0.5368p pd=3.32u as=0.3477p ps=1.79u w=1.22u l=0.5u
X4 VSS A4 a_56_472# VPW nfet_05v0 ad=0.23375p pd=1.52u as=0.1209p ps=0.985u w=0.465u l=0.6u
X5 VSS a_56_472# Z VPW nfet_05v0 ad=0.3608p pd=2.52u as=0.2132p ps=1.34u w=0.82u l=0.6u
X6 a_692_472# A3 a_468_472# VNW pfet_05v0 ad=0.3782p pd=1.84u as=0.3782p ps=1.84u w=1.22u l=0.5u
X7 VSS A2 a_56_472# VPW nfet_05v0 ad=0.1209p pd=0.985u as=0.1209p ps=0.985u w=0.465u l=0.6u
X8 Z a_56_472# VDD VNW pfet_05v0 ad=0.3477p pd=1.79u as=0.4575p ps=1.97u w=1.22u l=0.5u
X9 a_56_472# A3 VSS VPW nfet_05v0 ad=0.1209p pd=0.985u as=0.1209p ps=0.985u w=0.465u l=0.6u
X10 a_56_472# A1 VSS VPW nfet_05v0 ad=0.1209p pd=0.985u as=0.2046p ps=1.81u w=0.465u l=0.6u
X11 a_468_472# A2 a_244_472# VNW pfet_05v0 ad=0.3782p pd=1.84u as=0.3782p ps=1.84u w=1.22u l=0.5u
.ends

.subckt gf180mcu_fd_sc_mcu7t5v0__aoi211_2 A1 A2 B C ZN VDD VNW VPW VSS
X0 VSS B ZN VPW nfet_05v0 ad=0.2266p pd=1.91u as=0.1339p ps=1.035u w=0.515u l=0.6u
X1 VSS C ZN VPW nfet_05v0 ad=0.1339p pd=1.035u as=0.1339p ps=1.035u w=0.515u l=0.6u
X2 a_244_68# A2 VSS VPW nfet_05v0 ad=93.59999f pd=1.02u as=0.3432p ps=2.44u w=0.78u l=0.6u
X3 ZN A1 a_244_68# VPW nfet_05v0 ad=0.2028p pd=1.3u as=93.59999f ps=1.02u w=0.78u l=0.6u
X4 ZN C VSS VPW nfet_05v0 ad=0.1339p pd=1.035u as=0.1339p ps=1.035u w=0.515u l=0.6u
X5 VDD C a_1044_488# VNW pfet_05v0 ad=0.3534p pd=1.76u as=0.3534p ps=1.76u w=1.14u l=0.5u
X6 ZN A1 a_36_488# VNW pfet_05v0 ad=0.2964p pd=1.66u as=0.3078p ps=1.68u w=1.14u l=0.5u
X7 ZN B VSS VPW nfet_05v0 ad=0.1339p pd=1.035u as=0.23325p ps=1.48u w=0.515u l=0.6u
X8 ZN A2 a_36_488# VNW pfet_05v0 ad=0.2964p pd=1.66u as=0.5016p ps=3.16u w=1.14u l=0.5u
X9 a_36_488# A2 ZN VNW pfet_05v0 ad=0.2964p pd=1.66u as=0.2964p ps=1.66u w=1.14u l=0.5u
X10 a_1044_488# B a_36_488# VNW pfet_05v0 ad=0.3534p pd=1.76u as=0.2964p ps=1.66u w=1.14u l=0.5u
X11 a_36_488# A1 ZN VNW pfet_05v0 ad=0.3078p pd=1.68u as=0.2964p ps=1.66u w=1.14u l=0.5u
X12 a_36_488# B a_1492_488# VNW pfet_05v0 ad=0.5016p pd=3.16u as=0.3534p ps=1.76u w=1.14u l=0.5u
X13 a_636_68# A1 ZN VPW nfet_05v0 ad=93.59999f pd=1.02u as=0.2028p ps=1.3u w=0.78u l=0.6u
X14 a_1492_488# C VDD VNW pfet_05v0 ad=0.3534p pd=1.76u as=0.3534p ps=1.76u w=1.14u l=0.5u
X15 VSS A2 a_636_68# VPW nfet_05v0 ad=0.23325p pd=1.48u as=93.59999f ps=1.02u w=0.78u l=0.6u
.ends

.subckt gf180mcu_fd_sc_mcu7t5v0__nand4_2 A1 A2 A3 A4 ZN VDD VNW VPW VSS
X0 a_1458_68# A3 a_1254_68# VPW nfet_05v0 ad=0.1517p pd=1.19u as=0.1722p ps=1.24u w=0.82u l=0.6u
X1 a_632_68# A2 a_438_68# VPW nfet_05v0 ad=0.1722p pd=1.24u as=0.1517p ps=1.19u w=0.82u l=0.6u
X2 VDD A4 ZN VNW pfet_05v0 ad=0.2197p pd=1.365u as=0.3718p ps=2.57u w=0.845u l=0.5u
X3 a_244_68# A4 VSS VPW nfet_05v0 ad=0.1517p pd=1.19u as=0.3608p ps=2.52u w=0.82u l=0.6u
X4 ZN A3 VDD VNW pfet_05v0 ad=0.2197p pd=1.365u as=0.2197p ps=1.365u w=0.845u l=0.5u
X5 a_438_68# A3 a_244_68# VPW nfet_05v0 ad=0.1517p pd=1.19u as=0.1517p ps=1.19u w=0.82u l=0.6u
X6 VDD A2 ZN VNW pfet_05v0 ad=0.2197p pd=1.365u as=0.2197p ps=1.365u w=0.845u l=0.5u
X7 ZN A1 a_632_68# VPW nfet_05v0 ad=0.2132p pd=1.34u as=0.1722p ps=1.24u w=0.82u l=0.6u
X8 ZN A1 VDD VNW pfet_05v0 ad=0.2197p pd=1.365u as=0.2197p ps=1.365u w=0.845u l=0.5u
X9 VDD A1 ZN VNW pfet_05v0 ad=0.2197p pd=1.365u as=0.2197p ps=1.365u w=0.845u l=0.5u
X10 a_1060_68# A1 ZN VPW nfet_05v0 ad=0.1517p pd=1.19u as=0.2132p ps=1.34u w=0.82u l=0.6u
X11 a_1254_68# A2 a_1060_68# VPW nfet_05v0 ad=0.1722p pd=1.24u as=0.1517p ps=1.19u w=0.82u l=0.6u
X12 ZN A2 VDD VNW pfet_05v0 ad=0.2197p pd=1.365u as=0.2197p ps=1.365u w=0.845u l=0.5u
X13 VSS A4 a_1458_68# VPW nfet_05v0 ad=0.3608p pd=2.52u as=0.1517p ps=1.19u w=0.82u l=0.6u
X14 VDD A3 ZN VNW pfet_05v0 ad=0.2197p pd=1.365u as=0.2197p ps=1.365u w=0.845u l=0.5u
X15 ZN A4 VDD VNW pfet_05v0 ad=0.3718p pd=2.57u as=0.2197p ps=1.365u w=0.845u l=0.5u
.ends

.subckt gf180mcu_fd_sc_mcu7t5v0__xnor2_2 A1 A2 ZN VDD VNW VPW VSS
X0 a_728_472# a_56_565# VDD VNW pfet_05v0 ad=0.3172p pd=1.74u as=0.371125p ps=2.07u w=1.22u l=0.5u
X1 ZN a_728_68# VSS VPW nfet_05v0 ad=0.2132p pd=1.34u as=0.3608p ps=2.52u w=0.82u l=0.6u
X2 a_728_68# A1 a_728_472# VNW pfet_05v0 ad=0.3172p pd=1.74u as=0.3172p ps=1.74u w=1.22u l=0.5u
X3 VDD A1 a_244_565# VNW pfet_05v0 ad=0.371125p pd=2.07u as=0.161025p ps=1.135u w=0.565u l=0.5u
X4 VSS A1 a_56_565# VPW nfet_05v0 ad=0.218p pd=1.52u as=93.59999f ps=0.88u w=0.36u l=0.6u
X5 a_244_565# A2 a_56_565# VNW pfet_05v0 ad=0.161025p pd=1.135u as=0.2486p ps=2.01u w=0.565u l=0.5u
X6 a_728_472# A2 a_728_68# VNW pfet_05v0 ad=0.5368p pd=3.32u as=0.3172p ps=1.74u w=1.22u l=0.5u
X7 a_728_68# a_56_565# VSS VPW nfet_05v0 ad=0.2132p pd=1.34u as=0.218p ps=1.52u w=0.82u l=0.6u
X8 VSS A2 a_952_68# VPW nfet_05v0 ad=0.3608p pd=2.52u as=0.1312p ps=1.14u w=0.82u l=0.6u
X9 a_56_565# A2 VSS VPW nfet_05v0 ad=93.59999f pd=0.88u as=0.1584p ps=1.6u w=0.36u l=0.6u
X10 a_952_68# A1 a_728_68# VPW nfet_05v0 ad=0.1312p pd=1.14u as=0.2132p ps=1.34u w=0.82u l=0.6u
X11 VDD a_728_68# ZN VNW pfet_05v0 ad=0.5368p pd=3.32u as=0.3782p ps=1.84u w=1.22u l=0.5u
X12 VSS a_728_68# ZN VPW nfet_05v0 ad=0.3608p pd=2.52u as=0.2132p ps=1.34u w=0.82u l=0.6u
X13 ZN a_728_68# VDD VNW pfet_05v0 ad=0.3782p pd=1.84u as=0.5368p ps=3.32u w=1.22u l=0.5u
.ends

.subckt gf180mcu_fd_sc_mcu7t5v0__oai222_2 A1 A2 B1 B2 C1 C2 ZN VDD VNW VPW VSS
X0 VDD C2 a_244_497# VNW pfet_05v0 ad=0.2847p pd=1.615u as=0.33945p ps=1.715u w=1.095u l=0.5u
X1 ZN B1 a_1712_497# VNW pfet_05v0 ad=0.3942p pd=1.815u as=0.33945p ps=1.715u w=1.095u l=0.5u
X2 ZN A1 a_2608_497# VNW pfet_05v0 ad=0.4818p pd=3.07u as=0.4599p ps=1.935u w=1.095u l=0.5u
X3 ZN A2 a_1076_93# VPW nfet_05v0 ad=0.30965p pd=1.685u as=0.2132p ps=1.34u w=0.82u l=0.6u
X4 a_672_497# C2 VDD VNW pfet_05v0 ad=0.3942p pd=1.815u as=0.2847p ps=1.615u w=1.095u l=0.5u
X5 a_244_68# C2 VSS VPW nfet_05v0 ad=0.2132p pd=1.34u as=0.2132p ps=1.34u w=0.82u l=0.6u
X6 a_244_68# C1 VSS VPW nfet_05v0 ad=0.2132p pd=1.34u as=0.3608p ps=2.52u w=0.82u l=0.6u
X7 a_1076_93# B1 a_244_68# VPW nfet_05v0 ad=0.2132p pd=1.34u as=0.2132p ps=1.34u w=0.82u l=0.6u
X8 a_1076_93# B2 a_244_68# VPW nfet_05v0 ad=0.2132p pd=1.34u as=0.2132p ps=1.34u w=0.82u l=0.6u
X9 VDD B2 a_1284_497# VNW pfet_05v0 ad=0.2847p pd=1.615u as=0.33945p ps=1.715u w=1.095u l=0.5u
X10 a_1076_93# A2 ZN VPW nfet_05v0 ad=0.2132p pd=1.34u as=0.2132p ps=1.34u w=0.82u l=0.6u
X11 a_244_497# C1 ZN VNW pfet_05v0 ad=0.33945p pd=1.715u as=0.4818p ps=3.07u w=1.095u l=0.5u
X12 a_1712_497# B2 VDD VNW pfet_05v0 ad=0.33945p pd=1.715u as=0.2847p ps=1.615u w=1.095u l=0.5u
X13 ZN C1 a_672_497# VNW pfet_05v0 ad=0.73365p pd=2.435u as=0.3942p ps=1.815u w=1.095u l=0.5u
X14 a_1284_497# B1 ZN VNW pfet_05v0 ad=0.33945p pd=1.715u as=0.73365p ps=2.435u w=1.095u l=0.5u
X15 a_1076_93# A1 ZN VPW nfet_05v0 ad=0.3608p pd=2.52u as=0.30965p ps=1.685u w=0.82u l=0.6u
X16 a_244_68# B2 a_1076_93# VPW nfet_05v0 ad=0.2132p pd=1.34u as=0.2132p ps=1.34u w=0.82u l=0.6u
X17 a_244_68# B1 a_1076_93# VPW nfet_05v0 ad=0.2132p pd=1.34u as=0.3608p ps=2.52u w=0.82u l=0.6u
X18 VDD A2 a_2180_497# VNW pfet_05v0 ad=0.2847p pd=1.615u as=0.33945p ps=1.715u w=1.095u l=0.5u
X19 ZN A1 a_1076_93# VPW nfet_05v0 ad=0.2132p pd=1.34u as=0.2132p ps=1.34u w=0.82u l=0.6u
X20 VSS C1 a_244_68# VPW nfet_05v0 ad=0.3608p pd=2.52u as=0.2132p ps=1.34u w=0.82u l=0.6u
X21 a_2180_497# A1 ZN VNW pfet_05v0 ad=0.33945p pd=1.715u as=0.3942p ps=1.815u w=1.095u l=0.5u
X22 a_2608_497# A2 VDD VNW pfet_05v0 ad=0.4599p pd=1.935u as=0.2847p ps=1.615u w=1.095u l=0.5u
X23 VSS C2 a_244_68# VPW nfet_05v0 ad=0.2132p pd=1.34u as=0.2132p ps=1.34u w=0.82u l=0.6u
.ends

.subckt gf180mcu_fd_sc_mcu7t5v0__nand4_4 A1 A2 A3 A4 ZN VDD VNW VPW VSS
X0 ZN A2 VDD VNW pfet_05v0 ad=0.2197p pd=1.365u as=0.2197p ps=1.365u w=0.845u l=0.5u
X1 VDD A1 ZN VNW pfet_05v0 ad=0.4056p pd=1.805u as=0.2197p ps=1.365u w=0.845u l=0.5u
X2 ZN A3 VDD VNW pfet_05v0 ad=0.2197p pd=1.365u as=0.3718p ps=2.57u w=0.845u l=0.5u
X3 a_244_68# A3 a_36_68# VPW nfet_05v0 ad=0.1312p pd=1.14u as=0.3608p ps=2.52u w=0.82u l=0.6u
X4 VSS A4 a_244_68# VPW nfet_05v0 ad=0.2132p pd=1.34u as=0.1312p ps=1.14u w=0.82u l=0.6u
X5 a_1468_68# A4 VSS VPW nfet_05v0 ad=0.1517p pd=1.19u as=0.2132p ps=1.34u w=0.82u l=0.6u
X6 VDD A4 ZN VNW pfet_05v0 ad=0.2197p pd=1.365u as=0.2197p ps=1.365u w=0.845u l=0.5u
X7 a_1866_68# A2 a_1662_68# VPW nfet_05v0 ad=0.1517p pd=1.19u as=0.1722p ps=1.24u w=0.82u l=0.6u
X8 ZN A4 VDD VNW pfet_05v0 ad=0.2197p pd=1.365u as=0.2197p ps=1.365u w=0.845u l=0.5u
X9 ZN A1 VDD VNW pfet_05v0 ad=0.2197p pd=1.365u as=0.4056p ps=1.805u w=0.845u l=0.5u
X10 a_3276_68# A1 ZN VPW nfet_05v0 ad=0.1312p pd=1.14u as=0.4161p ps=1.905u w=0.82u l=0.6u
X11 a_652_68# A4 VSS VPW nfet_05v0 ad=0.1312p pd=1.14u as=0.2132p ps=1.34u w=0.82u l=0.6u
X12 a_36_68# A3 a_652_68# VPW nfet_05v0 ad=0.2132p pd=1.34u as=0.1312p ps=1.14u w=0.82u l=0.6u
X13 VDD A2 ZN VNW pfet_05v0 ad=0.3718p pd=2.57u as=0.2197p ps=1.365u w=0.845u l=0.5u
X14 VDD A3 ZN VNW pfet_05v0 ad=0.2197p pd=1.365u as=0.2197p ps=1.365u w=0.845u l=0.5u
X15 VSS A4 a_1060_68# VPW nfet_05v0 ad=0.2132p pd=1.34u as=0.1312p ps=1.14u w=0.82u l=0.6u
X16 ZN A3 VDD VNW pfet_05v0 ad=0.2197p pd=1.365u as=0.2197p ps=1.365u w=0.845u l=0.5u
X17 a_2372_68# A1 ZN VPW nfet_05v0 ad=0.1312p pd=1.14u as=0.4161p ps=1.905u w=0.82u l=0.6u
X18 a_36_68# A2 a_2372_68# VPW nfet_05v0 ad=0.2132p pd=1.34u as=0.1312p ps=1.14u w=0.82u l=0.6u
X19 ZN A1 VDD VNW pfet_05v0 ad=0.2197p pd=1.365u as=0.4056p ps=1.805u w=0.845u l=0.5u
X20 a_1060_68# A3 a_36_68# VPW nfet_05v0 ad=0.1312p pd=1.14u as=0.2132p ps=1.34u w=0.82u l=0.6u
X21 VDD A2 ZN VNW pfet_05v0 ad=0.2197p pd=1.365u as=0.2197p ps=1.365u w=0.845u l=0.5u
X22 VDD A4 ZN VNW pfet_05v0 ad=0.2197p pd=1.365u as=0.2197p ps=1.365u w=0.845u l=0.5u
X23 ZN A2 VDD VNW pfet_05v0 ad=0.2197p pd=1.365u as=0.2197p ps=1.365u w=0.845u l=0.5u
X24 ZN A1 a_2780_68# VPW nfet_05v0 ad=0.4161p pd=1.905u as=0.1312p ps=1.14u w=0.82u l=0.6u
X25 a_2780_68# A2 a_36_68# VPW nfet_05v0 ad=0.1312p pd=1.14u as=0.2132p ps=1.34u w=0.82u l=0.6u
X26 ZN A4 VDD VNW pfet_05v0 ad=0.2197p pd=1.365u as=0.2197p ps=1.365u w=0.845u l=0.5u
X27 VDD A1 ZN VNW pfet_05v0 ad=0.4056p pd=1.805u as=0.2197p ps=1.365u w=0.845u l=0.5u
X28 a_36_68# A2 a_3276_68# VPW nfet_05v0 ad=0.3608p pd=2.52u as=0.1312p ps=1.14u w=0.82u l=0.6u
X29 VDD A3 ZN VNW pfet_05v0 ad=0.2197p pd=1.365u as=0.2197p ps=1.365u w=0.845u l=0.5u
X30 a_1662_68# A3 a_1468_68# VPW nfet_05v0 ad=0.1722p pd=1.24u as=0.1517p ps=1.19u w=0.82u l=0.6u
X31 ZN A1 a_1866_68# VPW nfet_05v0 ad=0.4161p pd=1.905u as=0.1517p ps=1.19u w=0.82u l=0.6u
.ends

.subckt gf180mcu_fd_sc_mcu7t5v0__oai22_2 A1 A2 B1 B2 ZN VDD VNW VPW VSS
X0 VDD A2 a_1612_497# VNW pfet_05v0 ad=0.4818p pd=3.07u as=0.4599p ps=1.935u w=1.095u l=0.5u
X1 ZN B1 a_244_497# VNW pfet_05v0 ad=0.2847p pd=1.615u as=0.33945p ps=1.715u w=1.095u l=0.5u
X2 a_672_497# B1 ZN VNW pfet_05v0 ad=0.33945p pd=1.715u as=0.2847p ps=1.615u w=1.095u l=0.5u
X3 a_1140_497# A2 VDD VNW pfet_05v0 ad=0.4599p pd=1.935u as=0.3942p ps=1.815u w=1.095u l=0.5u
X4 VSS B1 a_36_68# VPW nfet_05v0 ad=0.2132p pd=1.34u as=0.2132p ps=1.34u w=0.82u l=0.6u
X5 VSS B2 a_36_68# VPW nfet_05v0 ad=0.2132p pd=1.34u as=0.3608p ps=2.52u w=0.82u l=0.6u
X6 a_36_68# A2 ZN VPW nfet_05v0 ad=0.3608p pd=2.52u as=0.30965p ps=1.685u w=0.82u l=0.6u
X7 a_244_497# B2 VDD VNW pfet_05v0 ad=0.33945p pd=1.715u as=0.4818p ps=3.07u w=1.095u l=0.5u
X8 a_36_68# A1 ZN VPW nfet_05v0 ad=0.2132p pd=1.34u as=0.30965p ps=1.685u w=0.82u l=0.6u
X9 ZN A1 a_1140_497# VNW pfet_05v0 ad=0.2847p pd=1.615u as=0.4599p ps=1.935u w=1.095u l=0.5u
X10 VDD B2 a_672_497# VNW pfet_05v0 ad=0.3942p pd=1.815u as=0.33945p ps=1.715u w=1.095u l=0.5u
X11 a_1612_497# A1 ZN VNW pfet_05v0 ad=0.4599p pd=1.935u as=0.2847p ps=1.615u w=1.095u l=0.5u
X12 ZN A1 a_36_68# VPW nfet_05v0 ad=0.30965p pd=1.685u as=0.2132p ps=1.34u w=0.82u l=0.6u
X13 a_36_68# B2 VSS VPW nfet_05v0 ad=0.2132p pd=1.34u as=0.2132p ps=1.34u w=0.82u l=0.6u
X14 a_36_68# B1 VSS VPW nfet_05v0 ad=0.2132p pd=1.34u as=0.2132p ps=1.34u w=0.82u l=0.6u
X15 ZN A2 a_36_68# VPW nfet_05v0 ad=0.30965p pd=1.685u as=0.2132p ps=1.34u w=0.82u l=0.6u
.ends

.subckt gf180mcu_fd_sc_mcu7t5v0__clkinv_12 I ZN VDD VNW VPW VSS
X0 ZN I VDD VNW pfet_05v0 ad=0.3782p pd=1.84u as=0.3782p ps=1.84u w=1.22u l=0.5u
X1 ZN I VDD VNW pfet_05v0 ad=0.3782p pd=1.84u as=0.3782p ps=1.84u w=1.22u l=0.5u
X2 ZN I VSS VPW nfet_05v0 ad=0.1248p pd=1u as=0.1248p ps=1u w=0.48u l=0.6u
X3 VDD I ZN VNW pfet_05v0 ad=0.3782p pd=1.84u as=0.3782p ps=1.84u w=1.22u l=0.5u
X4 ZN I VDD VNW pfet_05v0 ad=0.3782p pd=1.84u as=0.3782p ps=1.84u w=1.22u l=0.5u
X5 ZN I VSS VPW nfet_05v0 ad=0.1248p pd=1u as=0.1248p ps=1u w=0.48u l=0.6u
X6 VSS I ZN VPW nfet_05v0 ad=0.1248p pd=1u as=0.1248p ps=1u w=0.48u l=0.6u
X7 ZN I VSS VPW nfet_05v0 ad=0.1248p pd=1u as=0.1248p ps=1u w=0.48u l=0.6u
X8 VDD I ZN VNW pfet_05v0 ad=0.3782p pd=1.84u as=0.3782p ps=1.84u w=1.22u l=0.5u
X9 VSS I ZN VPW nfet_05v0 ad=0.1248p pd=1u as=0.1248p ps=1u w=0.48u l=0.6u
X10 VDD I ZN VNW pfet_05v0 ad=0.3782p pd=1.84u as=0.3782p ps=1.84u w=1.22u l=0.5u
X11 VDD I ZN VNW pfet_05v0 ad=0.3782p pd=1.84u as=0.3782p ps=1.84u w=1.22u l=0.5u
X12 ZN I VDD VNW pfet_05v0 ad=0.3782p pd=1.84u as=0.3782p ps=1.84u w=1.22u l=0.5u
X13 VSS I ZN VPW nfet_05v0 ad=0.1248p pd=1u as=0.1248p ps=1u w=0.48u l=0.6u
X14 VSS I ZN VPW nfet_05v0 ad=0.1248p pd=1u as=0.1248p ps=1u w=0.48u l=0.6u
X15 VDD I ZN VNW pfet_05v0 ad=0.3782p pd=1.84u as=0.3782p ps=1.84u w=1.22u l=0.5u
X16 ZN I VSS VPW nfet_05v0 ad=0.1248p pd=1u as=0.1248p ps=1u w=0.48u l=0.6u
X17 VDD I ZN VNW pfet_05v0 ad=0.5368p pd=3.32u as=0.3782p ps=1.84u w=1.22u l=0.5u
X18 VSS I ZN VPW nfet_05v0 ad=0.1248p pd=1u as=0.1248p ps=1u w=0.48u l=0.6u
X19 ZN I VDD VNW pfet_05v0 ad=0.3782p pd=1.84u as=0.3782p ps=1.84u w=1.22u l=0.5u
X20 VSS I ZN VPW nfet_05v0 ad=0.2112p pd=1.84u as=0.1248p ps=1u w=0.48u l=0.6u
X21 ZN I VSS VPW nfet_05v0 ad=0.1248p pd=1u as=0.1248p ps=1u w=0.48u l=0.6u
X22 ZN I VDD VNW pfet_05v0 ad=0.3782p pd=1.84u as=0.5368p ps=3.32u w=1.22u l=0.5u
X23 ZN I VSS VPW nfet_05v0 ad=0.1248p pd=1u as=0.2112p ps=1.84u w=0.48u l=0.6u
.ends

.subckt gf180mcu_fd_sc_mcu7t5v0__oai31_4 A1 A2 A3 B ZN VDD VNW VPW VSS
X0 ZN A1 a_2060_497# VNW pfet_05v0 ad=0.2847p pd=1.615u as=0.3942p ps=1.815u w=1.095u l=0.5u
X1 a_36_68# B VSS VPW nfet_05v0 ad=0.2132p pd=1.34u as=0.2132p ps=1.34u w=0.82u l=0.6u
X2 VDD B ZN VNW pfet_05v0 ad=0.3942p pd=1.815u as=0.2847p ps=1.615u w=1.095u l=0.5u
X3 ZN A3 a_36_68# VPW nfet_05v0 ad=0.2132p pd=1.34u as=0.2132p ps=1.34u w=0.82u l=0.6u
X4 VSS B a_36_68# VPW nfet_05v0 ad=0.2132p pd=1.34u as=0.43265p ps=1.985u w=0.82u l=0.6u
X5 a_2508_497# A1 ZN VNW pfet_05v0 ad=0.33945p pd=1.715u as=0.2847p ps=1.615u w=1.095u l=0.5u
X6 ZN B VDD VNW pfet_05v0 ad=0.2847p pd=1.615u as=0.4818p ps=3.07u w=1.095u l=0.5u
X7 ZN A3 a_36_68# VPW nfet_05v0 ad=0.30965p pd=1.685u as=0.3608p ps=2.52u w=0.82u l=0.6u
X8 a_56_497# A3 VDD VNW pfet_05v0 ad=0.3942p pd=1.815u as=0.40515p ps=1.835u w=1.095u l=0.5u
X9 a_36_68# A3 ZN VPW nfet_05v0 ad=0.2132p pd=1.34u as=0.2132p ps=1.34u w=0.82u l=0.6u
X10 ZN A1 a_36_68# VPW nfet_05v0 ad=0.2132p pd=1.34u as=0.2132p ps=1.34u w=0.82u l=0.6u
X11 ZN B VDD VNW pfet_05v0 ad=0.2847p pd=1.615u as=0.3942p ps=1.815u w=1.095u l=0.5u
X12 a_36_68# A3 ZN VPW nfet_05v0 ad=0.2132p pd=1.34u as=0.30965p ps=1.685u w=0.82u l=0.6u
X13 VDD A3 a_56_497# VNW pfet_05v0 ad=0.40515p pd=1.835u as=0.4818p ps=3.07u w=1.095u l=0.5u
X14 VDD B ZN VNW pfet_05v0 ad=0.53655p pd=3.17u as=0.2847p ps=1.615u w=1.095u l=0.5u
X15 a_36_68# A2 ZN VPW nfet_05v0 ad=0.2132p pd=1.34u as=0.2132p ps=1.34u w=0.82u l=0.6u
X16 VDD A3 a_56_497# VNW pfet_05v0 ad=0.2847p pd=1.615u as=0.3942p ps=1.815u w=1.095u l=0.5u
X17 a_36_68# A1 ZN VPW nfet_05v0 ad=0.2132p pd=1.34u as=0.2132p ps=1.34u w=0.82u l=0.6u
X18 a_36_68# A2 ZN VPW nfet_05v0 ad=0.43265p pd=1.985u as=0.2132p ps=1.34u w=0.82u l=0.6u
X19 a_940_497# A3 VDD VNW pfet_05v0 ad=0.3942p pd=1.815u as=0.2847p ps=1.615u w=1.095u l=0.5u
X20 VSS B a_36_68# VPW nfet_05v0 ad=0.2132p pd=1.34u as=0.2132p ps=1.34u w=0.82u l=0.6u
X21 ZN A1 a_1184_497# VNW pfet_05v0 ad=0.2847p pd=1.615u as=0.33945p ps=1.715u w=1.095u l=0.5u
X22 a_56_497# A2 a_2508_497# VNW pfet_05v0 ad=0.4818p pd=3.07u as=0.33945p ps=1.715u w=1.095u l=0.5u
X23 a_36_68# A1 ZN VPW nfet_05v0 ad=0.2132p pd=1.34u as=0.2132p ps=1.34u w=0.82u l=0.6u
X24 ZN A2 a_36_68# VPW nfet_05v0 ad=0.2132p pd=1.34u as=0.2132p ps=1.34u w=0.82u l=0.6u
X25 a_1612_497# A1 ZN VNW pfet_05v0 ad=0.3942p pd=1.815u as=0.2847p ps=1.615u w=1.095u l=0.5u
X26 ZN A1 a_36_68# VPW nfet_05v0 ad=0.2132p pd=1.34u as=0.2132p ps=1.34u w=0.82u l=0.6u
X27 a_1184_497# A2 a_940_497# VNW pfet_05v0 ad=0.33945p pd=1.715u as=0.3942p ps=1.815u w=1.095u l=0.5u
X28 a_56_497# A2 a_1612_497# VNW pfet_05v0 ad=0.2847p pd=1.615u as=0.3942p ps=1.815u w=1.095u l=0.5u
X29 ZN A2 a_36_68# VPW nfet_05v0 ad=0.2132p pd=1.34u as=0.2132p ps=1.34u w=0.82u l=0.6u
X30 a_2060_497# A2 a_56_497# VNW pfet_05v0 ad=0.3942p pd=1.815u as=0.2847p ps=1.615u w=1.095u l=0.5u
X31 a_36_68# B VSS VPW nfet_05v0 ad=0.3608p pd=2.52u as=0.2132p ps=1.34u w=0.82u l=0.6u
.ends

.subckt gf180mcu_fd_sc_mcu7t5v0__mux2_2 I0 I1 S Z VDD VNW VPW VSS
X0 a_1152_472# S a_124_24# VNW pfet_05v0 ad=0.1464p pd=1.46u as=0.3172p ps=1.74u w=1.22u l=0.5u
X1 a_692_68# I1 VSS VPW nfet_05v0 ad=98.399994f pd=1.06u as=0.2132p ps=1.34u w=0.82u l=0.6u
X2 a_124_24# S a_692_68# VPW nfet_05v0 ad=0.2132p pd=1.34u as=98.399994f ps=1.06u w=0.82u l=0.6u
X3 Z a_124_24# VSS VPW nfet_05v0 ad=0.2132p pd=1.34u as=0.3608p ps=2.52u w=0.82u l=0.6u
X4 a_848_380# S VSS VPW nfet_05v0 ad=0.3608p pd=2.52u as=0.2132p ps=1.34u w=0.82u l=0.6u
X5 VDD a_124_24# Z VNW pfet_05v0 ad=0.4392p pd=1.94u as=0.3477p ps=1.79u w=1.22u l=0.5u
X6 VDD I0 a_1152_472# VNW pfet_05v0 ad=0.3172p pd=1.74u as=0.1464p ps=1.46u w=1.22u l=0.5u
X7 a_692_472# I1 VDD VNW pfet_05v0 ad=0.4758p pd=2u as=0.4392p ps=1.94u w=1.22u l=0.5u
X8 a_848_380# S VDD VNW pfet_05v0 ad=0.5368p pd=3.32u as=0.3172p ps=1.74u w=1.22u l=0.5u
X9 Z a_124_24# VDD VNW pfet_05v0 ad=0.3477p pd=1.79u as=0.5368p ps=3.32u w=1.22u l=0.5u
X10 VSS I0 a_1084_68# VPW nfet_05v0 ad=0.2132p pd=1.34u as=0.1968p ps=1.3u w=0.82u l=0.6u
X11 a_1084_68# a_848_380# a_124_24# VPW nfet_05v0 ad=0.1968p pd=1.3u as=0.2132p ps=1.34u w=0.82u l=0.6u
X12 VSS a_124_24# Z VPW nfet_05v0 ad=0.2132p pd=1.34u as=0.2132p ps=1.34u w=0.82u l=0.6u
X13 a_124_24# a_848_380# a_692_472# VNW pfet_05v0 ad=0.3172p pd=1.74u as=0.4758p ps=2u w=1.22u l=0.5u
.ends

.subckt gf180mcu_fd_sc_mcu7t5v0__clkinv_8 I ZN VDD VNW VPW VSS
X0 ZN I VDD VNW pfet_05v0 ad=0.3782p pd=1.84u as=0.3782p ps=1.84u w=1.22u l=0.5u
X1 ZN I VSS VPW nfet_05v0 ad=0.1248p pd=1u as=0.1248p ps=1u w=0.48u l=0.6u
X2 VSS I ZN VPW nfet_05v0 ad=0.1248p pd=1u as=0.1248p ps=1u w=0.48u l=0.6u
X3 VDD I ZN VNW pfet_05v0 ad=0.3782p pd=1.84u as=0.3782p ps=1.84u w=1.22u l=0.5u
X4 ZN I VSS VPW nfet_05v0 ad=0.1248p pd=1u as=0.1248p ps=1u w=0.48u l=0.6u
X5 VDD I ZN VNW pfet_05v0 ad=0.5368p pd=3.32u as=0.3782p ps=1.84u w=1.22u l=0.5u
X6 ZN I VSS VPW nfet_05v0 ad=0.1248p pd=1u as=0.2112p ps=1.84u w=0.48u l=0.6u
X7 VDD I ZN VNW pfet_05v0 ad=0.3782p pd=1.84u as=0.3782p ps=1.84u w=1.22u l=0.5u
X8 ZN I VSS VPW nfet_05v0 ad=0.1248p pd=1u as=0.1248p ps=1u w=0.48u l=0.6u
X9 ZN I VDD VNW pfet_05v0 ad=0.3782p pd=1.84u as=0.3782p ps=1.84u w=1.22u l=0.5u
X10 VDD I ZN VNW pfet_05v0 ad=0.3782p pd=1.84u as=0.3782p ps=1.84u w=1.22u l=0.5u
X11 VSS I ZN VPW nfet_05v0 ad=0.1248p pd=1u as=0.1248p ps=1u w=0.48u l=0.6u
X12 ZN I VDD VNW pfet_05v0 ad=0.3782p pd=1.84u as=0.3782p ps=1.84u w=1.22u l=0.5u
X13 VSS I ZN VPW nfet_05v0 ad=0.2112p pd=1.84u as=0.1248p ps=1u w=0.48u l=0.6u
X14 ZN I VDD VNW pfet_05v0 ad=0.3782p pd=1.84u as=0.5368p ps=3.32u w=1.22u l=0.5u
X15 VSS I ZN VPW nfet_05v0 ad=0.1248p pd=1u as=0.1248p ps=1u w=0.48u l=0.6u
.ends

.subckt gf180mcu_fd_sc_mcu7t5v0__inv_8 I ZN VDD VNW VPW VSS
X0 ZN I VDD VNW pfet_05v0 ad=0.4392p pd=1.94u as=0.3172p ps=1.74u w=1.22u l=0.5u
X1 VDD I ZN VNW pfet_05v0 ad=0.5368p pd=3.32u as=0.4392p ps=1.94u w=1.22u l=0.5u
X2 ZN I VSS VPW nfet_05v0 ad=0.2132p pd=1.34u as=0.2132p ps=1.34u w=0.82u l=0.6u
X3 ZN I VSS VPW nfet_05v0 ad=0.2132p pd=1.34u as=0.3608p ps=2.52u w=0.82u l=0.6u
X4 ZN I VSS VPW nfet_05v0 ad=0.2132p pd=1.34u as=0.2132p ps=1.34u w=0.82u l=0.6u
X5 VDD I ZN VNW pfet_05v0 ad=0.3172p pd=1.74u as=0.4392p ps=1.94u w=1.22u l=0.5u
X6 ZN I VDD VNW pfet_05v0 ad=0.4392p pd=1.94u as=0.3172p ps=1.74u w=1.22u l=0.5u
X7 VSS I ZN VPW nfet_05v0 ad=0.3608p pd=2.52u as=0.2132p ps=1.34u w=0.82u l=0.6u
X8 VDD I ZN VNW pfet_05v0 ad=0.3172p pd=1.74u as=0.4392p ps=1.94u w=1.22u l=0.5u
X9 VSS I ZN VPW nfet_05v0 ad=0.2132p pd=1.34u as=0.2132p ps=1.34u w=0.82u l=0.6u
X10 ZN I VDD VNW pfet_05v0 ad=0.4392p pd=1.94u as=0.3172p ps=1.74u w=1.22u l=0.5u
X11 VSS I ZN VPW nfet_05v0 ad=0.2132p pd=1.34u as=0.2132p ps=1.34u w=0.82u l=0.6u
X12 ZN I VDD VNW pfet_05v0 ad=0.4392p pd=1.94u as=0.5368p ps=3.32u w=1.22u l=0.5u
X13 VSS I ZN VPW nfet_05v0 ad=0.2132p pd=1.34u as=0.2132p ps=1.34u w=0.82u l=0.6u
X14 ZN I VSS VPW nfet_05v0 ad=0.2132p pd=1.34u as=0.2132p ps=1.34u w=0.82u l=0.6u
X15 VDD I ZN VNW pfet_05v0 ad=0.3172p pd=1.74u as=0.4392p ps=1.94u w=1.22u l=0.5u
.ends

.subckt gf180mcu_fd_sc_mcu7t5v0__aoi222_1 A1 A2 B1 B2 C1 C2 ZN VDD VNW VPW VSS
X0 a_291_68# C2 VSS VPW nfet_05v0 ad=98.399994f pd=1.06u as=0.3608p ps=2.52u w=0.82u l=0.6u
X1 a_1235_68# A2 VSS VPW nfet_05v0 ad=0.1722p pd=1.24u as=0.2132p ps=1.34u w=0.82u l=0.6u
X2 a_619_484# A1 ZN VNW pfet_05v0 ad=0.5104p pd=3.2u as=0.3596p ps=1.78u w=1.16u l=0.5u
X3 a_255_484# B1 a_619_484# VNW pfet_05v0 ad=0.3016p pd=1.68u as=0.5104p ps=3.2u w=1.16u l=0.5u
X4 a_619_484# B2 a_255_484# VNW pfet_05v0 ad=0.3016p pd=1.68u as=0.3016p ps=1.68u w=1.16u l=0.5u
X5 a_255_484# C2 VDD VNW pfet_05v0 ad=0.3016p pd=1.68u as=0.5104p ps=3.2u w=1.16u l=0.5u
X6 ZN C1 a_291_68# VPW nfet_05v0 ad=0.33825p pd=1.645u as=98.399994f ps=1.06u w=0.82u l=0.6u
X7 ZN A1 a_1235_68# VPW nfet_05v0 ad=0.3608p pd=2.52u as=0.1722p ps=1.24u w=0.82u l=0.6u
X8 VSS B2 a_744_68# VPW nfet_05v0 ad=0.2132p pd=1.34u as=0.30135p ps=1.555u w=0.82u l=0.6u
X9 VDD C1 a_255_484# VNW pfet_05v0 ad=0.5104p pd=3.2u as=0.3016p ps=1.68u w=1.16u l=0.5u
X10 ZN A2 a_619_484# VNW pfet_05v0 ad=0.3596p pd=1.78u as=0.3016p ps=1.68u w=1.16u l=0.5u
X11 a_744_68# B1 ZN VPW nfet_05v0 ad=0.30135p pd=1.555u as=0.33825p ps=1.645u w=0.82u l=0.6u
.ends

.subckt gf180mcu_fd_sc_mcu7t5v0__or3_4 A1 A2 A3 Z VDD VNW VPW VSS
X0 VSS a_244_68# Z VPW nfet_05v0 ad=0.3608p pd=2.52u as=0.2132p ps=1.34u w=0.82u l=0.6u
X1 Z a_244_68# VSS VPW nfet_05v0 ad=0.2132p pd=1.34u as=0.2132p ps=1.34u w=0.82u l=0.6u
X2 a_244_68# A1 VSS VPW nfet_05v0 ad=0.1729p pd=1.185u as=0.1729p ps=1.185u w=0.665u l=0.6u
X3 VDD A3 a_1120_472# VNW pfet_05v0 ad=0.549p pd=2.12u as=0.3782p ps=1.84u w=1.22u l=0.5u
X4 Z a_244_68# VSS VPW nfet_05v0 ad=0.2132p pd=1.34u as=0.26375p ps=1.52u w=0.82u l=0.6u
X5 Z a_244_68# VDD VNW pfet_05v0 ad=0.3477p pd=1.79u as=0.3782p ps=1.84u w=1.22u l=0.5u
X6 a_244_68# A3 VSS VPW nfet_05v0 ad=0.1729p pd=1.185u as=0.2926p ps=2.21u w=0.665u l=0.6u
X7 a_458_472# A2 a_244_472# VNW pfet_05v0 ad=0.3782p pd=1.84u as=0.3477p ps=1.79u w=1.22u l=0.5u
X8 a_244_472# A3 VDD VNW pfet_05v0 ad=0.3477p pd=1.79u as=0.5368p ps=3.32u w=1.22u l=0.5u
X9 a_1120_472# A2 a_906_472# VNW pfet_05v0 ad=0.3782p pd=1.84u as=0.3477p ps=1.79u w=1.22u l=0.5u
X10 VDD a_244_68# Z VNW pfet_05v0 ad=0.3782p pd=1.84u as=0.3477p ps=1.79u w=1.22u l=0.5u
X11 VSS A3 a_244_68# VPW nfet_05v0 ad=0.26375p pd=1.52u as=0.1729p ps=1.185u w=0.665u l=0.6u
X12 a_906_472# A1 a_244_68# VNW pfet_05v0 ad=0.3477p pd=1.79u as=0.3782p ps=1.84u w=1.22u l=0.5u
X13 Z a_244_68# VDD VNW pfet_05v0 ad=0.3477p pd=1.79u as=0.549p ps=2.12u w=1.22u l=0.5u
X14 a_244_68# A1 a_458_472# VNW pfet_05v0 ad=0.3782p pd=1.84u as=0.3782p ps=1.84u w=1.22u l=0.5u
X15 VDD a_244_68# Z VNW pfet_05v0 ad=0.5368p pd=3.32u as=0.3477p ps=1.79u w=1.22u l=0.5u
X16 VSS A1 a_244_68# VPW nfet_05v0 ad=0.1729p pd=1.185u as=0.1729p ps=1.185u w=0.665u l=0.6u
X17 VSS a_244_68# Z VPW nfet_05v0 ad=0.2132p pd=1.34u as=0.2132p ps=1.34u w=0.82u l=0.6u
X18 VSS A2 a_244_68# VPW nfet_05v0 ad=0.1729p pd=1.185u as=0.1729p ps=1.185u w=0.665u l=0.6u
X19 a_244_68# A2 VSS VPW nfet_05v0 ad=0.1729p pd=1.185u as=0.1729p ps=1.185u w=0.665u l=0.6u
.ends

.subckt gf180mcu_fd_sc_mcu7t5v0__buf_16 I Z VDD VNW VPW VSS
X0 Z a_224_472# VSS VPW nfet_05v0 ad=0.2132p pd=1.34u as=0.2132p ps=1.34u w=0.82u l=0.6u
X1 a_224_472# I VDD VNW pfet_05v0 ad=0.3782p pd=1.84u as=0.3782p ps=1.84u w=1.22u l=0.5u
X2 VDD a_224_472# Z VNW pfet_05v0 ad=0.3782p pd=1.84u as=0.3782p ps=1.84u w=1.22u l=0.5u
X3 Z a_224_472# VDD VNW pfet_05v0 ad=0.3782p pd=1.84u as=0.3782p ps=1.84u w=1.22u l=0.5u
X4 Z a_224_472# VSS VPW nfet_05v0 ad=0.2132p pd=1.34u as=0.2132p ps=1.34u w=0.82u l=0.6u
X5 a_224_472# I VSS VPW nfet_05v0 ad=0.2132p pd=1.34u as=0.2132p ps=1.34u w=0.82u l=0.6u
X6 VSS a_224_472# Z VPW nfet_05v0 ad=0.2132p pd=1.34u as=0.2132p ps=1.34u w=0.82u l=0.6u
X7 VSS a_224_472# Z VPW nfet_05v0 ad=0.2132p pd=1.34u as=0.2132p ps=1.34u w=0.82u l=0.6u
X8 VDD I a_224_472# VNW pfet_05v0 ad=0.3782p pd=1.84u as=0.3782p ps=1.84u w=1.22u l=0.5u
X9 Z a_224_472# VDD VNW pfet_05v0 ad=0.3782p pd=1.84u as=0.3782p ps=1.84u w=1.22u l=0.5u
X10 Z a_224_472# VDD VNW pfet_05v0 ad=0.3782p pd=1.84u as=0.3782p ps=1.84u w=1.22u l=0.5u
X11 a_224_472# I VSS VPW nfet_05v0 ad=0.2132p pd=1.34u as=0.3608p ps=2.52u w=0.82u l=0.6u
X12 Z a_224_472# VSS VPW nfet_05v0 ad=0.2132p pd=1.34u as=0.2132p ps=1.34u w=0.82u l=0.6u
X13 Z a_224_472# VSS VPW nfet_05v0 ad=0.2132p pd=1.34u as=0.2132p ps=1.34u w=0.82u l=0.6u
X14 VSS a_224_472# Z VPW nfet_05v0 ad=0.2132p pd=1.34u as=0.2132p ps=1.34u w=0.82u l=0.6u
X15 Z a_224_472# VDD VNW pfet_05v0 ad=0.3782p pd=1.84u as=0.3782p ps=1.84u w=1.22u l=0.5u
X16 VSS a_224_472# Z VPW nfet_05v0 ad=0.2132p pd=1.34u as=0.2132p ps=1.34u w=0.82u l=0.6u
X17 VDD I a_224_472# VNW pfet_05v0 ad=0.3782p pd=1.84u as=0.3782p ps=1.84u w=1.22u l=0.5u
X18 a_224_472# I VSS VPW nfet_05v0 ad=0.2132p pd=1.34u as=0.2132p ps=1.34u w=0.82u l=0.6u
X19 Z a_224_472# VSS VPW nfet_05v0 ad=0.2132p pd=1.34u as=0.2132p ps=1.34u w=0.82u l=0.6u
X20 VSS a_224_472# Z VPW nfet_05v0 ad=0.2132p pd=1.34u as=0.2132p ps=1.34u w=0.82u l=0.6u
X21 VDD a_224_472# Z VNW pfet_05v0 ad=0.3782p pd=1.84u as=0.3782p ps=1.84u w=1.22u l=0.5u
X22 Z a_224_472# VDD VNW pfet_05v0 ad=0.3782p pd=1.84u as=0.3782p ps=1.84u w=1.22u l=0.5u
X23 Z a_224_472# VSS VPW nfet_05v0 ad=0.2132p pd=1.34u as=0.2132p ps=1.34u w=0.82u l=0.6u
X24 VDD I a_224_472# VNW pfet_05v0 ad=0.3782p pd=1.84u as=0.3782p ps=1.84u w=1.22u l=0.5u
X25 VDD a_224_472# Z VNW pfet_05v0 ad=0.3782p pd=1.84u as=0.3782p ps=1.84u w=1.22u l=0.5u
X26 VDD a_224_472# Z VNW pfet_05v0 ad=0.3782p pd=1.84u as=0.3782p ps=1.84u w=1.22u l=0.5u
X27 Z a_224_472# VDD VNW pfet_05v0 ad=0.3782p pd=1.84u as=0.3782p ps=1.84u w=1.22u l=0.5u
X28 Z a_224_472# VSS VPW nfet_05v0 ad=0.2132p pd=1.34u as=0.2132p ps=1.34u w=0.82u l=0.6u
X29 a_224_472# I VDD VNW pfet_05v0 ad=0.3782p pd=1.84u as=0.3782p ps=1.84u w=1.22u l=0.5u
X30 VSS I a_224_472# VPW nfet_05v0 ad=0.2132p pd=1.34u as=0.2132p ps=1.34u w=0.82u l=0.6u
X31 VDD I a_224_472# VNW pfet_05v0 ad=0.3782p pd=1.84u as=0.3782p ps=1.84u w=1.22u l=0.5u
X32 VSS I a_224_472# VPW nfet_05v0 ad=0.2132p pd=1.34u as=0.2132p ps=1.34u w=0.82u l=0.6u
X33 VDD a_224_472# Z VNW pfet_05v0 ad=0.3782p pd=1.84u as=0.3782p ps=1.84u w=1.22u l=0.5u
X34 VSS a_224_472# Z VPW nfet_05v0 ad=0.2132p pd=1.34u as=0.2132p ps=1.34u w=0.82u l=0.6u
X35 VSS a_224_472# Z VPW nfet_05v0 ad=0.2132p pd=1.34u as=0.2132p ps=1.34u w=0.82u l=0.6u
X36 a_224_472# I VDD VNW pfet_05v0 ad=0.3782p pd=1.84u as=0.3782p ps=1.84u w=1.22u l=0.5u
X37 VDD a_224_472# Z VNW pfet_05v0 ad=0.5368p pd=3.32u as=0.3782p ps=1.84u w=1.22u l=0.5u
X38 Z a_224_472# VDD VNW pfet_05v0 ad=0.3782p pd=1.84u as=0.3782p ps=1.84u w=1.22u l=0.5u
X39 VSS I a_224_472# VPW nfet_05v0 ad=0.2132p pd=1.34u as=0.2132p ps=1.34u w=0.82u l=0.6u
X40 VDD a_224_472# Z VNW pfet_05v0 ad=0.3782p pd=1.84u as=0.3782p ps=1.84u w=1.22u l=0.5u
X41 a_224_472# I VDD VNW pfet_05v0 ad=0.3782p pd=1.84u as=0.5368p ps=3.32u w=1.22u l=0.5u
X42 VDD a_224_472# Z VNW pfet_05v0 ad=0.3782p pd=1.84u as=0.3782p ps=1.84u w=1.22u l=0.5u
X43 VSS I a_224_472# VPW nfet_05v0 ad=0.2132p pd=1.34u as=0.2132p ps=1.34u w=0.82u l=0.6u
X44 Z a_224_472# VSS VPW nfet_05v0 ad=0.2132p pd=1.34u as=0.2132p ps=1.34u w=0.82u l=0.6u
X45 VSS a_224_472# Z VPW nfet_05v0 ad=0.3608p pd=2.52u as=0.2132p ps=1.34u w=0.82u l=0.6u
X46 Z a_224_472# VDD VNW pfet_05v0 ad=0.3782p pd=1.84u as=0.3782p ps=1.84u w=1.22u l=0.5u
X47 a_224_472# I VSS VPW nfet_05v0 ad=0.2132p pd=1.34u as=0.2132p ps=1.34u w=0.82u l=0.6u
.ends

.subckt gf180mcu_fd_sc_mcu7t5v0__clkinv_20 I ZN VDD VNW VPW VSS
X0 ZN I VDD VNW pfet_05v0 ad=0.3782p pd=1.84u as=0.3782p ps=1.84u w=1.22u l=0.5u
X1 VDD I ZN VNW pfet_05v0 ad=0.3782p pd=1.84u as=0.3782p ps=1.84u w=1.22u l=0.5u
X2 ZN I VSS VPW nfet_05v0 ad=0.1248p pd=1u as=0.1248p ps=1u w=0.48u l=0.6u
X3 ZN I VDD VNW pfet_05v0 ad=0.3782p pd=1.84u as=0.3782p ps=1.84u w=1.22u l=0.5u
X4 ZN I VSS VPW nfet_05v0 ad=0.1248p pd=1u as=0.1248p ps=1u w=0.48u l=0.6u
X5 VSS I ZN VPW nfet_05v0 ad=0.1248p pd=1u as=0.1248p ps=1u w=0.48u l=0.6u
X6 VSS I ZN VPW nfet_05v0 ad=0.1248p pd=1u as=0.1248p ps=1u w=0.48u l=0.6u
X7 VDD I ZN VNW pfet_05v0 ad=0.3782p pd=1.84u as=0.3782p ps=1.84u w=1.22u l=0.5u
X8 ZN I VSS VPW nfet_05v0 ad=0.1248p pd=1u as=0.2112p ps=1.84u w=0.48u l=0.6u
X9 ZN I VDD VNW pfet_05v0 ad=0.3782p pd=1.84u as=0.3782p ps=1.84u w=1.22u l=0.5u
X10 ZN I VSS VPW nfet_05v0 ad=0.1248p pd=1u as=0.1248p ps=1u w=0.48u l=0.6u
X11 VSS I ZN VPW nfet_05v0 ad=0.1248p pd=1u as=0.1248p ps=1u w=0.48u l=0.6u
X12 VSS I ZN VPW nfet_05v0 ad=0.1248p pd=1u as=0.1248p ps=1u w=0.48u l=0.6u
X13 VDD I ZN VNW pfet_05v0 ad=0.3782p pd=1.84u as=0.3782p ps=1.84u w=1.22u l=0.5u
X14 ZN I VSS VPW nfet_05v0 ad=0.1248p pd=1u as=0.1248p ps=1u w=0.48u l=0.6u
X15 ZN I VSS VPW nfet_05v0 ad=0.1248p pd=1u as=0.1248p ps=1u w=0.48u l=0.6u
X16 VSS I ZN VPW nfet_05v0 ad=0.2112p pd=1.84u as=0.1248p ps=1u w=0.48u l=0.6u
X17 VDD I ZN VNW pfet_05v0 ad=0.5368p pd=3.32u as=0.3782p ps=1.84u w=1.22u l=0.5u
X18 ZN I VSS VPW nfet_05v0 ad=0.1248p pd=1u as=0.1248p ps=1u w=0.48u l=0.6u
X19 ZN I VDD VNW pfet_05v0 ad=0.3782p pd=1.84u as=0.3782p ps=1.84u w=1.22u l=0.5u
X20 VDD I ZN VNW pfet_05v0 ad=0.3782p pd=1.84u as=0.3782p ps=1.84u w=1.22u l=0.5u
X21 VDD I ZN VNW pfet_05v0 ad=0.3782p pd=1.84u as=0.3782p ps=1.84u w=1.22u l=0.5u
X22 VDD I ZN VNW pfet_05v0 ad=0.3782p pd=1.84u as=0.3782p ps=1.84u w=1.22u l=0.5u
X23 ZN I VSS VPW nfet_05v0 ad=0.1248p pd=1u as=0.1248p ps=1u w=0.48u l=0.6u
X24 ZN I VDD VNW pfet_05v0 ad=0.3782p pd=1.84u as=0.3782p ps=1.84u w=1.22u l=0.5u
X25 VSS I ZN VPW nfet_05v0 ad=0.1248p pd=1u as=0.1248p ps=1u w=0.48u l=0.6u
X26 ZN I VDD VNW pfet_05v0 ad=0.3782p pd=1.84u as=0.3782p ps=1.84u w=1.22u l=0.5u
X27 VSS I ZN VPW nfet_05v0 ad=0.1248p pd=1u as=0.1248p ps=1u w=0.48u l=0.6u
X28 VDD I ZN VNW pfet_05v0 ad=0.3782p pd=1.84u as=0.3782p ps=1.84u w=1.22u l=0.5u
X29 VDD I ZN VNW pfet_05v0 ad=0.3782p pd=1.84u as=0.3782p ps=1.84u w=1.22u l=0.5u
X30 VSS I ZN VPW nfet_05v0 ad=0.1248p pd=1u as=0.1248p ps=1u w=0.48u l=0.6u
X31 ZN I VDD VNW pfet_05v0 ad=0.3782p pd=1.84u as=0.3782p ps=1.84u w=1.22u l=0.5u
X32 ZN I VDD VNW pfet_05v0 ad=0.3782p pd=1.84u as=0.3782p ps=1.84u w=1.22u l=0.5u
X33 VSS I ZN VPW nfet_05v0 ad=0.1248p pd=1u as=0.1248p ps=1u w=0.48u l=0.6u
X34 ZN I VDD VNW pfet_05v0 ad=0.3782p pd=1.84u as=0.5368p ps=3.32u w=1.22u l=0.5u
X35 VDD I ZN VNW pfet_05v0 ad=0.3782p pd=1.84u as=0.3782p ps=1.84u w=1.22u l=0.5u
X36 VSS I ZN VPW nfet_05v0 ad=0.1248p pd=1u as=0.1248p ps=1u w=0.48u l=0.6u
X37 ZN I VSS VPW nfet_05v0 ad=0.1248p pd=1u as=0.1248p ps=1u w=0.48u l=0.6u
X38 ZN I VDD VNW pfet_05v0 ad=0.3782p pd=1.84u as=0.3782p ps=1.84u w=1.22u l=0.5u
X39 ZN I VSS VPW nfet_05v0 ad=0.1248p pd=1u as=0.1248p ps=1u w=0.48u l=0.6u
.ends

.subckt gf180mcu_fd_sc_mcu7t5v0__oai211_2 A1 A2 B C ZN VDD VNW VPW VSS
X0 a_1229_68# B a_36_68# VPW nfet_05v0 ad=0.1722p pd=1.24u as=0.21525p ps=1.345u w=0.82u l=0.6u
X1 VDD B ZN VNW pfet_05v0 ad=0.4334p pd=2.85u as=0.2561p ps=1.505u w=0.985u l=0.5u
X2 ZN A1 a_36_68# VPW nfet_05v0 ad=0.30965p pd=1.685u as=0.2132p ps=1.34u w=0.82u l=0.6u
X3 a_716_497# A1 ZN VNW pfet_05v0 ad=0.4599p pd=1.935u as=0.2847p ps=1.615u w=1.095u l=0.5u
X4 a_36_68# B a_1657_68# VPW nfet_05v0 ad=0.3608p pd=2.52u as=0.1312p ps=1.14u w=0.82u l=0.6u
X5 ZN A2 a_36_68# VPW nfet_05v0 ad=0.31215p pd=1.685u as=0.3608p ps=2.52u w=0.82u l=0.6u
X6 VDD A2 a_716_497# VNW pfet_05v0 ad=0.37905p pd=1.82u as=0.4599p ps=1.935u w=1.095u l=0.5u
X7 a_36_68# A1 ZN VPW nfet_05v0 ad=0.2132p pd=1.34u as=0.31215p ps=1.685u w=0.82u l=0.6u
X8 a_244_497# A2 VDD VNW pfet_05v0 ad=0.4599p pd=1.935u as=0.4818p ps=3.07u w=1.095u l=0.5u
X9 a_36_68# A2 ZN VPW nfet_05v0 ad=0.21525p pd=1.345u as=0.30965p ps=1.685u w=0.82u l=0.6u
X10 a_1657_68# C VSS VPW nfet_05v0 ad=0.1312p pd=1.14u as=0.2132p ps=1.34u w=0.82u l=0.6u
X11 ZN B VDD VNW pfet_05v0 ad=0.2561p pd=1.505u as=0.37905p ps=1.82u w=0.985u l=0.5u
X12 VDD C ZN VNW pfet_05v0 ad=0.2561p pd=1.505u as=0.2561p ps=1.505u w=0.985u l=0.5u
X13 VSS C a_1229_68# VPW nfet_05v0 ad=0.2132p pd=1.34u as=0.1722p ps=1.24u w=0.82u l=0.6u
X14 ZN A1 a_244_497# VNW pfet_05v0 ad=0.2847p pd=1.615u as=0.4599p ps=1.935u w=1.095u l=0.5u
X15 ZN C VDD VNW pfet_05v0 ad=0.2561p pd=1.505u as=0.2561p ps=1.505u w=0.985u l=0.5u
.ends

.subckt gf180mcu_fd_sc_mcu7t5v0__buf_12 I Z VDD VNW VPW VSS
X0 a_224_472# I VDD VNW pfet_05v0 ad=0.3782p pd=1.84u as=0.3782p ps=1.84u w=1.22u l=0.5u
X1 VDD a_224_472# Z VNW pfet_05v0 ad=0.3782p pd=1.84u as=0.3782p ps=1.84u w=1.22u l=0.5u
X2 Z a_224_472# VDD VNW pfet_05v0 ad=0.3782p pd=1.84u as=0.3782p ps=1.84u w=1.22u l=0.5u
X3 a_224_472# I VSS VPW nfet_05v0 ad=0.2132p pd=1.34u as=0.2132p ps=1.34u w=0.82u l=0.6u
X4 VSS a_224_472# Z VPW nfet_05v0 ad=0.2132p pd=1.34u as=0.2132p ps=1.34u w=0.82u l=0.6u
X5 VSS a_224_472# Z VPW nfet_05v0 ad=0.3608p pd=2.52u as=0.2132p ps=1.34u w=0.82u l=0.6u
X6 VDD I a_224_472# VNW pfet_05v0 ad=0.3782p pd=1.84u as=0.3782p ps=1.84u w=1.22u l=0.5u
X7 Z a_224_472# VDD VNW pfet_05v0 ad=0.3782p pd=1.84u as=0.3782p ps=1.84u w=1.22u l=0.5u
X8 a_224_472# I VSS VPW nfet_05v0 ad=0.2132p pd=1.34u as=0.3608p ps=2.52u w=0.82u l=0.6u
X9 Z a_224_472# VSS VPW nfet_05v0 ad=0.2132p pd=1.34u as=0.2132p ps=1.34u w=0.82u l=0.6u
X10 VSS a_224_472# Z VPW nfet_05v0 ad=0.2132p pd=1.34u as=0.2132p ps=1.34u w=0.82u l=0.6u
X11 VSS a_224_472# Z VPW nfet_05v0 ad=0.2132p pd=1.34u as=0.2132p ps=1.34u w=0.82u l=0.6u
X12 VDD a_224_472# Z VNW pfet_05v0 ad=0.3782p pd=1.84u as=0.3782p ps=1.84u w=1.22u l=0.5u
X13 Z a_224_472# VSS VPW nfet_05v0 ad=0.2132p pd=1.34u as=0.2132p ps=1.34u w=0.82u l=0.6u
X14 Z a_224_472# VSS VPW nfet_05v0 ad=0.2132p pd=1.34u as=0.2132p ps=1.34u w=0.82u l=0.6u
X15 Z a_224_472# VDD VNW pfet_05v0 ad=0.3782p pd=1.84u as=0.3782p ps=1.84u w=1.22u l=0.5u
X16 Z a_224_472# VSS VPW nfet_05v0 ad=0.2132p pd=1.34u as=0.2132p ps=1.34u w=0.82u l=0.6u
X17 VDD I a_224_472# VNW pfet_05v0 ad=0.3782p pd=1.84u as=0.3782p ps=1.84u w=1.22u l=0.5u
X18 VDD a_224_472# Z VNW pfet_05v0 ad=0.5368p pd=3.32u as=0.3782p ps=1.84u w=1.22u l=0.5u
X19 VDD a_224_472# Z VNW pfet_05v0 ad=0.3782p pd=1.84u as=0.3782p ps=1.84u w=1.22u l=0.5u
X20 Z a_224_472# VDD VNW pfet_05v0 ad=0.3782p pd=1.84u as=0.3782p ps=1.84u w=1.22u l=0.5u
X21 Z a_224_472# VSS VPW nfet_05v0 ad=0.2132p pd=1.34u as=0.2132p ps=1.34u w=0.82u l=0.6u
X22 a_224_472# I VDD VNW pfet_05v0 ad=0.3782p pd=1.84u as=0.3782p ps=1.84u w=1.22u l=0.5u
X23 VSS a_224_472# Z VPW nfet_05v0 ad=0.2132p pd=1.34u as=0.2132p ps=1.34u w=0.82u l=0.6u
X24 VDD I a_224_472# VNW pfet_05v0 ad=0.3782p pd=1.84u as=0.3782p ps=1.84u w=1.22u l=0.5u
X25 VSS I a_224_472# VPW nfet_05v0 ad=0.2132p pd=1.34u as=0.2132p ps=1.34u w=0.82u l=0.6u
X26 VDD a_224_472# Z VNW pfet_05v0 ad=0.3782p pd=1.84u as=0.3782p ps=1.84u w=1.22u l=0.5u
X27 VSS a_224_472# Z VPW nfet_05v0 ad=0.2132p pd=1.34u as=0.2132p ps=1.34u w=0.82u l=0.6u
X28 Z a_224_472# VDD VNW pfet_05v0 ad=0.3782p pd=1.84u as=0.3782p ps=1.84u w=1.22u l=0.5u
X29 VSS I a_224_472# VPW nfet_05v0 ad=0.2132p pd=1.34u as=0.2132p ps=1.34u w=0.82u l=0.6u
X30 a_224_472# I VDD VNW pfet_05v0 ad=0.3782p pd=1.84u as=0.5368p ps=3.32u w=1.22u l=0.5u
X31 VDD a_224_472# Z VNW pfet_05v0 ad=0.3782p pd=1.84u as=0.3782p ps=1.84u w=1.22u l=0.5u
X32 VSS I a_224_472# VPW nfet_05v0 ad=0.2132p pd=1.34u as=0.2132p ps=1.34u w=0.82u l=0.6u
X33 Z a_224_472# VSS VPW nfet_05v0 ad=0.2132p pd=1.34u as=0.2132p ps=1.34u w=0.82u l=0.6u
X34 Z a_224_472# VDD VNW pfet_05v0 ad=0.3782p pd=1.84u as=0.3782p ps=1.84u w=1.22u l=0.5u
X35 a_224_472# I VSS VPW nfet_05v0 ad=0.2132p pd=1.34u as=0.2132p ps=1.34u w=0.82u l=0.6u
.ends

.subckt gf180mcu_fd_sc_mcu7t5v0__or2_4 A1 A2 Z VDD VNW VPW VSS
X0 Z a_244_68# VSS VPW nfet_05v0 ad=0.2132p pd=1.34u as=0.2706p ps=1.48u w=0.82u l=0.6u
X1 a_244_68# A1 VSS VPW nfet_05v0 ad=0.2132p pd=1.34u as=0.2132p ps=1.34u w=0.82u l=0.6u
X2 VSS a_244_68# Z VPW nfet_05v0 ad=0.3608p pd=2.52u as=0.2132p ps=1.34u w=0.82u l=0.6u
X3 a_244_68# A2 VSS VPW nfet_05v0 ad=0.2132p pd=1.34u as=0.3608p ps=2.52u w=0.82u l=0.6u
X4 a_244_68# A1 a_244_472# VNW pfet_05v0 ad=0.3782p pd=1.84u as=0.3477p ps=1.79u w=1.22u l=0.5u
X5 VSS a_244_68# Z VPW nfet_05v0 ad=0.2132p pd=1.34u as=0.2132p ps=1.34u w=0.82u l=0.6u
X6 a_244_472# A2 VDD VNW pfet_05v0 ad=0.3477p pd=1.79u as=0.5368p ps=3.32u w=1.22u l=0.5u
X7 VDD a_244_68# Z VNW pfet_05v0 ad=0.5368p pd=3.32u as=0.3477p ps=1.79u w=1.22u l=0.5u
X8 VDD a_244_68# Z VNW pfet_05v0 ad=0.3477p pd=1.79u as=0.3782p ps=1.84u w=1.22u l=0.5u
X9 VDD A2 a_682_472# VNW pfet_05v0 ad=0.5246p pd=2.08u as=0.3477p ps=1.79u w=1.22u l=0.5u
X10 Z a_244_68# VDD VNW pfet_05v0 ad=0.3477p pd=1.79u as=0.3477p ps=1.79u w=1.22u l=0.5u
X11 a_682_472# A1 a_244_68# VNW pfet_05v0 ad=0.3477p pd=1.79u as=0.3782p ps=1.84u w=1.22u l=0.5u
X12 VSS A2 a_244_68# VPW nfet_05v0 ad=0.2706p pd=1.48u as=0.2132p ps=1.34u w=0.82u l=0.6u
X13 VSS A1 a_244_68# VPW nfet_05v0 ad=0.2132p pd=1.34u as=0.2132p ps=1.34u w=0.82u l=0.6u
X14 Z a_244_68# VDD VNW pfet_05v0 ad=0.3782p pd=1.84u as=0.5246p ps=2.08u w=1.22u l=0.5u
X15 Z a_244_68# VSS VPW nfet_05v0 ad=0.2132p pd=1.34u as=0.2132p ps=1.34u w=0.82u l=0.6u
.ends

.subckt gf180mcu_fd_sc_mcu7t5v0__aoi211_4 A1 A2 B C ZN VDD VNW VPW VSS
X0 a_170_472# B a_3662_472# VNW pfet_05v0 ad=0.5978p pd=3.42u as=0.3172p ps=1.74u w=1.22u l=0.5u
X1 a_1194_69# A2 VSS VPW nfet_05v0 ad=0.1232p pd=1.09u as=0.2002p ps=1.29u w=0.77u l=0.6u
X2 ZN A1 a_1194_69# VPW nfet_05v0 ad=0.2002p pd=1.29u as=0.1232p ps=1.09u w=0.77u l=0.6u
X3 VSS C ZN VPW nfet_05v0 ad=0.2541p pd=1.605u as=0.1196p ps=0.98u w=0.46u l=0.6u
X4 a_170_472# A1 ZN VNW pfet_05v0 ad=0.3172p pd=1.74u as=0.3172p ps=1.74u w=1.22u l=0.5u
X5 ZN B VSS VPW nfet_05v0 ad=0.1196p pd=0.98u as=0.2384p ps=1.51u w=0.46u l=0.6u
X6 a_3126_472# B a_170_472# VNW pfet_05v0 ad=0.3172p pd=1.74u as=0.7076p ps=2.38u w=1.22u l=0.5u
X7 ZN A1 a_170_472# VNW pfet_05v0 ad=0.3172p pd=1.74u as=0.3172p ps=1.74u w=1.22u l=0.5u
X8 ZN A1 a_358_69# VPW nfet_05v0 ad=0.2002p pd=1.29u as=0.1617p ps=1.19u w=0.77u l=0.6u
X9 ZN C VSS VPW nfet_05v0 ad=0.1196p pd=0.98u as=0.2541p ps=1.605u w=0.46u l=0.6u
X10 VDD C a_3126_472# VNW pfet_05v0 ad=0.7076p pd=2.38u as=0.3172p ps=1.74u w=1.22u l=0.5u
X11 VSS A2 a_1602_69# VPW nfet_05v0 ad=0.2384p pd=1.51u as=0.1232p ps=1.09u w=0.77u l=0.6u
X12 VSS B ZN VPW nfet_05v0 ad=0.2541p pd=1.605u as=0.1196p ps=0.98u w=0.46u l=0.6u
X13 a_1602_69# A1 ZN VPW nfet_05v0 ad=0.1232p pd=1.09u as=0.2002p ps=1.29u w=0.77u l=0.6u
X14 a_170_472# A2 ZN VNW pfet_05v0 ad=0.4514p pd=1.96u as=0.3172p ps=1.74u w=1.22u l=0.5u
X15 a_2034_472# B a_170_472# VNW pfet_05v0 ad=0.3782p pd=1.84u as=0.4514p ps=1.96u w=1.22u l=0.5u
X16 a_2590_472# C VDD VNW pfet_05v0 ad=0.3172p pd=1.74u as=0.7076p ps=2.38u w=1.22u l=0.5u
X17 a_358_69# A2 VSS VPW nfet_05v0 ad=0.1617p pd=1.19u as=0.4466p ps=2.7u w=0.77u l=0.6u
X18 VSS A2 a_786_69# VPW nfet_05v0 ad=0.2002p pd=1.29u as=0.1232p ps=1.09u w=0.77u l=0.6u
X19 a_170_472# B a_2590_472# VNW pfet_05v0 ad=0.7076p pd=2.38u as=0.3172p ps=1.74u w=1.22u l=0.5u
X20 VSS C ZN VPW nfet_05v0 ad=0.264p pd=1.66u as=0.1196p ps=0.98u w=0.46u l=0.6u
X21 ZN B VSS VPW nfet_05v0 ad=0.1196p pd=0.98u as=0.2541p ps=1.605u w=0.46u l=0.6u
X22 ZN A2 a_170_472# VNW pfet_05v0 ad=0.3172p pd=1.74u as=0.5368p ps=3.32u w=1.22u l=0.5u
X23 a_170_472# A1 ZN VNW pfet_05v0 ad=0.3172p pd=1.74u as=0.3172p ps=1.74u w=1.22u l=0.5u
X24 ZN C VSS VPW nfet_05v0 ad=0.1196p pd=0.98u as=0.264p ps=1.66u w=0.46u l=0.6u
X25 VDD C a_2034_472# VNW pfet_05v0 ad=0.7076p pd=2.38u as=0.3782p ps=1.84u w=1.22u l=0.5u
X26 ZN A1 a_170_472# VNW pfet_05v0 ad=0.3172p pd=1.74u as=0.3172p ps=1.74u w=1.22u l=0.5u
X27 a_170_472# A2 ZN VNW pfet_05v0 ad=0.3172p pd=1.74u as=0.3172p ps=1.74u w=1.22u l=0.5u
X28 VSS B ZN VPW nfet_05v0 ad=0.2024p pd=1.8u as=0.1196p ps=0.98u w=0.46u l=0.6u
X29 a_786_69# A1 ZN VPW nfet_05v0 ad=0.1232p pd=1.09u as=0.2002p ps=1.29u w=0.77u l=0.6u
X30 a_3662_472# C VDD VNW pfet_05v0 ad=0.3172p pd=1.74u as=0.7076p ps=2.38u w=1.22u l=0.5u
X31 ZN A2 a_170_472# VNW pfet_05v0 ad=0.3172p pd=1.74u as=0.3172p ps=1.74u w=1.22u l=0.5u
.ends

.subckt NanoCGRA_Lite clk rst_n uart_rx uart_tx
X_7963_ _9897_/Q _7962_/Z _7981_/B PHY_9/VDD PHY_9/VDD VSUBS VSUBS gf180mcu_fd_sc_mcu7t5v0__and2_1
X_9702_ _9702_/D _9940_/CLK _9702_/Q PHY_9/VDD PHY_9/VDD VSUBS VSUBS gf180mcu_fd_sc_mcu7t5v0__dffq_1
X_6914_ _6914_/A1 _6914_/A2 _6991_/A2 PHY_9/VDD PHY_9/VDD VSUBS VSUBS gf180mcu_fd_sc_mcu7t5v0__nand2_2
X_7894_ _9810_/Q _7771_/Z _7899_/A2 PHY_9/VDD PHY_9/VDD VSUBS VSUBS gf180mcu_fd_sc_mcu7t5v0__nand2_1
X_6845_ _6845_/A1 _6845_/A2 _6847_/A2 PHY_9/VDD PHY_9/VDD VSUBS VSUBS gf180mcu_fd_sc_mcu7t5v0__nand2_1
X_9633_ _9633_/D _9948_/CLK _9633_/Q PHY_9/VDD PHY_9/VDD VSUBS VSUBS gf180mcu_fd_sc_mcu7t5v0__dffq_1
X_6776_ _9807_/Q _6966_/A2 _6777_/I PHY_9/VDD PHY_9/VDD VSUBS VSUBS gf180mcu_fd_sc_mcu7t5v0__nand2_1
X_9564_ _9564_/D _9801_/CLK _9564_/Q PHY_9/VDD PHY_9/VDD VSUBS VSUBS gf180mcu_fd_sc_mcu7t5v0__dffq_1
X_8515_ _8516_/A1 _8516_/A2 _8515_/Z PHY_9/VDD PHY_9/VDD VSUBS VSUBS gf180mcu_fd_sc_mcu7t5v0__or2_1
X_5727_ _5406_/Z _5727_/A2 _5727_/B1 _5727_/B2 _9565_/D PHY_9/VDD PHY_9/VDD VSUBS
+ VSUBS gf180mcu_fd_sc_mcu7t5v0__oai22_1
X_9495_ _9495_/D _9901_/CLK _9495_/Q PHY_9/VDD PHY_9/VDD VSUBS VSUBS gf180mcu_fd_sc_mcu7t5v0__dffq_1
X_8446_ _9227_/A1 _8446_/A2 _8485_/A1 PHY_9/VDD PHY_9/VDD VSUBS VSUBS gf180mcu_fd_sc_mcu7t5v0__nor2_1
X_5658_ _5961_/B _5831_/A2 _5658_/A3 _5659_/I PHY_9/VDD PHY_9/VDD VSUBS VSUBS gf180mcu_fd_sc_mcu7t5v0__nand3_4
X_8377_ _8389_/A1 _9921_/Q _8390_/A3 _8634_/A1 PHY_9/VDD PHY_9/VDD VSUBS VSUBS gf180mcu_fd_sc_mcu7t5v0__nand3_4
X_5589_ _9496_/Q _5594_/A1 _6089_/B _5590_/B PHY_9/VDD PHY_9/VDD VSUBS VSUBS gf180mcu_fd_sc_mcu7t5v0__oai21_1
X_7328_ _6089_/B _7336_/A2 _7336_/B1 PHY_9/VDD PHY_9/VDD VSUBS VSUBS gf180mcu_fd_sc_mcu7t5v0__nand2_2
X_7259_ _7296_/A1 _7259_/A2 _7257_/B _7259_/Z PHY_9/VDD PHY_9/VDD VSUBS VSUBS gf180mcu_fd_sc_mcu7t5v0__xor3_1
X_4960_ _9780_/Q _6298_/B2 PHY_9/VDD PHY_9/VDD VSUBS VSUBS gf180mcu_fd_sc_mcu7t5v0__clkinv_1
X_4891_ _9912_/Q _8346_/B2 PHY_9/VDD PHY_9/VDD VSUBS VSUBS gf180mcu_fd_sc_mcu7t5v0__clkinv_1
X_6630_ _9807_/Q _6650_/A3 _6633_/A2 PHY_9/VDD PHY_9/VDD VSUBS VSUBS gf180mcu_fd_sc_mcu7t5v0__nand2_1
X_6561_ _6611_/C _6556_/Z _6561_/B _6562_/C PHY_9/VDD PHY_9/VDD VSUBS VSUBS gf180mcu_fd_sc_mcu7t5v0__aoi21_1
X_5512_ _9430_/Q _9725_/Q _5522_/A2 _5513_/C PHY_9/VDD PHY_9/VDD VSUBS VSUBS gf180mcu_fd_sc_mcu7t5v0__and3_1
X_8300_ _9813_/Q _8300_/A2 _8300_/B1 _8301_/A2 _8300_/C _8301_/B PHY_9/VDD PHY_9/VDD
+ VSUBS VSUBS gf180mcu_fd_sc_mcu7t5v0__aoi221_1
X_6492_ _9811_/Q _6584_/B1 _6535_/A1 PHY_9/VDD PHY_9/VDD VSUBS VSUBS gf180mcu_fd_sc_mcu7t5v0__nand2_1
X_9280_ _9279_/B _9280_/A2 _9335_/B2 _9280_/Z PHY_9/VDD PHY_9/VDD VSUBS VSUBS gf180mcu_fd_sc_mcu7t5v0__xor3_1
X_8231_ _8232_/A1 _8256_/A3 _8231_/Z PHY_9/VDD PHY_9/VDD VSUBS VSUBS gf180mcu_fd_sc_mcu7t5v0__xor2_1
X_5443_ _9434_/Q _5458_/A2 _9031_/B _5444_/B PHY_9/VDD PHY_9/VDD VSUBS VSUBS gf180mcu_fd_sc_mcu7t5v0__oai21_1
X_5374_ _9491_/Q _5560_/A2 _5572_/A2 PHY_9/VDD PHY_9/VDD VSUBS VSUBS gf180mcu_fd_sc_mcu7t5v0__nand2_2
X_8162_ _8162_/A1 _8162_/A2 _8162_/B _8209_/A1 PHY_9/VDD PHY_9/VDD VSUBS VSUBS gf180mcu_fd_sc_mcu7t5v0__oai21_1
X_7113_ _9810_/Q _7254_/A2 _7158_/A2 PHY_9/VDD PHY_9/VDD VSUBS VSUBS gf180mcu_fd_sc_mcu7t5v0__nand2_1
X_8093_ _8093_/A1 _8093_/A2 _8093_/A3 _8092_/Z _8330_/B _8095_/A2 PHY_9/VDD PHY_9/VDD
+ VSUBS VSUBS gf180mcu_fd_sc_mcu7t5v0__oai32_1
X_7044_ _7145_/B _9507_/Q _7045_/C PHY_9/VDD PHY_9/VDD VSUBS VSUBS gf180mcu_fd_sc_mcu7t5v0__nor2_1
X_8995_ _9328_/A1 _8719_/C _8995_/B1 _8995_/B2 _9023_/B1 PHY_9/VDD PHY_9/VDD VSUBS
+ VSUBS gf180mcu_fd_sc_mcu7t5v0__aoi22_4
X_7946_ _7953_/A1 _7953_/A2 _7954_/A2 PHY_9/VDD PHY_9/VDD VSUBS VSUBS gf180mcu_fd_sc_mcu7t5v0__nand2_1
X_7877_ _7977_/A1 _7859_/Z _7877_/B _7877_/C _7878_/A2 PHY_9/VDD PHY_9/VDD VSUBS VSUBS
+ gf180mcu_fd_sc_mcu7t5v0__aoi211_1
X_6828_ _6828_/A1 _6828_/A2 _6828_/A3 _6828_/Z PHY_9/VDD PHY_9/VDD VSUBS VSUBS gf180mcu_fd_sc_mcu7t5v0__xor3_1
X_9616_ _9616_/D _9948_/CLK _9616_/Q PHY_9/VDD PHY_9/VDD VSUBS VSUBS gf180mcu_fd_sc_mcu7t5v0__dffq_1
X_6759_ _9809_/Q _6974_/A2 _6764_/B2 PHY_9/VDD PHY_9/VDD VSUBS VSUBS gf180mcu_fd_sc_mcu7t5v0__nor2_1
X_9547_ _9547_/D _9800_/CLK _9547_/Q PHY_9/VDD PHY_9/VDD VSUBS VSUBS gf180mcu_fd_sc_mcu7t5v0__dffq_1
X_9478_ _9478_/D _9689_/CLK _9478_/Q PHY_9/VDD PHY_9/VDD VSUBS VSUBS gf180mcu_fd_sc_mcu7t5v0__dffq_2
X_8429_ _9956_/Q _8647_/A2 _9923_/Q _8430_/B2 PHY_9/VDD PHY_9/VDD VSUBS VSUBS gf180mcu_fd_sc_mcu7t5v0__oai21_2
X_5090_ _9712_/Q _6007_/B2 PHY_9/VDD PHY_9/VDD VSUBS VSUBS gf180mcu_fd_sc_mcu7t5v0__clkinv_1
X_5992_ _8691_/A1 _5998_/A2 _5998_/B1 _5992_/B2 _9699_/D PHY_9/VDD PHY_9/VDD VSUBS
+ VSUBS gf180mcu_fd_sc_mcu7t5v0__oai22_1
X_8780_ _9969_/Q _9953_/Q _9952_/Q _8781_/B PHY_9/VDD PHY_9/VDD VSUBS VSUBS gf180mcu_fd_sc_mcu7t5v0__nand3_1
X_7800_ _9957_/Q _9873_/Q _9839_/Q _9907_/Q _9890_/Q _9889_/Q _7800_/Z PHY_9/VDD PHY_9/VDD
+ VSUBS VSUBS gf180mcu_fd_sc_mcu7t5v0__mux4_4
X_4943_ _9756_/Q _6044_/B2 PHY_9/VDD PHY_9/VDD VSUBS VSUBS gf180mcu_fd_sc_mcu7t5v0__clkinv_1
X_7731_ _8720_/A2 _9356_/C _9357_/B _7731_/C _9891_/D PHY_9/VDD PHY_9/VDD VSUBS VSUBS
+ gf180mcu_fd_sc_mcu7t5v0__aoi211_1
X_7662_ _7662_/A1 _7662_/A2 _7661_/Z _7662_/Z PHY_9/VDD PHY_9/VDD VSUBS VSUBS gf180mcu_fd_sc_mcu7t5v0__xor3_1
X_6613_ _6649_/B _6613_/A2 _6613_/B _6615_/A2 PHY_9/VDD PHY_9/VDD VSUBS VSUBS gf180mcu_fd_sc_mcu7t5v0__aoi21_1
X_4874_ _9550_/Q _5708_/B2 PHY_9/VDD PHY_9/VDD VSUBS VSUBS gf180mcu_fd_sc_mcu7t5v0__clkinv_1
X_9401_ _9401_/D _9856_/CLK _9401_/Q PHY_9/VDD PHY_9/VDD VSUBS VSUBS gf180mcu_fd_sc_mcu7t5v0__dffq_1
X_7593_ _9812_/Q _7382_/Z _7645_/A1 PHY_9/VDD PHY_9/VDD VSUBS VSUBS gf180mcu_fd_sc_mcu7t5v0__nand2_1
X_6544_ _6545_/A1 _6543_/Z _6599_/A2 PHY_9/VDD PHY_9/VDD VSUBS VSUBS gf180mcu_fd_sc_mcu7t5v0__nor2_1
X_9332_ _9332_/A1 _9332_/A2 _9332_/Z PHY_9/VDD PHY_9/VDD VSUBS VSUBS gf180mcu_fd_sc_mcu7t5v0__xor2_1
X_6475_ _6475_/A1 _6475_/A2 _6476_/C PHY_9/VDD PHY_9/VDD VSUBS VSUBS gf180mcu_fd_sc_mcu7t5v0__nand2_1
X_9263_ _9343_/B _9263_/A2 _9263_/A3 _9263_/A4 _9264_/B PHY_9/VDD PHY_9/VDD VSUBS
+ VSUBS gf180mcu_fd_sc_mcu7t5v0__nand4_1
X_8214_ _9807_/Q _8316_/A2 _8214_/Z PHY_9/VDD PHY_9/VDD VSUBS VSUBS gf180mcu_fd_sc_mcu7t5v0__and2_1
X_5426_ _9731_/Q _5486_/A1 _5426_/B _9430_/D PHY_9/VDD PHY_9/VDD VSUBS VSUBS gf180mcu_fd_sc_mcu7t5v0__aoi21_1
X_9194_ _9183_/Z _9222_/A2 _9194_/Z PHY_9/VDD PHY_9/VDD VSUBS VSUBS gf180mcu_fd_sc_mcu7t5v0__and2_1
X_5357_ _9461_/Q _5364_/A2 _9035_/B _5358_/B PHY_9/VDD PHY_9/VDD VSUBS VSUBS gf180mcu_fd_sc_mcu7t5v0__oai21_1
X_8145_ _8145_/A1 _8113_/Z _8145_/B _8151_/A1 PHY_9/VDD PHY_9/VDD VSUBS VSUBS gf180mcu_fd_sc_mcu7t5v0__oai21_1
X_5288_ _5288_/A1 _5296_/A2 _5288_/B _9383_/D PHY_9/VDD PHY_9/VDD VSUBS VSUBS gf180mcu_fd_sc_mcu7t5v0__aoi21_1
X_8076_ _8074_/Z _8076_/A2 _9091_/B _8108_/B PHY_9/VDD PHY_9/VDD VSUBS VSUBS gf180mcu_fd_sc_mcu7t5v0__aoi21_1
X_7027_ _9845_/Q _9844_/Q _7182_/A1 PHY_9/VDD PHY_9/VDD VSUBS VSUBS gf180mcu_fd_sc_mcu7t5v0__nand2_1
X_8978_ _9813_/Q _8977_/Z _8978_/Z PHY_9/VDD PHY_9/VDD VSUBS VSUBS gf180mcu_fd_sc_mcu7t5v0__xor2_1
X_7929_ _9357_/B _7929_/A2 _9896_/D PHY_9/VDD PHY_9/VDD VSUBS VSUBS gf180mcu_fd_sc_mcu7t5v0__nor2_1
X_6260_ _5372_/Z _6260_/A2 _6260_/B1 _6291_/B2 _6263_/A1 PHY_9/VDD PHY_9/VDD VSUBS
+ VSUBS gf180mcu_fd_sc_mcu7t5v0__aoi22_1
X_6191_ _9530_/Q _6288_/A2 _6288_/B1 _9718_/Q _6192_/A2 PHY_9/VDD PHY_9/VDD VSUBS
+ VSUBS gf180mcu_fd_sc_mcu7t5v0__aoi22_1
X_5211_ _5459_/A1 _5495_/A2 _9458_/Q _5973_/C _9724_/D PHY_9/VDD PHY_9/VDD VSUBS VSUBS
+ gf180mcu_fd_sc_mcu7t5v0__nor4_1
X_5142_ _9457_/Q _9456_/Q _9455_/Q _9454_/Q _5145_/A2 PHY_9/VDD PHY_9/VDD VSUBS VSUBS
+ gf180mcu_fd_sc_mcu7t5v0__nor4_2
X_5073_ _9744_/Q _6028_/B2 PHY_9/VDD PHY_9/VDD VSUBS VSUBS gf180mcu_fd_sc_mcu7t5v0__clkinv_1
X_9950_ _9950_/D _9974_/CLK _9950_/Q PHY_9/VDD PHY_9/VDD VSUBS VSUBS gf180mcu_fd_sc_mcu7t5v0__dffq_2
X_9881_ _9881_/D _9948_/CLK _9881_/Q PHY_9/VDD PHY_9/VDD VSUBS VSUBS gf180mcu_fd_sc_mcu7t5v0__dffq_1
X_8901_ _8903_/A1 _8903_/A3 _8946_/B PHY_9/VDD PHY_9/VDD VSUBS VSUBS gf180mcu_fd_sc_mcu7t5v0__nor2_1
X_8832_ _8832_/A1 _8752_/I _8784_/I _8925_/A2 PHY_9/VDD PHY_9/VDD VSUBS VSUBS gf180mcu_fd_sc_mcu7t5v0__nand3_1
X_8763_ _9091_/B _8752_/I _8763_/B _8769_/C PHY_9/VDD PHY_9/VDD VSUBS VSUBS gf180mcu_fd_sc_mcu7t5v0__aoi21_1
X_5975_ _9688_/Q _5972_/I _5975_/Z PHY_9/VDD PHY_9/VDD VSUBS VSUBS gf180mcu_fd_sc_mcu7t5v0__xor2_1
X_8694_ _5399_/Z _8697_/A2 _8697_/B1 _8694_/B2 _9945_/D PHY_9/VDD PHY_9/VDD VSUBS
+ VSUBS gf180mcu_fd_sc_mcu7t5v0__oai22_1
X_4926_ _9824_/Q _6659_/B2 PHY_9/VDD PHY_9/VDD VSUBS VSUBS gf180mcu_fd_sc_mcu7t5v0__clkinv_1
X_7714_ _9888_/Q _7724_/A2 _8008_/I0 PHY_9/VDD PHY_9/VDD VSUBS VSUBS gf180mcu_fd_sc_mcu7t5v0__nor2_2
X_4857_ _9407_/Q _5342_/A1 PHY_9/VDD PHY_9/VDD VSUBS VSUBS gf180mcu_fd_sc_mcu7t5v0__clkinv_1
X_7645_ _7645_/A1 _7645_/A2 _7645_/B _7661_/A2 PHY_9/VDD PHY_9/VDD VSUBS VSUBS gf180mcu_fd_sc_mcu7t5v0__oai21_1
X_7576_ _7576_/A1 _7576_/A2 _7576_/B _7631_/A2 PHY_9/VDD PHY_9/VDD VSUBS VSUBS gf180mcu_fd_sc_mcu7t5v0__aoi21_1
X_6527_ _9809_/Q _6577_/A2 _6578_/A2 PHY_9/VDD PHY_9/VDD VSUBS VSUBS gf180mcu_fd_sc_mcu7t5v0__nand2_1
X_4788_ _9822_/Q _7651_/A1 PHY_9/VDD PHY_9/VDD VSUBS VSUBS gf180mcu_fd_sc_mcu7t5v0__clkinv_2
X_9315_ _9813_/Q _9351_/A2 _9315_/B _9316_/A4 PHY_9/VDD PHY_9/VDD VSUBS VSUBS gf180mcu_fd_sc_mcu7t5v0__oai21_1
X_6458_ _6487_/A1 _6458_/A2 _6458_/A3 _6499_/A2 PHY_9/VDD PHY_9/VDD VSUBS VSUBS gf180mcu_fd_sc_mcu7t5v0__xnor3_1
X_9246_ _9246_/A1 _9245_/Z _9267_/A2 PHY_9/VDD PHY_9/VDD VSUBS VSUBS gf180mcu_fd_sc_mcu7t5v0__xnor2_1
X_6389_ _6648_/A1 _6389_/A2 _9802_/Q _6646_/B PHY_9/VDD PHY_9/VDD VSUBS VSUBS gf180mcu_fd_sc_mcu7t5v0__nand3_4
X_9177_ _9177_/A1 _9152_/Z _9177_/B _9297_/A1 PHY_9/VDD PHY_9/VDD VSUBS VSUBS gf180mcu_fd_sc_mcu7t5v0__aoi21_2
X_5409_ _9731_/Q _5478_/A1 _5409_/B _9426_/D PHY_9/VDD PHY_9/VDD VSUBS VSUBS gf180mcu_fd_sc_mcu7t5v0__aoi21_1
X_8128_ _9807_/Q _8311_/A2 _8129_/I PHY_9/VDD PHY_9/VDD VSUBS VSUBS gf180mcu_fd_sc_mcu7t5v0__nand2_1
X_8059_ _9090_/C _8309_/A2 _8059_/B1 _8059_/B2 _8156_/B _8062_/B PHY_9/VDD PHY_9/VDD
+ VSUBS VSUBS gf180mcu_fd_sc_mcu7t5v0__aoi221_1
X_5760_ _8344_/A1 _8678_/A2 _5769_/A2 PHY_9/VDD PHY_9/VDD VSUBS VSUBS gf180mcu_fd_sc_mcu7t5v0__nand2_4
X_5691_ _9545_/Q _5687_/Z _5700_/B _5692_/A2 PHY_9/VDD PHY_9/VDD VSUBS VSUBS gf180mcu_fd_sc_mcu7t5v0__oai21_1
X_4711_ _9929_/Q _8540_/A1 PHY_9/VDD PHY_9/VDD VSUBS VSUBS gf180mcu_fd_sc_mcu7t5v0__clkinv_2
X_7430_ _7657_/A2 _7430_/A2 _7430_/Z PHY_9/VDD PHY_9/VDD VSUBS VSUBS gf180mcu_fd_sc_mcu7t5v0__xor2_1
X_7361_ _9866_/Q _9865_/Q _7367_/A2 PHY_9/VDD PHY_9/VDD VSUBS VSUBS gf180mcu_fd_sc_mcu7t5v0__nand2_4
X_7292_ _7297_/A2 _7292_/A2 _7292_/Z PHY_9/VDD PHY_9/VDD VSUBS VSUBS gf180mcu_fd_sc_mcu7t5v0__xor2_1
X_6312_ _5404_/Z _6313_/A2 _6313_/B1 _6312_/B2 _9792_/D PHY_9/VDD PHY_9/VDD VSUBS
+ VSUBS gf180mcu_fd_sc_mcu7t5v0__oai22_1
X_9100_ _9968_/Q _9317_/C _9100_/B _9101_/B PHY_9/VDD PHY_9/VDD VSUBS VSUBS gf180mcu_fd_sc_mcu7t5v0__oai21_1
X_6243_ _9637_/Q _6288_/A2 _6288_/B1 _9621_/Q _6244_/A2 PHY_9/VDD PHY_9/VDD VSUBS
+ VSUBS gf180mcu_fd_sc_mcu7t5v0__aoi22_1
X_9031_ _9360_/Q _9036_/A2 _9031_/B _9032_/B PHY_9/VDD PHY_9/VDD VSUBS VSUBS gf180mcu_fd_sc_mcu7t5v0__oai21_1
X_6174_ _6283_/B2 _6174_/A2 _6174_/B1 _6656_/A2 _6174_/C1 _6291_/B2 _6176_/A2 PHY_9/VDD
+ PHY_9/VDD VSUBS VSUBS gf180mcu_fd_sc_mcu7t5v0__aoi222_2
X_5125_ _9606_/Q _5782_/B2 PHY_9/VDD PHY_9/VDD VSUBS VSUBS gf180mcu_fd_sc_mcu7t5v0__clkinv_1
X_9933_ _9933_/D _9940_/CLK _9933_/Q PHY_9/VDD PHY_9/VDD VSUBS VSUBS gf180mcu_fd_sc_mcu7t5v0__dffq_1
X_5056_ _9783_/Q _6301_/B2 PHY_9/VDD PHY_9/VDD VSUBS VSUBS gf180mcu_fd_sc_mcu7t5v0__clkinv_1
X_9864_ _9864_/D _9948_/CLK _9864_/Q PHY_9/VDD PHY_9/VDD VSUBS VSUBS gf180mcu_fd_sc_mcu7t5v0__dffq_1
X_8815_ _8815_/I _8852_/A2 PHY_9/VDD PHY_9/VDD VSUBS VSUBS gf180mcu_fd_sc_mcu7t5v0__clkinv_1
X_9795_ _9795_/D _9801_/CLK _9795_/Q PHY_9/VDD PHY_9/VDD VSUBS VSUBS gf180mcu_fd_sc_mcu7t5v0__dffq_1
X_5958_ _5958_/A1 _5973_/A2 _5958_/B _9681_/D PHY_9/VDD PHY_9/VDD VSUBS VSUBS gf180mcu_fd_sc_mcu7t5v0__aoi21_1
X_8746_ _8746_/I _9954_/D PHY_9/VDD PHY_9/VDD VSUBS VSUBS gf180mcu_fd_sc_mcu7t5v0__clkinv_1
X_4909_ _9787_/Q _6307_/B2 PHY_9/VDD PHY_9/VDD VSUBS VSUBS gf180mcu_fd_sc_mcu7t5v0__clkinv_1
X_5889_ _5967_/B _5889_/A2 _5907_/A1 PHY_9/VDD PHY_9/VDD VSUBS VSUBS gf180mcu_fd_sc_mcu7t5v0__nand2_1
X_8677_ _8677_/A1 _9356_/C _8677_/B1 _8677_/B2 _9357_/B _9932_/D PHY_9/VDD PHY_9/VDD
+ VSUBS VSUBS gf180mcu_fd_sc_mcu7t5v0__aoi221_1
X_7628_ _9813_/Q _7627_/Z _7669_/A1 PHY_9/VDD PHY_9/VDD VSUBS VSUBS gf180mcu_fd_sc_mcu7t5v0__nand2_1
X_7559_ _7544_/Z _7559_/A2 _7559_/Z PHY_9/VDD PHY_9/VDD VSUBS VSUBS gf180mcu_fd_sc_mcu7t5v0__and2_1
X_9229_ _9809_/Q _9178_/Z _9280_/A2 PHY_9/VDD PHY_9/VDD VSUBS VSUBS gf180mcu_fd_sc_mcu7t5v0__nand2_1
X_6930_ _6931_/A1 _6931_/A3 _6930_/Z PHY_9/VDD PHY_9/VDD VSUBS VSUBS gf180mcu_fd_sc_mcu7t5v0__and2_1
X_6861_ _9841_/Q _9356_/C _6909_/A1 PHY_9/VDD PHY_9/VDD VSUBS VSUBS gf180mcu_fd_sc_mcu7t5v0__nand2_1
X_9580_ _9580_/D _9939_/CLK _9580_/Q PHY_9/VDD PHY_9/VDD VSUBS VSUBS gf180mcu_fd_sc_mcu7t5v0__dffq_1
X_6792_ _9839_/Q _6791_/Z _6812_/B PHY_9/VDD PHY_9/VDD VSUBS VSUBS gf180mcu_fd_sc_mcu7t5v0__and2_1
X_5812_ _8695_/A1 _5814_/A2 _5814_/B1 _5812_/B2 _9628_/D PHY_9/VDD PHY_9/VDD VSUBS
+ VSUBS gf180mcu_fd_sc_mcu7t5v0__oai22_1
X_8600_ _9810_/Q _8600_/A2 _8657_/A2 PHY_9/VDD PHY_9/VDD VSUBS VSUBS gf180mcu_fd_sc_mcu7t5v0__nand2_1
X_5743_ _8691_/A1 _5749_/A2 _5749_/B1 _5743_/B2 _9575_/D PHY_9/VDD PHY_9/VDD VSUBS
+ VSUBS gf180mcu_fd_sc_mcu7t5v0__oai22_1
X_8531_ _8531_/A1 _8529_/Z _8580_/A2 PHY_9/VDD PHY_9/VDD VSUBS VSUBS gf180mcu_fd_sc_mcu7t5v0__nand2_1
X_5674_ _5659_/I _5674_/A2 _5673_/Z _9539_/D PHY_9/VDD PHY_9/VDD VSUBS VSUBS gf180mcu_fd_sc_mcu7t5v0__nor3_1
X_8462_ _8647_/A2 _9501_/Q _9923_/Q _8463_/C PHY_9/VDD PHY_9/VDD VSUBS VSUBS gf180mcu_fd_sc_mcu7t5v0__aoi21_2
X_7413_ _7413_/I _7490_/A1 PHY_9/VDD PHY_9/VDD VSUBS VSUBS gf180mcu_fd_sc_mcu7t5v0__clkinv_1
X_8393_ _9925_/Q _8422_/A2 _8423_/A1 PHY_9/VDD PHY_9/VDD VSUBS VSUBS gf180mcu_fd_sc_mcu7t5v0__nand2_1
X_7344_ _7604_/B1 _9034_/A2 _7344_/B _9868_/D PHY_9/VDD PHY_9/VDD VSUBS VSUBS gf180mcu_fd_sc_mcu7t5v0__aoi21_1
X_7275_ _9813_/Q _7274_/Z _7318_/A1 PHY_9/VDD PHY_9/VDD VSUBS VSUBS gf180mcu_fd_sc_mcu7t5v0__nand2_1
X_6226_ _9783_/Q _6288_/A2 _6288_/B1 _9828_/Q _6227_/A2 PHY_9/VDD PHY_9/VDD VSUBS
+ VSUBS gf180mcu_fd_sc_mcu7t5v0__aoi22_1
X_9014_ _8842_/B _9013_/Z _9026_/B1 PHY_9/VDD PHY_9/VDD VSUBS VSUBS gf180mcu_fd_sc_mcu7t5v0__nand2_1
X_6157_ _6157_/A1 _6157_/A2 _6173_/B1 PHY_9/VDD PHY_9/VDD VSUBS VSUBS gf180mcu_fd_sc_mcu7t5v0__nand2_1
X_5108_ _9533_/Q _5656_/B2 PHY_9/VDD PHY_9/VDD VSUBS VSUBS gf180mcu_fd_sc_mcu7t5v0__clkinv_1
X_6088_ _6088_/A1 _6088_/A2 _6088_/A3 _6089_/A2 PHY_9/VDD PHY_9/VDD VSUBS VSUBS gf180mcu_fd_sc_mcu7t5v0__nand3_1
X_5039_ _9759_/Q _6047_/B2 PHY_9/VDD PHY_9/VDD VSUBS VSUBS gf180mcu_fd_sc_mcu7t5v0__clkinv_1
X_9916_ _9916_/D _9948_/CLK _9916_/Q PHY_9/VDD PHY_9/VDD VSUBS VSUBS gf180mcu_fd_sc_mcu7t5v0__dffq_1
X_9847_ _9847_/D _9856_/CLK _9847_/Q PHY_9/VDD PHY_9/VDD VSUBS VSUBS gf180mcu_fd_sc_mcu7t5v0__dffq_4
X_9778_ _9778_/D _9830_/CLK _9778_/Q PHY_9/VDD PHY_9/VDD VSUBS VSUBS gf180mcu_fd_sc_mcu7t5v0__dffq_1
X_8729_ _8768_/A1 _9950_/Q _8740_/A3 _8983_/A1 PHY_9/VDD PHY_9/VDD VSUBS VSUBS gf180mcu_fd_sc_mcu7t5v0__nand3_4
X_5390_ _5390_/A1 _5201_/Z _5391_/B PHY_9/VDD PHY_9/VDD VSUBS VSUBS gf180mcu_fd_sc_mcu7t5v0__nor2_1
X_7060_ _9808_/Q _7019_/I _7062_/A2 PHY_9/VDD PHY_9/VDD VSUBS VSUBS gf180mcu_fd_sc_mcu7t5v0__nand2_1
X_6011_ _5388_/Z _6018_/A2 _6018_/B1 _6011_/B2 _9714_/D PHY_9/VDD PHY_9/VDD VSUBS
+ VSUBS gf180mcu_fd_sc_mcu7t5v0__oai22_1
X_7962_ _7959_/Z _7962_/A2 _7962_/Z PHY_9/VDD PHY_9/VDD VSUBS VSUBS gf180mcu_fd_sc_mcu7t5v0__xor2_1
X_9701_ _9701_/D _9940_/CLK _9701_/Q PHY_9/VDD PHY_9/VDD VSUBS VSUBS gf180mcu_fd_sc_mcu7t5v0__dffq_1
X_6913_ _9821_/Q _6970_/A2 _6970_/B1 _9897_/Q _6914_/A2 PHY_9/VDD PHY_9/VDD VSUBS
+ VSUBS gf180mcu_fd_sc_mcu7t5v0__aoi22_1
X_9632_ _9632_/D _9830_/CLK _9632_/Q PHY_9/VDD PHY_9/VDD VSUBS VSUBS gf180mcu_fd_sc_mcu7t5v0__dffq_1
X_7893_ _7847_/Z _7901_/A2 _7903_/A2 PHY_9/VDD PHY_9/VDD VSUBS VSUBS gf180mcu_fd_sc_mcu7t5v0__nand2_1
X_6844_ _6948_/B _6966_/A2 _6845_/A2 PHY_9/VDD PHY_9/VDD VSUBS VSUBS gf180mcu_fd_sc_mcu7t5v0__nand2_1
X_6775_ _6775_/A1 _6775_/A2 _6970_/B1 _6775_/B2 _6966_/A2 PHY_9/VDD PHY_9/VDD VSUBS
+ VSUBS gf180mcu_fd_sc_mcu7t5v0__aoi22_4
X_9563_ _9563_/D _9801_/CLK _9563_/Q PHY_9/VDD PHY_9/VDD VSUBS VSUBS gf180mcu_fd_sc_mcu7t5v0__dffq_1
X_8514_ _8503_/Z _8514_/A2 _8511_/Z _8516_/A2 PHY_9/VDD PHY_9/VDD VSUBS VSUBS gf180mcu_fd_sc_mcu7t5v0__xnor3_1
X_5726_ _5404_/Z _5727_/A2 _5727_/B1 _5726_/B2 _9564_/D PHY_9/VDD PHY_9/VDD VSUBS
+ VSUBS gf180mcu_fd_sc_mcu7t5v0__oai22_1
X_9494_ _9494_/D _9901_/CLK _9494_/Q PHY_9/VDD PHY_9/VDD VSUBS VSUBS gf180mcu_fd_sc_mcu7t5v0__dffq_1
X_8445_ _8653_/A2 _8447_/A3 _8446_/A2 PHY_9/VDD PHY_9/VDD VSUBS VSUBS gf180mcu_fd_sc_mcu7t5v0__xnor2_1
X_5657_ _5657_/A1 _5657_/A2 _5867_/A2 _5658_/A3 PHY_9/VDD PHY_9/VDD VSUBS VSUBS gf180mcu_fd_sc_mcu7t5v0__nand3_2
X_8376_ _9922_/Q _8389_/A2 _8673_/I0 PHY_9/VDD PHY_9/VDD VSUBS VSUBS gf180mcu_fd_sc_mcu7t5v0__nor2_1
X_5588_ _9416_/Q _9317_/C _5592_/B1 _9406_/Q _5588_/C _5590_/A2 PHY_9/VDD PHY_9/VDD
+ VSUBS VSUBS gf180mcu_fd_sc_mcu7t5v0__aoi221_2
X_7327_ _7327_/A1 _8688_/A2 _7336_/A2 PHY_9/VDD PHY_9/VDD VSUBS VSUBS gf180mcu_fd_sc_mcu7t5v0__nand2_4
X_7258_ _7258_/A1 _7258_/A2 _7257_/B _7296_/A2 PHY_9/VDD PHY_9/VDD VSUBS VSUBS gf180mcu_fd_sc_mcu7t5v0__nor3_1
X_6209_ _6209_/A1 _6209_/A2 _6231_/A2 PHY_9/VDD PHY_9/VDD VSUBS VSUBS gf180mcu_fd_sc_mcu7t5v0__nand2_1
X_7189_ _7189_/A1 _7189_/A2 _7189_/B _7236_/A1 PHY_9/VDD PHY_9/VDD VSUBS VSUBS gf180mcu_fd_sc_mcu7t5v0__oai21_1
X_4890_ _9941_/Q _8690_/B2 PHY_9/VDD PHY_9/VDD VSUBS VSUBS gf180mcu_fd_sc_mcu7t5v0__clkinv_1
X_6560_ _6401_/C _6560_/A2 _6560_/A3 _6634_/A2 _9812_/Q _6562_/B PHY_9/VDD PHY_9/VDD
+ VSUBS VSUBS gf180mcu_fd_sc_mcu7t5v0__oai32_1
X_5511_ _5973_/C _5511_/A2 _9463_/D PHY_9/VDD PHY_9/VDD VSUBS VSUBS gf180mcu_fd_sc_mcu7t5v0__nor2_1
X_6491_ _9811_/Q _6624_/A2 _6584_/B1 _9810_/Q _6530_/A2 PHY_9/VDD PHY_9/VDD VSUBS
+ VSUBS gf180mcu_fd_sc_mcu7t5v0__aoi22_1
X_8230_ _8256_/B2 _8256_/B1 _8256_/A3 PHY_9/VDD PHY_9/VDD VSUBS VSUBS gf180mcu_fd_sc_mcu7t5v0__xnor2_1
X_5442_ _5459_/A1 _5495_/A2 _5458_/A2 PHY_9/VDD PHY_9/VDD VSUBS VSUBS gf180mcu_fd_sc_mcu7t5v0__nor2_4
X_5373_ _5739_/A1 _5371_/Z _6286_/B PHY_9/VDD PHY_9/VDD VSUBS VSUBS gf180mcu_fd_sc_mcu7t5v0__nand2_1
X_8161_ _9357_/B _8161_/A2 _9907_/D PHY_9/VDD PHY_9/VDD VSUBS VSUBS gf180mcu_fd_sc_mcu7t5v0__nor2_1
X_7112_ _9808_/Q _7290_/A2 _7152_/B2 PHY_9/VDD PHY_9/VDD VSUBS VSUBS gf180mcu_fd_sc_mcu7t5v0__nand2_1
X_8092_ _8060_/Z _8091_/Z _8092_/Z PHY_9/VDD PHY_9/VDD VSUBS VSUBS gf180mcu_fd_sc_mcu7t5v0__xor2_1
X_7043_ _9905_/Q _7145_/B _7045_/B1 PHY_9/VDD PHY_9/VDD VSUBS VSUBS gf180mcu_fd_sc_mcu7t5v0__nand2_1
X_8994_ _8994_/A1 _9932_/Q _8994_/B _8995_/B2 PHY_9/VDD PHY_9/VDD VSUBS VSUBS gf180mcu_fd_sc_mcu7t5v0__oai21_2
X_7945_ _7945_/I _7991_/A1 PHY_9/VDD PHY_9/VDD VSUBS VSUBS gf180mcu_fd_sc_mcu7t5v0__clkinv_1
X_7876_ _7876_/A1 _7876_/A2 _7876_/B _7877_/C PHY_9/VDD PHY_9/VDD VSUBS VSUBS gf180mcu_fd_sc_mcu7t5v0__aoi21_1
X_6827_ _6828_/A2 _6828_/A3 _6874_/B PHY_9/VDD PHY_9/VDD VSUBS VSUBS gf180mcu_fd_sc_mcu7t5v0__nor2_1
X_9615_ _9615_/D _9830_/CLK _9615_/Q PHY_9/VDD PHY_9/VDD VSUBS VSUBS gf180mcu_fd_sc_mcu7t5v0__dffq_1
X_9546_ _9546_/D _9800_/CLK _9546_/Q PHY_9/VDD PHY_9/VDD VSUBS VSUBS gf180mcu_fd_sc_mcu7t5v0__dffq_1
X_6758_ _6995_/C _6795_/A2 _6766_/A2 PHY_9/VDD PHY_9/VDD VSUBS VSUBS gf180mcu_fd_sc_mcu7t5v0__nand2_1
X_6689_ _6690_/A2 _6997_/B2 _6997_/A2 _6995_/C PHY_9/VDD PHY_9/VDD VSUBS VSUBS gf180mcu_fd_sc_mcu7t5v0__and3_2
X_5709_ _8691_/A1 _5715_/A2 _5715_/B1 _5709_/B2 _9551_/D PHY_9/VDD PHY_9/VDD VSUBS
+ VSUBS gf180mcu_fd_sc_mcu7t5v0__oai22_1
X_9477_ _9477_/D _9689_/CLK _9477_/Q PHY_9/VDD PHY_9/VDD VSUBS VSUBS gf180mcu_fd_sc_mcu7t5v0__dffq_1
X_8428_ _8647_/A2 _9500_/Q _8430_/B1 PHY_9/VDD PHY_9/VDD VSUBS VSUBS gf180mcu_fd_sc_mcu7t5v0__nand2_1
X_8359_ _8389_/A1 _9034_/A2 _8359_/B _9922_/D PHY_9/VDD PHY_9/VDD VSUBS VSUBS gf180mcu_fd_sc_mcu7t5v0__aoi21_1
X_5991_ _5388_/Z _5998_/A2 _5998_/B1 _5991_/B2 _9698_/D PHY_9/VDD PHY_9/VDD VSUBS
+ VSUBS gf180mcu_fd_sc_mcu7t5v0__oai22_1
X_4942_ _9764_/Q _6054_/B2 PHY_9/VDD PHY_9/VDD VSUBS VSUBS gf180mcu_fd_sc_mcu7t5v0__clkinv_1
X_7730_ _7730_/A1 _7730_/A2 _7731_/C PHY_9/VDD PHY_9/VDD VSUBS VSUBS gf180mcu_fd_sc_mcu7t5v0__nor2_1
X_7661_ _7661_/A1 _7661_/A2 _7660_/Z _7661_/Z PHY_9/VDD PHY_9/VDD VSUBS VSUBS gf180mcu_fd_sc_mcu7t5v0__xor3_1
X_6612_ _6650_/A2 _6646_/A1 _6613_/A2 PHY_9/VDD PHY_9/VDD VSUBS VSUBS gf180mcu_fd_sc_mcu7t5v0__nand2_1
X_4873_ _9574_/Q _5742_/B2 PHY_9/VDD PHY_9/VDD VSUBS VSUBS gf180mcu_fd_sc_mcu7t5v0__clkinv_1
X_9400_ _9400_/D _9856_/CLK _9400_/Q PHY_9/VDD PHY_9/VDD VSUBS VSUBS gf180mcu_fd_sc_mcu7t5v0__dffq_1
X_7592_ _9813_/Q _7647_/A2 _7597_/A1 PHY_9/VDD PHY_9/VDD VSUBS VSUBS gf180mcu_fd_sc_mcu7t5v0__nand2_1
X_6543_ _6567_/A1 _6543_/A2 _6540_/Z _6543_/Z PHY_9/VDD PHY_9/VDD VSUBS VSUBS gf180mcu_fd_sc_mcu7t5v0__xor3_1
X_9331_ _9814_/Q _9331_/A2 _9332_/A2 PHY_9/VDD PHY_9/VDD VSUBS VSUBS gf180mcu_fd_sc_mcu7t5v0__nand2_1
X_6474_ _9810_/Q _6474_/A2 _6578_/A1 _6650_/A2 _6561_/B _6475_/A2 PHY_9/VDD PHY_9/VDD
+ VSUBS VSUBS gf180mcu_fd_sc_mcu7t5v0__aoi221_1
X_9262_ _9812_/Q _9322_/A2 _9262_/B _9263_/A4 PHY_9/VDD PHY_9/VDD VSUBS VSUBS gf180mcu_fd_sc_mcu7t5v0__oai21_1
X_5425_ _9731_/Q _9430_/Q _9031_/B _5426_/B PHY_9/VDD PHY_9/VDD VSUBS VSUBS gf180mcu_fd_sc_mcu7t5v0__oai21_1
X_8213_ _8319_/A2 _8213_/A2 _8213_/B _8316_/A2 PHY_9/VDD PHY_9/VDD VSUBS VSUBS gf180mcu_fd_sc_mcu7t5v0__oai21_4
X_9193_ _9193_/A1 _9192_/B _9222_/A2 PHY_9/VDD PHY_9/VDD VSUBS VSUBS gf180mcu_fd_sc_mcu7t5v0__xnor2_1
X_5356_ _5356_/A1 _5364_/A2 _5356_/B _9413_/D PHY_9/VDD PHY_9/VDD VSUBS VSUBS gf180mcu_fd_sc_mcu7t5v0__aoi21_1
X_8144_ _9907_/Q _8162_/A1 _8141_/Z _8144_/Z PHY_9/VDD PHY_9/VDD VSUBS VSUBS gf180mcu_fd_sc_mcu7t5v0__xor3_1
X_5287_ _9460_/Q _5296_/A2 _7695_/B _5288_/B PHY_9/VDD PHY_9/VDD VSUBS VSUBS gf180mcu_fd_sc_mcu7t5v0__oai21_1
X_8075_ _8309_/A2 _8110_/B _8075_/B _8076_/A2 PHY_9/VDD PHY_9/VDD VSUBS VSUBS gf180mcu_fd_sc_mcu7t5v0__oai21_1
X_7026_ _9846_/Q _9845_/Q _7047_/A2 PHY_9/VDD PHY_9/VDD VSUBS VSUBS gf180mcu_fd_sc_mcu7t5v0__nor2_1
X_8977_ _9017_/A2 _9018_/A1 _8977_/Z PHY_9/VDD PHY_9/VDD VSUBS VSUBS gf180mcu_fd_sc_mcu7t5v0__xor2_1
X_7928_ _9896_/Q _9356_/C _7928_/B1 _7928_/B2 _7929_/A2 PHY_9/VDD PHY_9/VDD VSUBS
+ VSUBS gf180mcu_fd_sc_mcu7t5v0__aoi22_1
X_7859_ _7960_/A1 _7960_/A2 _7859_/Z PHY_9/VDD PHY_9/VDD VSUBS VSUBS gf180mcu_fd_sc_mcu7t5v0__xor2_1
X_9529_ _9529_/D _9830_/CLK _9529_/Q PHY_9/VDD PHY_9/VDD VSUBS VSUBS gf180mcu_fd_sc_mcu7t5v0__dffq_1
X_5210_ _5961_/B _9736_/Q _9723_/D PHY_9/VDD PHY_9/VDD VSUBS VSUBS gf180mcu_fd_sc_mcu7t5v0__and2_1
X_6190_ _9485_/Q _6287_/A2 _6287_/B1 _9518_/Q _6192_/A1 PHY_9/VDD PHY_9/VDD VSUBS
+ VSUBS gf180mcu_fd_sc_mcu7t5v0__aoi22_1
X_5141_ _5770_/B _9730_/Q _5480_/A1 _5150_/A1 PHY_9/VDD PHY_9/VDD VSUBS VSUBS gf180mcu_fd_sc_mcu7t5v0__nand3_1
X_5072_ _9752_/Q _6038_/B2 PHY_9/VDD PHY_9/VDD VSUBS VSUBS gf180mcu_fd_sc_mcu7t5v0__clkinv_1
X_8900_ _9809_/Q _8850_/Z _8954_/A2 PHY_9/VDD PHY_9/VDD VSUBS VSUBS gf180mcu_fd_sc_mcu7t5v0__nand2_1
X_9880_ _9880_/D _9948_/CLK _9880_/Q PHY_9/VDD PHY_9/VDD VSUBS VSUBS gf180mcu_fd_sc_mcu7t5v0__dffq_1
X_8831_ _9136_/A2 _8848_/A1 _8844_/A2 _8831_/Z PHY_9/VDD PHY_9/VDD VSUBS VSUBS gf180mcu_fd_sc_mcu7t5v0__xor3_1
X_8762_ _8982_/B1 _8790_/A1 _8982_/C _8763_/B PHY_9/VDD PHY_9/VDD VSUBS VSUBS gf180mcu_fd_sc_mcu7t5v0__aoi21_1
X_5974_ _5967_/B _5970_/B _5978_/A1 PHY_9/VDD PHY_9/VDD VSUBS VSUBS gf180mcu_fd_sc_mcu7t5v0__nand2_1
X_7713_ _9887_/Q _7725_/A3 _7724_/A2 PHY_9/VDD PHY_9/VDD VSUBS VSUBS gf180mcu_fd_sc_mcu7t5v0__nand2_2
X_8693_ _8693_/A1 _8697_/A2 _8697_/B1 _8693_/B2 _9944_/D PHY_9/VDD PHY_9/VDD VSUBS
+ VSUBS gf180mcu_fd_sc_mcu7t5v0__oai22_1
X_4925_ _9858_/Q _7330_/B2 PHY_9/VDD PHY_9/VDD VSUBS VSUBS gf180mcu_fd_sc_mcu7t5v0__clkinv_1
X_4856_ _9408_/Q _5575_/A2 PHY_9/VDD PHY_9/VDD VSUBS VSUBS gf180mcu_fd_sc_mcu7t5v0__clkinv_1
X_7644_ _7644_/A1 _7644_/A2 _7661_/A1 PHY_9/VDD PHY_9/VDD VSUBS VSUBS gf180mcu_fd_sc_mcu7t5v0__nand2_1
X_7575_ _6558_/B _7575_/A2 _7576_/B PHY_9/VDD PHY_9/VDD VSUBS VSUBS gf180mcu_fd_sc_mcu7t5v0__xor2_1
X_6526_ _9809_/Q _6625_/A2 _6622_/A1 PHY_9/VDD PHY_9/VDD VSUBS VSUBS gf180mcu_fd_sc_mcu7t5v0__nand2_1
X_4787_ _9393_/Q _5310_/A1 PHY_9/VDD PHY_9/VDD VSUBS VSUBS gf180mcu_fd_sc_mcu7t5v0__clkinv_1
X_9314_ _9314_/A1 _9314_/A2 _9314_/B _9315_/B PHY_9/VDD PHY_9/VDD VSUBS VSUBS gf180mcu_fd_sc_mcu7t5v0__oai21_1
X_6457_ _6458_/A2 _6458_/A3 _6481_/A2 PHY_9/VDD PHY_9/VDD VSUBS VSUBS gf180mcu_fd_sc_mcu7t5v0__nor2_1
X_9245_ _9245_/A1 _9245_/A2 _9243_/Z _9245_/Z PHY_9/VDD PHY_9/VDD VSUBS VSUBS gf180mcu_fd_sc_mcu7t5v0__xor3_1
X_6388_ _7739_/A2 _6353_/Z _6388_/B _6584_/B1 PHY_9/VDD PHY_9/VDD VSUBS VSUBS gf180mcu_fd_sc_mcu7t5v0__oai21_4
X_9176_ _9176_/A1 _9156_/Z _9176_/B _9202_/A1 PHY_9/VDD PHY_9/VDD VSUBS VSUBS gf180mcu_fd_sc_mcu7t5v0__aoi21_1
X_5408_ _9731_/Q _9426_/Q _9031_/B _5409_/B PHY_9/VDD PHY_9/VDD VSUBS VSUBS gf180mcu_fd_sc_mcu7t5v0__oai21_1
X_5339_ _9463_/Q _5342_/A2 _7007_/B _5340_/B PHY_9/VDD PHY_9/VDD VSUBS VSUBS gf180mcu_fd_sc_mcu7t5v0__oai21_1
X_8127_ _8319_/A2 _8127_/A2 _8127_/B _8311_/A2 PHY_9/VDD PHY_9/VDD VSUBS VSUBS gf180mcu_fd_sc_mcu7t5v0__oai21_4
X_8058_ _9901_/Q _9900_/Q _8058_/A3 _8330_/B PHY_9/VDD PHY_9/VDD VSUBS VSUBS gf180mcu_fd_sc_mcu7t5v0__nand3_2
X_7009_ _9391_/Q _9036_/A2 _8027_/B _7010_/B PHY_9/VDD PHY_9/VDD VSUBS VSUBS gf180mcu_fd_sc_mcu7t5v0__oai21_1
X_5690_ _9545_/Q _5687_/Z _5690_/Z PHY_9/VDD PHY_9/VDD VSUBS VSUBS gf180mcu_fd_sc_mcu7t5v0__and2_1
X_4710_ _9930_/Q _7554_/A1 PHY_9/VDD PHY_9/VDD VSUBS VSUBS gf180mcu_fd_sc_mcu7t5v0__inv_1
X_7360_ _9867_/Q _9866_/Q _7384_/A2 PHY_9/VDD PHY_9/VDD VSUBS VSUBS gf180mcu_fd_sc_mcu7t5v0__nor2_1
X_7291_ _9814_/Q _7019_/I _7292_/A2 PHY_9/VDD PHY_9/VDD VSUBS VSUBS gf180mcu_fd_sc_mcu7t5v0__nand2_1
X_6311_ _8695_/A1 _6313_/A2 _6313_/B1 _6311_/B2 _9791_/D PHY_9/VDD PHY_9/VDD VSUBS
+ VSUBS gf180mcu_fd_sc_mcu7t5v0__oai22_1
X_6242_ _9613_/Q _6287_/A2 _6287_/B1 _9629_/Q _6244_/A1 PHY_9/VDD PHY_9/VDD VSUBS
+ VSUBS gf180mcu_fd_sc_mcu7t5v0__aoi22_1
X_9030_ _9059_/A2 _9036_/A2 _9030_/B _9963_/D PHY_9/VDD PHY_9/VDD VSUBS VSUBS gf180mcu_fd_sc_mcu7t5v0__aoi21_1
X_6173_ _5372_/Z _6173_/A2 _6173_/B1 _8688_/A2 _6176_/A1 PHY_9/VDD PHY_9/VDD VSUBS
+ VSUBS gf180mcu_fd_sc_mcu7t5v0__aoi22_1
X_5124_ _9697_/Q _5988_/B2 PHY_9/VDD PHY_9/VDD VSUBS VSUBS gf180mcu_fd_sc_mcu7t5v0__clkinv_1
X_9932_ _9932_/D _9957_/CLK _9932_/Q PHY_9/VDD PHY_9/VDD VSUBS VSUBS gf180mcu_fd_sc_mcu7t5v0__dffq_2
X_5055_ _9799_/Q _6321_/B2 PHY_9/VDD PHY_9/VDD VSUBS VSUBS gf180mcu_fd_sc_mcu7t5v0__clkinv_1
X_9863_ _9863_/D _9948_/CLK _9863_/Q PHY_9/VDD PHY_9/VDD VSUBS VSUBS gf180mcu_fd_sc_mcu7t5v0__dffq_1
X_8814_ _9807_/Q _8813_/Z _8815_/I PHY_9/VDD PHY_9/VDD VSUBS VSUBS gf180mcu_fd_sc_mcu7t5v0__nand2_1
X_9794_ _9794_/D _9801_/CLK _9794_/Q PHY_9/VDD PHY_9/VDD VSUBS VSUBS gf180mcu_fd_sc_mcu7t5v0__dffq_1
X_5957_ _9682_/Q _5973_/A2 _5961_/B _5958_/B PHY_9/VDD PHY_9/VDD VSUBS VSUBS gf180mcu_fd_sc_mcu7t5v0__oai21_1
X_8745_ _9954_/Q _9317_/C _9100_/B _8745_/C _8746_/I PHY_9/VDD PHY_9/VDD VSUBS VSUBS
+ gf180mcu_fd_sc_mcu7t5v0__oai211_1
X_4908_ _9419_/Q _5392_/A1 PHY_9/VDD PHY_9/VDD VSUBS VSUBS gf180mcu_fd_sc_mcu7t5v0__clkinv_1
X_8676_ _8391_/C _8676_/A2 _9356_/C _8677_/B2 PHY_9/VDD PHY_9/VDD VSUBS VSUBS gf180mcu_fd_sc_mcu7t5v0__aoi21_1
X_7627_ _7670_/A2 _7671_/A1 _7627_/Z PHY_9/VDD PHY_9/VDD VSUBS VSUBS gf180mcu_fd_sc_mcu7t5v0__xor2_1
X_5888_ _5888_/A1 _5887_/Z _5889_/A2 PHY_9/VDD PHY_9/VDD VSUBS VSUBS gf180mcu_fd_sc_mcu7t5v0__nand2_1
X_4839_ _9469_/Q _5530_/A1 PHY_9/VDD PHY_9/VDD VSUBS VSUBS gf180mcu_fd_sc_mcu7t5v0__inv_2
X_7558_ _7558_/I _7559_/A2 PHY_9/VDD PHY_9/VDD VSUBS VSUBS gf180mcu_fd_sc_mcu7t5v0__clkinv_1
X_6509_ _6510_/A1 _6469_/Z _6510_/B _6509_/Z PHY_9/VDD PHY_9/VDD VSUBS VSUBS gf180mcu_fd_sc_mcu7t5v0__and3_1
X_7489_ _7489_/A1 _7469_/Z _7489_/B _7534_/A1 PHY_9/VDD PHY_9/VDD VSUBS VSUBS gf180mcu_fd_sc_mcu7t5v0__aoi21_1
X_9228_ _9809_/Q _9333_/A2 _9335_/A1 PHY_9/VDD PHY_9/VDD VSUBS VSUBS gf180mcu_fd_sc_mcu7t5v0__nand2_1
X_9159_ _9331_/A2 _9285_/A2 _9103_/Z _9159_/Z PHY_9/VDD PHY_9/VDD VSUBS VSUBS gf180mcu_fd_sc_mcu7t5v0__or3_1
X_6860_ _7147_/A1 _9356_/C _6860_/B1 _6860_/B2 _9357_/B _9840_/D PHY_9/VDD PHY_9/VDD
+ VSUBS VSUBS gf180mcu_fd_sc_mcu7t5v0__aoi221_1
X_6791_ _6791_/A1 _6789_/Z _6791_/Z PHY_9/VDD PHY_9/VDD VSUBS VSUBS gf180mcu_fd_sc_mcu7t5v0__xor2_1
X_5811_ _5399_/Z _5814_/A2 _5814_/B1 _5811_/B2 _9627_/D PHY_9/VDD PHY_9/VDD VSUBS
+ VSUBS gf180mcu_fd_sc_mcu7t5v0__oai22_1
X_5742_ _5388_/Z _5749_/A2 _5749_/B1 _5742_/B2 _9574_/D PHY_9/VDD PHY_9/VDD VSUBS
+ VSUBS gf180mcu_fd_sc_mcu7t5v0__oai22_1
X_8530_ _8531_/A1 _8529_/Z _8538_/A1 PHY_9/VDD PHY_9/VDD VSUBS VSUBS gf180mcu_fd_sc_mcu7t5v0__nor2_1
X_5673_ _9539_/Q _5670_/Z _5673_/Z PHY_9/VDD PHY_9/VDD VSUBS VSUBS gf180mcu_fd_sc_mcu7t5v0__and2_1
X_8461_ _8461_/A1 _8441_/Z _8461_/B _8495_/A1 PHY_9/VDD PHY_9/VDD VSUBS VSUBS gf180mcu_fd_sc_mcu7t5v0__oai21_1
X_7412_ _9809_/Q _9808_/Q _7647_/A2 _7382_/Z _7413_/I PHY_9/VDD PHY_9/VDD VSUBS VSUBS
+ gf180mcu_fd_sc_mcu7t5v0__and4_1
X_8392_ _9925_/Q _8422_/A2 _8394_/A2 PHY_9/VDD PHY_9/VDD VSUBS VSUBS gf180mcu_fd_sc_mcu7t5v0__nor2_1
X_7343_ _9386_/Q _9034_/A2 _7695_/B _7344_/B PHY_9/VDD PHY_9/VDD VSUBS VSUBS gf180mcu_fd_sc_mcu7t5v0__oai21_1
X_7274_ _7319_/A2 _7320_/A1 _7274_/Z PHY_9/VDD PHY_9/VDD VSUBS VSUBS gf180mcu_fd_sc_mcu7t5v0__xor2_1
X_9013_ _9026_/A1 _9013_/A2 _9012_/Z _9013_/Z PHY_9/VDD PHY_9/VDD VSUBS VSUBS gf180mcu_fd_sc_mcu7t5v0__xor3_1
X_6225_ _9799_/Q _6287_/A2 _6287_/B1 _9563_/Q _6227_/A1 PHY_9/VDD PHY_9/VDD VSUBS
+ VSUBS gf180mcu_fd_sc_mcu7t5v0__aoi22_1
X_6156_ _9881_/Q _6288_/A2 _6288_/B1 _9944_/Q _6157_/A2 PHY_9/VDD PHY_9/VDD VSUBS
+ VSUBS gf180mcu_fd_sc_mcu7t5v0__aoi22_1
X_5107_ _9488_/Q _5558_/B2 PHY_9/VDD PHY_9/VDD VSUBS VSUBS gf180mcu_fd_sc_mcu7t5v0__clkinv_1
X_6087_ _6290_/B2 _6087_/A2 _8688_/A2 _6087_/B2 _6087_/C1 _6283_/A1 _6088_/A3 PHY_9/VDD
+ PHY_9/VDD VSUBS VSUBS gf180mcu_fd_sc_mcu7t5v0__aoi222_2
X_5038_ _9767_/Q _6057_/B2 PHY_9/VDD PHY_9/VDD VSUBS VSUBS gf180mcu_fd_sc_mcu7t5v0__clkinv_1
X_9915_ _9915_/D _9948_/CLK _9915_/Q PHY_9/VDD PHY_9/VDD VSUBS VSUBS gf180mcu_fd_sc_mcu7t5v0__dffq_1
X_9846_ _9846_/D _9940_/CLK _9846_/Q PHY_9/VDD PHY_9/VDD VSUBS VSUBS gf180mcu_fd_sc_mcu7t5v0__dffq_2
X_9777_ _9777_/D _9801_/CLK _9777_/Q PHY_9/VDD PHY_9/VDD VSUBS VSUBS gf180mcu_fd_sc_mcu7t5v0__dffq_2
X_6989_ _9814_/Q _6998_/A2 _6997_/B1 PHY_9/VDD PHY_9/VDD VSUBS VSUBS gf180mcu_fd_sc_mcu7t5v0__nand2_1
X_8728_ _9951_/Q _8739_/A2 _9020_/A1 PHY_9/VDD PHY_9/VDD VSUBS VSUBS gf180mcu_fd_sc_mcu7t5v0__nor2_2
X_8659_ _8659_/A1 _8659_/A2 _8658_/Z _8659_/Z PHY_9/VDD PHY_9/VDD VSUBS VSUBS gf180mcu_fd_sc_mcu7t5v0__xor3_1
X_6010_ _8689_/A1 _6018_/A2 _6018_/B1 PHY_9/VDD PHY_9/VDD VSUBS VSUBS gf180mcu_fd_sc_mcu7t5v0__nand2_2
X_7961_ _7959_/Z _7962_/A2 _8002_/A1 PHY_9/VDD PHY_9/VDD VSUBS VSUBS gf180mcu_fd_sc_mcu7t5v0__nand2_1
X_9700_ _9700_/D _9940_/CLK _9700_/Q PHY_9/VDD PHY_9/VDD VSUBS VSUBS gf180mcu_fd_sc_mcu7t5v0__dffq_1
X_6912_ _9855_/Q _6771_/Z _6914_/A1 PHY_9/VDD PHY_9/VDD VSUBS VSUBS gf180mcu_fd_sc_mcu7t5v0__nand2_1
X_7892_ _7892_/A1 _7887_/I _7989_/A1 _7892_/Z PHY_9/VDD PHY_9/VDD VSUBS VSUBS gf180mcu_fd_sc_mcu7t5v0__xor3_1
X_6843_ _6795_/Z _6799_/Z _6843_/B _6852_/A1 PHY_9/VDD PHY_9/VDD VSUBS VSUBS gf180mcu_fd_sc_mcu7t5v0__oai21_1
X_9631_ _9631_/D _9830_/CLK _9631_/Q PHY_9/VDD PHY_9/VDD VSUBS VSUBS gf180mcu_fd_sc_mcu7t5v0__dffq_1
X_6774_ _9835_/Q _9834_/Q _6970_/B1 PHY_9/VDD PHY_9/VDD VSUBS VSUBS gf180mcu_fd_sc_mcu7t5v0__nor2_4
X_9562_ _9562_/D _9801_/CLK _9562_/Q PHY_9/VDD PHY_9/VDD VSUBS VSUBS gf180mcu_fd_sc_mcu7t5v0__dffq_1
X_8513_ _8514_/A2 _8511_/Z _8543_/A2 PHY_9/VDD PHY_9/VDD VSUBS VSUBS gf180mcu_fd_sc_mcu7t5v0__nand2_1
X_9493_ _9493_/D _9901_/CLK _9493_/Q PHY_9/VDD PHY_9/VDD VSUBS VSUBS gf180mcu_fd_sc_mcu7t5v0__dffq_1
X_5725_ _8695_/A1 _5727_/A2 _5727_/B1 _5725_/B2 _9563_/D PHY_9/VDD PHY_9/VDD VSUBS
+ VSUBS gf180mcu_fd_sc_mcu7t5v0__oai22_1
X_5656_ _5406_/Z _5656_/A2 _5656_/B1 _5656_/B2 _9533_/D PHY_9/VDD PHY_9/VDD VSUBS
+ VSUBS gf180mcu_fd_sc_mcu7t5v0__oai22_1
X_8444_ _8654_/A2 _8606_/A2 _8444_/B _8447_/A3 PHY_9/VDD PHY_9/VDD VSUBS VSUBS gf180mcu_fd_sc_mcu7t5v0__oai21_1
X_5587_ _9411_/Q _5591_/A2 _5588_/C PHY_9/VDD PHY_9/VDD VSUBS VSUBS gf180mcu_fd_sc_mcu7t5v0__and2_1
X_8375_ _9921_/Q _8390_/A3 _8389_/A2 PHY_9/VDD PHY_9/VDD VSUBS VSUBS gf180mcu_fd_sc_mcu7t5v0__nand2_1
X_7326_ _7326_/A1 _7326_/A2 _9856_/D PHY_9/VDD PHY_9/VDD VSUBS VSUBS gf180mcu_fd_sc_mcu7t5v0__nor2_1
X_7257_ _7258_/A1 _7258_/A2 _7257_/B _7296_/B PHY_9/VDD PHY_9/VDD VSUBS VSUBS gf180mcu_fd_sc_mcu7t5v0__oai21_1
X_6208_ _9531_/Q _6288_/A2 _6288_/B1 _9719_/Q _6209_/A2 PHY_9/VDD PHY_9/VDD VSUBS
+ VSUBS gf180mcu_fd_sc_mcu7t5v0__aoi22_1
X_7188_ _9854_/Q _9356_/C _7235_/A1 PHY_9/VDD PHY_9/VDD VSUBS VSUBS gf180mcu_fd_sc_mcu7t5v0__nand2_1
X_6139_ _9584_/Q _6288_/A2 _6287_/A2 _9592_/Q _6140_/A2 PHY_9/VDD PHY_9/VDD VSUBS
+ VSUBS gf180mcu_fd_sc_mcu7t5v0__aoi22_1
X_9829_ _9829_/D _9830_/CLK _9829_/Q PHY_9/VDD PHY_9/VDD VSUBS VSUBS gf180mcu_fd_sc_mcu7t5v0__dffq_1
X_5510_ _9437_/Q _5498_/Z _5522_/B _9463_/Q _5510_/C _5511_/A2 PHY_9/VDD PHY_9/VDD
+ VSUBS VSUBS gf180mcu_fd_sc_mcu7t5v0__aoi221_1
X_6490_ _9811_/Q _6624_/A2 _6580_/A1 PHY_9/VDD PHY_9/VDD VSUBS VSUBS gf180mcu_fd_sc_mcu7t5v0__nand2_1
X_5441_ _9731_/Q _5492_/A1 _5441_/B _9433_/D PHY_9/VDD PHY_9/VDD VSUBS VSUBS gf180mcu_fd_sc_mcu7t5v0__aoi21_1
X_5372_ _5739_/A1 _5371_/Z _5372_/Z PHY_9/VDD PHY_9/VDD VSUBS VSUBS gf180mcu_fd_sc_mcu7t5v0__and2_4
X_8160_ _9907_/Q _9356_/C _8160_/B _8161_/A2 PHY_9/VDD PHY_9/VDD VSUBS VSUBS gf180mcu_fd_sc_mcu7t5v0__aoi21_1
X_7111_ _7119_/A1 _7082_/Z _7120_/A2 PHY_9/VDD PHY_9/VDD VSUBS VSUBS gf180mcu_fd_sc_mcu7t5v0__nor2_1
X_8091_ _9905_/Q _8087_/Z _8091_/Z PHY_9/VDD PHY_9/VDD VSUBS VSUBS gf180mcu_fd_sc_mcu7t5v0__xor2_1
X_7042_ _8037_/A2 _9356_/C _7042_/B1 _7042_/B2 _9357_/B _9849_/D PHY_9/VDD PHY_9/VDD
+ VSUBS VSUBS gf180mcu_fd_sc_mcu7t5v0__aoi221_1
X_8993_ _9974_/Q _8717_/Z _8993_/B1 _9898_/Q _8995_/B1 PHY_9/VDD PHY_9/VDD VSUBS VSUBS
+ gf180mcu_fd_sc_mcu7t5v0__aoi22_2
X_7944_ _7944_/A1 _7944_/A2 _7989_/B2 _7945_/I PHY_9/VDD PHY_9/VDD VSUBS VSUBS gf180mcu_fd_sc_mcu7t5v0__xor3_1
X_7875_ _9811_/Q _7973_/A2 _8008_/I1 _7875_/B2 _8009_/C _7876_/A2 PHY_9/VDD PHY_9/VDD
+ VSUBS VSUBS gf180mcu_fd_sc_mcu7t5v0__aoi221_1
X_6826_ _9811_/Q _6710_/Z _6880_/A1 PHY_9/VDD PHY_9/VDD VSUBS VSUBS gf180mcu_fd_sc_mcu7t5v0__nand2_1
X_9614_ _9614_/D _9948_/CLK _9614_/Q PHY_9/VDD PHY_9/VDD VSUBS VSUBS gf180mcu_fd_sc_mcu7t5v0__dffq_1
X_6757_ _6715_/Z _6757_/A2 _6757_/B _6795_/A2 PHY_9/VDD PHY_9/VDD VSUBS VSUBS gf180mcu_fd_sc_mcu7t5v0__oai21_1
X_9545_ _9545_/D _9689_/CLK _9545_/Q PHY_9/VDD PHY_9/VDD VSUBS VSUBS gf180mcu_fd_sc_mcu7t5v0__dffq_1
X_5708_ _5388_/Z _5715_/A2 _5715_/B1 _5708_/B2 _9550_/D PHY_9/VDD PHY_9/VDD VSUBS
+ VSUBS gf180mcu_fd_sc_mcu7t5v0__oai22_1
X_6688_ _9832_/Q _9831_/Q _6997_/A2 PHY_9/VDD PHY_9/VDD VSUBS VSUBS gf180mcu_fd_sc_mcu7t5v0__nand2_1
X_9476_ _9476_/D _9801_/CLK _9476_/Q PHY_9/VDD PHY_9/VDD VSUBS VSUBS gf180mcu_fd_sc_mcu7t5v0__dffq_1
X_8427_ _9926_/Q _8418_/Z _8427_/B _8461_/A1 PHY_9/VDD PHY_9/VDD VSUBS VSUBS gf180mcu_fd_sc_mcu7t5v0__aoi21_1
X_5639_ _5388_/Z _5646_/A2 _5646_/B1 _5639_/B2 _9514_/D PHY_9/VDD PHY_9/VDD VSUBS
+ VSUBS gf180mcu_fd_sc_mcu7t5v0__oai22_1
X_8358_ _9370_/Q _9036_/A2 rst_n _8359_/B PHY_9/VDD PHY_9/VDD VSUBS VSUBS gf180mcu_fd_sc_mcu7t5v0__oai21_1
X_7309_ _7309_/A1 _7309_/A2 _7308_/Z _7309_/Z PHY_9/VDD PHY_9/VDD VSUBS VSUBS gf180mcu_fd_sc_mcu7t5v0__xor3_1
X_8289_ _9910_/Q _8287_/Z _8289_/Z PHY_9/VDD PHY_9/VDD VSUBS VSUBS gf180mcu_fd_sc_mcu7t5v0__or2_1
X_5990_ _7007_/B _5998_/A2 _5998_/B1 PHY_9/VDD PHY_9/VDD VSUBS VSUBS gf180mcu_fd_sc_mcu7t5v0__nand2_2
X_4941_ _9788_/Q _6308_/B2 PHY_9/VDD PHY_9/VDD VSUBS VSUBS gf180mcu_fd_sc_mcu7t5v0__clkinv_1
X_4872_ _9582_/Q _5752_/B2 PHY_9/VDD PHY_9/VDD VSUBS VSUBS gf180mcu_fd_sc_mcu7t5v0__clkinv_1
X_7660_ _7660_/A1 _7660_/A2 _7659_/Z _7660_/Z PHY_9/VDD PHY_9/VDD VSUBS VSUBS gf180mcu_fd_sc_mcu7t5v0__xor3_1
X_6611_ _6644_/A1 _6609_/Z _6611_/B _6611_/C _6616_/A3 PHY_9/VDD PHY_9/VDD VSUBS VSUBS
+ gf180mcu_fd_sc_mcu7t5v0__oai211_1
X_7591_ _7539_/Z _7591_/A2 _7591_/B _7643_/A1 PHY_9/VDD PHY_9/VDD VSUBS VSUBS gf180mcu_fd_sc_mcu7t5v0__aoi21_1
X_9330_ _9330_/A1 _9330_/A2 _9330_/A3 _9330_/Z PHY_9/VDD PHY_9/VDD VSUBS VSUBS gf180mcu_fd_sc_mcu7t5v0__xor3_1
X_6542_ _6543_/A2 _6542_/A2 _6599_/A1 PHY_9/VDD PHY_9/VDD VSUBS VSUBS gf180mcu_fd_sc_mcu7t5v0__nor2_1
X_6473_ _9810_/Q _6625_/A2 _6473_/B1 _6401_/C _6475_/A1 PHY_9/VDD PHY_9/VDD VSUBS
+ VSUBS gf180mcu_fd_sc_mcu7t5v0__oai22_1
X_9261_ _9314_/A1 _9261_/A2 _9261_/B _9262_/B PHY_9/VDD PHY_9/VDD VSUBS VSUBS gf180mcu_fd_sc_mcu7t5v0__oai21_1
X_9192_ _9184_/B _9149_/Z _9192_/B _9222_/B PHY_9/VDD PHY_9/VDD VSUBS VSUBS gf180mcu_fd_sc_mcu7t5v0__aoi21_1
X_5424_ _9774_/Q _5439_/A2 _5424_/B1 _5130_/I _5486_/A1 PHY_9/VDD PHY_9/VDD VSUBS
+ VSUBS gf180mcu_fd_sc_mcu7t5v0__aoi22_4
X_8212_ _9972_/Q _8319_/A2 _8213_/B PHY_9/VDD PHY_9/VDD VSUBS VSUBS gf180mcu_fd_sc_mcu7t5v0__nand2_1
X_8143_ _9907_/Q _8141_/Z _8162_/B PHY_9/VDD PHY_9/VDD VSUBS VSUBS gf180mcu_fd_sc_mcu7t5v0__nand2_1
X_5355_ _9460_/Q _5364_/A2 _8027_/B _5356_/B PHY_9/VDD PHY_9/VDD VSUBS VSUBS gf180mcu_fd_sc_mcu7t5v0__oai21_1
X_8074_ _8309_/A2 _8075_/B _8110_/B _8074_/Z PHY_9/VDD PHY_9/VDD VSUBS VSUBS gf180mcu_fd_sc_mcu7t5v0__or3_1
X_5286_ _5237_/Z _5308_/A2 _5296_/A2 PHY_9/VDD PHY_9/VDD VSUBS VSUBS gf180mcu_fd_sc_mcu7t5v0__nand2_4
X_7025_ _7036_/A1 _9845_/Q _7037_/A3 _7281_/A1 PHY_9/VDD PHY_9/VDD VSUBS VSUBS gf180mcu_fd_sc_mcu7t5v0__nand3_2
X_8976_ _8925_/B _8998_/A2 _8976_/B _9018_/A1 PHY_9/VDD PHY_9/VDD VSUBS VSUBS gf180mcu_fd_sc_mcu7t5v0__aoi21_1
X_7927_ _7831_/C _7911_/Z _9356_/C _7928_/B2 PHY_9/VDD PHY_9/VDD VSUBS VSUBS gf180mcu_fd_sc_mcu7t5v0__aoi21_1
X_7858_ _7960_/A1 _7960_/A2 _7908_/A1 PHY_9/VDD PHY_9/VDD VSUBS VSUBS gf180mcu_fd_sc_mcu7t5v0__nor2_1
X_6809_ _6809_/A1 _6809_/A2 _6809_/B _6810_/B PHY_9/VDD PHY_9/VDD VSUBS VSUBS gf180mcu_fd_sc_mcu7t5v0__oai21_1
X_7789_ _9227_/A1 _7819_/A1 _7789_/A3 _7789_/Z PHY_9/VDD PHY_9/VDD VSUBS VSUBS gf180mcu_fd_sc_mcu7t5v0__xor3_1
X_9528_ _9528_/D _9830_/CLK _9528_/Q PHY_9/VDD PHY_9/VDD VSUBS VSUBS gf180mcu_fd_sc_mcu7t5v0__dffq_1
X_9459_ _9459_/D _9800_/CLK _9459_/Q PHY_9/VDD PHY_9/VDD VSUBS VSUBS gf180mcu_fd_sc_mcu7t5v0__dffq_1
X_5140_ _5770_/B _9730_/Q _5217_/A2 PHY_9/VDD PHY_9/VDD VSUBS VSUBS gf180mcu_fd_sc_mcu7t5v0__nand2_1
X_5071_ _9760_/Q _6048_/B2 PHY_9/VDD PHY_9/VDD VSUBS VSUBS gf180mcu_fd_sc_mcu7t5v0__clkinv_1
X_8830_ _9957_/Q _8844_/A2 _8848_/B PHY_9/VDD PHY_9/VDD VSUBS VSUBS gf180mcu_fd_sc_mcu7t5v0__nand2_1
X_8761_ _9808_/Q _8958_/A2 _8790_/A1 PHY_9/VDD PHY_9/VDD VSUBS VSUBS gf180mcu_fd_sc_mcu7t5v0__nand2_2
X_5973_ _5973_/A1 _5973_/A2 _5973_/B _5973_/C _9687_/D PHY_9/VDD PHY_9/VDD VSUBS VSUBS
+ gf180mcu_fd_sc_mcu7t5v0__aoi211_1
X_4924_ _9879_/Q _7680_/B2 PHY_9/VDD PHY_9/VDD VSUBS VSUBS gf180mcu_fd_sc_mcu7t5v0__clkinv_1
X_7712_ _9886_/Q _7791_/A2 _8008_/I1 PHY_9/VDD PHY_9/VDD VSUBS VSUBS gf180mcu_fd_sc_mcu7t5v0__nor2_2
X_8692_ _8692_/A1 _8697_/A2 _8697_/B1 _8692_/B2 _9943_/D PHY_9/VDD PHY_9/VDD VSUBS
+ VSUBS gf180mcu_fd_sc_mcu7t5v0__oai22_1
X_7643_ _7643_/A1 _7643_/A2 _7643_/B _7662_/A2 PHY_9/VDD PHY_9/VDD VSUBS VSUBS gf180mcu_fd_sc_mcu7t5v0__oai21_1
X_4855_ _9413_/Q _5356_/A1 PHY_9/VDD PHY_9/VDD VSUBS VSUBS gf180mcu_fd_sc_mcu7t5v0__clkinv_1
X_4786_ _9831_/Q _6699_/A3 PHY_9/VDD PHY_9/VDD VSUBS VSUBS gf180mcu_fd_sc_mcu7t5v0__clkinv_3
X_7574_ _9812_/Q _7575_/A2 _7574_/Z PHY_9/VDD PHY_9/VDD VSUBS VSUBS gf180mcu_fd_sc_mcu7t5v0__and2_1
X_6525_ _9807_/Q _6634_/A2 _6572_/B2 PHY_9/VDD PHY_9/VDD VSUBS VSUBS gf180mcu_fd_sc_mcu7t5v0__nand2_1
X_9313_ _9813_/Q _9313_/A2 _9347_/I1 _9314_/A2 _9348_/C _9314_/B PHY_9/VDD PHY_9/VDD
+ VSUBS VSUBS gf180mcu_fd_sc_mcu7t5v0__aoi221_1
X_9244_ _9245_/A1 _9243_/Z _9244_/Z PHY_9/VDD PHY_9/VDD VSUBS VSUBS gf180mcu_fd_sc_mcu7t5v0__xor2_1
X_6456_ _6458_/A2 _6458_/A3 _6481_/B PHY_9/VDD PHY_9/VDD VSUBS VSUBS gf180mcu_fd_sc_mcu7t5v0__nand2_1
X_6387_ _9837_/Q _6350_/Z _6569_/A2 _9871_/Q _6583_/A4 PHY_9/VDD PHY_9/VDD VSUBS VSUBS
+ gf180mcu_fd_sc_mcu7t5v0__aoi22_4
X_5407_ _5407_/A1 _5407_/A2 _5406_/Z _5407_/B2 _9425_/D PHY_9/VDD PHY_9/VDD VSUBS
+ VSUBS gf180mcu_fd_sc_mcu7t5v0__oai22_1
X_9175_ _9175_/A1 _9175_/A2 _9357_/B _9970_/D PHY_9/VDD PHY_9/VDD VSUBS VSUBS gf180mcu_fd_sc_mcu7t5v0__aoi21_1
X_8126_ _9970_/Q _8319_/A2 _8127_/B PHY_9/VDD PHY_9/VDD VSUBS VSUBS gf180mcu_fd_sc_mcu7t5v0__nand2_1
X_5338_ _5338_/A1 _5342_/A2 _5338_/B _9405_/D PHY_9/VDD PHY_9/VDD VSUBS VSUBS gf180mcu_fd_sc_mcu7t5v0__aoi21_1
X_8057_ _8057_/A1 _8057_/A2 _8156_/B PHY_9/VDD PHY_9/VDD VSUBS VSUBS gf180mcu_fd_sc_mcu7t5v0__nor2_4
X_7008_ _7036_/A1 _9036_/A2 _7008_/B _9846_/D PHY_9/VDD PHY_9/VDD VSUBS VSUBS gf180mcu_fd_sc_mcu7t5v0__aoi21_1
X_5269_ _9463_/Q _5272_/A2 _8027_/B _5270_/B PHY_9/VDD PHY_9/VDD VSUBS VSUBS gf180mcu_fd_sc_mcu7t5v0__oai21_1
X_8959_ _9813_/Q _9004_/A2 _8959_/B _8999_/A3 PHY_9/VDD PHY_9/VDD VSUBS VSUBS gf180mcu_fd_sc_mcu7t5v0__aoi21_1
X_6310_ _5399_/Z _6313_/A2 _6313_/B1 _6310_/B2 _9790_/D PHY_9/VDD PHY_9/VDD VSUBS
+ VSUBS gf180mcu_fd_sc_mcu7t5v0__oai22_1
X_7290_ _9812_/Q _7290_/A2 _7295_/A1 PHY_9/VDD PHY_9/VDD VSUBS VSUBS gf180mcu_fd_sc_mcu7t5v0__nand2_1
X_6241_ _6241_/A1 _6241_/A2 _6262_/A2 PHY_9/VDD PHY_9/VDD VSUBS VSUBS gf180mcu_fd_sc_mcu7t5v0__nand2_1
X_6172_ _6172_/A1 _6172_/A2 _6174_/C1 PHY_9/VDD PHY_9/VDD VSUBS VSUBS gf180mcu_fd_sc_mcu7t5v0__nand2_1
X_5123_ _9705_/Q _5998_/B2 PHY_9/VDD PHY_9/VDD VSUBS VSUBS gf180mcu_fd_sc_mcu7t5v0__clkinv_1
X_5054_ _9828_/Q _6663_/B2 PHY_9/VDD PHY_9/VDD VSUBS VSUBS gf180mcu_fd_sc_mcu7t5v0__clkinv_1
X_9931_ _9931_/D _9957_/CLK _9931_/Q PHY_9/VDD PHY_9/VDD VSUBS VSUBS gf180mcu_fd_sc_mcu7t5v0__dffq_2
X_9862_ _9862_/D _9948_/CLK _9862_/Q PHY_9/VDD PHY_9/VDD VSUBS VSUBS gf180mcu_fd_sc_mcu7t5v0__dffq_1
X_8813_ _9501_/Q _9894_/Q _9928_/Q _9970_/Q _9952_/Q _9953_/Q _8813_/Z PHY_9/VDD PHY_9/VDD
+ VSUBS VSUBS gf180mcu_fd_sc_mcu7t5v0__mux4_4
X_9793_ _9793_/D _9940_/CLK _9793_/Q PHY_9/VDD PHY_9/VDD VSUBS VSUBS gf180mcu_fd_sc_mcu7t5v0__dffq_1
X_5956_ _5956_/A1 _5973_/A2 _5956_/B _9680_/D PHY_9/VDD PHY_9/VDD VSUBS VSUBS gf180mcu_fd_sc_mcu7t5v0__aoi21_1
X_8744_ _8985_/C _8743_/Z _8744_/B _9317_/C _8745_/C PHY_9/VDD PHY_9/VDD VSUBS VSUBS
+ gf180mcu_fd_sc_mcu7t5v0__oai211_1
X_4907_ _9567_/Q _5731_/B2 PHY_9/VDD PHY_9/VDD VSUBS VSUBS gf180mcu_fd_sc_mcu7t5v0__clkinv_1
X_5887_ _5158_/I _5899_/A2 _5887_/Z PHY_9/VDD PHY_9/VDD VSUBS VSUBS gf180mcu_fd_sc_mcu7t5v0__or2_1
X_8675_ _8675_/A1 _8675_/A2 _8675_/B _8675_/C _8676_/A2 PHY_9/VDD PHY_9/VDD VSUBS
+ VSUBS gf180mcu_fd_sc_mcu7t5v0__oai211_1
X_7626_ _7473_/B _7655_/A2 _7626_/B _7671_/A1 PHY_9/VDD PHY_9/VDD VSUBS VSUBS gf180mcu_fd_sc_mcu7t5v0__aoi21_1
X_4838_ _9471_/Q _5369_/A1 PHY_9/VDD PHY_9/VDD VSUBS VSUBS gf180mcu_fd_sc_mcu7t5v0__clkinv_2
X_4769_ _9847_/Q _7145_/B PHY_9/VDD PHY_9/VDD VSUBS VSUBS gf180mcu_fd_sc_mcu7t5v0__clkinv_3
X_7557_ _7551_/Z _7606_/A1 _7558_/I PHY_9/VDD PHY_9/VDD VSUBS VSUBS gf180mcu_fd_sc_mcu7t5v0__xnor2_1
X_6508_ _6512_/B _6507_/Z _6510_/B PHY_9/VDD PHY_9/VDD VSUBS VSUBS gf180mcu_fd_sc_mcu7t5v0__xor2_1
X_7488_ _9874_/Q _9356_/C _7533_/A1 PHY_9/VDD PHY_9/VDD VSUBS VSUBS gf180mcu_fd_sc_mcu7t5v0__nand2_1
X_6439_ _9809_/Q _6474_/A2 _6435_/Z _6650_/A2 _6561_/B _6440_/C PHY_9/VDD PHY_9/VDD
+ VSUBS VSUBS gf180mcu_fd_sc_mcu7t5v0__aoi221_1
X_9227_ _9227_/A1 _9227_/A2 _9230_/A2 PHY_9/VDD PHY_9/VDD VSUBS VSUBS gf180mcu_fd_sc_mcu7t5v0__nor2_1
X_9158_ _9970_/Q _9176_/A1 _9155_/Z _9158_/Z PHY_9/VDD PHY_9/VDD VSUBS VSUBS gf180mcu_fd_sc_mcu7t5v0__xor3_1
X_8109_ _8309_/A2 _8075_/B _8192_/A2 PHY_9/VDD PHY_9/VDD VSUBS VSUBS gf180mcu_fd_sc_mcu7t5v0__nand2_1
X_9089_ _9347_/I1 _9109_/A1 _9089_/B _9348_/C _9095_/B2 PHY_9/VDD PHY_9/VDD VSUBS
+ VSUBS gf180mcu_fd_sc_mcu7t5v0__aoi211_1
X_6790_ _6791_/A1 _6789_/Z _6837_/A1 PHY_9/VDD PHY_9/VDD VSUBS VSUBS gf180mcu_fd_sc_mcu7t5v0__nand2_1
X_5810_ _8693_/A1 _5814_/A2 _5814_/B1 _5810_/B2 _9626_/D PHY_9/VDD PHY_9/VDD VSUBS
+ VSUBS gf180mcu_fd_sc_mcu7t5v0__oai22_1
X_5741_ _7007_/B _5749_/A2 _5749_/B1 PHY_9/VDD PHY_9/VDD VSUBS VSUBS gf180mcu_fd_sc_mcu7t5v0__nand2_2
X_8460_ _9928_/Q _9356_/C _8494_/A1 PHY_9/VDD PHY_9/VDD VSUBS VSUBS gf180mcu_fd_sc_mcu7t5v0__nand2_1
X_5672_ _9539_/Q _5670_/Z _5674_/A2 PHY_9/VDD PHY_9/VDD VSUBS VSUBS gf180mcu_fd_sc_mcu7t5v0__nor2_1
X_7411_ _9809_/Q _7411_/A2 _7411_/A3 _7449_/A1 PHY_9/VDD PHY_9/VDD VSUBS VSUBS gf180mcu_fd_sc_mcu7t5v0__nand3_1
X_8391_ _9807_/Q _8654_/A2 _8391_/B _8391_/C _8396_/B1 PHY_9/VDD PHY_9/VDD VSUBS VSUBS
+ gf180mcu_fd_sc_mcu7t5v0__oai211_1
X_7342_ _7370_/A1 _9036_/A2 _7342_/B _9867_/D PHY_9/VDD PHY_9/VDD VSUBS VSUBS gf180mcu_fd_sc_mcu7t5v0__aoi21_1
X_7273_ _7089_/B _7303_/A2 _7273_/B _7320_/A1 PHY_9/VDD PHY_9/VDD VSUBS VSUBS gf180mcu_fd_sc_mcu7t5v0__aoi21_1
X_6224_ _6224_/A1 _6224_/A2 _6233_/A2 PHY_9/VDD PHY_9/VDD VSUBS VSUBS gf180mcu_fd_sc_mcu7t5v0__nand2_1
X_9012_ _9012_/A1 _9010_/Z _9011_/Z _9012_/Z PHY_9/VDD PHY_9/VDD VSUBS VSUBS gf180mcu_fd_sc_mcu7t5v0__xor3_2
X_6155_ _9915_/Q _6287_/A2 _6287_/B1 _9860_/Q _6157_/A1 PHY_9/VDD PHY_9/VDD VSUBS
+ VSUBS gf180mcu_fd_sc_mcu7t5v0__aoi22_1
X_6086_ _5372_/Z _6086_/A2 _6086_/B1 _6656_/A2 _6088_/A2 PHY_9/VDD PHY_9/VDD VSUBS
+ VSUBS gf180mcu_fd_sc_mcu7t5v0__aoi22_1
X_5106_ _9721_/Q _6018_/B2 PHY_9/VDD PHY_9/VDD VSUBS VSUBS gf180mcu_fd_sc_mcu7t5v0__clkinv_1
X_9914_ _9914_/D _9948_/CLK _9914_/Q PHY_9/VDD PHY_9/VDD VSUBS VSUBS gf180mcu_fd_sc_mcu7t5v0__dffq_1
X_5037_ _9791_/Q _6311_/B2 PHY_9/VDD PHY_9/VDD VSUBS VSUBS gf180mcu_fd_sc_mcu7t5v0__clkinv_1
X_9845_ _9845_/D _9940_/CLK _9845_/Q PHY_9/VDD PHY_9/VDD VSUBS VSUBS gf180mcu_fd_sc_mcu7t5v0__dffq_4
X_9776_ _9776_/D _9901_/CLK _9776_/Q PHY_9/VDD PHY_9/VDD VSUBS VSUBS gf180mcu_fd_sc_mcu7t5v0__dffq_2
X_6988_ _6988_/A1 _6951_/Z _6988_/B _6995_/A1 PHY_9/VDD PHY_9/VDD VSUBS VSUBS gf180mcu_fd_sc_mcu7t5v0__oai21_1
X_8727_ _9950_/Q _8740_/A3 _8739_/A2 PHY_9/VDD PHY_9/VDD VSUBS VSUBS gf180mcu_fd_sc_mcu7t5v0__nand2_1
X_5939_ _5939_/A1 _5951_/A2 _5939_/B _9672_/D PHY_9/VDD PHY_9/VDD VSUBS VSUBS gf180mcu_fd_sc_mcu7t5v0__aoi21_1
X_8658_ _8651_/Z _8656_/Z _8658_/A3 _8658_/Z PHY_9/VDD PHY_9/VDD VSUBS VSUBS gf180mcu_fd_sc_mcu7t5v0__xor3_1
X_8589_ _8589_/A1 _8589_/A2 _9357_/B _9930_/D PHY_9/VDD PHY_9/VDD VSUBS VSUBS gf180mcu_fd_sc_mcu7t5v0__aoi21_1
X_7609_ _7601_/Z _7608_/Z _7660_/A1 PHY_9/VDD PHY_9/VDD VSUBS VSUBS gf180mcu_fd_sc_mcu7t5v0__nor2_1
X_7960_ _7960_/A1 _7960_/A2 _7960_/A3 _7960_/B1 _7960_/B2 _7962_/A2 PHY_9/VDD PHY_9/VDD
+ VSUBS VSUBS gf180mcu_fd_sc_mcu7t5v0__oai32_1
X_6911_ _6911_/A1 _6884_/Z _6935_/A2 _6886_/Z _6911_/B2 _6939_/A1 PHY_9/VDD PHY_9/VDD
+ VSUBS VSUBS gf180mcu_fd_sc_mcu7t5v0__oai32_2
X_7891_ _7892_/A1 _7989_/A1 _7936_/A2 PHY_9/VDD PHY_9/VDD VSUBS VSUBS gf180mcu_fd_sc_mcu7t5v0__nand2_1
X_6842_ _6946_/A1 _6837_/Z _6858_/C PHY_9/VDD PHY_9/VDD VSUBS VSUBS gf180mcu_fd_sc_mcu7t5v0__nand2_1
X_9630_ _9630_/D _9948_/CLK _9630_/Q PHY_9/VDD PHY_9/VDD VSUBS VSUBS gf180mcu_fd_sc_mcu7t5v0__dffq_1
X_6773_ _6815_/A1 _9818_/Q _6815_/B _6775_/A2 PHY_9/VDD PHY_9/VDD VSUBS VSUBS gf180mcu_fd_sc_mcu7t5v0__oai21_2
X_9561_ _9561_/D _9801_/CLK _9561_/Q PHY_9/VDD PHY_9/VDD VSUBS VSUBS gf180mcu_fd_sc_mcu7t5v0__dffq_1
X_8512_ _8514_/A2 _8511_/Z _8543_/B PHY_9/VDD PHY_9/VDD VSUBS VSUBS gf180mcu_fd_sc_mcu7t5v0__nor2_1
X_9492_ _9492_/D _9901_/CLK _9492_/Q PHY_9/VDD PHY_9/VDD VSUBS VSUBS gf180mcu_fd_sc_mcu7t5v0__dffq_1
X_5724_ _5399_/Z _5727_/A2 _5727_/B1 _5724_/B2 _9562_/D PHY_9/VDD PHY_9/VDD VSUBS
+ VSUBS gf180mcu_fd_sc_mcu7t5v0__oai22_1
X_5655_ _5404_/Z _5656_/A2 _5656_/B1 _5655_/B2 _9532_/D PHY_9/VDD PHY_9/VDD VSUBS
+ VSUBS gf180mcu_fd_sc_mcu7t5v0__oai22_1
X_8443_ _8782_/A2 _8461_/A1 _8455_/A2 _8443_/Z PHY_9/VDD PHY_9/VDD VSUBS VSUBS gf180mcu_fd_sc_mcu7t5v0__xor3_1
X_8374_ _8390_/A3 _8382_/A2 _8452_/B PHY_9/VDD PHY_9/VDD VSUBS VSUBS gf180mcu_fd_sc_mcu7t5v0__nand2_1
X_7325_ _9856_/Q _9317_/C _9100_/B _7326_/A2 PHY_9/VDD PHY_9/VDD VSUBS VSUBS gf180mcu_fd_sc_mcu7t5v0__oai21_1
X_5586_ _5594_/A1 _5586_/A2 _5586_/B _9495_/D PHY_9/VDD PHY_9/VDD VSUBS VSUBS gf180mcu_fd_sc_mcu7t5v0__aoi21_1
X_7256_ _7256_/A1 _7297_/B2 _7256_/A3 _7257_/B PHY_9/VDD PHY_9/VDD VSUBS VSUBS gf180mcu_fd_sc_mcu7t5v0__xnor3_1
X_7187_ _8165_/A3 _9356_/C _7187_/B1 _7187_/B2 _9357_/B _9853_/D PHY_9/VDD PHY_9/VDD
+ VSUBS VSUBS gf180mcu_fd_sc_mcu7t5v0__aoi221_1
X_6207_ _9486_/Q _6287_/A2 _6287_/B1 _9519_/Q _6209_/A1 PHY_9/VDD PHY_9/VDD VSUBS
+ VSUBS gf180mcu_fd_sc_mcu7t5v0__aoi22_1
X_6138_ _9576_/Q _6287_/B1 _6288_/B1 _9935_/Q _6140_/A1 PHY_9/VDD PHY_9/VDD VSUBS
+ VSUBS gf180mcu_fd_sc_mcu7t5v0__aoi22_1
X_6069_ _6069_/A1 _6069_/A2 _6087_/B2 PHY_9/VDD PHY_9/VDD VSUBS VSUBS gf180mcu_fd_sc_mcu7t5v0__nand2_1
X_9828_ _9828_/D _9830_/CLK _9828_/Q PHY_9/VDD PHY_9/VDD VSUBS VSUBS gf180mcu_fd_sc_mcu7t5v0__dffq_1
X_9759_ _9759_/D _9939_/CLK _9759_/Q PHY_9/VDD PHY_9/VDD VSUBS VSUBS gf180mcu_fd_sc_mcu7t5v0__dffq_1
X_5440_ _9433_/Q _9731_/Q _9031_/B _5441_/B PHY_9/VDD PHY_9/VDD VSUBS VSUBS gf180mcu_fd_sc_mcu7t5v0__oai21_1
X_5371_ _9495_/Q _9471_/Q _5559_/B _5371_/Z PHY_9/VDD PHY_9/VDD VSUBS VSUBS gf180mcu_fd_sc_mcu7t5v0__mux2_4
X_7110_ _9807_/Q _7293_/A2 _7149_/A1 PHY_9/VDD PHY_9/VDD VSUBS VSUBS gf180mcu_fd_sc_mcu7t5v0__nand2_1
X_8090_ _9905_/Q _8087_/Z _8096_/B PHY_9/VDD PHY_9/VDD VSUBS VSUBS gf180mcu_fd_sc_mcu7t5v0__and2_1
X_7041_ _7069_/A2 _7041_/A2 _9356_/C _7042_/B2 PHY_9/VDD PHY_9/VDD VSUBS VSUBS gf180mcu_fd_sc_mcu7t5v0__aoi21_1
X_8992_ _8992_/A1 _8992_/A2 _8992_/B _9010_/A1 PHY_9/VDD PHY_9/VDD VSUBS VSUBS gf180mcu_fd_sc_mcu7t5v0__oai21_1
X_7943_ _7944_/A1 _7944_/A2 _7943_/Z PHY_9/VDD PHY_9/VDD VSUBS VSUBS gf180mcu_fd_sc_mcu7t5v0__and2_1
X_7874_ _9811_/Q _8008_/I0 _7836_/Z _7876_/A1 PHY_9/VDD PHY_9/VDD VSUBS VSUBS gf180mcu_fd_sc_mcu7t5v0__nand3_1
X_6825_ _6828_/A2 _6828_/A3 _6874_/A2 PHY_9/VDD PHY_9/VDD VSUBS VSUBS gf180mcu_fd_sc_mcu7t5v0__nand2_1
X_9613_ _9613_/D _9830_/CLK _9613_/Q PHY_9/VDD PHY_9/VDD VSUBS VSUBS gf180mcu_fd_sc_mcu7t5v0__dffq_1
X_6756_ _6715_/Z _6757_/A2 _6757_/B _6766_/A1 PHY_9/VDD PHY_9/VDD VSUBS VSUBS gf180mcu_fd_sc_mcu7t5v0__nor3_1
X_9544_ _9544_/D _9689_/CLK _9544_/Q PHY_9/VDD PHY_9/VDD VSUBS VSUBS gf180mcu_fd_sc_mcu7t5v0__dffq_1
X_5707_ _6089_/B _5715_/A2 _5715_/B1 PHY_9/VDD PHY_9/VDD VSUBS VSUBS gf180mcu_fd_sc_mcu7t5v0__nand2_2
X_6687_ _6698_/A2 _6699_/A3 _6696_/B PHY_9/VDD PHY_9/VDD VSUBS VSUBS gf180mcu_fd_sc_mcu7t5v0__nor2_2
X_9475_ _9475_/D _9801_/CLK _9475_/Q PHY_9/VDD PHY_9/VDD VSUBS VSUBS gf180mcu_fd_sc_mcu7t5v0__dffq_2
X_8426_ _9317_/C _8426_/A2 _8426_/B _9926_/D PHY_9/VDD PHY_9/VDD VSUBS VSUBS gf180mcu_fd_sc_mcu7t5v0__aoi21_1
X_5638_ _9031_/B _5646_/A2 _5646_/B1 PHY_9/VDD PHY_9/VDD VSUBS VSUBS gf180mcu_fd_sc_mcu7t5v0__nand2_2
X_8357_ _8372_/A2 _9034_/A2 _8357_/B _9921_/D PHY_9/VDD PHY_9/VDD VSUBS VSUBS gf180mcu_fd_sc_mcu7t5v0__aoi21_1
X_5569_ _5569_/A1 _5569_/A2 _5973_/C _9492_/D PHY_9/VDD PHY_9/VDD VSUBS VSUBS gf180mcu_fd_sc_mcu7t5v0__aoi21_1
X_7308_ _7308_/A1 _7295_/Z _7307_/Z _7308_/Z PHY_9/VDD PHY_9/VDD VSUBS VSUBS gf180mcu_fd_sc_mcu7t5v0__xor3_1
X_8288_ _9910_/Q _8287_/Z _8306_/B PHY_9/VDD PHY_9/VDD VSUBS VSUBS gf180mcu_fd_sc_mcu7t5v0__and2_1
X_7239_ _9842_/Q _7299_/A2 _7299_/B1 _9910_/Q _7240_/A2 PHY_9/VDD PHY_9/VDD VSUBS
+ VSUBS gf180mcu_fd_sc_mcu7t5v0__aoi22_1
X_4940_ _9420_/Q _5395_/A1 PHY_9/VDD PHY_9/VDD VSUBS VSUBS gf180mcu_fd_sc_mcu7t5v0__clkinv_1
X_4871_ _9590_/Q _5762_/B2 PHY_9/VDD PHY_9/VDD VSUBS VSUBS gf180mcu_fd_sc_mcu7t5v0__clkinv_1
X_6610_ _6644_/A1 _6609_/Z _6611_/B PHY_9/VDD PHY_9/VDD VSUBS VSUBS gf180mcu_fd_sc_mcu7t5v0__nand2_1
X_7590_ _7620_/A1 _7563_/Z _7621_/A2 PHY_9/VDD PHY_9/VDD VSUBS VSUBS gf180mcu_fd_sc_mcu7t5v0__nor2_1
X_6541_ _6567_/A1 _6540_/Z _6542_/A2 PHY_9/VDD PHY_9/VDD VSUBS VSUBS gf180mcu_fd_sc_mcu7t5v0__xnor2_1
X_6472_ _6614_/B _6578_/A1 _6473_/B1 PHY_9/VDD PHY_9/VDD VSUBS VSUBS gf180mcu_fd_sc_mcu7t5v0__nor2_1
X_9260_ _9812_/Q _9313_/A2 _9347_/I1 _9261_/A2 _9348_/C _9261_/B PHY_9/VDD PHY_9/VDD
+ VSUBS VSUBS gf180mcu_fd_sc_mcu7t5v0__aoi221_1
X_9191_ _9191_/A1 _9191_/A2 _9281_/A1 _9192_/B PHY_9/VDD PHY_9/VDD VSUBS VSUBS gf180mcu_fd_sc_mcu7t5v0__xor3_1
X_5423_ _5423_/I _5424_/B1 PHY_9/VDD PHY_9/VDD VSUBS VSUBS gf180mcu_fd_sc_mcu7t5v0__clkinv_1
X_8211_ _8318_/B _9896_/Q _9511_/Q _8035_/Z _8317_/B1 _9854_/Q _8213_/A2 PHY_9/VDD
+ PHY_9/VDD VSUBS VSUBS gf180mcu_fd_sc_mcu7t5v0__aoi222_4
X_5354_ _5261_/Z _5354_/A2 _5364_/A2 PHY_9/VDD PHY_9/VDD VSUBS VSUBS gf180mcu_fd_sc_mcu7t5v0__nand2_4
X_8142_ _9907_/Q _8141_/Z _8162_/A2 PHY_9/VDD PHY_9/VDD VSUBS VSUBS gf180mcu_fd_sc_mcu7t5v0__nor2_1
X_8073_ _8309_/A2 _8110_/B _8077_/A3 PHY_9/VDD PHY_9/VDD VSUBS VSUBS gf180mcu_fd_sc_mcu7t5v0__nor2_1
X_5285_ _5853_/A1 _5285_/A2 _5285_/B _5973_/C _9382_/D PHY_9/VDD PHY_9/VDD VSUBS VSUBS
+ gf180mcu_fd_sc_mcu7t5v0__aoi211_1
X_7024_ _9846_/Q _7028_/S _7314_/I0 PHY_9/VDD PHY_9/VDD VSUBS VSUBS gf180mcu_fd_sc_mcu7t5v0__nor2_1
X_8975_ _8975_/A1 _8975_/A2 _8980_/A1 PHY_9/VDD PHY_9/VDD VSUBS VSUBS gf180mcu_fd_sc_mcu7t5v0__nand2_1
X_7926_ _8004_/B _7926_/A2 _7926_/A3 _7926_/A4 _7928_/B1 PHY_9/VDD PHY_9/VDD VSUBS
+ VSUBS gf180mcu_fd_sc_mcu7t5v0__nand4_1
X_7857_ _7960_/B2 _7856_/Z _7960_/A2 PHY_9/VDD PHY_9/VDD VSUBS VSUBS gf180mcu_fd_sc_mcu7t5v0__nand2_1
X_6808_ _6946_/A1 _6791_/Z _6808_/B _6808_/C _6809_/B PHY_9/VDD PHY_9/VDD VSUBS VSUBS
+ gf180mcu_fd_sc_mcu7t5v0__aoi211_1
X_7788_ _9809_/Q _7789_/A3 _7819_/A2 PHY_9/VDD PHY_9/VDD VSUBS VSUBS gf180mcu_fd_sc_mcu7t5v0__nor2_1
X_6739_ _9851_/Q _9835_/Q _6740_/B2 PHY_9/VDD PHY_9/VDD VSUBS VSUBS gf180mcu_fd_sc_mcu7t5v0__nand2_1
X_9527_ _9527_/D _9830_/CLK _9527_/Q PHY_9/VDD PHY_9/VDD VSUBS VSUBS gf180mcu_fd_sc_mcu7t5v0__dffq_1
X_9458_ _9458_/D _9800_/CLK _9458_/Q PHY_9/VDD PHY_9/VDD VSUBS VSUBS gf180mcu_fd_sc_mcu7t5v0__dffq_2
X_8409_ _9807_/Q _8369_/Z _8408_/B _8420_/A1 PHY_9/VDD PHY_9/VDD VSUBS VSUBS gf180mcu_fd_sc_mcu7t5v0__nor3_1
X_9389_ _9389_/D _9940_/CLK _9389_/Q PHY_9/VDD PHY_9/VDD VSUBS VSUBS gf180mcu_fd_sc_mcu7t5v0__dffq_1
X_5070_ _9768_/Q _6058_/B2 PHY_9/VDD PHY_9/VDD VSUBS VSUBS gf180mcu_fd_sc_mcu7t5v0__clkinv_1
X_5972_ _5972_/I _5973_/B PHY_9/VDD PHY_9/VDD VSUBS VSUBS gf180mcu_fd_sc_mcu7t5v0__clkinv_1
X_8760_ _8760_/A1 _8758_/Z _8980_/B _8770_/A2 PHY_9/VDD PHY_9/VDD VSUBS VSUBS gf180mcu_fd_sc_mcu7t5v0__oai21_1
X_4923_ _9913_/Q _8347_/B2 PHY_9/VDD PHY_9/VDD VSUBS VSUBS gf180mcu_fd_sc_mcu7t5v0__clkinv_1
X_7711_ _9888_/Q _7711_/A2 _7791_/A2 PHY_9/VDD PHY_9/VDD VSUBS VSUBS gf180mcu_fd_sc_mcu7t5v0__nand2_1
X_8691_ _8691_/A1 _8697_/A2 _8697_/B1 _8691_/B2 _9942_/D PHY_9/VDD PHY_9/VDD VSUBS
+ VSUBS gf180mcu_fd_sc_mcu7t5v0__oai22_1
X_7642_ _7642_/A1 _7642_/A2 _7642_/B _7662_/A1 PHY_9/VDD PHY_9/VDD VSUBS VSUBS gf180mcu_fd_sc_mcu7t5v0__oai21_1
X_4854_ _9414_/Q _5358_/A1 PHY_9/VDD PHY_9/VDD VSUBS VSUBS gf180mcu_fd_sc_mcu7t5v0__clkinv_1
X_4785_ _9394_/Q _5312_/A1 PHY_9/VDD PHY_9/VDD VSUBS VSUBS gf180mcu_fd_sc_mcu7t5v0__clkinv_1
X_7573_ _7655_/A2 _7626_/B _7575_/A2 PHY_9/VDD PHY_9/VDD VSUBS VSUBS gf180mcu_fd_sc_mcu7t5v0__xnor2_1
X_6524_ _6524_/A1 _6524_/A2 _6634_/A2 PHY_9/VDD PHY_9/VDD VSUBS VSUBS gf180mcu_fd_sc_mcu7t5v0__nand2_4
X_9312_ _9813_/Q _9351_/A2 _9314_/A2 PHY_9/VDD PHY_9/VDD VSUBS VSUBS gf180mcu_fd_sc_mcu7t5v0__nand2_1
X_9243_ _9243_/A1 _9242_/B _9243_/Z PHY_9/VDD PHY_9/VDD VSUBS VSUBS gf180mcu_fd_sc_mcu7t5v0__xor2_1
X_6455_ _6455_/A1 _6455_/A2 _6530_/B2 _6458_/A3 PHY_9/VDD PHY_9/VDD VSUBS VSUBS gf180mcu_fd_sc_mcu7t5v0__xnor3_1
X_6386_ _9837_/Q _9806_/Q _9805_/Q _6388_/B PHY_9/VDD PHY_9/VDD VSUBS VSUBS gf180mcu_fd_sc_mcu7t5v0__nand3_2
X_9174_ _9343_/B _9158_/Z _9174_/B _9317_/C _9175_/A2 PHY_9/VDD PHY_9/VDD VSUBS VSUBS
+ gf180mcu_fd_sc_mcu7t5v0__oai211_1
X_5406_ _9357_/A1 _5523_/A1 _5559_/B _5406_/Z PHY_9/VDD PHY_9/VDD VSUBS VSUBS gf180mcu_fd_sc_mcu7t5v0__mux2_4
X_5337_ _9462_/Q _5342_/A2 _7007_/B _5338_/B PHY_9/VDD PHY_9/VDD VSUBS VSUBS gf180mcu_fd_sc_mcu7t5v0__oai21_1
X_8125_ _8318_/B _9894_/Q _9509_/Q _8035_/Z _8317_/B1 _9852_/Q _8127_/A2 PHY_9/VDD
+ PHY_9/VDD VSUBS VSUBS gf180mcu_fd_sc_mcu7t5v0__aoi222_4
X_8056_ _9807_/Q _8300_/A2 _8086_/A1 _8056_/B2 _8300_/C _8059_/B2 PHY_9/VDD PHY_9/VDD
+ VSUBS VSUBS gf180mcu_fd_sc_mcu7t5v0__aoi221_1
X_5268_ _5268_/A1 _5272_/A2 _5268_/B _9375_/D PHY_9/VDD PHY_9/VDD VSUBS VSUBS gf180mcu_fd_sc_mcu7t5v0__aoi21_1
X_7007_ _9390_/Q _9036_/A2 _7007_/B _7008_/B PHY_9/VDD PHY_9/VDD VSUBS VSUBS gf180mcu_fd_sc_mcu7t5v0__oai21_1
X_5199_ _5199_/I _5202_/C PHY_9/VDD PHY_9/VDD VSUBS VSUBS gf180mcu_fd_sc_mcu7t5v0__inv_1
X_8958_ _9813_/Q _8958_/A2 _9007_/A1 PHY_9/VDD PHY_9/VDD VSUBS VSUBS gf180mcu_fd_sc_mcu7t5v0__nand2_1
X_7909_ _9896_/Q _7912_/A2 _7930_/A2 PHY_9/VDD PHY_9/VDD VSUBS VSUBS gf180mcu_fd_sc_mcu7t5v0__nor2_1
X_8889_ _8985_/C _8889_/A2 _9356_/C _8890_/B2 PHY_9/VDD PHY_9/VDD VSUBS VSUBS gf180mcu_fd_sc_mcu7t5v0__aoi21_1
X_6240_ _9696_/Q _6288_/A2 _6288_/B1 _9712_/Q _6241_/A2 PHY_9/VDD PHY_9/VDD VSUBS
+ VSUBS gf180mcu_fd_sc_mcu7t5v0__aoi22_1
X_6171_ _9634_/Q _6288_/A2 _6288_/B1 _9618_/Q _6172_/A2 PHY_9/VDD PHY_9/VDD VSUBS
+ VSUBS gf180mcu_fd_sc_mcu7t5v0__aoi22_1
X_5122_ _9713_/Q _6008_/B2 PHY_9/VDD PHY_9/VDD VSUBS VSUBS gf180mcu_fd_sc_mcu7t5v0__clkinv_1
X_5053_ _9862_/Q _7334_/B2 PHY_9/VDD PHY_9/VDD VSUBS VSUBS gf180mcu_fd_sc_mcu7t5v0__clkinv_1
X_9930_ _9930_/D _9957_/CLK _9930_/Q PHY_9/VDD PHY_9/VDD VSUBS VSUBS gf180mcu_fd_sc_mcu7t5v0__dffq_2
X_9861_ _9861_/D _9948_/CLK _9861_/Q PHY_9/VDD PHY_9/VDD VSUBS VSUBS gf180mcu_fd_sc_mcu7t5v0__dffq_1
X_8812_ _8812_/A1 _8793_/Z _8812_/B _8848_/A1 PHY_9/VDD PHY_9/VDD VSUBS VSUBS gf180mcu_fd_sc_mcu7t5v0__aoi21_1
X_9792_ _9792_/D _9830_/CLK _9792_/Q PHY_9/VDD PHY_9/VDD VSUBS VSUBS gf180mcu_fd_sc_mcu7t5v0__dffq_1
X_5955_ _9681_/Q _5973_/A2 _5961_/B _5956_/B PHY_9/VDD PHY_9/VDD VSUBS VSUBS gf180mcu_fd_sc_mcu7t5v0__oai21_1
X_8743_ _9954_/Q _8736_/B _8743_/Z PHY_9/VDD PHY_9/VDD VSUBS VSUBS gf180mcu_fd_sc_mcu7t5v0__xor2_1
X_4906_ _9551_/Q _5709_/B2 PHY_9/VDD PHY_9/VDD VSUBS VSUBS gf180mcu_fd_sc_mcu7t5v0__clkinv_1
X_5886_ _9480_/Q _9478_/Q _5899_/A2 PHY_9/VDD PHY_9/VDD VSUBS VSUBS gf180mcu_fd_sc_mcu7t5v0__nor2_1
X_8674_ _9814_/Q _8674_/A2 _8674_/B _8674_/C _8675_/A2 PHY_9/VDD PHY_9/VDD VSUBS VSUBS
+ gf180mcu_fd_sc_mcu7t5v0__aoi211_1
X_7625_ _7625_/A1 _7621_/Z _7638_/A2 PHY_9/VDD PHY_9/VDD VSUBS VSUBS gf180mcu_fd_sc_mcu7t5v0__nand2_1
X_4837_ _9472_/Q _5319_/A1 PHY_9/VDD PHY_9/VDD VSUBS VSUBS gf180mcu_fd_sc_mcu7t5v0__clkinv_1
X_4768_ _9848_/Q _7045_/B2 PHY_9/VDD PHY_9/VDD VSUBS VSUBS gf180mcu_fd_sc_mcu7t5v0__inv_2
X_7556_ _7551_/Z _7606_/A1 _7612_/A1 PHY_9/VDD PHY_9/VDD VSUBS VSUBS gf180mcu_fd_sc_mcu7t5v0__nor2_1
X_6507_ _6577_/A2 _6507_/A2 _6507_/Z PHY_9/VDD PHY_9/VDD VSUBS VSUBS gf180mcu_fd_sc_mcu7t5v0__xor2_1
X_7487_ _7487_/A1 _7487_/A2 _9357_/B _9873_/D PHY_9/VDD PHY_9/VDD VSUBS VSUBS gf180mcu_fd_sc_mcu7t5v0__aoi21_1
X_4699_ _9953_/Q _8994_/A1 PHY_9/VDD PHY_9/VDD VSUBS VSUBS gf180mcu_fd_sc_mcu7t5v0__clkinv_4
X_6438_ _9809_/Q _6627_/A2 _6438_/B1 _6401_/C _6440_/B PHY_9/VDD PHY_9/VDD VSUBS VSUBS
+ gf180mcu_fd_sc_mcu7t5v0__oai22_1
X_9226_ _9807_/Q _9322_/A2 _9232_/A1 PHY_9/VDD PHY_9/VDD VSUBS VSUBS gf180mcu_fd_sc_mcu7t5v0__nand2_1
X_9157_ _9970_/Q _9155_/Z _9176_/B PHY_9/VDD PHY_9/VDD VSUBS VSUBS gf180mcu_fd_sc_mcu7t5v0__and2_1
X_6369_ _6408_/A2 _6400_/A2 _6651_/A1 _6370_/B PHY_9/VDD PHY_9/VDD VSUBS VSUBS gf180mcu_fd_sc_mcu7t5v0__nand3_1
X_8108_ _8108_/A1 _8077_/Z _8108_/B _8145_/A1 PHY_9/VDD PHY_9/VDD VSUBS VSUBS gf180mcu_fd_sc_mcu7t5v0__aoi21_1
X_9088_ _9314_/A1 _9109_/A1 _9089_/B PHY_9/VDD PHY_9/VDD VSUBS VSUBS gf180mcu_fd_sc_mcu7t5v0__nor2_1
X_8039_ _9903_/Q _8318_/B _8317_/B1 PHY_9/VDD PHY_9/VDD VSUBS VSUBS gf180mcu_fd_sc_mcu7t5v0__nor2_4
X_5740_ _7327_/A1 _8678_/A2 _5749_/A2 PHY_9/VDD PHY_9/VDD VSUBS VSUBS gf180mcu_fd_sc_mcu7t5v0__nand2_4
X_7410_ _9809_/Q _7647_/A2 _7448_/A1 PHY_9/VDD PHY_9/VDD VSUBS VSUBS gf180mcu_fd_sc_mcu7t5v0__nand2_1
X_5671_ _5659_/I _5671_/A2 _5670_/Z _9538_/D PHY_9/VDD PHY_9/VDD VSUBS VSUBS gf180mcu_fd_sc_mcu7t5v0__nor3_1
X_8390_ _9922_/Q _9921_/Q _8390_/A3 _8391_/C PHY_9/VDD PHY_9/VDD VSUBS VSUBS gf180mcu_fd_sc_mcu7t5v0__nand3_4
X_7341_ _9385_/Q _9036_/A2 _7695_/B _7342_/B PHY_9/VDD PHY_9/VDD VSUBS VSUBS gf180mcu_fd_sc_mcu7t5v0__oai21_1
X_7272_ _6558_/B _7224_/Z _7272_/B _7278_/A1 PHY_9/VDD PHY_9/VDD VSUBS VSUBS gf180mcu_fd_sc_mcu7t5v0__oai21_1
X_6223_ _9423_/Q _6288_/A2 _6288_/B1 _9555_/Q _6224_/A2 PHY_9/VDD PHY_9/VDD VSUBS
+ VSUBS gf180mcu_fd_sc_mcu7t5v0__aoi22_1
X_9011_ _9011_/A1 _9011_/A2 _9011_/Z PHY_9/VDD PHY_9/VDD VSUBS VSUBS gf180mcu_fd_sc_mcu7t5v0__xor2_1
X_6154_ _6154_/A1 _6154_/A2 _6276_/B _6175_/C PHY_9/VDD PHY_9/VDD VSUBS VSUBS gf180mcu_fd_sc_mcu7t5v0__aoi21_1
X_5105_ _9745_/Q _6029_/B2 PHY_9/VDD PHY_9/VDD VSUBS VSUBS gf180mcu_fd_sc_mcu7t5v0__clkinv_1
X_6085_ _6283_/B2 _6085_/A2 _6085_/B1 _6291_/B2 _6088_/A1 PHY_9/VDD PHY_9/VDD VSUBS
+ VSUBS gf180mcu_fd_sc_mcu7t5v0__aoi22_1
X_9913_ _9913_/D _9948_/CLK _9913_/Q PHY_9/VDD PHY_9/VDD VSUBS VSUBS gf180mcu_fd_sc_mcu7t5v0__dffq_1
X_5036_ _9423_/Q _5403_/A1 PHY_9/VDD PHY_9/VDD VSUBS VSUBS gf180mcu_fd_sc_mcu7t5v0__clkinv_1
X_9844_ _9844_/D _9940_/CLK _9844_/Q PHY_9/VDD PHY_9/VDD VSUBS VSUBS gf180mcu_fd_sc_mcu7t5v0__dffq_2
X_6987_ _6700_/C _6986_/Z _7000_/B PHY_9/VDD PHY_9/VDD VSUBS VSUBS gf180mcu_fd_sc_mcu7t5v0__nor2_1
X_9775_ _9775_/D _9901_/CLK _9775_/Q PHY_9/VDD PHY_9/VDD VSUBS VSUBS gf180mcu_fd_sc_mcu7t5v0__dffq_2
X_5938_ _9680_/Q _5951_/A2 _5961_/B _5939_/B PHY_9/VDD PHY_9/VDD VSUBS VSUBS gf180mcu_fd_sc_mcu7t5v0__oai21_1
X_8726_ _9949_/Q _9022_/B _8982_/B1 PHY_9/VDD PHY_9/VDD VSUBS VSUBS gf180mcu_fd_sc_mcu7t5v0__nor2_2
X_8657_ _8657_/A1 _8657_/A2 _8657_/B1 _8657_/B2 _8658_/A3 PHY_9/VDD PHY_9/VDD VSUBS
+ VSUBS gf180mcu_fd_sc_mcu7t5v0__oai22_1
X_5869_ _9647_/Q _5832_/Z _5869_/B _5870_/I PHY_9/VDD PHY_9/VDD VSUBS VSUBS gf180mcu_fd_sc_mcu7t5v0__oai21_1
X_8588_ _8391_/C _8573_/Z _8588_/B _9317_/C _8589_/A2 PHY_9/VDD PHY_9/VDD VSUBS VSUBS
+ gf180mcu_fd_sc_mcu7t5v0__oai211_1
X_7608_ _7656_/S _7608_/A2 _7608_/Z PHY_9/VDD PHY_9/VDD VSUBS VSUBS gf180mcu_fd_sc_mcu7t5v0__or2_1
X_7539_ _9812_/Q _7647_/A2 _7539_/Z PHY_9/VDD PHY_9/VDD VSUBS VSUBS gf180mcu_fd_sc_mcu7t5v0__and2_1
X_9209_ _9209_/A1 _9209_/A2 _9209_/B _9210_/I PHY_9/VDD PHY_9/VDD VSUBS VSUBS gf180mcu_fd_sc_mcu7t5v0__aoi21_1
X_6910_ _6910_/A1 _6892_/Z _6910_/B _6962_/A1 PHY_9/VDD PHY_9/VDD VSUBS VSUBS gf180mcu_fd_sc_mcu7t5v0__aoi21_1
X_7890_ _7892_/A1 _7989_/A1 _7936_/B PHY_9/VDD PHY_9/VDD VSUBS VSUBS gf180mcu_fd_sc_mcu7t5v0__nor2_1
X_6841_ _6808_/C _6840_/Z _6860_/B1 PHY_9/VDD PHY_9/VDD VSUBS VSUBS gf180mcu_fd_sc_mcu7t5v0__nand2_1
X_9560_ _9560_/D _9801_/CLK _9560_/Q PHY_9/VDD PHY_9/VDD VSUBS VSUBS gf180mcu_fd_sc_mcu7t5v0__dffq_1
X_6772_ _9852_/Q _6771_/Z _6775_/A1 PHY_9/VDD PHY_9/VDD VSUBS VSUBS gf180mcu_fd_sc_mcu7t5v0__nand2_1
X_8511_ _8511_/A1 _8511_/A2 _8603_/A1 _8511_/Z PHY_9/VDD PHY_9/VDD VSUBS VSUBS gf180mcu_fd_sc_mcu7t5v0__xor3_1
X_9491_ _9491_/D _9972_/CLK _9491_/Q PHY_9/VDD PHY_9/VDD VSUBS VSUBS gf180mcu_fd_sc_mcu7t5v0__dffq_4
X_5723_ _8693_/A1 _5727_/A2 _5727_/B1 _5723_/B2 _9561_/D PHY_9/VDD PHY_9/VDD VSUBS
+ VSUBS gf180mcu_fd_sc_mcu7t5v0__oai22_1
X_5654_ _8695_/A1 _5656_/A2 _5656_/B1 _5654_/B2 _9531_/D PHY_9/VDD PHY_9/VDD VSUBS
+ VSUBS gf180mcu_fd_sc_mcu7t5v0__oai22_1
X_8442_ _8782_/A2 _8455_/A2 _8461_/B PHY_9/VDD PHY_9/VDD VSUBS VSUBS gf180mcu_fd_sc_mcu7t5v0__or2_1
X_8373_ _9920_/Q _8381_/A2 _8673_/I1 PHY_9/VDD PHY_9/VDD VSUBS VSUBS gf180mcu_fd_sc_mcu7t5v0__nor2_2
X_7324_ _7139_/C _7311_/Z _7324_/B _7326_/A1 PHY_9/VDD PHY_9/VDD VSUBS VSUBS gf180mcu_fd_sc_mcu7t5v0__aoi21_1
X_5585_ _9495_/Q _5594_/A1 _7007_/B _5586_/B PHY_9/VDD PHY_9/VDD VSUBS VSUBS gf180mcu_fd_sc_mcu7t5v0__oai21_1
X_7255_ _7256_/A1 _7256_/A3 _7255_/Z PHY_9/VDD PHY_9/VDD VSUBS VSUBS gf180mcu_fd_sc_mcu7t5v0__and2_1
X_7186_ _7040_/B _7186_/A2 _9356_/C _7187_/B2 PHY_9/VDD PHY_9/VDD VSUBS VSUBS gf180mcu_fd_sc_mcu7t5v0__aoi21_1
X_6206_ _9031_/B _6206_/A2 _9774_/D PHY_9/VDD PHY_9/VDD VSUBS VSUBS gf180mcu_fd_sc_mcu7t5v0__and2_1
X_6137_ _6137_/A1 _6137_/A2 _6146_/B1 PHY_9/VDD PHY_9/VDD VSUBS VSUBS gf180mcu_fd_sc_mcu7t5v0__nand2_1
X_6068_ _9878_/Q _6288_/A2 _6288_/B1 _9941_/Q _6069_/A2 PHY_9/VDD PHY_9/VDD VSUBS
+ VSUBS gf180mcu_fd_sc_mcu7t5v0__aoi22_1
X_5019_ _9916_/Q _8350_/B2 PHY_9/VDD PHY_9/VDD VSUBS VSUBS gf180mcu_fd_sc_mcu7t5v0__clkinv_1
X_9827_ _9827_/D _9830_/CLK _9827_/Q PHY_9/VDD PHY_9/VDD VSUBS VSUBS gf180mcu_fd_sc_mcu7t5v0__dffq_1
X_9758_ _9758_/D _9939_/CLK _9758_/Q PHY_9/VDD PHY_9/VDD VSUBS VSUBS gf180mcu_fd_sc_mcu7t5v0__dffq_1
X_8709_ _9950_/Q _9949_/Q _8885_/A1 PHY_9/VDD PHY_9/VDD VSUBS VSUBS gf180mcu_fd_sc_mcu7t5v0__nand2_2
X_9689_ _9689_/D _9689_/CLK _9689_/Q PHY_9/VDD PHY_9/VDD VSUBS VSUBS gf180mcu_fd_sc_mcu7t5v0__dffq_1
X_5370_ _9495_/Q _5201_/Z _5370_/B _6066_/A1 PHY_9/VDD PHY_9/VDD VSUBS VSUBS gf180mcu_fd_sc_mcu7t5v0__aoi21_4
X_7040_ _8037_/A2 _7084_/A1 _7040_/B _7041_/A2 PHY_9/VDD PHY_9/VDD VSUBS VSUBS gf180mcu_fd_sc_mcu7t5v0__aoi21_1
X_8991_ _8971_/S _8991_/A2 _8991_/B _9012_/A1 PHY_9/VDD PHY_9/VDD VSUBS VSUBS gf180mcu_fd_sc_mcu7t5v0__oai21_1
X_7942_ _9810_/Q _7836_/Z _7989_/A2 PHY_9/VDD PHY_9/VDD VSUBS VSUBS gf180mcu_fd_sc_mcu7t5v0__nand2_1
X_9612_ _9612_/D _9830_/CLK _9612_/Q PHY_9/VDD PHY_9/VDD VSUBS VSUBS gf180mcu_fd_sc_mcu7t5v0__dffq_1
X_7873_ _9811_/Q _7836_/Z _7875_/B2 PHY_9/VDD PHY_9/VDD VSUBS VSUBS gf180mcu_fd_sc_mcu7t5v0__nand2_1
X_6824_ _9811_/Q _6824_/A2 _6824_/A3 _6828_/A3 PHY_9/VDD PHY_9/VDD VSUBS VSUBS gf180mcu_fd_sc_mcu7t5v0__nand3_2
X_6755_ _9227_/A1 _6974_/A2 _6755_/A3 _6757_/B PHY_9/VDD PHY_9/VDD VSUBS VSUBS gf180mcu_fd_sc_mcu7t5v0__xor3_1
X_9543_ _9543_/D _9689_/CLK _9543_/Q PHY_9/VDD PHY_9/VDD VSUBS VSUBS gf180mcu_fd_sc_mcu7t5v0__dffq_1
X_5706_ _5372_/Z _8688_/A1 _5715_/A2 PHY_9/VDD PHY_9/VDD VSUBS VSUBS gf180mcu_fd_sc_mcu7t5v0__nand2_4
X_9474_ _9474_/D _9801_/CLK _9474_/Q PHY_9/VDD PHY_9/VDD VSUBS VSUBS gf180mcu_fd_sc_mcu7t5v0__dffq_2
X_6686_ _9833_/Q _9832_/Q _6752_/A2 PHY_9/VDD PHY_9/VDD VSUBS VSUBS gf180mcu_fd_sc_mcu7t5v0__nor2_2
X_8425_ _9926_/Q _9317_/C _9100_/B _8426_/B PHY_9/VDD PHY_9/VDD VSUBS VSUBS gf180mcu_fd_sc_mcu7t5v0__oai21_1
X_5637_ _6283_/B2 _7327_/A1 _5646_/A2 PHY_9/VDD PHY_9/VDD VSUBS VSUBS gf180mcu_fd_sc_mcu7t5v0__nand2_4
X_8356_ _9369_/Q _9036_/A2 rst_n _8357_/B PHY_9/VDD PHY_9/VDD VSUBS VSUBS gf180mcu_fd_sc_mcu7t5v0__oai21_1
X_5568_ _9492_/Q _5567_/Z _5569_/A2 PHY_9/VDD PHY_9/VDD VSUBS VSUBS gf180mcu_fd_sc_mcu7t5v0__nand2_1
X_7307_ _7307_/A1 _7305_/Z _7307_/A3 _7307_/Z PHY_9/VDD PHY_9/VDD VSUBS VSUBS gf180mcu_fd_sc_mcu7t5v0__xor3_1
X_8287_ _8284_/Z _8287_/A2 _8287_/Z PHY_9/VDD PHY_9/VDD VSUBS VSUBS gf180mcu_fd_sc_mcu7t5v0__xor2_1
X_7238_ _9848_/Q _9847_/Q _9512_/Q _7240_/A1 PHY_9/VDD PHY_9/VDD VSUBS VSUBS gf180mcu_fd_sc_mcu7t5v0__nand3_1
X_5499_ _9434_/Q _5498_/Z _5502_/B2 PHY_9/VDD PHY_9/VDD VSUBS VSUBS gf180mcu_fd_sc_mcu7t5v0__nand2_1
X_7169_ _7139_/C _7168_/Z _7187_/B1 PHY_9/VDD PHY_9/VDD VSUBS VSUBS gf180mcu_fd_sc_mcu7t5v0__nand2_1
X_4870_ _9933_/Q _8680_/B2 PHY_9/VDD PHY_9/VDD VSUBS VSUBS gf180mcu_fd_sc_mcu7t5v0__clkinv_1
X_6540_ _6540_/A1 _6540_/A2 _6540_/Z PHY_9/VDD PHY_9/VDD VSUBS VSUBS gf180mcu_fd_sc_mcu7t5v0__xor2_1
Xclkbuf_leaf_12_clk clkbuf_leaf_9_clk/I _9689_/CLK PHY_9/VDD PHY_9/VDD VSUBS VSUBS
+ gf180mcu_fd_sc_mcu7t5v0__clkbuf_16
X_6471_ _6471_/A1 _6471_/A2 _6471_/B _6578_/A1 PHY_9/VDD PHY_9/VDD VSUBS VSUBS gf180mcu_fd_sc_mcu7t5v0__aoi21_2
X_8210_ _8174_/Z _8181_/Z _8210_/B _8256_/B2 PHY_9/VDD PHY_9/VDD VSUBS VSUBS gf180mcu_fd_sc_mcu7t5v0__aoi21_2
X_9190_ _9191_/A1 _9190_/A2 _9188_/Z _9190_/Z PHY_9/VDD PHY_9/VDD VSUBS VSUBS gf180mcu_fd_sc_mcu7t5v0__or3_1
X_5422_ _9644_/Q _5437_/A2 _5883_/A3 _9675_/Q _5423_/I PHY_9/VDD PHY_9/VDD VSUBS VSUBS
+ gf180mcu_fd_sc_mcu7t5v0__aoi22_1
X_8141_ _8103_/Z _8139_/Z _8141_/Z PHY_9/VDD PHY_9/VDD VSUBS VSUBS gf180mcu_fd_sc_mcu7t5v0__xor2_1
X_5353_ _5853_/A1 _5353_/A2 _5353_/B _5973_/C _9412_/D PHY_9/VDD PHY_9/VDD VSUBS VSUBS
+ gf180mcu_fd_sc_mcu7t5v0__aoi211_1
X_5284_ _9382_/Q _5285_/A2 _5285_/B PHY_9/VDD PHY_9/VDD VSUBS VSUBS gf180mcu_fd_sc_mcu7t5v0__nor2_1
X_8072_ _9899_/Q _8072_/A2 _8293_/B PHY_9/VDD PHY_9/VDD VSUBS VSUBS gf180mcu_fd_sc_mcu7t5v0__nand2_2
X_7023_ _9845_/Q _7037_/A3 _7028_/S PHY_9/VDD PHY_9/VDD VSUBS VSUBS gf180mcu_fd_sc_mcu7t5v0__nand2_2
X_8974_ _8990_/A1 _8973_/Z _8987_/A2 PHY_9/VDD PHY_9/VDD VSUBS VSUBS gf180mcu_fd_sc_mcu7t5v0__xnor2_1
X_7925_ _9812_/Q _7992_/A2 _7925_/B _7926_/A4 PHY_9/VDD PHY_9/VDD VSUBS VSUBS gf180mcu_fd_sc_mcu7t5v0__oai21_1
X_7856_ _7856_/A1 _7856_/A2 _7855_/B _7856_/Z PHY_9/VDD PHY_9/VDD VSUBS VSUBS gf180mcu_fd_sc_mcu7t5v0__or3_1
X_6807_ _6997_/B2 _6924_/A1 _6807_/B1 _6807_/B2 _6807_/C _6808_/B PHY_9/VDD PHY_9/VDD
+ VSUBS VSUBS gf180mcu_fd_sc_mcu7t5v0__oai221_2
X_4999_ _9594_/Q _5766_/B2 PHY_9/VDD PHY_9/VDD VSUBS VSUBS gf180mcu_fd_sc_mcu7t5v0__clkinv_1
X_9526_ _9526_/D _9830_/CLK _9526_/Q PHY_9/VDD PHY_9/VDD VSUBS VSUBS gf180mcu_fd_sc_mcu7t5v0__dffq_1
X_7787_ _9809_/Q _7789_/A3 _7819_/B PHY_9/VDD PHY_9/VDD VSUBS VSUBS gf180mcu_fd_sc_mcu7t5v0__nand2_1
X_6738_ _9893_/Q _9835_/Q _6815_/B _6740_/B1 PHY_9/VDD PHY_9/VDD VSUBS VSUBS gf180mcu_fd_sc_mcu7t5v0__oai21_2
X_6669_ _6698_/A2 _9036_/A2 _6669_/B _9832_/D PHY_9/VDD PHY_9/VDD VSUBS VSUBS gf180mcu_fd_sc_mcu7t5v0__aoi21_1
X_9457_ _9457_/D _9800_/CLK _9457_/Q PHY_9/VDD PHY_9/VDD VSUBS VSUBS gf180mcu_fd_sc_mcu7t5v0__dffq_1
X_9388_ _9388_/D _9940_/CLK _9388_/Q PHY_9/VDD PHY_9/VDD VSUBS VSUBS gf180mcu_fd_sc_mcu7t5v0__dffq_1
X_8408_ _9807_/Q _8369_/Z _8408_/B _8449_/A2 PHY_9/VDD PHY_9/VDD VSUBS VSUBS gf180mcu_fd_sc_mcu7t5v0__oai21_1
X_8339_ _9814_/Q _8340_/B1 _8339_/B _9899_/Q _8340_/A3 PHY_9/VDD PHY_9/VDD VSUBS VSUBS
+ gf180mcu_fd_sc_mcu7t5v0__aoi211_1
Xclkbuf_leaf_1_clk clkbuf_leaf_9_clk/I _9801_/CLK PHY_9/VDD PHY_9/VDD VSUBS VSUBS
+ gf180mcu_fd_sc_mcu7t5v0__clkbuf_16
X_5971_ _9687_/Q _5971_/A2 _5972_/I PHY_9/VDD PHY_9/VDD VSUBS VSUBS gf180mcu_fd_sc_mcu7t5v0__nand2_1
X_8690_ _5388_/Z _8697_/A2 _8697_/B1 _8690_/B2 _9941_/D PHY_9/VDD PHY_9/VDD VSUBS
+ VSUBS gf180mcu_fd_sc_mcu7t5v0__oai22_1
X_4922_ _9942_/Q _8691_/B2 PHY_9/VDD PHY_9/VDD VSUBS VSUBS gf180mcu_fd_sc_mcu7t5v0__clkinv_1
X_7710_ _7724_/A1 _9887_/Q _7719_/A2 PHY_9/VDD PHY_9/VDD VSUBS VSUBS gf180mcu_fd_sc_mcu7t5v0__nor2_2
X_7641_ _7641_/A1 _7641_/A2 _7641_/B _7663_/A2 PHY_9/VDD PHY_9/VDD VSUBS VSUBS gf180mcu_fd_sc_mcu7t5v0__oai21_1
X_4853_ _9415_/Q _5583_/A1 PHY_9/VDD PHY_9/VDD VSUBS VSUBS gf180mcu_fd_sc_mcu7t5v0__clkinv_1
X_4784_ _9832_/Q _6698_/A2 PHY_9/VDD PHY_9/VDD VSUBS VSUBS gf180mcu_fd_sc_mcu7t5v0__clkinv_3
X_7572_ _7572_/A1 _7572_/A2 _7572_/B _7626_/B PHY_9/VDD PHY_9/VDD VSUBS VSUBS gf180mcu_fd_sc_mcu7t5v0__aoi21_1
X_6523_ _9875_/Q _6569_/A2 _6524_/A2 PHY_9/VDD PHY_9/VDD VSUBS VSUBS gf180mcu_fd_sc_mcu7t5v0__nand2_1
X_9311_ _9311_/A1 _9308_/Z _9311_/B _9316_/A3 PHY_9/VDD PHY_9/VDD VSUBS VSUBS gf180mcu_fd_sc_mcu7t5v0__oai21_1
X_6454_ _6455_/A2 _6495_/A1 _6454_/A3 _6495_/A2 PHY_9/VDD PHY_9/VDD VSUBS VSUBS gf180mcu_fd_sc_mcu7t5v0__nor3_2
X_9242_ _9222_/B _9194_/Z _9242_/B _9268_/B PHY_9/VDD PHY_9/VDD VSUBS VSUBS gf180mcu_fd_sc_mcu7t5v0__oai21_1
X_5405_ _5405_/A1 _5407_/A2 _5404_/Z _5407_/B2 _9424_/D PHY_9/VDD PHY_9/VDD VSUBS
+ VSUBS gf180mcu_fd_sc_mcu7t5v0__oai22_1
X_6385_ _9807_/Q _6583_/A3 _6395_/A1 PHY_9/VDD PHY_9/VDD VSUBS VSUBS gf180mcu_fd_sc_mcu7t5v0__nor2_1
X_9173_ _9173_/A1 _9173_/A2 _9173_/B _9174_/B PHY_9/VDD PHY_9/VDD VSUBS VSUBS gf180mcu_fd_sc_mcu7t5v0__oai21_1
X_5336_ _5336_/A1 _5342_/A2 _5336_/B _9404_/D PHY_9/VDD PHY_9/VDD VSUBS VSUBS gf180mcu_fd_sc_mcu7t5v0__aoi21_1
X_8124_ _9906_/Q _8104_/Z _8124_/B _8162_/A1 PHY_9/VDD PHY_9/VDD VSUBS VSUBS gf180mcu_fd_sc_mcu7t5v0__aoi21_1
X_5267_ _9462_/Q _5272_/A2 _8027_/B _5268_/B PHY_9/VDD PHY_9/VDD VSUBS VSUBS gf180mcu_fd_sc_mcu7t5v0__oai21_1
X_8055_ _8057_/A1 _8055_/A2 _8337_/B PHY_9/VDD PHY_9/VDD VSUBS VSUBS gf180mcu_fd_sc_mcu7t5v0__nor2_2
X_7006_ _7006_/A1 _9036_/A2 _7006_/B _9845_/D PHY_9/VDD PHY_9/VDD VSUBS VSUBS gf180mcu_fd_sc_mcu7t5v0__aoi21_1
X_5198_ _5130_/I _5198_/A2 _5199_/I PHY_9/VDD PHY_9/VDD VSUBS VSUBS gf180mcu_fd_sc_mcu7t5v0__nand2_1
X_8957_ _9813_/Q _9004_/A2 _8960_/A3 PHY_9/VDD PHY_9/VDD VSUBS VSUBS gf180mcu_fd_sc_mcu7t5v0__nand2_1
X_7908_ _7908_/A1 _7960_/A3 _7912_/A2 PHY_9/VDD PHY_9/VDD VSUBS VSUBS gf180mcu_fd_sc_mcu7t5v0__xnor2_1
X_8888_ _8931_/A2 _8888_/A2 _8888_/B1 _8888_/B2 _8888_/C _8889_/A2 PHY_9/VDD PHY_9/VDD
+ VSUBS VSUBS gf180mcu_fd_sc_mcu7t5v0__oai221_1
X_7839_ _9808_/Q _7800_/Z _7836_/Z _9807_/Q _7840_/I PHY_9/VDD PHY_9/VDD VSUBS VSUBS
+ gf180mcu_fd_sc_mcu7t5v0__aoi22_1
X_9509_ _9509_/D _9974_/CLK _9509_/Q PHY_9/VDD PHY_9/VDD VSUBS VSUBS gf180mcu_fd_sc_mcu7t5v0__dffq_2
X_6170_ _9610_/Q _6287_/A2 _6287_/B1 _9626_/Q _6172_/A1 PHY_9/VDD PHY_9/VDD VSUBS
+ VSUBS gf180mcu_fd_sc_mcu7t5v0__aoi22_1
X_5121_ _9565_/Q _5727_/B2 PHY_9/VDD PHY_9/VDD VSUBS VSUBS gf180mcu_fd_sc_mcu7t5v0__clkinv_1
X_5052_ _9883_/Q _7684_/B2 PHY_9/VDD PHY_9/VDD VSUBS VSUBS gf180mcu_fd_sc_mcu7t5v0__clkinv_1
X_9860_ _9860_/D _9948_/CLK _9860_/Q PHY_9/VDD PHY_9/VDD VSUBS VSUBS gf180mcu_fd_sc_mcu7t5v0__dffq_1
X_9791_ _9791_/D _9940_/CLK _9791_/Q PHY_9/VDD PHY_9/VDD VSUBS VSUBS gf180mcu_fd_sc_mcu7t5v0__dffq_1
X_8811_ _8811_/A1 _8811_/A2 _9357_/B _9956_/D PHY_9/VDD PHY_9/VDD VSUBS VSUBS gf180mcu_fd_sc_mcu7t5v0__aoi21_1
X_8742_ _8742_/A1 _8736_/B _8774_/A1 PHY_9/VDD PHY_9/VDD VSUBS VSUBS gf180mcu_fd_sc_mcu7t5v0__nor2_1
X_5954_ _5954_/A1 _5973_/A2 _5954_/B _9679_/D PHY_9/VDD PHY_9/VDD VSUBS VSUBS gf180mcu_fd_sc_mcu7t5v0__aoi21_1
X_4905_ _9575_/Q _5743_/B2 PHY_9/VDD PHY_9/VDD VSUBS VSUBS gf180mcu_fd_sc_mcu7t5v0__clkinv_1
X_5885_ _5951_/A2 _5885_/A2 _5973_/C _9654_/D PHY_9/VDD PHY_9/VDD VSUBS VSUBS gf180mcu_fd_sc_mcu7t5v0__aoi21_1
X_8673_ _8673_/I0 _8673_/I1 _8673_/S _8674_/C PHY_9/VDD PHY_9/VDD VSUBS VSUBS gf180mcu_fd_sc_mcu7t5v0__mux2_1
X_7624_ _9876_/Q _7641_/A1 _7621_/Z _7639_/A2 PHY_9/VDD PHY_9/VDD VSUBS VSUBS gf180mcu_fd_sc_mcu7t5v0__xnor3_1
X_4836_ _9473_/Q _5137_/A2 PHY_9/VDD PHY_9/VDD VSUBS VSUBS gf180mcu_fd_sc_mcu7t5v0__inv_1
X_7555_ _9807_/Q _7655_/A2 _7606_/A1 PHY_9/VDD PHY_9/VDD VSUBS VSUBS gf180mcu_fd_sc_mcu7t5v0__nand2_1
X_6506_ _6646_/B _6505_/Z _6507_/A2 PHY_9/VDD PHY_9/VDD VSUBS VSUBS gf180mcu_fd_sc_mcu7t5v0__nand2_1
X_4767_ _9849_/Q _8037_/A2 PHY_9/VDD PHY_9/VDD VSUBS VSUBS gf180mcu_fd_sc_mcu7t5v0__clkinv_3
X_7486_ _7582_/C _7471_/Z _7486_/B _9317_/C _7487_/A2 PHY_9/VDD PHY_9/VDD VSUBS VSUBS
+ gf180mcu_fd_sc_mcu7t5v0__oai211_1
X_4698_ _9954_/Q _8742_/A1 PHY_9/VDD PHY_9/VDD VSUBS VSUBS gf180mcu_fd_sc_mcu7t5v0__clkinv_1
X_6437_ _6614_/B _6435_/Z _6438_/B1 PHY_9/VDD PHY_9/VDD VSUBS VSUBS gf180mcu_fd_sc_mcu7t5v0__nor2_1
X_9225_ _9270_/B _9225_/A2 _9225_/B _9322_/A2 PHY_9/VDD PHY_9/VDD VSUBS VSUBS gf180mcu_fd_sc_mcu7t5v0__oai21_4
X_6368_ _9802_/Q _6368_/A2 _6651_/A1 PHY_9/VDD PHY_9/VDD VSUBS VSUBS gf180mcu_fd_sc_mcu7t5v0__nand2_2
X_9156_ _9970_/Q _9155_/Z _9156_/Z PHY_9/VDD PHY_9/VDD VSUBS VSUBS gf180mcu_fd_sc_mcu7t5v0__or2_1
X_5319_ _5319_/A1 _9471_/Q _5354_/A2 PHY_9/VDD PHY_9/VDD VSUBS VSUBS gf180mcu_fd_sc_mcu7t5v0__nor2_2
X_8107_ _8107_/A1 _8107_/A2 _8121_/A2 PHY_9/VDD PHY_9/VDD VSUBS VSUBS gf180mcu_fd_sc_mcu7t5v0__xnor2_1
X_9087_ _9808_/Q _9285_/A2 _9109_/A1 PHY_9/VDD PHY_9/VDD VSUBS VSUBS gf180mcu_fd_sc_mcu7t5v0__nand2_1
X_6299_ _8693_/A1 _6303_/A2 _6303_/B1 _6299_/B2 _9781_/D PHY_9/VDD PHY_9/VDD VSUBS
+ VSUBS gf180mcu_fd_sc_mcu7t5v0__oai22_1
X_8038_ _9902_/Q _8720_/A2 _8040_/A3 PHY_9/VDD PHY_9/VDD VSUBS VSUBS gf180mcu_fd_sc_mcu7t5v0__nor2_1
X_5670_ _9538_/Q _5667_/Z _5670_/Z PHY_9/VDD PHY_9/VDD VSUBS VSUBS gf180mcu_fd_sc_mcu7t5v0__and2_1
X_7340_ _7364_/A2 _9036_/A2 _7340_/B _9866_/D PHY_9/VDD PHY_9/VDD VSUBS VSUBS gf180mcu_fd_sc_mcu7t5v0__aoi21_1
X_7271_ _7322_/A1 _7271_/A2 _7283_/A2 PHY_9/VDD PHY_9/VDD VSUBS VSUBS gf180mcu_fd_sc_mcu7t5v0__nand2_1
X_6222_ _9571_/Q _6287_/A2 _6287_/B1 _9791_/Q _6224_/A1 PHY_9/VDD PHY_9/VDD VSUBS
+ VSUBS gf180mcu_fd_sc_mcu7t5v0__aoi22_1
X_9010_ _9010_/A1 _9010_/A2 _9009_/Z _9010_/Z PHY_9/VDD PHY_9/VDD VSUBS VSUBS gf180mcu_fd_sc_mcu7t5v0__xor3_1
X_6153_ _9585_/Q _6288_/A2 _6287_/A2 _9593_/Q _6154_/A2 PHY_9/VDD PHY_9/VDD VSUBS
+ VSUBS gf180mcu_fd_sc_mcu7t5v0__aoi22_1
X_5104_ _9753_/Q _6039_/B2 PHY_9/VDD PHY_9/VDD VSUBS VSUBS gf180mcu_fd_sc_mcu7t5v0__clkinv_1
X_6084_ _6084_/A1 _6084_/A2 _6276_/B _6089_/A1 PHY_9/VDD PHY_9/VDD VSUBS VSUBS gf180mcu_fd_sc_mcu7t5v0__aoi21_1
X_9912_ _9912_/D _9939_/CLK _9912_/Q PHY_9/VDD PHY_9/VDD VSUBS VSUBS gf180mcu_fd_sc_mcu7t5v0__dffq_1
X_5035_ _9571_/Q _5735_/B2 PHY_9/VDD PHY_9/VDD VSUBS VSUBS gf180mcu_fd_sc_mcu7t5v0__clkinv_1
X_9843_ _9843_/D _9856_/CLK _9843_/Q PHY_9/VDD PHY_9/VDD VSUBS VSUBS gf180mcu_fd_sc_mcu7t5v0__dffq_2
X_6986_ _9843_/Q _6986_/A2 _6985_/Z _6986_/Z PHY_9/VDD PHY_9/VDD VSUBS VSUBS gf180mcu_fd_sc_mcu7t5v0__xor3_1
X_9774_ _9774_/D _9901_/CLK _9774_/Q PHY_9/VDD PHY_9/VDD VSUBS VSUBS gf180mcu_fd_sc_mcu7t5v0__dffq_2
X_8725_ _9951_/Q _8725_/A2 _9022_/B PHY_9/VDD PHY_9/VDD VSUBS VSUBS gf180mcu_fd_sc_mcu7t5v0__nand2_4
X_5937_ _5937_/A1 _5951_/A2 _5937_/B _9671_/D PHY_9/VDD PHY_9/VDD VSUBS VSUBS gf180mcu_fd_sc_mcu7t5v0__aoi21_1
X_8656_ _8656_/A1 _8655_/Z _8656_/Z PHY_9/VDD PHY_9/VDD VSUBS VSUBS gf180mcu_fd_sc_mcu7t5v0__xor2_1
X_5868_ _5832_/Z _5868_/A2 _5973_/C _5869_/B PHY_9/VDD PHY_9/VDD VSUBS VSUBS gf180mcu_fd_sc_mcu7t5v0__aoi21_1
X_7607_ _9808_/Q _7655_/A2 _7670_/A2 _9807_/Q _7608_/A2 PHY_9/VDD PHY_9/VDD VSUBS
+ VSUBS gf180mcu_fd_sc_mcu7t5v0__aoi22_1
X_5799_ _8692_/A1 _5804_/A2 _5804_/B1 _5799_/B2 _9617_/D PHY_9/VDD PHY_9/VDD VSUBS
+ VSUBS gf180mcu_fd_sc_mcu7t5v0__oai22_1
X_4819_ _9676_/Q _5947_/A1 PHY_9/VDD PHY_9/VDD VSUBS VSUBS gf180mcu_fd_sc_mcu7t5v0__clkinv_1
X_8587_ _8391_/C _8587_/A2 _8587_/A3 _8587_/A4 _8588_/B PHY_9/VDD PHY_9/VDD VSUBS
+ VSUBS gf180mcu_fd_sc_mcu7t5v0__nand4_1
X_7538_ _7538_/A1 _7538_/A2 _7538_/B _7564_/A1 PHY_9/VDD PHY_9/VDD VSUBS VSUBS gf180mcu_fd_sc_mcu7t5v0__oai21_1
X_7469_ _9873_/Q _7468_/Z _7469_/Z PHY_9/VDD PHY_9/VDD VSUBS VSUBS gf180mcu_fd_sc_mcu7t5v0__or2_1
X_9208_ _9209_/A1 _9209_/A2 _9209_/B _9211_/A2 PHY_9/VDD PHY_9/VDD VSUBS VSUBS gf180mcu_fd_sc_mcu7t5v0__nand3_1
X_9139_ _9501_/Q _9041_/Z _9139_/B1 _9139_/B2 _9227_/A2 PHY_9/VDD PHY_9/VDD VSUBS
+ VSUBS gf180mcu_fd_sc_mcu7t5v0__oai22_4
X_6840_ _7147_/A1 _6862_/A1 _6837_/Z _6840_/Z PHY_9/VDD PHY_9/VDD VSUBS VSUBS gf180mcu_fd_sc_mcu7t5v0__xor3_1
X_6771_ _9835_/Q _9834_/Q _6771_/Z PHY_9/VDD PHY_9/VDD VSUBS VSUBS gf180mcu_fd_sc_mcu7t5v0__and2_2
X_8510_ _8511_/A1 _8510_/A2 _8510_/A3 _8510_/Z PHY_9/VDD PHY_9/VDD VSUBS VSUBS gf180mcu_fd_sc_mcu7t5v0__or3_1
X_5722_ _8692_/A1 _5727_/A2 _5727_/B1 _5722_/B2 _9560_/D PHY_9/VDD PHY_9/VDD VSUBS
+ VSUBS gf180mcu_fd_sc_mcu7t5v0__oai22_1
X_9490_ _9490_/D _9974_/CLK _9490_/Q PHY_9/VDD PHY_9/VDD VSUBS VSUBS gf180mcu_fd_sc_mcu7t5v0__dffq_2
X_5653_ _5399_/Z _5656_/A2 _5656_/B1 _5653_/B2 _9530_/D PHY_9/VDD PHY_9/VDD VSUBS
+ VSUBS gf180mcu_fd_sc_mcu7t5v0__oai22_1
X_8441_ _8782_/A2 _8455_/A2 _8441_/Z PHY_9/VDD PHY_9/VDD VSUBS VSUBS gf180mcu_fd_sc_mcu7t5v0__and2_1
X_8372_ _9922_/Q _8372_/A2 _8381_/A2 PHY_9/VDD PHY_9/VDD VSUBS VSUBS gf180mcu_fd_sc_mcu7t5v0__nand2_1
X_5584_ _9410_/Q _5591_/A2 _5592_/B1 _9405_/Q _5584_/C _5586_/A2 PHY_9/VDD PHY_9/VDD
+ VSUBS VSUBS gf180mcu_fd_sc_mcu7t5v0__aoi221_2
X_7323_ _7139_/C _7323_/A2 _9317_/C _7324_/B PHY_9/VDD PHY_9/VDD VSUBS VSUBS gf180mcu_fd_sc_mcu7t5v0__oai21_1
X_7254_ _9813_/Q _7254_/A2 _7297_/A2 PHY_9/VDD PHY_9/VDD VSUBS VSUBS gf180mcu_fd_sc_mcu7t5v0__nand2_1
X_7185_ _7227_/A2 _7185_/A2 _7185_/B1 _7185_/B2 _7185_/C _7186_/A2 PHY_9/VDD PHY_9/VDD
+ VSUBS VSUBS gf180mcu_fd_sc_mcu7t5v0__oai221_1
X_6205_ _6205_/A1 _6205_/A2 _6205_/A3 _6206_/A2 PHY_9/VDD PHY_9/VDD VSUBS VSUBS gf180mcu_fd_sc_mcu7t5v0__nand3_1
X_6136_ _9748_/Q _6288_/A2 _6288_/B1 _9764_/Q _6137_/A2 PHY_9/VDD PHY_9/VDD VSUBS
+ VSUBS gf180mcu_fd_sc_mcu7t5v0__aoi22_1
X_6067_ _9912_/Q _6287_/A2 _6287_/B1 _9857_/Q _6069_/A1 PHY_9/VDD PHY_9/VDD VSUBS
+ VSUBS gf180mcu_fd_sc_mcu7t5v0__aoi22_1
X_5018_ _9945_/Q _8694_/B2 PHY_9/VDD PHY_9/VDD VSUBS VSUBS gf180mcu_fd_sc_mcu7t5v0__clkinv_1
X_9826_ _9826_/D _9830_/CLK _9826_/Q PHY_9/VDD PHY_9/VDD VSUBS VSUBS gf180mcu_fd_sc_mcu7t5v0__dffq_1
X_9757_ _9757_/D _9939_/CLK _9757_/Q PHY_9/VDD PHY_9/VDD VSUBS VSUBS gf180mcu_fd_sc_mcu7t5v0__dffq_1
X_6969_ _9856_/Q _6771_/Z _6971_/A1 PHY_9/VDD PHY_9/VDD VSUBS VSUBS gf180mcu_fd_sc_mcu7t5v0__nand2_1
X_8708_ _8725_/A2 _8740_/A3 _8711_/B PHY_9/VDD PHY_9/VDD VSUBS VSUBS gf180mcu_fd_sc_mcu7t5v0__nor2_1
X_9688_ _9688_/D _9689_/CLK _9688_/Q PHY_9/VDD PHY_9/VDD VSUBS VSUBS gf180mcu_fd_sc_mcu7t5v0__dffq_1
X_8639_ _9357_/B _8639_/A2 _9931_/D PHY_9/VDD PHY_9/VDD VSUBS VSUBS gf180mcu_fd_sc_mcu7t5v0__nor2_1
Xrepeater10 _9031_/B _9035_/B PHY_9/VDD PHY_9/VDD VSUBS VSUBS gf180mcu_fd_sc_mcu7t5v0__buf_8
X_8990_ _8990_/A1 _8973_/Z _8990_/B _9013_/A2 PHY_9/VDD PHY_9/VDD VSUBS VSUBS gf180mcu_fd_sc_mcu7t5v0__oai21_1
X_7941_ _9808_/Q _7992_/A2 _7989_/B2 PHY_9/VDD PHY_9/VDD VSUBS VSUBS gf180mcu_fd_sc_mcu7t5v0__nand2_1
X_7872_ _9811_/Q _7836_/Z _7876_/B PHY_9/VDD PHY_9/VDD VSUBS VSUBS gf180mcu_fd_sc_mcu7t5v0__nor2_1
X_9611_ _9611_/D _9830_/CLK _9611_/Q PHY_9/VDD PHY_9/VDD VSUBS VSUBS gf180mcu_fd_sc_mcu7t5v0__dffq_1
X_6823_ _6779_/Z _6823_/A2 _6823_/B _6831_/A2 PHY_9/VDD PHY_9/VDD VSUBS VSUBS gf180mcu_fd_sc_mcu7t5v0__aoi21_2
X_6754_ _9809_/Q _6754_/A2 _6795_/A1 PHY_9/VDD PHY_9/VDD VSUBS VSUBS gf180mcu_fd_sc_mcu7t5v0__nand2_1
X_9542_ _9542_/D _9689_/CLK _9542_/Q PHY_9/VDD PHY_9/VDD VSUBS VSUBS gf180mcu_fd_sc_mcu7t5v0__dffq_1
X_6685_ _6698_/A1 _9832_/Q _6699_/A3 _6997_/B2 PHY_9/VDD PHY_9/VDD VSUBS VSUBS gf180mcu_fd_sc_mcu7t5v0__nand3_4
X_5705_ _5705_/A1 _5381_/I _5383_/I _8688_/A1 PHY_9/VDD PHY_9/VDD VSUBS VSUBS gf180mcu_fd_sc_mcu7t5v0__nor3_4
X_9473_ _9473_/D _9801_/CLK _9473_/Q PHY_9/VDD PHY_9/VDD VSUBS VSUBS gf180mcu_fd_sc_mcu7t5v0__dffq_1
X_8424_ _8391_/C _8424_/A2 _8424_/B _8426_/A2 PHY_9/VDD PHY_9/VDD VSUBS VSUBS gf180mcu_fd_sc_mcu7t5v0__oai21_1
X_5636_ _5705_/A1 _5636_/A2 _5636_/A3 _7327_/A1 PHY_9/VDD PHY_9/VDD VSUBS VSUBS gf180mcu_fd_sc_mcu7t5v0__nor3_4
X_8355_ _8390_/A3 _9034_/A2 _8355_/B _9920_/D PHY_9/VDD PHY_9/VDD VSUBS VSUBS gf180mcu_fd_sc_mcu7t5v0__aoi21_1
X_5567_ _5567_/A1 _5567_/A2 _5201_/Z _5567_/Z PHY_9/VDD PHY_9/VDD VSUBS VSUBS gf180mcu_fd_sc_mcu7t5v0__or3_1
X_7306_ _7306_/A1 _7306_/A2 _7306_/B _7307_/A3 PHY_9/VDD PHY_9/VDD VSUBS VSUBS gf180mcu_fd_sc_mcu7t5v0__aoi21_1
X_8286_ _8284_/Z _8287_/A2 _8328_/A1 PHY_9/VDD PHY_9/VDD VSUBS VSUBS gf180mcu_fd_sc_mcu7t5v0__nand2_1
X_5498_ _9729_/Q _9732_/Q _5498_/Z PHY_9/VDD PHY_9/VDD VSUBS VSUBS gf180mcu_fd_sc_mcu7t5v0__or2_2
X_7237_ _7237_/A1 _7213_/Z _7237_/B _7264_/A1 PHY_9/VDD PHY_9/VDD VSUBS VSUBS gf180mcu_fd_sc_mcu7t5v0__aoi21_1
X_7168_ _8165_/A3 _7189_/A1 _7165_/Z _7168_/Z PHY_9/VDD PHY_9/VDD VSUBS VSUBS gf180mcu_fd_sc_mcu7t5v0__xor3_1
X_7099_ _9809_/Q _7315_/A2 _7139_/C _7100_/C PHY_9/VDD PHY_9/VDD VSUBS VSUBS gf180mcu_fd_sc_mcu7t5v0__aoi21_1
X_6119_ _8689_/A1 _6119_/A2 _9771_/D PHY_9/VDD PHY_9/VDD VSUBS VSUBS gf180mcu_fd_sc_mcu7t5v0__and2_1
X_9809_ _9809_/D _9974_/CLK _9809_/Q PHY_9/VDD PHY_9/VDD VSUBS VSUBS gf180mcu_fd_sc_mcu7t5v0__dffq_4
X_6470_ _6464_/Z _6468_/Z _6470_/B _6476_/B2 PHY_9/VDD PHY_9/VDD VSUBS VSUBS gf180mcu_fd_sc_mcu7t5v0__aoi21_1
X_5421_ _9731_/Q _5484_/A1 _5421_/B _9429_/D PHY_9/VDD PHY_9/VDD VSUBS VSUBS gf180mcu_fd_sc_mcu7t5v0__aoi21_1
X_8140_ _8103_/Z _8139_/Z _8186_/A1 PHY_9/VDD PHY_9/VDD VSUBS VSUBS gf180mcu_fd_sc_mcu7t5v0__nand2_1
X_5352_ _9412_/Q _5353_/A2 _5353_/B PHY_9/VDD PHY_9/VDD VSUBS VSUBS gf180mcu_fd_sc_mcu7t5v0__nor2_1
X_8071_ _9899_/Q _8072_/A2 _8110_/B PHY_9/VDD PHY_9/VDD VSUBS VSUBS gf180mcu_fd_sc_mcu7t5v0__and2_1
X_7022_ _7036_/A1 _9845_/Q _9844_/Q _7314_/I1 PHY_9/VDD PHY_9/VDD VSUBS VSUBS gf180mcu_fd_sc_mcu7t5v0__nor3_4
X_5283_ _5396_/A1 _5285_/A2 _5283_/B _5973_/C _9381_/D PHY_9/VDD PHY_9/VDD VSUBS VSUBS
+ gf180mcu_fd_sc_mcu7t5v0__aoi211_1
X_8973_ _8973_/A1 _8971_/Z _8973_/Z PHY_9/VDD PHY_9/VDD VSUBS VSUBS gf180mcu_fd_sc_mcu7t5v0__xor2_1
X_7924_ _7974_/A1 _7924_/A2 _7924_/B _7925_/B PHY_9/VDD PHY_9/VDD VSUBS VSUBS gf180mcu_fd_sc_mcu7t5v0__oai21_1
X_7855_ _7856_/A1 _7856_/A2 _7855_/B _7960_/B2 PHY_9/VDD PHY_9/VDD VSUBS VSUBS gf180mcu_fd_sc_mcu7t5v0__oai21_2
X_6806_ _9810_/Q _6806_/A2 _6807_/C PHY_9/VDD PHY_9/VDD VSUBS VSUBS gf180mcu_fd_sc_mcu7t5v0__nand2_1
X_4998_ _9937_/Q _8684_/B2 PHY_9/VDD PHY_9/VDD VSUBS VSUBS gf180mcu_fd_sc_mcu7t5v0__clkinv_1
X_9525_ _9525_/D _9800_/CLK _9525_/Q PHY_9/VDD PHY_9/VDD VSUBS VSUBS gf180mcu_fd_sc_mcu7t5v0__dffq_1
X_7786_ _7771_/Z _7786_/A2 _7789_/A3 PHY_9/VDD PHY_9/VDD VSUBS VSUBS gf180mcu_fd_sc_mcu7t5v0__xnor2_1
X_6737_ _6737_/A1 _6737_/A2 _6737_/B _6770_/A1 PHY_9/VDD PHY_9/VDD VSUBS VSUBS gf180mcu_fd_sc_mcu7t5v0__aoi21_1
X_6668_ _9394_/Q _9036_/A2 _8027_/B _6669_/B PHY_9/VDD PHY_9/VDD VSUBS VSUBS gf180mcu_fd_sc_mcu7t5v0__oai21_1
X_9456_ _9456_/D _9800_/CLK _9456_/Q PHY_9/VDD PHY_9/VDD VSUBS VSUBS gf180mcu_fd_sc_mcu7t5v0__dffq_1
X_6599_ _6599_/A1 _6599_/A2 _6596_/Z _6599_/Z PHY_9/VDD PHY_9/VDD VSUBS VSUBS gf180mcu_fd_sc_mcu7t5v0__xor3_1
X_8407_ _9091_/B _8606_/A2 _8407_/A3 _8408_/B PHY_9/VDD PHY_9/VDD VSUBS VSUBS gf180mcu_fd_sc_mcu7t5v0__xor3_1
X_5619_ _5619_/A1 _5619_/A2 _5973_/C _9508_/D PHY_9/VDD PHY_9/VDD VSUBS VSUBS gf180mcu_fd_sc_mcu7t5v0__aoi21_1
X_9387_ _9387_/D _9907_/CLK _9387_/Q PHY_9/VDD PHY_9/VDD VSUBS VSUBS gf180mcu_fd_sc_mcu7t5v0__dffq_1
X_8338_ _9349_/A1 _8338_/A2 _8340_/A2 PHY_9/VDD PHY_9/VDD VSUBS VSUBS gf180mcu_fd_sc_mcu7t5v0__nor2_1
X_8269_ _8269_/I _8315_/A1 PHY_9/VDD PHY_9/VDD VSUBS VSUBS gf180mcu_fd_sc_mcu7t5v0__clkinv_1
X_5970_ _5162_/Z _5973_/A2 _5970_/B _5971_/A2 PHY_9/VDD PHY_9/VDD VSUBS VSUBS gf180mcu_fd_sc_mcu7t5v0__oai21_1
X_4921_ _9624_/Q _5808_/B2 PHY_9/VDD PHY_9/VDD VSUBS VSUBS gf180mcu_fd_sc_mcu7t5v0__clkinv_1
X_7640_ _7640_/A1 _7640_/A2 _9357_/B _9876_/D PHY_9/VDD PHY_9/VDD VSUBS VSUBS gf180mcu_fd_sc_mcu7t5v0__aoi21_1
X_4852_ _9416_/Q _5362_/A1 PHY_9/VDD PHY_9/VDD VSUBS VSUBS gf180mcu_fd_sc_mcu7t5v0__clkinv_1
X_4783_ _9395_/Q _5314_/A1 PHY_9/VDD PHY_9/VDD VSUBS VSUBS gf180mcu_fd_sc_mcu7t5v0__clkinv_1
X_7571_ _7576_/A1 _7576_/A2 _7577_/A1 PHY_9/VDD PHY_9/VDD VSUBS VSUBS gf180mcu_fd_sc_mcu7t5v0__nand2_1
X_6522_ _9841_/Q _6350_/Z _6524_/A1 PHY_9/VDD PHY_9/VDD VSUBS VSUBS gf180mcu_fd_sc_mcu7t5v0__nand2_1
X_9310_ _9354_/A1 _9350_/A2 _9311_/B PHY_9/VDD PHY_9/VDD VSUBS VSUBS gf180mcu_fd_sc_mcu7t5v0__and2_1
X_6453_ _9810_/Q _6624_/A2 _6584_/B1 _9809_/Q _6454_/A3 PHY_9/VDD PHY_9/VDD VSUBS
+ VSUBS gf180mcu_fd_sc_mcu7t5v0__aoi22_1
X_9241_ _9276_/A1 _9241_/A2 _9239_/B _9242_/B PHY_9/VDD PHY_9/VDD VSUBS VSUBS gf180mcu_fd_sc_mcu7t5v0__xnor3_1
X_9172_ _9344_/A1 _9155_/Z _9172_/B _9173_/B PHY_9/VDD PHY_9/VDD VSUBS VSUBS gf180mcu_fd_sc_mcu7t5v0__aoi21_1
X_5404_ _9301_/A1 _5520_/A1 _5559_/B _5404_/Z PHY_9/VDD PHY_9/VDD VSUBS VSUBS gf180mcu_fd_sc_mcu7t5v0__mux2_4
X_6384_ _6677_/A3 _9356_/C _6384_/B1 _6384_/B2 _9357_/B _9815_/D PHY_9/VDD PHY_9/VDD
+ VSUBS VSUBS gf180mcu_fd_sc_mcu7t5v0__aoi221_1
X_8123_ _9357_/B _8123_/A2 _9906_/D PHY_9/VDD PHY_9/VDD VSUBS VSUBS gf180mcu_fd_sc_mcu7t5v0__nor2_1
X_5335_ _9461_/Q _5342_/A2 _9035_/B _5336_/B PHY_9/VDD PHY_9/VDD VSUBS VSUBS gf180mcu_fd_sc_mcu7t5v0__oai21_1
X_8054_ _9090_/C _8309_/A2 _8300_/B1 _8151_/B _8059_/B1 PHY_9/VDD PHY_9/VDD VSUBS
+ VSUBS gf180mcu_fd_sc_mcu7t5v0__oai22_1
X_5266_ _5266_/A1 _5272_/A2 _5266_/B _9374_/D PHY_9/VDD PHY_9/VDD VSUBS VSUBS gf180mcu_fd_sc_mcu7t5v0__aoi21_1
X_7005_ _9389_/Q _9036_/A2 _7007_/B _7006_/B PHY_9/VDD PHY_9/VDD VSUBS VSUBS gf180mcu_fd_sc_mcu7t5v0__oai21_1
X_5197_ _5197_/A1 _5197_/A2 _5198_/A2 PHY_9/VDD PHY_9/VDD VSUBS VSUBS gf180mcu_fd_sc_mcu7t5v0__nand2_1
X_8956_ _9811_/Q _9003_/A2 _8960_/A2 PHY_9/VDD PHY_9/VDD VSUBS VSUBS gf180mcu_fd_sc_mcu7t5v0__nand2_1
X_7907_ _7960_/B2 _7960_/B1 _7960_/A3 PHY_9/VDD PHY_9/VDD VSUBS VSUBS gf180mcu_fd_sc_mcu7t5v0__xnor2_1
X_8887_ _9811_/Q _8887_/A2 _8887_/B1 _8982_/B1 _8982_/C _8888_/B2 PHY_9/VDD PHY_9/VDD
+ VSUBS VSUBS gf180mcu_fd_sc_mcu7t5v0__aoi221_2
X_7838_ _7838_/A1 _7892_/A1 _7838_/Z PHY_9/VDD PHY_9/VDD VSUBS VSUBS gf180mcu_fd_sc_mcu7t5v0__or2_1
X_7769_ _7769_/I _9892_/D PHY_9/VDD PHY_9/VDD VSUBS VSUBS gf180mcu_fd_sc_mcu7t5v0__clkinv_1
X_9508_ _9508_/D _9974_/CLK _9508_/Q PHY_9/VDD PHY_9/VDD VSUBS VSUBS gf180mcu_fd_sc_mcu7t5v0__dffq_2
X_9439_ _9439_/D _9972_/CLK _9439_/Q PHY_9/VDD PHY_9/VDD VSUBS VSUBS gf180mcu_fd_sc_mcu7t5v0__dffq_1
X_5120_ _9785_/Q _6303_/B2 PHY_9/VDD PHY_9/VDD VSUBS VSUBS gf180mcu_fd_sc_mcu7t5v0__clkinv_1
X_5051_ _9917_/Q _8351_/B2 PHY_9/VDD PHY_9/VDD VSUBS VSUBS gf180mcu_fd_sc_mcu7t5v0__clkinv_1
X_9790_ _9790_/D _9940_/CLK _9790_/Q PHY_9/VDD PHY_9/VDD VSUBS VSUBS gf180mcu_fd_sc_mcu7t5v0__dffq_1
X_8810_ _8985_/C _8795_/Z _8810_/B _9317_/C _8811_/A2 PHY_9/VDD PHY_9/VDD VSUBS VSUBS
+ gf180mcu_fd_sc_mcu7t5v0__oai211_1
X_8741_ _9807_/Q _9004_/A2 _8741_/B _8985_/C _8744_/B PHY_9/VDD PHY_9/VDD VSUBS VSUBS
+ gf180mcu_fd_sc_mcu7t5v0__oai211_1
X_5953_ _9680_/Q _5973_/A2 _5961_/B _5954_/B PHY_9/VDD PHY_9/VDD VSUBS VSUBS gf180mcu_fd_sc_mcu7t5v0__oai21_1
X_4904_ _9583_/Q _5753_/B2 PHY_9/VDD PHY_9/VDD VSUBS VSUBS gf180mcu_fd_sc_mcu7t5v0__clkinv_1
X_5884_ _9654_/Q _5884_/A2 _5885_/A2 PHY_9/VDD PHY_9/VDD VSUBS VSUBS gf180mcu_fd_sc_mcu7t5v0__nand2_1
X_8672_ _8380_/Z _8671_/Z _8675_/B PHY_9/VDD PHY_9/VDD VSUBS VSUBS gf180mcu_fd_sc_mcu7t5v0__nand2_1
X_7623_ _9876_/Q _7621_/Z _7641_/A2 PHY_9/VDD PHY_9/VDD VSUBS VSUBS gf180mcu_fd_sc_mcu7t5v0__nor2_1
X_4835_ _9476_/Q _5544_/A1 PHY_9/VDD PHY_9/VDD VSUBS VSUBS gf180mcu_fd_sc_mcu7t5v0__clkinv_1
X_4766_ _9853_/Q _8165_/A3 PHY_9/VDD PHY_9/VDD VSUBS VSUBS gf180mcu_fd_sc_mcu7t5v0__inv_1
X_7554_ _7554_/A1 _7650_/B1 _7554_/B1 _7554_/B2 _7655_/A2 PHY_9/VDD PHY_9/VDD VSUBS
+ VSUBS gf180mcu_fd_sc_mcu7t5v0__aoi22_4
X_6505_ _6624_/A2 _6584_/B1 _6627_/A2 _6625_/A2 _6505_/Z PHY_9/VDD PHY_9/VDD VSUBS
+ VSUBS gf180mcu_fd_sc_mcu7t5v0__or4_1
X_7485_ _7674_/C2 _7485_/A2 _7478_/Z _7485_/B _7486_/B PHY_9/VDD PHY_9/VDD VSUBS VSUBS
+ gf180mcu_fd_sc_mcu7t5v0__oai31_1
X_4697_ _9955_/Q _8777_/A1 PHY_9/VDD PHY_9/VDD VSUBS VSUBS gf180mcu_fd_sc_mcu7t5v0__inv_2
X_6436_ _9809_/Q _6627_/A2 _6530_/A1 PHY_9/VDD PHY_9/VDD VSUBS VSUBS gf180mcu_fd_sc_mcu7t5v0__nand2_1
X_9224_ _9503_/Q _9270_/B _9225_/B PHY_9/VDD PHY_9/VDD VSUBS VSUBS gf180mcu_fd_sc_mcu7t5v0__nand2_1
X_6367_ _6376_/A3 _6367_/A2 _6603_/A1 PHY_9/VDD PHY_9/VDD VSUBS VSUBS gf180mcu_fd_sc_mcu7t5v0__nor2_1
X_9155_ _9110_/Z _9153_/Z _9155_/Z PHY_9/VDD PHY_9/VDD VSUBS VSUBS gf180mcu_fd_sc_mcu7t5v0__xor2_1
X_5318_ _5318_/A1 _5318_/A2 _5318_/B _9397_/D PHY_9/VDD PHY_9/VDD VSUBS VSUBS gf180mcu_fd_sc_mcu7t5v0__aoi21_1
X_8106_ _8107_/A1 _8107_/A2 _8124_/B PHY_9/VDD PHY_9/VDD VSUBS VSUBS gf180mcu_fd_sc_mcu7t5v0__nor2_1
X_9086_ _9808_/Q _9285_/A2 _9095_/B1 PHY_9/VDD PHY_9/VDD VSUBS VSUBS gf180mcu_fd_sc_mcu7t5v0__nor2_1
X_6298_ _8692_/A1 _6303_/A2 _6303_/B1 _6298_/B2 _9780_/D PHY_9/VDD PHY_9/VDD VSUBS
+ VSUBS gf180mcu_fd_sc_mcu7t5v0__oai22_1
X_5249_ _5132_/Z _5224_/Z _5343_/A1 PHY_9/VDD PHY_9/VDD VSUBS VSUBS gf180mcu_fd_sc_mcu7t5v0__nand2_2
X_8037_ _9902_/Q _8037_/A2 _9903_/Q _8040_/A2 PHY_9/VDD PHY_9/VDD VSUBS VSUBS gf180mcu_fd_sc_mcu7t5v0__aoi21_2
X_8939_ _8939_/A1 _8939_/A2 _9357_/B _9959_/D PHY_9/VDD PHY_9/VDD VSUBS VSUBS gf180mcu_fd_sc_mcu7t5v0__aoi21_1
X_7270_ _9855_/Q _7287_/A1 _7271_/A2 _7270_/Z PHY_9/VDD PHY_9/VDD VSUBS VSUBS gf180mcu_fd_sc_mcu7t5v0__xor3_1
X_6221_ _6221_/A1 _6221_/A2 _6232_/B1 PHY_9/VDD PHY_9/VDD VSUBS VSUBS gf180mcu_fd_sc_mcu7t5v0__nand2_1
X_6152_ _9577_/Q _6287_/B1 _6288_/B1 _9936_/Q _6154_/A1 PHY_9/VDD PHY_9/VDD VSUBS
+ VSUBS gf180mcu_fd_sc_mcu7t5v0__aoi22_1
X_5103_ _9761_/Q _6049_/B2 PHY_9/VDD PHY_9/VDD VSUBS VSUBS gf180mcu_fd_sc_mcu7t5v0__clkinv_1
X_6083_ _9582_/Q _6288_/A2 _6287_/A2 _9590_/Q _6084_/A2 PHY_9/VDD PHY_9/VDD VSUBS
+ VSUBS gf180mcu_fd_sc_mcu7t5v0__aoi22_1
X_5034_ _9555_/Q _5713_/B2 PHY_9/VDD PHY_9/VDD VSUBS VSUBS gf180mcu_fd_sc_mcu7t5v0__clkinv_1
X_9911_ _9911_/D _9974_/CLK _9911_/Q PHY_9/VDD PHY_9/VDD VSUBS VSUBS gf180mcu_fd_sc_mcu7t5v0__dffq_2
X_9842_ _9842_/D _9856_/CLK _9842_/Q PHY_9/VDD PHY_9/VDD VSUBS VSUBS gf180mcu_fd_sc_mcu7t5v0__dffq_2
X_6985_ _6985_/A1 _6983_/Z _6984_/Z _6985_/Z PHY_9/VDD PHY_9/VDD VSUBS VSUBS gf180mcu_fd_sc_mcu7t5v0__xor3_1
X_9773_ _9773_/D _9801_/CLK _9773_/Q PHY_9/VDD PHY_9/VDD VSUBS VSUBS gf180mcu_fd_sc_mcu7t5v0__dffq_2
X_5936_ _9679_/Q _5951_/A2 _5961_/B _5937_/B PHY_9/VDD PHY_9/VDD VSUBS VSUBS gf180mcu_fd_sc_mcu7t5v0__oai21_1
X_8724_ _9807_/Q _9004_/A2 _8736_/B PHY_9/VDD PHY_9/VDD VSUBS VSUBS gf180mcu_fd_sc_mcu7t5v0__nand2_2
X_8655_ _8655_/A1 _8655_/A2 _8655_/A3 _8655_/Z PHY_9/VDD PHY_9/VDD VSUBS VSUBS gf180mcu_fd_sc_mcu7t5v0__xor3_1
X_5867_ _9467_/Q _5867_/A2 _5868_/A2 PHY_9/VDD PHY_9/VDD VSUBS VSUBS gf180mcu_fd_sc_mcu7t5v0__nand2_1
X_7606_ _7606_/A1 _7653_/A1 _7656_/S PHY_9/VDD PHY_9/VDD VSUBS VSUBS gf180mcu_fd_sc_mcu7t5v0__nor2_1
X_5798_ _8691_/A1 _5804_/A2 _5804_/B1 _5798_/B2 _9616_/D PHY_9/VDD PHY_9/VDD VSUBS
+ VSUBS gf180mcu_fd_sc_mcu7t5v0__oai22_1
X_4818_ _9677_/Q _5949_/A1 PHY_9/VDD PHY_9/VDD VSUBS VSUBS gf180mcu_fd_sc_mcu7t5v0__clkinv_1
X_8586_ _9812_/Q _8644_/A2 _8586_/B _8587_/A4 PHY_9/VDD PHY_9/VDD VSUBS VSUBS gf180mcu_fd_sc_mcu7t5v0__oai21_1
X_7537_ _7537_/I _7566_/A1 PHY_9/VDD PHY_9/VDD VSUBS VSUBS gf180mcu_fd_sc_mcu7t5v0__clkinv_1
X_4749_ _9886_/Q _7725_/A3 PHY_9/VDD PHY_9/VDD VSUBS VSUBS gf180mcu_fd_sc_mcu7t5v0__inv_3
X_7468_ _7535_/A1 _7466_/Z _7468_/Z PHY_9/VDD PHY_9/VDD VSUBS VSUBS gf180mcu_fd_sc_mcu7t5v0__xor2_1
X_6419_ _9809_/Q _6584_/B1 _6455_/A1 PHY_9/VDD PHY_9/VDD VSUBS VSUBS gf180mcu_fd_sc_mcu7t5v0__nand2_1
X_9207_ _6512_/B _9205_/Z _9209_/B PHY_9/VDD PHY_9/VDD VSUBS VSUBS gf180mcu_fd_sc_mcu7t5v0__xor2_1
X_7399_ _9808_/Q _7668_/A2 _7399_/B1 _7625_/A1 _7482_/B _7400_/C PHY_9/VDD PHY_9/VDD
+ VSUBS VSUBS gf180mcu_fd_sc_mcu7t5v0__aoi221_1
X_9138_ _9138_/A1 _9270_/B _9138_/B _9333_/A2 PHY_9/VDD PHY_9/VDD VSUBS VSUBS gf180mcu_fd_sc_mcu7t5v0__aoi21_4
X_9069_ _9071_/A1 _9061_/B _9343_/B _9070_/A2 PHY_9/VDD PHY_9/VDD VSUBS VSUBS gf180mcu_fd_sc_mcu7t5v0__aoi21_1
X_6770_ _6770_/A1 _6770_/A2 _6770_/B _6812_/A1 PHY_9/VDD PHY_9/VDD VSUBS VSUBS gf180mcu_fd_sc_mcu7t5v0__oai21_1
X_5721_ _8691_/A1 _5727_/A2 _5727_/B1 _5721_/B2 _9559_/D PHY_9/VDD PHY_9/VDD VSUBS
+ VSUBS gf180mcu_fd_sc_mcu7t5v0__oai22_1
X_5652_ _8693_/A1 _5656_/A2 _5656_/B1 _5652_/B2 _9529_/D PHY_9/VDD PHY_9/VDD VSUBS
+ VSUBS gf180mcu_fd_sc_mcu7t5v0__oai22_1
X_8440_ _8475_/A1 _8438_/Z _8455_/A2 PHY_9/VDD PHY_9/VDD VSUBS VSUBS gf180mcu_fd_sc_mcu7t5v0__xnor2_1
X_5583_ _5583_/A1 _9356_/C _5584_/C PHY_9/VDD PHY_9/VDD VSUBS VSUBS gf180mcu_fd_sc_mcu7t5v0__nor2_1
X_8371_ _8389_/A1 _9921_/Q _8382_/A2 PHY_9/VDD PHY_9/VDD VSUBS VSUBS gf180mcu_fd_sc_mcu7t5v0__nor2_1
X_7322_ _7322_/A1 _7310_/Z _7321_/Z _7278_/C _7322_/C _7323_/A2 PHY_9/VDD PHY_9/VDD
+ VSUBS VSUBS gf180mcu_fd_sc_mcu7t5v0__aoi221_1
X_7253_ _9813_/Q _7019_/I _7256_/A3 PHY_9/VDD PHY_9/VDD VSUBS VSUBS gf180mcu_fd_sc_mcu7t5v0__nand2_1
X_6204_ _6283_/A1 _6204_/A2 _6204_/B1 _6290_/B2 _6204_/C _6205_/A3 PHY_9/VDD PHY_9/VDD
+ VSUBS VSUBS gf180mcu_fd_sc_mcu7t5v0__aoi221_2
X_7184_ _9811_/Q _7184_/A2 _7184_/B1 _7314_/I1 _7315_/B _7185_/B2 PHY_9/VDD PHY_9/VDD
+ VSUBS VSUBS gf180mcu_fd_sc_mcu7t5v0__aoi221_1
X_6135_ _9756_/Q _6287_/A2 _6287_/B1 _9740_/Q _6137_/A1 PHY_9/VDD PHY_9/VDD VSUBS
+ VSUBS gf180mcu_fd_sc_mcu7t5v0__aoi22_1
X_6066_ _6066_/A1 _5783_/Z _8688_/A2 PHY_9/VDD PHY_9/VDD VSUBS VSUBS gf180mcu_fd_sc_mcu7t5v0__nor2_4
X_5017_ _9627_/Q _5811_/B2 PHY_9/VDD PHY_9/VDD VSUBS VSUBS gf180mcu_fd_sc_mcu7t5v0__clkinv_1
X_9825_ _9825_/D _9830_/CLK _9825_/Q PHY_9/VDD PHY_9/VDD VSUBS VSUBS gf180mcu_fd_sc_mcu7t5v0__dffq_1
X_9756_ _9756_/D _9939_/CLK _9756_/Q PHY_9/VDD PHY_9/VDD VSUBS VSUBS gf180mcu_fd_sc_mcu7t5v0__dffq_1
X_6968_ _6978_/A2 _6968_/A2 _6967_/Z _6968_/Z PHY_9/VDD PHY_9/VDD VSUBS VSUBS gf180mcu_fd_sc_mcu7t5v0__xor3_1
X_8707_ _8994_/A1 _9034_/A2 _8707_/B _9953_/D PHY_9/VDD PHY_9/VDD VSUBS VSUBS gf180mcu_fd_sc_mcu7t5v0__aoi21_1
X_6899_ _6900_/A1 _6900_/A2 _6900_/B _6899_/Z PHY_9/VDD PHY_9/VDD VSUBS VSUBS gf180mcu_fd_sc_mcu7t5v0__and3_1
X_9687_ _9687_/D _9689_/CLK _9687_/Q PHY_9/VDD PHY_9/VDD VSUBS VSUBS gf180mcu_fd_sc_mcu7t5v0__dffq_1
X_5919_ _9665_/Q _5916_/Z _5919_/Z PHY_9/VDD PHY_9/VDD VSUBS VSUBS gf180mcu_fd_sc_mcu7t5v0__and2_1
X_8638_ _9931_/Q _9356_/C _8638_/B1 _8638_/B2 _8639_/A2 PHY_9/VDD PHY_9/VDD VSUBS
+ VSUBS gf180mcu_fd_sc_mcu7t5v0__aoi22_1
X_8569_ _8570_/A1 _8568_/Z _8641_/A1 PHY_9/VDD PHY_9/VDD VSUBS VSUBS gf180mcu_fd_sc_mcu7t5v0__nand2_1
Xrepeater11 rst_n _9031_/B PHY_9/VDD PHY_9/VDD VSUBS VSUBS gf180mcu_fd_sc_mcu7t5v0__buf_8
X_7940_ _7955_/A1 _7955_/A2 _7956_/A1 PHY_9/VDD PHY_9/VDD VSUBS VSUBS gf180mcu_fd_sc_mcu7t5v0__nor2_1
X_7871_ _7913_/A1 _7913_/A2 _7871_/B _7877_/B PHY_9/VDD PHY_9/VDD VSUBS VSUBS gf180mcu_fd_sc_mcu7t5v0__aoi21_1
X_6822_ _6822_/I _6863_/A1 PHY_9/VDD PHY_9/VDD VSUBS VSUBS gf180mcu_fd_sc_mcu7t5v0__clkinv_1
X_9610_ _9610_/D _9830_/CLK _9610_/Q PHY_9/VDD PHY_9/VDD VSUBS VSUBS gf180mcu_fd_sc_mcu7t5v0__dffq_1
X_6753_ _6974_/A2 _6755_/A3 _6754_/A2 PHY_9/VDD PHY_9/VDD VSUBS VSUBS gf180mcu_fd_sc_mcu7t5v0__xnor2_1
X_9541_ _9541_/D _9689_/CLK _9541_/Q PHY_9/VDD PHY_9/VDD VSUBS VSUBS gf180mcu_fd_sc_mcu7t5v0__dffq_1
X_6684_ _9831_/Q _6690_/A2 _6996_/A1 PHY_9/VDD PHY_9/VDD VSUBS VSUBS gf180mcu_fd_sc_mcu7t5v0__nor2_4
X_5704_ _5381_/I _5383_/I _6288_/B1 PHY_9/VDD PHY_9/VDD VSUBS VSUBS gf180mcu_fd_sc_mcu7t5v0__nor2_4
X_9472_ _9472_/D _9801_/CLK _9472_/Q PHY_9/VDD PHY_9/VDD VSUBS VSUBS gf180mcu_fd_sc_mcu7t5v0__dffq_2
X_8423_ _8423_/A1 _8421_/Z _8424_/A2 PHY_9/VDD PHY_9/VDD VSUBS VSUBS gf180mcu_fd_sc_mcu7t5v0__xnor2_1
X_5635_ _5636_/A2 _5636_/A3 _6287_/B1 PHY_9/VDD PHY_9/VDD VSUBS VSUBS gf180mcu_fd_sc_mcu7t5v0__nor2_4
X_8354_ _9368_/Q _9036_/A2 rst_n _8355_/B PHY_9/VDD PHY_9/VDD VSUBS VSUBS gf180mcu_fd_sc_mcu7t5v0__oai21_1
X_5566_ _5572_/A2 _9036_/A2 _5973_/C _9491_/D PHY_9/VDD PHY_9/VDD VSUBS VSUBS gf180mcu_fd_sc_mcu7t5v0__aoi21_1
X_7305_ _7305_/A1 _7304_/Z _7305_/Z PHY_9/VDD PHY_9/VDD VSUBS VSUBS gf180mcu_fd_sc_mcu7t5v0__xor2_1
X_8285_ _8285_/A1 _8285_/A2 _8231_/Z _8285_/B _8287_/A2 PHY_9/VDD PHY_9/VDD VSUBS
+ VSUBS gf180mcu_fd_sc_mcu7t5v0__oai31_1
X_5497_ _9729_/Q _9732_/Q _5522_/A2 PHY_9/VDD PHY_9/VDD VSUBS VSUBS gf180mcu_fd_sc_mcu7t5v0__nor2_4
X_7236_ _7236_/A1 _7219_/Z _7236_/B _7287_/A1 PHY_9/VDD PHY_9/VDD VSUBS VSUBS gf180mcu_fd_sc_mcu7t5v0__aoi21_1
X_7167_ _9853_/Q _7165_/Z _7189_/B PHY_9/VDD PHY_9/VDD VSUBS VSUBS gf180mcu_fd_sc_mcu7t5v0__nand2_1
X_7098_ _7314_/I1 _7158_/A1 _7315_/B _7100_/B1 PHY_9/VDD PHY_9/VDD VSUBS VSUBS gf180mcu_fd_sc_mcu7t5v0__aoi21_1
X_6118_ _6118_/A1 _6118_/A2 _6118_/A3 _6119_/A2 PHY_9/VDD PHY_9/VDD VSUBS VSUBS gf180mcu_fd_sc_mcu7t5v0__nand3_1
X_6049_ _5406_/Z _6049_/A2 _6049_/B1 _6049_/B2 _9761_/D PHY_9/VDD PHY_9/VDD VSUBS
+ VSUBS gf180mcu_fd_sc_mcu7t5v0__oai22_1
X_9808_ _9808_/D _9974_/CLK _9808_/Q PHY_9/VDD PHY_9/VDD VSUBS VSUBS gf180mcu_fd_sc_mcu7t5v0__dffq_4
X_9739_ _9739_/D _9939_/CLK _9739_/Q PHY_9/VDD PHY_9/VDD VSUBS VSUBS gf180mcu_fd_sc_mcu7t5v0__dffq_1
X_5420_ _9731_/Q _9429_/Q _5474_/B _5421_/B PHY_9/VDD PHY_9/VDD VSUBS VSUBS gf180mcu_fd_sc_mcu7t5v0__oai21_1
X_5351_ _5396_/A1 _5353_/A2 _5351_/B _5973_/C _9411_/D PHY_9/VDD PHY_9/VDD VSUBS VSUBS
+ gf180mcu_fd_sc_mcu7t5v0__aoi211_1
X_8070_ _8067_/Z _8068_/Z _8070_/A3 _8169_/A2 _9968_/Q _8075_/B PHY_9/VDD PHY_9/VDD
+ VSUBS VSUBS gf180mcu_fd_sc_mcu7t5v0__oai32_4
X_5282_ _9381_/Q _5285_/A2 _5283_/B PHY_9/VDD PHY_9/VDD VSUBS VSUBS gf180mcu_fd_sc_mcu7t5v0__nor2_1
X_7021_ _9807_/Q _7019_/I _7084_/A1 PHY_9/VDD PHY_9/VDD VSUBS VSUBS gf180mcu_fd_sc_mcu7t5v0__nand2_2
X_8972_ _9960_/Q _8971_/Z _8990_/B PHY_9/VDD PHY_9/VDD VSUBS VSUBS gf180mcu_fd_sc_mcu7t5v0__nand2_1
X_7923_ _9812_/Q _7973_/A2 _8008_/I1 _7924_/A2 _8009_/C _7924_/B PHY_9/VDD PHY_9/VDD
+ VSUBS VSUBS gf180mcu_fd_sc_mcu7t5v0__aoi221_1
X_7854_ _7842_/I _7854_/A2 _7850_/B _7855_/B PHY_9/VDD PHY_9/VDD VSUBS VSUBS gf180mcu_fd_sc_mcu7t5v0__xor3_1
X_6805_ _6996_/A1 _6924_/A1 _6955_/C _6807_/B1 PHY_9/VDD PHY_9/VDD VSUBS VSUBS gf180mcu_fd_sc_mcu7t5v0__aoi21_1
X_7785_ _7988_/A2 _7746_/B _7785_/B _7786_/A2 PHY_9/VDD PHY_9/VDD VSUBS VSUBS gf180mcu_fd_sc_mcu7t5v0__aoi21_1
X_4997_ _9602_/Q _5778_/B2 PHY_9/VDD PHY_9/VDD VSUBS VSUBS gf180mcu_fd_sc_mcu7t5v0__clkinv_1
X_6736_ _9838_/Q _9356_/C _6768_/A1 PHY_9/VDD PHY_9/VDD VSUBS VSUBS gf180mcu_fd_sc_mcu7t5v0__nand2_1
X_9524_ _9524_/D _9800_/CLK _9524_/Q PHY_9/VDD PHY_9/VDD VSUBS VSUBS gf180mcu_fd_sc_mcu7t5v0__dffq_1
X_6667_ _6699_/A3 _9036_/A2 _6667_/B _9831_/D PHY_9/VDD PHY_9/VDD VSUBS VSUBS gf180mcu_fd_sc_mcu7t5v0__aoi21_1
X_9455_ _9455_/D _9800_/CLK _9455_/Q PHY_9/VDD PHY_9/VDD VSUBS VSUBS gf180mcu_fd_sc_mcu7t5v0__dffq_1
X_6598_ _6599_/A2 _6596_/Z _6621_/A2 PHY_9/VDD PHY_9/VDD VSUBS VSUBS gf180mcu_fd_sc_mcu7t5v0__nand2_1
X_9386_ _9386_/D _9907_/CLK _9386_/Q PHY_9/VDD PHY_9/VDD VSUBS VSUBS gf180mcu_fd_sc_mcu7t5v0__dffq_1
X_8406_ _9808_/Q _8405_/Z _8449_/A1 PHY_9/VDD PHY_9/VDD VSUBS VSUBS gf180mcu_fd_sc_mcu7t5v0__nand2_1
X_5618_ _9508_/Q _5633_/A2 _5619_/A2 PHY_9/VDD PHY_9/VDD VSUBS VSUBS gf180mcu_fd_sc_mcu7t5v0__nand2_1
X_8337_ _8337_/A1 _8340_/B1 _8337_/B _8338_/A2 PHY_9/VDD PHY_9/VDD VSUBS VSUBS gf180mcu_fd_sc_mcu7t5v0__aoi21_1
X_5549_ _6283_/B2 _8344_/A1 _5558_/A2 PHY_9/VDD PHY_9/VDD VSUBS VSUBS gf180mcu_fd_sc_mcu7t5v0__nand2_4
X_8268_ _8268_/A1 _8267_/B _8314_/B2 _8269_/I PHY_9/VDD PHY_9/VDD VSUBS VSUBS gf180mcu_fd_sc_mcu7t5v0__xor3_1
X_7219_ _9854_/Q _7218_/Z _7219_/Z PHY_9/VDD PHY_9/VDD VSUBS VSUBS gf180mcu_fd_sc_mcu7t5v0__or2_1
X_8199_ _8191_/Z _8199_/A2 _8199_/B _8204_/B2 PHY_9/VDD PHY_9/VDD VSUBS VSUBS gf180mcu_fd_sc_mcu7t5v0__aoi21_1
X_4920_ _9632_/Q _5818_/B2 PHY_9/VDD PHY_9/VDD VSUBS VSUBS gf180mcu_fd_sc_mcu7t5v0__clkinv_1
X_4851_ _9450_/Q _5222_/A1 PHY_9/VDD PHY_9/VDD VSUBS VSUBS gf180mcu_fd_sc_mcu7t5v0__clkinv_1
X_4782_ _9833_/Q _6698_/A1 PHY_9/VDD PHY_9/VDD VSUBS VSUBS gf180mcu_fd_sc_mcu7t5v0__clkinv_3
X_7570_ _9875_/Q _7588_/A1 _7567_/Z _7584_/A2 PHY_9/VDD PHY_9/VDD VSUBS VSUBS gf180mcu_fd_sc_mcu7t5v0__xnor3_1
X_6521_ _6521_/A1 _6521_/A2 _6521_/B _6540_/A1 PHY_9/VDD PHY_9/VDD VSUBS VSUBS gf180mcu_fd_sc_mcu7t5v0__oai21_1
X_6452_ _6471_/B _9227_/A1 _6583_/A3 _6583_/A4 _6495_/A1 PHY_9/VDD PHY_9/VDD VSUBS
+ VSUBS gf180mcu_fd_sc_mcu7t5v0__nor4_4
X_9240_ _9189_/Z _9190_/Z _9239_/B _9276_/A2 PHY_9/VDD PHY_9/VDD VSUBS VSUBS gf180mcu_fd_sc_mcu7t5v0__nand3_1
X_5403_ _5403_/A1 _5407_/A2 _8695_/A1 _5407_/B2 _9423_/D PHY_9/VDD PHY_9/VDD VSUBS
+ VSUBS gf180mcu_fd_sc_mcu7t5v0__oai22_1
X_9171_ _9171_/A1 _9171_/A2 _9172_/B PHY_9/VDD PHY_9/VDD VSUBS VSUBS gf180mcu_fd_sc_mcu7t5v0__nand2_1
X_8122_ _9906_/Q _9356_/C _8122_/B _8123_/A2 PHY_9/VDD PHY_9/VDD VSUBS VSUBS gf180mcu_fd_sc_mcu7t5v0__aoi21_1
X_6383_ _7695_/B _9034_/A2 _9357_/B PHY_9/VDD PHY_9/VDD VSUBS VSUBS gf180mcu_fd_sc_mcu7t5v0__nand2_4
X_5334_ _5334_/A1 _5342_/A2 _5334_/B _9403_/D PHY_9/VDD PHY_9/VDD VSUBS VSUBS gf180mcu_fd_sc_mcu7t5v0__aoi21_1
X_5265_ _9461_/Q _5272_/A2 _8027_/B _5266_/B PHY_9/VDD PHY_9/VDD VSUBS VSUBS gf180mcu_fd_sc_mcu7t5v0__oai21_1
X_8053_ _8301_/A1 _8341_/A1 _8056_/B2 PHY_9/VDD PHY_9/VDD VSUBS VSUBS gf180mcu_fd_sc_mcu7t5v0__nand2_1
X_7004_ _7037_/A3 _9036_/A2 _7004_/B _9844_/D PHY_9/VDD PHY_9/VDD VSUBS VSUBS gf180mcu_fd_sc_mcu7t5v0__aoi21_1
X_5196_ _9640_/Q _5437_/A2 _5132_/Z _9639_/Q _5197_/A2 PHY_9/VDD PHY_9/VDD VSUBS VSUBS
+ gf180mcu_fd_sc_mcu7t5v0__aoi22_1
X_8955_ _6471_/B _8784_/I _8955_/A3 _8955_/B1 _8858_/B _8963_/A2 PHY_9/VDD PHY_9/VDD
+ VSUBS VSUBS gf180mcu_fd_sc_mcu7t5v0__oai32_2
X_8886_ _9811_/Q _8850_/Z _8887_/B1 PHY_9/VDD PHY_9/VDD VSUBS VSUBS gf180mcu_fd_sc_mcu7t5v0__nand2_1
X_7906_ _7838_/Z _7905_/Z _7960_/B1 PHY_9/VDD PHY_9/VDD VSUBS VSUBS gf180mcu_fd_sc_mcu7t5v0__xnor2_1
X_7837_ _9808_/Q _7836_/Z _7892_/A1 PHY_9/VDD PHY_9/VDD VSUBS VSUBS gf180mcu_fd_sc_mcu7t5v0__nand2_1
X_7768_ _9892_/Q _9317_/C _9100_/B _7768_/C _7769_/I PHY_9/VDD PHY_9/VDD VSUBS VSUBS
+ gf180mcu_fd_sc_mcu7t5v0__oai211_1
X_6719_ _6995_/C _6719_/A2 _6729_/A2 PHY_9/VDD PHY_9/VDD VSUBS VSUBS gf180mcu_fd_sc_mcu7t5v0__nand2_1
X_9507_ _9507_/D _9974_/CLK _9507_/Q PHY_9/VDD PHY_9/VDD VSUBS VSUBS gf180mcu_fd_sc_mcu7t5v0__dffq_2
X_7699_ _9888_/Q _7722_/A2 _8009_/C PHY_9/VDD PHY_9/VDD VSUBS VSUBS gf180mcu_fd_sc_mcu7t5v0__nor2_4
X_9438_ _9438_/D _9901_/CLK _9438_/Q PHY_9/VDD PHY_9/VDD VSUBS VSUBS gf180mcu_fd_sc_mcu7t5v0__dffq_1
X_9369_ _9369_/D _9957_/CLK _9369_/Q PHY_9/VDD PHY_9/VDD VSUBS VSUBS gf180mcu_fd_sc_mcu7t5v0__dffq_1
X_5050_ _9946_/Q _8695_/B2 PHY_9/VDD PHY_9/VDD VSUBS VSUBS gf180mcu_fd_sc_mcu7t5v0__clkinv_1
X_8740_ _9951_/Q _9950_/Q _8740_/A3 _8985_/C PHY_9/VDD PHY_9/VDD VSUBS VSUBS gf180mcu_fd_sc_mcu7t5v0__nand3_4
X_5952_ _9478_/Q _5158_/I _5973_/A2 PHY_9/VDD PHY_9/VDD VSUBS VSUBS gf180mcu_fd_sc_mcu7t5v0__nand2_4
X_4903_ _9591_/Q _5763_/B2 PHY_9/VDD PHY_9/VDD VSUBS VSUBS gf180mcu_fd_sc_mcu7t5v0__clkinv_1
X_5883_ _9598_/Q _5130_/I _5883_/A3 _5884_/A2 PHY_9/VDD PHY_9/VDD VSUBS VSUBS gf180mcu_fd_sc_mcu7t5v0__nand3_1
X_8671_ _8671_/A1 _8668_/Z _8671_/A3 _8671_/Z PHY_9/VDD PHY_9/VDD VSUBS VSUBS gf180mcu_fd_sc_mcu7t5v0__xor3_1
X_7622_ _9876_/Q _7621_/Z _7641_/B PHY_9/VDD PHY_9/VDD VSUBS VSUBS gf180mcu_fd_sc_mcu7t5v0__nand2_1
X_4834_ _9490_/Q _5560_/A2 PHY_9/VDD PHY_9/VDD VSUBS VSUBS gf180mcu_fd_sc_mcu7t5v0__clkinv_2
X_4765_ _9383_/Q _5288_/A1 PHY_9/VDD PHY_9/VDD VSUBS VSUBS gf180mcu_fd_sc_mcu7t5v0__clkinv_1
X_7553_ _7604_/B1 _9820_/Q _7553_/B _7554_/B2 PHY_9/VDD PHY_9/VDD VSUBS VSUBS gf180mcu_fd_sc_mcu7t5v0__oai21_2
X_6504_ _6504_/A1 _6502_/Z _6561_/B _6517_/A2 PHY_9/VDD PHY_9/VDD VSUBS VSUBS gf180mcu_fd_sc_mcu7t5v0__oai21_1
X_7484_ _7625_/A1 _7468_/Z _7484_/B _7485_/B PHY_9/VDD PHY_9/VDD VSUBS VSUBS gf180mcu_fd_sc_mcu7t5v0__aoi21_1
X_4696_ _9957_/Q _9136_/A2 PHY_9/VDD PHY_9/VDD VSUBS VSUBS gf180mcu_fd_sc_mcu7t5v0__inv_2
X_9223_ _9327_/B _9959_/Q _9511_/Q _9044_/Z _9326_/B1 _9909_/Q _9225_/A2 PHY_9/VDD
+ PHY_9/VDD VSUBS VSUBS gf180mcu_fd_sc_mcu7t5v0__aoi222_4
X_6435_ _9809_/Q _6627_/A2 _6435_/Z PHY_9/VDD PHY_9/VDD VSUBS VSUBS gf180mcu_fd_sc_mcu7t5v0__and2_1
X_6366_ _6614_/B _6470_/B _6370_/A2 PHY_9/VDD PHY_9/VDD VSUBS VSUBS gf180mcu_fd_sc_mcu7t5v0__nand2_1
X_9154_ _9110_/Z _9153_/Z _9154_/Z PHY_9/VDD PHY_9/VDD VSUBS VSUBS gf180mcu_fd_sc_mcu7t5v0__or2_1
X_5317_ _9464_/Q _5318_/A2 _8027_/B _5318_/B PHY_9/VDD PHY_9/VDD VSUBS VSUBS gf180mcu_fd_sc_mcu7t5v0__oai21_1
X_9085_ _9354_/A1 _9085_/A2 _9095_/A2 PHY_9/VDD PHY_9/VDD VSUBS VSUBS gf180mcu_fd_sc_mcu7t5v0__nand2_1
X_8105_ _9906_/Q _8104_/Z _8107_/A2 PHY_9/VDD PHY_9/VDD VSUBS VSUBS gf180mcu_fd_sc_mcu7t5v0__xnor2_1
X_6297_ _8691_/A1 _6303_/A2 _6303_/B1 _6297_/B2 _9779_/D PHY_9/VDD PHY_9/VDD VSUBS
+ VSUBS gf180mcu_fd_sc_mcu7t5v0__oai22_1
X_8036_ _9506_/Q _8035_/Z _8036_/Z PHY_9/VDD PHY_9/VDD VSUBS VSUBS gf180mcu_fd_sc_mcu7t5v0__and2_1
X_5248_ _5248_/A1 _5248_/A2 _5248_/B _9367_/D PHY_9/VDD PHY_9/VDD VSUBS VSUBS gf180mcu_fd_sc_mcu7t5v0__aoi21_1
X_5179_ _9534_/Q _9537_/Q _5179_/A3 _5182_/A2 PHY_9/VDD PHY_9/VDD VSUBS VSUBS gf180mcu_fd_sc_mcu7t5v0__nor3_2
X_8938_ _8985_/C _8923_/Z _8938_/B _9317_/C _8939_/A2 PHY_9/VDD PHY_9/VDD VSUBS VSUBS
+ gf180mcu_fd_sc_mcu7t5v0__oai211_1
X_8869_ _9958_/Q _8868_/Z _8892_/A1 PHY_9/VDD PHY_9/VDD VSUBS VSUBS gf180mcu_fd_sc_mcu7t5v0__nand2_1
X_6220_ _9751_/Q _6288_/A2 _6288_/B1 _9767_/Q _6221_/A2 PHY_9/VDD PHY_9/VDD VSUBS
+ VSUBS gf180mcu_fd_sc_mcu7t5v0__aoi22_1
X_6151_ _6151_/A1 _6151_/A2 _6173_/A2 PHY_9/VDD PHY_9/VDD VSUBS VSUBS gf180mcu_fd_sc_mcu7t5v0__nand2_1
X_5102_ _9769_/Q _6059_/B2 PHY_9/VDD PHY_9/VDD VSUBS VSUBS gf180mcu_fd_sc_mcu7t5v0__clkinv_1
X_6082_ _9574_/Q _6287_/B1 _6288_/B1 _9933_/Q _6084_/A1 PHY_9/VDD PHY_9/VDD VSUBS
+ VSUBS gf180mcu_fd_sc_mcu7t5v0__aoi22_1
X_5033_ _9579_/Q _5747_/B2 PHY_9/VDD PHY_9/VDD VSUBS VSUBS gf180mcu_fd_sc_mcu7t5v0__clkinv_1
X_9910_ _9910_/D _9957_/CLK _9910_/Q PHY_9/VDD PHY_9/VDD VSUBS VSUBS gf180mcu_fd_sc_mcu7t5v0__dffq_2
X_9841_ _9841_/D _9856_/CLK _9841_/Q PHY_9/VDD PHY_9/VDD VSUBS VSUBS gf180mcu_fd_sc_mcu7t5v0__dffq_4
X_6984_ _6984_/A1 _6984_/A2 _6984_/Z PHY_9/VDD PHY_9/VDD VSUBS VSUBS gf180mcu_fd_sc_mcu7t5v0__xor2_1
X_9772_ _9772_/D _9801_/CLK _9772_/Q PHY_9/VDD PHY_9/VDD VSUBS VSUBS gf180mcu_fd_sc_mcu7t5v0__dffq_2
X_5935_ _5911_/I _5934_/Z _9670_/D PHY_9/VDD PHY_9/VDD VSUBS VSUBS gf180mcu_fd_sc_mcu7t5v0__nor2_1
X_8723_ _8857_/A1 _8857_/A2 _8857_/C _8832_/A1 PHY_9/VDD PHY_9/VDD VSUBS VSUBS gf180mcu_fd_sc_mcu7t5v0__oai21_2
X_8654_ _9814_/Q _8654_/A2 _8655_/A3 PHY_9/VDD PHY_9/VDD VSUBS VSUBS gf180mcu_fd_sc_mcu7t5v0__nand2_1
X_5866_ _5866_/A1 _5866_/A2 _9646_/D PHY_9/VDD PHY_9/VDD VSUBS VSUBS gf180mcu_fd_sc_mcu7t5v0__nor2_1
X_4817_ _9678_/Q _5951_/A1 PHY_9/VDD PHY_9/VDD VSUBS VSUBS gf180mcu_fd_sc_mcu7t5v0__clkinv_1
X_7605_ _9808_/Q _7670_/A2 _7653_/A1 PHY_9/VDD PHY_9/VDD VSUBS VSUBS gf180mcu_fd_sc_mcu7t5v0__nand2_1
X_5797_ _5388_/Z _5804_/A2 _5804_/B1 _5797_/B2 _9615_/D PHY_9/VDD PHY_9/VDD VSUBS
+ VSUBS gf180mcu_fd_sc_mcu7t5v0__oai22_1
X_8585_ _8634_/A1 _8585_/A2 _8585_/B _8586_/B PHY_9/VDD PHY_9/VDD VSUBS VSUBS gf180mcu_fd_sc_mcu7t5v0__oai21_1
X_7536_ _7463_/Z _7506_/Z _7562_/A1 _7536_/B _7537_/I PHY_9/VDD PHY_9/VDD VSUBS VSUBS
+ gf180mcu_fd_sc_mcu7t5v0__oai31_1
X_4748_ _9887_/Q _7711_/A2 PHY_9/VDD PHY_9/VDD VSUBS VSUBS gf180mcu_fd_sc_mcu7t5v0__inv_1
X_7467_ _7535_/A1 _7466_/Z _7513_/A1 PHY_9/VDD PHY_9/VDD VSUBS VSUBS gf180mcu_fd_sc_mcu7t5v0__nor2_1
X_4679_ _9974_/Q _9357_/A1 PHY_9/VDD PHY_9/VDD VSUBS VSUBS gf180mcu_fd_sc_mcu7t5v0__clkinv_2
X_6418_ _9809_/Q _6624_/A2 _6421_/A3 PHY_9/VDD PHY_9/VDD VSUBS VSUBS gf180mcu_fd_sc_mcu7t5v0__nand2_1
X_9206_ _9811_/Q _9205_/Z _9206_/Z PHY_9/VDD PHY_9/VDD VSUBS VSUBS gf180mcu_fd_sc_mcu7t5v0__and2_1
X_7398_ _7398_/I _7399_/B1 PHY_9/VDD PHY_9/VDD VSUBS VSUBS gf180mcu_fd_sc_mcu7t5v0__clkinv_1
X_9137_ _9139_/B1 _9139_/B2 _9138_/B PHY_9/VDD PHY_9/VDD VSUBS VSUBS gf180mcu_fd_sc_mcu7t5v0__nor2_1
X_6349_ _9349_/A1 _9034_/A2 _6349_/B _9814_/D PHY_9/VDD PHY_9/VDD VSUBS VSUBS gf180mcu_fd_sc_mcu7t5v0__aoi21_1
X_9068_ _9967_/Q _9807_/Q _9331_/A2 _9098_/A1 PHY_9/VDD PHY_9/VDD VSUBS VSUBS gf180mcu_fd_sc_mcu7t5v0__nand3_2
X_8019_ _9373_/Q _9036_/A2 _8027_/B _8020_/B PHY_9/VDD PHY_9/VDD VSUBS VSUBS gf180mcu_fd_sc_mcu7t5v0__oai21_1
X_5720_ _5388_/Z _5727_/A2 _5727_/B1 _5720_/B2 _9558_/D PHY_9/VDD PHY_9/VDD VSUBS
+ VSUBS gf180mcu_fd_sc_mcu7t5v0__oai22_1
X_5651_ _8692_/A1 _5656_/A2 _5656_/B1 _5651_/B2 _9528_/D PHY_9/VDD PHY_9/VDD VSUBS
+ VSUBS gf180mcu_fd_sc_mcu7t5v0__oai22_1
X_8370_ _9090_/C _8369_/Z _8422_/A2 PHY_9/VDD PHY_9/VDD VSUBS VSUBS gf180mcu_fd_sc_mcu7t5v0__nor2_2
X_5582_ _5594_/A1 _5582_/A2 _5582_/B _9494_/D PHY_9/VDD PHY_9/VDD VSUBS VSUBS gf180mcu_fd_sc_mcu7t5v0__aoi21_1
X_7321_ _7316_/Z _7321_/A2 _7321_/A3 _7321_/Z PHY_9/VDD PHY_9/VDD VSUBS VSUBS gf180mcu_fd_sc_mcu7t5v0__xor3_1
X_7252_ _9811_/Q _7290_/A2 _7297_/B2 PHY_9/VDD PHY_9/VDD VSUBS VSUBS gf180mcu_fd_sc_mcu7t5v0__nand2_1
X_6203_ _6283_/B2 _6203_/A2 _6203_/B1 _8688_/A2 _6203_/C _6205_/A2 PHY_9/VDD PHY_9/VDD
+ VSUBS VSUBS gf180mcu_fd_sc_mcu7t5v0__aoi221_1
X_7183_ _9811_/Q _7247_/A2 _7184_/B1 PHY_9/VDD PHY_9/VDD VSUBS VSUBS gf180mcu_fd_sc_mcu7t5v0__nand2_1
X_6134_ _6134_/A1 _6134_/A2 _6146_/A2 PHY_9/VDD PHY_9/VDD VSUBS VSUBS gf180mcu_fd_sc_mcu7t5v0__nand2_1
X_6065_ _6065_/A1 _6065_/A2 _6087_/A2 PHY_9/VDD PHY_9/VDD VSUBS VSUBS gf180mcu_fd_sc_mcu7t5v0__nand2_1
X_5016_ _9635_/Q _5821_/B2 PHY_9/VDD PHY_9/VDD VSUBS VSUBS gf180mcu_fd_sc_mcu7t5v0__clkinv_1
X_9824_ _9824_/D _9830_/CLK _9824_/Q PHY_9/VDD PHY_9/VDD VSUBS VSUBS gf180mcu_fd_sc_mcu7t5v0__dffq_1
X_9755_ _9755_/D _9939_/CLK _9755_/Q PHY_9/VDD PHY_9/VDD VSUBS VSUBS gf180mcu_fd_sc_mcu7t5v0__dffq_1
X_6967_ _6967_/A1 _6967_/A2 _6967_/Z PHY_9/VDD PHY_9/VDD VSUBS VSUBS gf180mcu_fd_sc_mcu7t5v0__xor2_1
X_5918_ _5916_/Z _5918_/A2 _9664_/D PHY_9/VDD PHY_9/VDD VSUBS VSUBS gf180mcu_fd_sc_mcu7t5v0__nor2_1
X_8706_ _9367_/Q _9034_/A2 _8706_/B _8707_/B PHY_9/VDD PHY_9/VDD VSUBS VSUBS gf180mcu_fd_sc_mcu7t5v0__oai21_1
X_6898_ _6558_/B _6897_/Z _6900_/B PHY_9/VDD PHY_9/VDD VSUBS VSUBS gf180mcu_fd_sc_mcu7t5v0__xor2_1
X_9686_ _9686_/D _9689_/CLK _9686_/Q PHY_9/VDD PHY_9/VDD VSUBS VSUBS gf180mcu_fd_sc_mcu7t5v0__dffq_1
X_5849_ _9643_/Q _5832_/Z _9031_/B _5852_/A1 PHY_9/VDD PHY_9/VDD VSUBS VSUBS gf180mcu_fd_sc_mcu7t5v0__oai21_1
X_8637_ _8491_/C _8623_/Z _9356_/C _8638_/B2 PHY_9/VDD PHY_9/VDD VSUBS VSUBS gf180mcu_fd_sc_mcu7t5v0__aoi21_1
X_8568_ _8515_/Z _8568_/A2 _8568_/Z PHY_9/VDD PHY_9/VDD VSUBS VSUBS gf180mcu_fd_sc_mcu7t5v0__xor2_1
X_7519_ _7647_/A2 _7382_/Z _7657_/A2 _7654_/A2 _7572_/A2 PHY_9/VDD PHY_9/VDD VSUBS
+ VSUBS gf180mcu_fd_sc_mcu7t5v0__nor4_2
X_8499_ _9807_/Q _8600_/A2 _8503_/A1 PHY_9/VDD PHY_9/VDD VSUBS VSUBS gf180mcu_fd_sc_mcu7t5v0__nand2_1
Xrepeater12 _8706_/B _7695_/B PHY_9/VDD PHY_9/VDD VSUBS VSUBS gf180mcu_fd_sc_mcu7t5v0__buf_8
X_7870_ _7913_/A1 _7913_/A2 _7870_/B _7871_/B PHY_9/VDD PHY_9/VDD VSUBS VSUBS gf180mcu_fd_sc_mcu7t5v0__oai21_1
X_6821_ _6821_/A1 _6821_/A2 _6822_/I PHY_9/VDD PHY_9/VDD VSUBS VSUBS gf180mcu_fd_sc_mcu7t5v0__xnor2_1
X_9540_ _9540_/D _9689_/CLK _9540_/Q PHY_9/VDD PHY_9/VDD VSUBS VSUBS gf180mcu_fd_sc_mcu7t5v0__dffq_1
X_6752_ _9831_/Q _6752_/A2 _6752_/B1 _6752_/B2 _6755_/A3 PHY_9/VDD PHY_9/VDD VSUBS
+ VSUBS gf180mcu_fd_sc_mcu7t5v0__aoi22_2
X_6683_ _9833_/Q _6698_/A2 _6690_/A2 PHY_9/VDD PHY_9/VDD VSUBS VSUBS gf180mcu_fd_sc_mcu7t5v0__nand2_2
X_5703_ _5659_/I _5702_/Z _9549_/D PHY_9/VDD PHY_9/VDD VSUBS VSUBS gf180mcu_fd_sc_mcu7t5v0__nor2_1
X_9471_ _9471_/D _9801_/CLK _9471_/Q PHY_9/VDD PHY_9/VDD VSUBS VSUBS gf180mcu_fd_sc_mcu7t5v0__dffq_2
X_8422_ _9925_/Q _8422_/A2 _8421_/Z _8427_/B PHY_9/VDD PHY_9/VDD VSUBS VSUBS gf180mcu_fd_sc_mcu7t5v0__and3_1
X_5634_ _5634_/A1 _5634_/A2 _5973_/C _9513_/D PHY_9/VDD PHY_9/VDD VSUBS VSUBS gf180mcu_fd_sc_mcu7t5v0__aoi21_1
X_8353_ _5406_/Z _8353_/A2 _8353_/B1 _8353_/B2 _9919_/D PHY_9/VDD PHY_9/VDD VSUBS
+ VSUBS gf180mcu_fd_sc_mcu7t5v0__oai22_1
X_7304_ _7304_/A1 _7304_/A2 _7304_/A3 _7304_/Z PHY_9/VDD PHY_9/VDD VSUBS VSUBS gf180mcu_fd_sc_mcu7t5v0__xor3_1
X_5565_ _5565_/A1 _9490_/Q _9489_/Q _9036_/A2 PHY_9/VDD PHY_9/VDD VSUBS VSUBS gf180mcu_fd_sc_mcu7t5v0__nand3_4
X_8284_ _8284_/A1 _8284_/A2 _8284_/Z PHY_9/VDD PHY_9/VDD VSUBS VSUBS gf180mcu_fd_sc_mcu7t5v0__xor2_1
X_5496_ _5973_/C _5496_/A2 _9459_/D PHY_9/VDD PHY_9/VDD VSUBS VSUBS gf180mcu_fd_sc_mcu7t5v0__nor2_1
X_7235_ _7235_/A1 _7235_/A2 _9357_/B _9854_/D PHY_9/VDD PHY_9/VDD VSUBS VSUBS gf180mcu_fd_sc_mcu7t5v0__aoi21_1
X_7166_ _9853_/Q _7165_/Z _7189_/A2 PHY_9/VDD PHY_9/VDD VSUBS VSUBS gf180mcu_fd_sc_mcu7t5v0__nor2_1
X_6117_ _6290_/B2 _6117_/A2 _6117_/B1 _6283_/A1 _6117_/C _6118_/A3 PHY_9/VDD PHY_9/VDD
+ VSUBS VSUBS gf180mcu_fd_sc_mcu7t5v0__aoi221_2
X_7097_ _9809_/Q _7290_/A2 _7158_/A1 PHY_9/VDD PHY_9/VDD VSUBS VSUBS gf180mcu_fd_sc_mcu7t5v0__nand2_2
X_6048_ _5404_/Z _6049_/A2 _6049_/B1 _6048_/B2 _9760_/D PHY_9/VDD PHY_9/VDD VSUBS
+ VSUBS gf180mcu_fd_sc_mcu7t5v0__oai22_1
X_9807_ _9807_/D _9974_/CLK _9807_/Q PHY_9/VDD PHY_9/VDD VSUBS VSUBS gf180mcu_fd_sc_mcu7t5v0__dffq_4
X_7999_ _7990_/Z _7999_/A2 _7998_/Z _7999_/Z PHY_9/VDD PHY_9/VDD VSUBS VSUBS gf180mcu_fd_sc_mcu7t5v0__xor3_1
X_9738_ _9738_/D _9939_/CLK _9738_/Q PHY_9/VDD PHY_9/VDD VSUBS VSUBS gf180mcu_fd_sc_mcu7t5v0__dffq_1
X_9669_ _9669_/D _9972_/CLK _9669_/Q PHY_9/VDD PHY_9/VDD VSUBS VSUBS gf180mcu_fd_sc_mcu7t5v0__dffq_1
X_5350_ _9411_/Q _5353_/A2 _5351_/B PHY_9/VDD PHY_9/VDD VSUBS VSUBS gf180mcu_fd_sc_mcu7t5v0__nor2_1
X_5281_ _5393_/A1 _5285_/A2 _5281_/B _5973_/C _9380_/D PHY_9/VDD PHY_9/VDD VSUBS VSUBS
+ gf180mcu_fd_sc_mcu7t5v0__aoi211_1
X_7020_ _9090_/C _7053_/A2 _7039_/A2 PHY_9/VDD PHY_9/VDD VSUBS VSUBS gf180mcu_fd_sc_mcu7t5v0__nor2_1
Xclkbuf_leaf_4_clk clkbuf_leaf_8_clk/I _9948_/CLK PHY_9/VDD PHY_9/VDD VSUBS VSUBS
+ gf180mcu_fd_sc_mcu7t5v0__clkbuf_16
X_8971_ _8970_/Z _8971_/I1 _8971_/S _8971_/Z PHY_9/VDD PHY_9/VDD VSUBS VSUBS gf180mcu_fd_sc_mcu7t5v0__mux2_1
X_7922_ _9812_/Q _7992_/A2 _7924_/A2 PHY_9/VDD PHY_9/VDD VSUBS VSUBS gf180mcu_fd_sc_mcu7t5v0__nand2_1
X_7853_ _7842_/I _7882_/B _7851_/Z _7904_/A2 PHY_9/VDD PHY_9/VDD VSUBS VSUBS gf180mcu_fd_sc_mcu7t5v0__nor3_1
X_4996_ _9693_/Q _5984_/B2 PHY_9/VDD PHY_9/VDD VSUBS VSUBS gf180mcu_fd_sc_mcu7t5v0__clkinv_1
X_6804_ _9810_/Q _6966_/A2 _6924_/A1 PHY_9/VDD PHY_9/VDD VSUBS VSUBS gf180mcu_fd_sc_mcu7t5v0__nand2_2
X_7784_ _7988_/A2 _7746_/B _7864_/A2 PHY_9/VDD PHY_9/VDD VSUBS VSUBS gf180mcu_fd_sc_mcu7t5v0__nand2_1
X_6735_ _9317_/C _6735_/A2 _6735_/B _9837_/D PHY_9/VDD PHY_9/VDD VSUBS VSUBS gf180mcu_fd_sc_mcu7t5v0__aoi21_1
X_9523_ _9523_/D _9800_/CLK _9523_/Q PHY_9/VDD PHY_9/VDD VSUBS VSUBS gf180mcu_fd_sc_mcu7t5v0__dffq_4
X_9454_ _9454_/D _9800_/CLK _9454_/Q PHY_9/VDD PHY_9/VDD VSUBS VSUBS gf180mcu_fd_sc_mcu7t5v0__dffq_1
X_6666_ _9393_/Q _9036_/A2 _8027_/B _6667_/B PHY_9/VDD PHY_9/VDD VSUBS VSUBS gf180mcu_fd_sc_mcu7t5v0__oai21_1
X_6597_ _6599_/A1 _6596_/Z _6621_/A1 PHY_9/VDD PHY_9/VDD VSUBS VSUBS gf180mcu_fd_sc_mcu7t5v0__nand2_1
X_9385_ _9385_/D _9907_/CLK _9385_/Q PHY_9/VDD PHY_9/VDD VSUBS VSUBS gf180mcu_fd_sc_mcu7t5v0__dffq_1
X_8405_ _8401_/Z _8407_/A3 _8405_/Z PHY_9/VDD PHY_9/VDD VSUBS VSUBS gf180mcu_fd_sc_mcu7t5v0__xor2_1
X_5617_ _9772_/Q _5561_/I _5619_/A1 PHY_9/VDD PHY_9/VDD VSUBS VSUBS gf180mcu_fd_sc_mcu7t5v0__nand2_1
X_8336_ _8336_/A1 _8335_/Z _8336_/Z PHY_9/VDD PHY_9/VDD VSUBS VSUBS gf180mcu_fd_sc_mcu7t5v0__xor2_1
X_5548_ _5705_/A1 _5636_/A2 _5383_/I _8344_/A1 PHY_9/VDD PHY_9/VDD VSUBS VSUBS gf180mcu_fd_sc_mcu7t5v0__nor3_4
X_8267_ _9810_/Q _8311_/A2 _8267_/B _8314_/B1 PHY_9/VDD PHY_9/VDD VSUBS VSUBS gf180mcu_fd_sc_mcu7t5v0__aoi21_1
X_7218_ _7218_/A1 _7216_/Z _7218_/Z PHY_9/VDD PHY_9/VDD VSUBS VSUBS gf180mcu_fd_sc_mcu7t5v0__xor2_1
X_5479_ _9451_/Q _5493_/B _5770_/B _5480_/B PHY_9/VDD PHY_9/VDD VSUBS VSUBS gf180mcu_fd_sc_mcu7t5v0__oai21_1
X_8198_ _8191_/Z _8199_/A2 _8198_/Z PHY_9/VDD PHY_9/VDD VSUBS VSUBS gf180mcu_fd_sc_mcu7t5v0__or2_1
X_7149_ _7149_/A1 _7200_/A1 _7237_/A1 PHY_9/VDD PHY_9/VDD VSUBS VSUBS gf180mcu_fd_sc_mcu7t5v0__nor2_1
X_4850_ _9451_/Q _5144_/A1 PHY_9/VDD PHY_9/VDD VSUBS VSUBS gf180mcu_fd_sc_mcu7t5v0__clkinv_1
X_6520_ _6501_/Z _6503_/Z _6550_/A1 PHY_9/VDD PHY_9/VDD VSUBS VSUBS gf180mcu_fd_sc_mcu7t5v0__nor2_1
X_4781_ _9396_/Q _5316_/A1 PHY_9/VDD PHY_9/VDD VSUBS VSUBS gf180mcu_fd_sc_mcu7t5v0__clkinv_1
X_6451_ _9810_/Q _6584_/B1 _6493_/A2 PHY_9/VDD PHY_9/VDD VSUBS VSUBS gf180mcu_fd_sc_mcu7t5v0__nand2_1
X_6382_ _7695_/B _9036_/A2 _9100_/B PHY_9/VDD PHY_9/VDD VSUBS VSUBS gf180mcu_fd_sc_mcu7t5v0__and2_4
X_9170_ _9810_/Q _9348_/A2 _9279_/B _9347_/I0 _9170_/C _9171_/A2 PHY_9/VDD PHY_9/VDD
+ VSUBS VSUBS gf180mcu_fd_sc_mcu7t5v0__aoi221_1
X_5402_ _9972_/Q _5201_/Z _5402_/B _8695_/A1 PHY_9/VDD PHY_9/VDD VSUBS VSUBS gf180mcu_fd_sc_mcu7t5v0__aoi21_4
X_8121_ _8156_/B _8121_/A2 _8121_/B1 _8121_/B2 _9356_/C _8122_/B PHY_9/VDD PHY_9/VDD
+ VSUBS VSUBS gf180mcu_fd_sc_mcu7t5v0__aoi221_1
X_5333_ _9460_/Q _5342_/A2 _9035_/B _5334_/B PHY_9/VDD PHY_9/VDD VSUBS VSUBS gf180mcu_fd_sc_mcu7t5v0__oai21_1
X_5264_ _5264_/A1 _5272_/A2 _5264_/B _9373_/D PHY_9/VDD PHY_9/VDD VSUBS VSUBS gf180mcu_fd_sc_mcu7t5v0__aoi21_1
X_8052_ _9899_/Q _8052_/A2 _8341_/A1 PHY_9/VDD PHY_9/VDD VSUBS VSUBS gf180mcu_fd_sc_mcu7t5v0__nand2_1
X_7003_ _9388_/Q _9036_/A2 _7007_/B _7004_/B PHY_9/VDD PHY_9/VDD VSUBS VSUBS gf180mcu_fd_sc_mcu7t5v0__oai21_1
X_5195_ _9671_/Q _5883_/A3 _5197_/A1 PHY_9/VDD PHY_9/VDD VSUBS VSUBS gf180mcu_fd_sc_mcu7t5v0__nand2_1
X_8954_ _8954_/A1 _8954_/A2 _8950_/Z _9002_/A1 PHY_9/VDD PHY_9/VDD VSUBS VSUBS gf180mcu_fd_sc_mcu7t5v0__xnor3_1
X_8885_ _8885_/A1 _8885_/A2 _8887_/A2 PHY_9/VDD PHY_9/VDD VSUBS VSUBS gf180mcu_fd_sc_mcu7t5v0__nand2_1
X_7905_ _7905_/A1 _7904_/B _7905_/Z PHY_9/VDD PHY_9/VDD VSUBS VSUBS gf180mcu_fd_sc_mcu7t5v0__xor2_1
X_7836_ _9958_/Q _9874_/Q _9840_/Q _9908_/Q _9890_/Q _9889_/Q _7836_/Z PHY_9/VDD PHY_9/VDD
+ VSUBS VSUBS gf180mcu_fd_sc_mcu7t5v0__mux4_4
X_7767_ _7831_/C _7767_/A2 _7767_/B _9317_/C _7768_/C PHY_9/VDD PHY_9/VDD VSUBS VSUBS
+ gf180mcu_fd_sc_mcu7t5v0__oai211_1
X_4979_ _9484_/Q _5554_/B2 PHY_9/VDD PHY_9/VDD VSUBS VSUBS gf180mcu_fd_sc_mcu7t5v0__clkinv_1
X_6718_ _9090_/C _6680_/Z _6717_/B _6719_/A2 PHY_9/VDD PHY_9/VDD VSUBS VSUBS gf180mcu_fd_sc_mcu7t5v0__nand3_1
X_9506_ _9506_/D _9974_/CLK _9506_/Q PHY_9/VDD PHY_9/VDD VSUBS VSUBS gf180mcu_fd_sc_mcu7t5v0__dffq_2
X_7698_ _9887_/Q _9886_/Q _7722_/A2 PHY_9/VDD PHY_9/VDD VSUBS VSUBS gf180mcu_fd_sc_mcu7t5v0__nand2_2
X_6649_ _9349_/A1 _6649_/A2 _6649_/B _6652_/B PHY_9/VDD PHY_9/VDD VSUBS VSUBS gf180mcu_fd_sc_mcu7t5v0__aoi21_1
X_9437_ _9437_/D _9800_/CLK _9437_/Q PHY_9/VDD PHY_9/VDD VSUBS VSUBS gf180mcu_fd_sc_mcu7t5v0__dffq_1
X_9368_ _9368_/D _9957_/CLK _9368_/Q PHY_9/VDD PHY_9/VDD VSUBS VSUBS gf180mcu_fd_sc_mcu7t5v0__dffq_1
X_9299_ _9296_/Z _9299_/A2 _9299_/Z PHY_9/VDD PHY_9/VDD VSUBS VSUBS gf180mcu_fd_sc_mcu7t5v0__xor2_1
X_8319_ _9357_/A1 _8319_/A2 _8319_/B1 _8319_/B2 _8340_/B1 PHY_9/VDD PHY_9/VDD VSUBS
+ VSUBS gf180mcu_fd_sc_mcu7t5v0__aoi22_4
X_5951_ _5951_/A1 _5951_/A2 _5951_/B _9678_/D PHY_9/VDD PHY_9/VDD VSUBS VSUBS gf180mcu_fd_sc_mcu7t5v0__aoi21_1
X_4902_ _9934_/Q _8681_/B2 PHY_9/VDD PHY_9/VDD VSUBS VSUBS gf180mcu_fd_sc_mcu7t5v0__clkinv_1
X_8670_ _8670_/A1 _8670_/A2 _8671_/A3 PHY_9/VDD PHY_9/VDD VSUBS VSUBS gf180mcu_fd_sc_mcu7t5v0__nand2_1
X_5882_ _5973_/C uart_rx _9653_/D PHY_9/VDD PHY_9/VDD VSUBS VSUBS gf180mcu_fd_sc_mcu7t5v0__or2_1
X_7621_ _7642_/A1 _7621_/A2 _7619_/B _7621_/Z PHY_9/VDD PHY_9/VDD VSUBS VSUBS gf180mcu_fd_sc_mcu7t5v0__xor3_1
X_4833_ _9491_/Q _5565_/A1 PHY_9/VDD PHY_9/VDD VSUBS VSUBS gf180mcu_fd_sc_mcu7t5v0__clkinv_1
X_4764_ _9865_/Q _7371_/A3 PHY_9/VDD PHY_9/VDD VSUBS VSUBS gf180mcu_fd_sc_mcu7t5v0__clkinv_3
X_7552_ _9896_/Q _7450_/Z _7554_/B1 PHY_9/VDD PHY_9/VDD VSUBS VSUBS gf180mcu_fd_sc_mcu7t5v0__nand2_1
X_6503_ _6504_/A1 _6502_/Z _6503_/Z PHY_9/VDD PHY_9/VDD VSUBS VSUBS gf180mcu_fd_sc_mcu7t5v0__and2_1
X_7483_ _7636_/A1 _7601_/A1 _7483_/B1 _7483_/B2 _7483_/C _7484_/B PHY_9/VDD PHY_9/VDD
+ VSUBS VSUBS gf180mcu_fd_sc_mcu7t5v0__oai221_1
X_6434_ _6434_/A1 _6434_/A2 _6441_/B1 PHY_9/VDD PHY_9/VDD VSUBS VSUBS gf180mcu_fd_sc_mcu7t5v0__nor2_1
X_9222_ _9183_/Z _9222_/A2 _9222_/B _9243_/A1 PHY_9/VDD PHY_9/VDD VSUBS VSUBS gf180mcu_fd_sc_mcu7t5v0__aoi21_1
X_4695_ _9958_/Q _8890_/A1 PHY_9/VDD PHY_9/VDD VSUBS VSUBS gf180mcu_fd_sc_mcu7t5v0__inv_1
X_6365_ _6367_/A2 _6400_/A2 _6649_/B _6470_/B PHY_9/VDD PHY_9/VDD VSUBS VSUBS gf180mcu_fd_sc_mcu7t5v0__nand3_2
X_9153_ _9268_/A1 _9153_/A2 _9153_/A3 _9153_/Z PHY_9/VDD PHY_9/VDD VSUBS VSUBS gf180mcu_fd_sc_mcu7t5v0__xor3_1
X_5316_ _5316_/A1 _5318_/A2 _5316_/B _9396_/D PHY_9/VDD PHY_9/VDD VSUBS VSUBS gf180mcu_fd_sc_mcu7t5v0__aoi21_1
X_8104_ _8086_/Z _8102_/Z _8104_/Z PHY_9/VDD PHY_9/VDD VSUBS VSUBS gf180mcu_fd_sc_mcu7t5v0__xor2_1
X_6296_ _5388_/Z _6303_/A2 _6303_/B1 _6296_/B2 _9778_/D PHY_9/VDD PHY_9/VDD VSUBS
+ VSUBS gf180mcu_fd_sc_mcu7t5v0__oai22_1
X_9084_ _9072_/Z _9081_/Z _9085_/A2 PHY_9/VDD PHY_9/VDD VSUBS VSUBS gf180mcu_fd_sc_mcu7t5v0__nand2_1
X_5247_ _9464_/Q _5248_/A2 _8706_/B _5248_/B PHY_9/VDD PHY_9/VDD VSUBS VSUBS gf180mcu_fd_sc_mcu7t5v0__oai21_1
X_8035_ _9903_/Q _9902_/Q _8035_/Z PHY_9/VDD PHY_9/VDD VSUBS VSUBS gf180mcu_fd_sc_mcu7t5v0__and2_2
X_5178_ _9535_/Q _9536_/Q _5179_/A3 PHY_9/VDD PHY_9/VDD VSUBS VSUBS gf180mcu_fd_sc_mcu7t5v0__nand2_1
X_8937_ _8985_/C _8937_/A2 _8937_/A3 _8937_/A4 _8938_/B PHY_9/VDD PHY_9/VDD VSUBS
+ VSUBS gf180mcu_fd_sc_mcu7t5v0__nand4_1
X_8868_ _8919_/A1 _8866_/Z _8868_/Z PHY_9/VDD PHY_9/VDD VSUBS VSUBS gf180mcu_fd_sc_mcu7t5v0__xor2_1
X_8799_ _9227_/A1 _9003_/A2 _8799_/A3 _8801_/B PHY_9/VDD PHY_9/VDD VSUBS VSUBS gf180mcu_fd_sc_mcu7t5v0__xor3_1
X_7819_ _7819_/A1 _7819_/A2 _7819_/B _7863_/A1 PHY_9/VDD PHY_9/VDD VSUBS VSUBS gf180mcu_fd_sc_mcu7t5v0__oai21_2
X_6150_ _9421_/Q _6288_/A2 _6288_/B1 _9553_/Q _6151_/A2 PHY_9/VDD PHY_9/VDD VSUBS
+ VSUBS gf180mcu_fd_sc_mcu7t5v0__aoi22_1
X_5101_ _9793_/Q _6313_/B2 PHY_9/VDD PHY_9/VDD VSUBS VSUBS gf180mcu_fd_sc_mcu7t5v0__clkinv_1
X_6081_ _6081_/A1 _6081_/A2 _6085_/B1 PHY_9/VDD PHY_9/VDD VSUBS VSUBS gf180mcu_fd_sc_mcu7t5v0__nand2_1
X_5032_ _9587_/Q _5757_/B2 PHY_9/VDD PHY_9/VDD VSUBS VSUBS gf180mcu_fd_sc_mcu7t5v0__clkinv_1
X_9840_ _9840_/D _9907_/CLK _9840_/Q PHY_9/VDD PHY_9/VDD VSUBS VSUBS gf180mcu_fd_sc_mcu7t5v0__dffq_2
X_6983_ _6983_/A1 _6982_/Z _6983_/Z PHY_9/VDD PHY_9/VDD VSUBS VSUBS gf180mcu_fd_sc_mcu7t5v0__xor2_1
X_9771_ _9771_/D _9801_/CLK _9771_/Q PHY_9/VDD PHY_9/VDD VSUBS VSUBS gf180mcu_fd_sc_mcu7t5v0__dffq_2
X_5934_ _9670_/Q _5934_/A2 _5934_/Z PHY_9/VDD PHY_9/VDD VSUBS VSUBS gf180mcu_fd_sc_mcu7t5v0__xor2_1
X_8722_ _8755_/A1 _8719_/C _8755_/B1 _8755_/B2 _9004_/A2 PHY_9/VDD PHY_9/VDD VSUBS
+ VSUBS gf180mcu_fd_sc_mcu7t5v0__aoi22_4
X_8653_ _9812_/Q _8653_/A2 _8655_/A2 PHY_9/VDD PHY_9/VDD VSUBS VSUBS gf180mcu_fd_sc_mcu7t5v0__nand2_1
X_5865_ _9466_/Q _5867_/A2 _5865_/B _5866_/A2 PHY_9/VDD PHY_9/VDD VSUBS VSUBS gf180mcu_fd_sc_mcu7t5v0__aoi21_1
X_4816_ _9679_/Q _5954_/A1 PHY_9/VDD PHY_9/VDD VSUBS VSUBS gf180mcu_fd_sc_mcu7t5v0__clkinv_1
X_7604_ _7965_/A1 _9869_/Q _7604_/B1 _7604_/B2 _7604_/C _7670_/A2 PHY_9/VDD PHY_9/VDD
+ VSUBS VSUBS gf180mcu_fd_sc_mcu7t5v0__aoi221_4
X_5796_ _8689_/A1 _5804_/A2 _5804_/B1 PHY_9/VDD PHY_9/VDD VSUBS VSUBS gf180mcu_fd_sc_mcu7t5v0__nand2_2
X_8584_ _9812_/Q _8674_/A2 _8585_/A2 _8673_/I1 _8674_/B _8585_/B PHY_9/VDD PHY_9/VDD
+ VSUBS VSUBS gf180mcu_fd_sc_mcu7t5v0__aoi221_1
X_7535_ _7535_/A1 _7466_/Z _7535_/A3 _7535_/B _7589_/A1 PHY_9/VDD PHY_9/VDD VSUBS
+ VSUBS gf180mcu_fd_sc_mcu7t5v0__oai31_1
X_4747_ _9888_/Q _7724_/A1 PHY_9/VDD PHY_9/VDD VSUBS VSUBS gf180mcu_fd_sc_mcu7t5v0__clkinv_3
X_7466_ _7490_/A1 _7465_/Z _7466_/Z PHY_9/VDD PHY_9/VDD VSUBS VSUBS gf180mcu_fd_sc_mcu7t5v0__xor2_1
X_6417_ _9807_/Q _6627_/A2 _6448_/B2 PHY_9/VDD PHY_9/VDD VSUBS VSUBS gf180mcu_fd_sc_mcu7t5v0__nand2_1
X_7397_ _7397_/A1 _7397_/A2 _7398_/I PHY_9/VDD PHY_9/VDD VSUBS VSUBS gf180mcu_fd_sc_mcu7t5v0__xnor2_1
X_9205_ _9178_/Z _9205_/A2 _9205_/Z PHY_9/VDD PHY_9/VDD VSUBS VSUBS gf180mcu_fd_sc_mcu7t5v0__xor2_1
X_9136_ _9966_/Q _9136_/A2 _9965_/Q _9139_/B2 PHY_9/VDD PHY_9/VDD VSUBS VSUBS gf180mcu_fd_sc_mcu7t5v0__aoi21_2
X_6348_ _9513_/Q _9034_/A2 _8706_/B _6349_/B PHY_9/VDD PHY_9/VDD VSUBS VSUBS gf180mcu_fd_sc_mcu7t5v0__oai21_1
X_6279_ _6279_/A1 _6279_/A2 _6283_/A2 PHY_9/VDD PHY_9/VDD VSUBS VSUBS gf180mcu_fd_sc_mcu7t5v0__nand2_1
X_9067_ _9807_/Q _9331_/A2 _9067_/B _9343_/B _9071_/B1 PHY_9/VDD PHY_9/VDD VSUBS VSUBS
+ gf180mcu_fd_sc_mcu7t5v0__oai211_1
X_8018_ _8018_/A1 _9356_/C _8018_/B1 _8018_/B2 _9357_/B _9898_/D PHY_9/VDD PHY_9/VDD
+ VSUBS VSUBS gf180mcu_fd_sc_mcu7t5v0__aoi221_1
X_9969_ _9969_/D _9972_/CLK _9969_/Q PHY_9/VDD PHY_9/VDD VSUBS VSUBS gf180mcu_fd_sc_mcu7t5v0__dffq_2
X_5650_ _8691_/A1 _5656_/A2 _5656_/B1 _5650_/B2 _9527_/D PHY_9/VDD PHY_9/VDD VSUBS
+ VSUBS gf180mcu_fd_sc_mcu7t5v0__oai22_1
Xclkbuf_0_clk clk clkbuf_0_clk/Z PHY_9/VDD PHY_9/VDD VSUBS VSUBS gf180mcu_fd_sc_mcu7t5v0__clkbuf_16
X_5581_ _9494_/Q _5594_/A1 _6089_/B _5582_/B PHY_9/VDD PHY_9/VDD VSUBS VSUBS gf180mcu_fd_sc_mcu7t5v0__oai21_1
X_7320_ _7320_/A1 _7320_/A2 _7321_/A3 PHY_9/VDD PHY_9/VDD VSUBS VSUBS gf180mcu_fd_sc_mcu7t5v0__nand2_1
X_7251_ _7258_/A1 _7258_/A2 _7259_/A2 PHY_9/VDD PHY_9/VDD VSUBS VSUBS gf180mcu_fd_sc_mcu7t5v0__nor2_1
X_6202_ _6656_/A2 _6202_/A2 _6202_/B1 _6291_/B2 _6205_/A1 PHY_9/VDD PHY_9/VDD VSUBS
+ VSUBS gf180mcu_fd_sc_mcu7t5v0__aoi22_1
X_7182_ _7182_/A1 _7182_/A2 _7184_/A2 PHY_9/VDD PHY_9/VDD VSUBS VSUBS gf180mcu_fd_sc_mcu7t5v0__nand2_1
X_6133_ _9692_/Q _6288_/A2 _6288_/B1 _9708_/Q _6134_/A2 PHY_9/VDD PHY_9/VDD VSUBS
+ VSUBS gf180mcu_fd_sc_mcu7t5v0__aoi22_1
X_6064_ _9746_/Q _6288_/A2 _6288_/B1 _9762_/Q _6065_/A2 PHY_9/VDD PHY_9/VDD VSUBS
+ VSUBS gf180mcu_fd_sc_mcu7t5v0__aoi22_1
X_5015_ _9611_/Q _5791_/B2 PHY_9/VDD PHY_9/VDD VSUBS VSUBS gf180mcu_fd_sc_mcu7t5v0__clkinv_1
X_9823_ _9823_/D _9830_/CLK _9823_/Q PHY_9/VDD PHY_9/VDD VSUBS VSUBS gf180mcu_fd_sc_mcu7t5v0__dffq_1
X_9754_ _9754_/D _9939_/CLK _9754_/Q PHY_9/VDD PHY_9/VDD VSUBS VSUBS gf180mcu_fd_sc_mcu7t5v0__dffq_1
X_6966_ _9811_/Q _6966_/A2 _6967_/A2 PHY_9/VDD PHY_9/VDD VSUBS VSUBS gf180mcu_fd_sc_mcu7t5v0__nand2_1
X_5917_ _9664_/Q _5913_/Z _5932_/B _5918_/A2 PHY_9/VDD PHY_9/VDD VSUBS VSUBS gf180mcu_fd_sc_mcu7t5v0__oai21_1
X_8705_ _8994_/B _9036_/A2 _8705_/B _9952_/D PHY_9/VDD PHY_9/VDD VSUBS VSUBS gf180mcu_fd_sc_mcu7t5v0__aoi21_1
X_6897_ _6977_/A2 _6897_/A2 _6897_/Z PHY_9/VDD PHY_9/VDD VSUBS VSUBS gf180mcu_fd_sc_mcu7t5v0__xor2_1
X_9685_ _9685_/D _9972_/CLK _9685_/Q PHY_9/VDD PHY_9/VDD VSUBS VSUBS gf180mcu_fd_sc_mcu7t5v0__dffq_1
X_5848_ _9644_/Q _9523_/Q _5850_/A2 PHY_9/VDD PHY_9/VDD VSUBS VSUBS gf180mcu_fd_sc_mcu7t5v0__nand2_1
X_8636_ _8391_/C _8636_/A2 _8636_/A3 _8636_/A4 _8638_/B1 PHY_9/VDD PHY_9/VDD VSUBS
+ VSUBS gf180mcu_fd_sc_mcu7t5v0__nand4_1
X_5779_ _5399_/Z _5782_/A2 _5782_/B1 _5779_/B2 _9603_/D PHY_9/VDD PHY_9/VDD VSUBS
+ VSUBS gf180mcu_fd_sc_mcu7t5v0__oai22_1
X_8567_ _8515_/Z _8568_/A2 _8620_/A1 PHY_9/VDD PHY_9/VDD VSUBS VSUBS gf180mcu_fd_sc_mcu7t5v0__nor2_1
X_7518_ _7625_/A1 _7518_/A2 _7531_/C PHY_9/VDD PHY_9/VDD VSUBS VSUBS gf180mcu_fd_sc_mcu7t5v0__nand2_1
X_8498_ _8890_/A1 _9924_/Q _8498_/B1 _8646_/A2 _8498_/C _8600_/A2 PHY_9/VDD PHY_9/VDD
+ VSUBS VSUBS gf180mcu_fd_sc_mcu7t5v0__aoi221_4
X_7449_ _7449_/A1 _7449_/A2 _7449_/Z PHY_9/VDD PHY_9/VDD VSUBS VSUBS gf180mcu_fd_sc_mcu7t5v0__xor2_1
X_9119_ _9227_/A1 _9119_/A2 _9165_/A1 PHY_9/VDD PHY_9/VDD VSUBS VSUBS gf180mcu_fd_sc_mcu7t5v0__nor2_1
Xrepeater13 rst_n _8706_/B PHY_9/VDD PHY_9/VDD VSUBS VSUBS gf180mcu_fd_sc_mcu7t5v0__buf_8
X_6820_ _9808_/Q _6820_/A2 _6921_/A2 _6911_/B2 PHY_9/VDD PHY_9/VDD VSUBS VSUBS gf180mcu_fd_sc_mcu7t5v0__nand3_2
X_6751_ _7077_/A1 _6770_/A1 _6748_/Z _6751_/Z PHY_9/VDD PHY_9/VDD VSUBS VSUBS gf180mcu_fd_sc_mcu7t5v0__xor3_1
X_6682_ _9090_/C _6752_/B2 _6724_/A2 PHY_9/VDD PHY_9/VDD VSUBS VSUBS gf180mcu_fd_sc_mcu7t5v0__nor2_2
X_5702_ _9549_/Q _5702_/A2 _5702_/Z PHY_9/VDD PHY_9/VDD VSUBS VSUBS gf180mcu_fd_sc_mcu7t5v0__xor2_1
X_9470_ _9470_/D _9801_/CLK _9470_/Q PHY_9/VDD PHY_9/VDD VSUBS VSUBS gf180mcu_fd_sc_mcu7t5v0__dffq_4
X_8421_ _9926_/Q _8418_/Z _8421_/Z PHY_9/VDD PHY_9/VDD VSUBS VSUBS gf180mcu_fd_sc_mcu7t5v0__xor2_1
X_5633_ _9513_/Q _5633_/A2 _5634_/A2 PHY_9/VDD PHY_9/VDD VSUBS VSUBS gf180mcu_fd_sc_mcu7t5v0__nand2_1
X_8352_ _5404_/Z _8353_/A2 _8353_/B1 _8352_/B2 _9918_/D PHY_9/VDD PHY_9/VDD VSUBS
+ VSUBS gf180mcu_fd_sc_mcu7t5v0__oai22_1
X_5564_ _5575_/A3 _5633_/A2 _5973_/C _9490_/D PHY_9/VDD PHY_9/VDD VSUBS VSUBS gf180mcu_fd_sc_mcu7t5v0__aoi21_1
X_7303_ _9809_/Q _7303_/A2 _7304_/A3 PHY_9/VDD PHY_9/VDD VSUBS VSUBS gf180mcu_fd_sc_mcu7t5v0__nand2_1
X_8283_ _8284_/A1 _8284_/A2 _8327_/A2 PHY_9/VDD PHY_9/VDD VSUBS VSUBS gf180mcu_fd_sc_mcu7t5v0__nand2_1
X_5495_ _9459_/Q _5495_/A2 _5495_/B _5496_/A2 PHY_9/VDD PHY_9/VDD VSUBS VSUBS gf180mcu_fd_sc_mcu7t5v0__aoi21_1
X_7234_ _7040_/B _7221_/Z _7234_/B _9317_/C _7235_/A2 PHY_9/VDD PHY_9/VDD VSUBS VSUBS
+ gf180mcu_fd_sc_mcu7t5v0__oai211_1
X_7165_ _7165_/A1 _7165_/A2 _7165_/Z PHY_9/VDD PHY_9/VDD VSUBS VSUBS gf180mcu_fd_sc_mcu7t5v0__xor2_1
X_6116_ _8688_/A2 _6116_/A2 _6116_/B1 _6283_/B2 _6116_/C _6118_/A2 PHY_9/VDD PHY_9/VDD
+ VSUBS VSUBS gf180mcu_fd_sc_mcu7t5v0__aoi221_1
X_7096_ _9809_/Q _7290_/A2 _7100_/B2 PHY_9/VDD PHY_9/VDD VSUBS VSUBS gf180mcu_fd_sc_mcu7t5v0__nor2_1
X_6047_ _8695_/A1 _6049_/A2 _6049_/B1 _6047_/B2 _9759_/D PHY_9/VDD PHY_9/VDD VSUBS
+ VSUBS gf180mcu_fd_sc_mcu7t5v0__oai22_1
X_9806_ _9806_/D _9907_/CLK _9806_/Q PHY_9/VDD PHY_9/VDD VSUBS VSUBS gf180mcu_fd_sc_mcu7t5v0__dffq_2
X_7998_ _7998_/A1 _7998_/A2 _7998_/A3 _7998_/Z PHY_9/VDD PHY_9/VDD VSUBS VSUBS gf180mcu_fd_sc_mcu7t5v0__xor3_1
X_6949_ _6991_/A2 _6992_/A1 _6949_/Z PHY_9/VDD PHY_9/VDD VSUBS VSUBS gf180mcu_fd_sc_mcu7t5v0__xor2_1
X_9737_ _9737_/D _9800_/CLK _9737_/Q PHY_9/VDD PHY_9/VDD VSUBS VSUBS gf180mcu_fd_sc_mcu7t5v0__dffq_1
X_9668_ _9668_/D _9972_/CLK _9668_/Q PHY_9/VDD PHY_9/VDD VSUBS VSUBS gf180mcu_fd_sc_mcu7t5v0__dffq_1
X_8619_ _8620_/A1 _8617_/Z _8641_/A2 PHY_9/VDD PHY_9/VDD VSUBS VSUBS gf180mcu_fd_sc_mcu7t5v0__nor2_1
X_9599_ _9599_/D _9940_/CLK _9599_/Q PHY_9/VDD PHY_9/VDD VSUBS VSUBS gf180mcu_fd_sc_mcu7t5v0__dffq_1
X_5280_ _9380_/Q _5285_/A2 _5281_/B PHY_9/VDD PHY_9/VDD VSUBS VSUBS gf180mcu_fd_sc_mcu7t5v0__nor2_1
X_8970_ _8991_/A2 _8991_/B _8970_/Z PHY_9/VDD PHY_9/VDD VSUBS VSUBS gf180mcu_fd_sc_mcu7t5v0__xor2_1
X_7921_ _7870_/B _7970_/A2 _7920_/Z _7926_/A3 PHY_9/VDD PHY_9/VDD VSUBS VSUBS gf180mcu_fd_sc_mcu7t5v0__nand3_1
X_7852_ _7806_/Z _7852_/A2 _7850_/B _7882_/A2 PHY_9/VDD PHY_9/VDD VSUBS VSUBS gf180mcu_fd_sc_mcu7t5v0__nand3_1
X_4995_ _9701_/Q _5994_/B2 PHY_9/VDD PHY_9/VDD VSUBS VSUBS gf180mcu_fd_sc_mcu7t5v0__clkinv_1
X_6803_ _9810_/Q _6966_/A2 _6807_/B2 PHY_9/VDD PHY_9/VDD VSUBS VSUBS gf180mcu_fd_sc_mcu7t5v0__nor2_1
X_7783_ _7783_/A1 _7748_/Z _7783_/B _7819_/A1 PHY_9/VDD PHY_9/VDD VSUBS VSUBS gf180mcu_fd_sc_mcu7t5v0__aoi21_2
X_6734_ _9837_/Q _9317_/C _9100_/B _6735_/B PHY_9/VDD PHY_9/VDD VSUBS VSUBS gf180mcu_fd_sc_mcu7t5v0__oai21_1
X_9522_ _9522_/D _9800_/CLK _9522_/Q PHY_9/VDD PHY_9/VDD VSUBS VSUBS gf180mcu_fd_sc_mcu7t5v0__dffq_1
X_9453_ _9453_/D _9800_/CLK _9453_/Q PHY_9/VDD PHY_9/VDD VSUBS VSUBS gf180mcu_fd_sc_mcu7t5v0__dffq_1
X_6665_ _5406_/Z _6665_/A2 _6665_/B1 _6665_/B2 _9830_/D PHY_9/VDD PHY_9/VDD VSUBS
+ VSUBS gf180mcu_fd_sc_mcu7t5v0__oai22_1
X_8404_ _8416_/A2 _8416_/A3 _8416_/A4 _8402_/Z _8407_/A3 PHY_9/VDD PHY_9/VDD VSUBS
+ VSUBS gf180mcu_fd_sc_mcu7t5v0__nor4_4
X_6596_ _6596_/A1 _6596_/A2 _6596_/Z PHY_9/VDD PHY_9/VDD VSUBS VSUBS gf180mcu_fd_sc_mcu7t5v0__xor2_1
X_9384_ _9384_/D _9907_/CLK _9384_/Q PHY_9/VDD PHY_9/VDD VSUBS VSUBS gf180mcu_fd_sc_mcu7t5v0__dffq_1
X_5616_ _5616_/A1 _5616_/A2 _5973_/C _9507_/D PHY_9/VDD PHY_9/VDD VSUBS VSUBS gf180mcu_fd_sc_mcu7t5v0__aoi21_1
X_8335_ _9814_/Q _8340_/B1 _8335_/A3 _8335_/Z PHY_9/VDD PHY_9/VDD VSUBS VSUBS gf180mcu_fd_sc_mcu7t5v0__xor3_1
X_5547_ _5636_/A2 _5383_/I _6287_/A2 PHY_9/VDD PHY_9/VDD VSUBS VSUBS gf180mcu_fd_sc_mcu7t5v0__nor2_4
X_8266_ _9810_/Q _8266_/A2 _8314_/A2 PHY_9/VDD PHY_9/VDD VSUBS VSUBS gf180mcu_fd_sc_mcu7t5v0__nand2_1
X_5478_ _5478_/A1 _5493_/B _5478_/B _9450_/D PHY_9/VDD PHY_9/VDD VSUBS VSUBS gf180mcu_fd_sc_mcu7t5v0__aoi21_1
X_7217_ _7218_/A1 _7216_/Z _7217_/Z PHY_9/VDD PHY_9/VDD VSUBS VSUBS gf180mcu_fd_sc_mcu7t5v0__and2_1
X_8197_ _8197_/I _8199_/A2 PHY_9/VDD PHY_9/VDD VSUBS VSUBS gf180mcu_fd_sc_mcu7t5v0__clkinv_1
X_7148_ _9808_/Q _7247_/A2 _7200_/A1 PHY_9/VDD PHY_9/VDD VSUBS VSUBS gf180mcu_fd_sc_mcu7t5v0__nand2_1
X_7079_ _9809_/Q _7019_/I _7152_/A1 PHY_9/VDD PHY_9/VDD VSUBS VSUBS gf180mcu_fd_sc_mcu7t5v0__nand2_1
X_4780_ _9834_/Q _6815_/B PHY_9/VDD PHY_9/VDD VSUBS VSUBS gf180mcu_fd_sc_mcu7t5v0__inv_3
X_6450_ _9810_/Q _6624_/A2 _6530_/B2 PHY_9/VDD PHY_9/VDD VSUBS VSUBS gf180mcu_fd_sc_mcu7t5v0__nand2_1
X_6381_ _9356_/C _6381_/A2 _6384_/B2 PHY_9/VDD PHY_9/VDD VSUBS VSUBS gf180mcu_fd_sc_mcu7t5v0__nor2_1
X_5401_ _5517_/A1 _5201_/Z _5402_/B PHY_9/VDD PHY_9/VDD VSUBS VSUBS gf180mcu_fd_sc_mcu7t5v0__nor2_1
X_5332_ _5237_/Z _5354_/A2 _5342_/A2 PHY_9/VDD PHY_9/VDD VSUBS VSUBS gf180mcu_fd_sc_mcu7t5v0__nand2_4
X_8120_ _8291_/A1 _8104_/Z _8114_/Z _8151_/B _8120_/C _8121_/B2 PHY_9/VDD PHY_9/VDD
+ VSUBS VSUBS gf180mcu_fd_sc_mcu7t5v0__aoi221_1
X_8051_ _8058_/A3 _8339_/B _8291_/A1 PHY_9/VDD PHY_9/VDD VSUBS VSUBS gf180mcu_fd_sc_mcu7t5v0__nor2_2
X_5263_ _9460_/Q _5272_/A2 _8027_/B _5264_/B PHY_9/VDD PHY_9/VDD VSUBS VSUBS gf180mcu_fd_sc_mcu7t5v0__oai21_1
X_7002_ _7002_/A1 _7002_/A2 _9843_/D PHY_9/VDD PHY_9/VDD VSUBS VSUBS gf180mcu_fd_sc_mcu7t5v0__nor2_1
X_5194_ _5827_/A2 _5194_/A2 _5973_/C _9524_/D PHY_9/VDD PHY_9/VDD VSUBS VSUBS gf180mcu_fd_sc_mcu7t5v0__aoi21_1
X_8953_ _8954_/A1 _8954_/A2 _9001_/A2 PHY_9/VDD PHY_9/VDD VSUBS VSUBS gf180mcu_fd_sc_mcu7t5v0__nand2_1
X_8884_ _9020_/A1 _8850_/Z _8885_/A2 PHY_9/VDD PHY_9/VDD VSUBS VSUBS gf180mcu_fd_sc_mcu7t5v0__nand2_1
X_7904_ _7882_/B _7904_/A2 _7904_/B _7931_/B PHY_9/VDD PHY_9/VDD VSUBS VSUBS gf180mcu_fd_sc_mcu7t5v0__oai21_1
X_7835_ _7835_/A1 _7835_/A2 _7835_/B _7881_/A1 PHY_9/VDD PHY_9/VDD VSUBS VSUBS gf180mcu_fd_sc_mcu7t5v0__oai21_1
X_4978_ _9717_/Q _6014_/B2 PHY_9/VDD PHY_9/VDD VSUBS VSUBS gf180mcu_fd_sc_mcu7t5v0__clkinv_1
X_9505_ _9505_/D _9974_/CLK _9505_/Q PHY_9/VDD PHY_9/VDD VSUBS VSUBS gf180mcu_fd_sc_mcu7t5v0__dffq_1
X_7766_ _7770_/A1 _7764_/Z _7766_/B _7767_/B PHY_9/VDD PHY_9/VDD VSUBS VSUBS gf180mcu_fd_sc_mcu7t5v0__oai21_1
X_6717_ _9090_/C _6680_/Z _6717_/B _6757_/A2 PHY_9/VDD PHY_9/VDD VSUBS VSUBS gf180mcu_fd_sc_mcu7t5v0__aoi21_2
X_7697_ _7711_/A2 _7725_/A3 _7973_/A2 PHY_9/VDD PHY_9/VDD VSUBS VSUBS gf180mcu_fd_sc_mcu7t5v0__nor2_4
X_6648_ _6648_/A1 _6650_/A3 _6649_/A2 PHY_9/VDD PHY_9/VDD VSUBS VSUBS gf180mcu_fd_sc_mcu7t5v0__nand2_1
X_9436_ _9436_/D _9801_/CLK _9436_/Q PHY_9/VDD PHY_9/VDD VSUBS VSUBS gf180mcu_fd_sc_mcu7t5v0__dffq_1
X_9367_ _9367_/D _9974_/CLK _9367_/Q PHY_9/VDD PHY_9/VDD VSUBS VSUBS gf180mcu_fd_sc_mcu7t5v0__dffq_1
X_6579_ _6622_/B2 _6578_/Z _6579_/Z PHY_9/VDD PHY_9/VDD VSUBS VSUBS gf180mcu_fd_sc_mcu7t5v0__xor2_1
X_8318_ _8318_/A1 _9898_/Q _8318_/B _8319_/B2 PHY_9/VDD PHY_9/VDD VSUBS VSUBS gf180mcu_fd_sc_mcu7t5v0__oai21_2
X_9298_ _9296_/Z _9299_/A2 _9340_/A1 PHY_9/VDD PHY_9/VDD VSUBS VSUBS gf180mcu_fd_sc_mcu7t5v0__nand2_1
X_8249_ _8301_/A1 _8249_/A2 _8249_/B _8250_/B PHY_9/VDD PHY_9/VDD VSUBS VSUBS gf180mcu_fd_sc_mcu7t5v0__oai21_1
X_5950_ _9686_/Q _5951_/A2 rst_n _5951_/B PHY_9/VDD PHY_9/VDD VSUBS VSUBS gf180mcu_fd_sc_mcu7t5v0__oai21_1
X_4901_ _9599_/Q _5775_/B2 PHY_9/VDD PHY_9/VDD VSUBS VSUBS gf180mcu_fd_sc_mcu7t5v0__clkinv_1
X_7620_ _7620_/A1 _7563_/Z _7619_/B _7642_/A2 PHY_9/VDD PHY_9/VDD VSUBS VSUBS gf180mcu_fd_sc_mcu7t5v0__nor3_1
X_5881_ _5973_/C _9653_/Q _9652_/D PHY_9/VDD PHY_9/VDD VSUBS VSUBS gf180mcu_fd_sc_mcu7t5v0__or2_1
X_4832_ _9498_/Q _8755_/A1 PHY_9/VDD PHY_9/VDD VSUBS VSUBS gf180mcu_fd_sc_mcu7t5v0__clkinv_3
X_4763_ _9384_/Q _5290_/A1 PHY_9/VDD PHY_9/VDD VSUBS VSUBS gf180mcu_fd_sc_mcu7t5v0__clkinv_1
X_7551_ _7551_/A1 _7551_/A2 _7646_/A1 _7551_/Z PHY_9/VDD PHY_9/VDD VSUBS VSUBS gf180mcu_fd_sc_mcu7t5v0__xor3_1
X_6502_ _9819_/Q _6516_/A2 _6502_/Z PHY_9/VDD PHY_9/VDD VSUBS VSUBS gf180mcu_fd_sc_mcu7t5v0__xor2_1
X_7482_ _9810_/Q _7668_/A2 _7482_/B _7483_/C PHY_9/VDD PHY_9/VDD VSUBS VSUBS gf180mcu_fd_sc_mcu7t5v0__aoi21_1
X_4694_ _9960_/Q _8973_/A1 PHY_9/VDD PHY_9/VDD VSUBS VSUBS gf180mcu_fd_sc_mcu7t5v0__clkinv_3
X_6433_ _6611_/C _6464_/A2 _6434_/A2 PHY_9/VDD PHY_9/VDD VSUBS VSUBS gf180mcu_fd_sc_mcu7t5v0__nand2_1
X_9221_ _9221_/A1 _9221_/A2 _9221_/B _9249_/A1 PHY_9/VDD PHY_9/VDD VSUBS VSUBS gf180mcu_fd_sc_mcu7t5v0__oai21_1
X_6364_ _6367_/A2 _6400_/A2 _6649_/B _6611_/C PHY_9/VDD PHY_9/VDD VSUBS VSUBS gf180mcu_fd_sc_mcu7t5v0__and3_1
X_9152_ _9153_/A2 _9153_/A3 _9152_/Z PHY_9/VDD PHY_9/VDD VSUBS VSUBS gf180mcu_fd_sc_mcu7t5v0__or2_1
X_5315_ _9463_/Q _5318_/A2 _8027_/B _5316_/B PHY_9/VDD PHY_9/VDD VSUBS VSUBS gf180mcu_fd_sc_mcu7t5v0__oai21_1
X_8103_ _8086_/Z _8102_/Z _8103_/Z PHY_9/VDD PHY_9/VDD VSUBS VSUBS gf180mcu_fd_sc_mcu7t5v0__and2_1
X_9083_ _9072_/Z _9081_/Z _9083_/Z PHY_9/VDD PHY_9/VDD VSUBS VSUBS gf180mcu_fd_sc_mcu7t5v0__or2_1
X_6295_ _5474_/B _6303_/A2 _6303_/B1 PHY_9/VDD PHY_9/VDD VSUBS VSUBS gf180mcu_fd_sc_mcu7t5v0__nand2_2
X_5246_ _5246_/A1 _5248_/A2 _5246_/B _9366_/D PHY_9/VDD PHY_9/VDD VSUBS VSUBS gf180mcu_fd_sc_mcu7t5v0__aoi21_1
X_8034_ _9071_/A1 _8319_/A2 _8040_/B PHY_9/VDD PHY_9/VDD VSUBS VSUBS gf180mcu_fd_sc_mcu7t5v0__nand2_1
X_5177_ _9539_/Q _9541_/Q _5177_/A3 _5182_/A1 PHY_9/VDD PHY_9/VDD VSUBS VSUBS gf180mcu_fd_sc_mcu7t5v0__nor3_2
X_8936_ _9812_/Q _8998_/A2 _8936_/B _8937_/A4 PHY_9/VDD PHY_9/VDD VSUBS VSUBS gf180mcu_fd_sc_mcu7t5v0__oai21_1
X_8867_ _8919_/A1 _8866_/Z _8920_/A1 PHY_9/VDD PHY_9/VDD VSUBS VSUBS gf180mcu_fd_sc_mcu7t5v0__nor2_1
X_8798_ _9809_/Q _8797_/Z _8837_/A1 PHY_9/VDD PHY_9/VDD VSUBS VSUBS gf180mcu_fd_sc_mcu7t5v0__nand2_1
X_7818_ _9894_/Q _7835_/A1 _7825_/A2 _7818_/Z PHY_9/VDD PHY_9/VDD VSUBS VSUBS gf180mcu_fd_sc_mcu7t5v0__xor3_1
X_7749_ _7783_/A1 _7748_/Z _7751_/A2 PHY_9/VDD PHY_9/VDD VSUBS VSUBS gf180mcu_fd_sc_mcu7t5v0__nand2_1
X_9419_ _9419_/D _9901_/CLK _9419_/Q PHY_9/VDD PHY_9/VDD VSUBS VSUBS gf180mcu_fd_sc_mcu7t5v0__dffq_1
X_6080_ _9631_/Q _6288_/A2 _6288_/B1 _9615_/Q _6081_/A2 PHY_9/VDD PHY_9/VDD VSUBS
+ VSUBS gf180mcu_fd_sc_mcu7t5v0__aoi22_1
X_5100_ _9425_/Q _5407_/A1 PHY_9/VDD PHY_9/VDD VSUBS VSUBS gf180mcu_fd_sc_mcu7t5v0__clkinv_1
X_5031_ _9595_/Q _5767_/B2 PHY_9/VDD PHY_9/VDD VSUBS VSUBS gf180mcu_fd_sc_mcu7t5v0__clkinv_1
X_9770_ _9770_/D _9901_/CLK _9770_/Q PHY_9/VDD PHY_9/VDD VSUBS VSUBS gf180mcu_fd_sc_mcu7t5v0__dffq_2
X_6982_ _6979_/Z _6982_/A2 _6982_/A3 _6982_/Z PHY_9/VDD PHY_9/VDD VSUBS VSUBS gf180mcu_fd_sc_mcu7t5v0__xor3_1
X_8721_ _9953_/Q _8994_/B _8993_/B1 PHY_9/VDD PHY_9/VDD VSUBS VSUBS gf180mcu_fd_sc_mcu7t5v0__nor2_2
X_5933_ _9669_/Q _5928_/Z _5933_/B _9669_/D PHY_9/VDD PHY_9/VDD VSUBS VSUBS gf180mcu_fd_sc_mcu7t5v0__aoi21_1
X_8652_ _8652_/A1 _8655_/A1 _8607_/Z _8652_/B2 _8656_/A1 PHY_9/VDD PHY_9/VDD VSUBS
+ VSUBS gf180mcu_fd_sc_mcu7t5v0__oai22_1
X_5864_ _5832_/Z _5864_/A2 _5865_/B PHY_9/VDD PHY_9/VDD VSUBS VSUBS gf180mcu_fd_sc_mcu7t5v0__nand2_1
X_4815_ _9680_/Q _5956_/A1 PHY_9/VDD PHY_9/VDD VSUBS VSUBS gf180mcu_fd_sc_mcu7t5v0__clkinv_1
X_8583_ _9812_/Q _8644_/A2 _8585_/A2 PHY_9/VDD PHY_9/VDD VSUBS VSUBS gf180mcu_fd_sc_mcu7t5v0__nand2_1
X_7603_ _9931_/Q _7553_/B _7604_/B2 PHY_9/VDD PHY_9/VDD VSUBS VSUBS gf180mcu_fd_sc_mcu7t5v0__nand2_1
X_5795_ _8688_/A1 _6291_/B2 _5804_/A2 PHY_9/VDD PHY_9/VDD VSUBS VSUBS gf180mcu_fd_sc_mcu7t5v0__nand2_4
X_7534_ _7534_/A1 _7534_/A2 _7534_/B _7588_/A1 PHY_9/VDD PHY_9/VDD VSUBS VSUBS gf180mcu_fd_sc_mcu7t5v0__oai21_1
X_4746_ _9889_/Q _7994_/B PHY_9/VDD PHY_9/VDD VSUBS VSUBS gf180mcu_fd_sc_mcu7t5v0__inv_4
X_7465_ _7420_/Z _7490_/B _7465_/Z PHY_9/VDD PHY_9/VDD VSUBS VSUBS gf180mcu_fd_sc_mcu7t5v0__xor2_1
X_6416_ _8430_/A1 _6353_/Z _6416_/B _6627_/A2 PHY_9/VDD PHY_9/VDD VSUBS VSUBS gf180mcu_fd_sc_mcu7t5v0__oai21_4
X_7396_ _7396_/A1 _7396_/A2 _7424_/A1 PHY_9/VDD PHY_9/VDD VSUBS VSUBS gf180mcu_fd_sc_mcu7t5v0__nor2_1
X_9204_ _9333_/A2 _9159_/Z _9251_/B _9205_/A2 PHY_9/VDD PHY_9/VDD VSUBS VSUBS gf180mcu_fd_sc_mcu7t5v0__oai21_1
X_6347_ _6613_/B _9034_/A2 _6347_/B _9813_/D PHY_9/VDD PHY_9/VDD VSUBS VSUBS gf180mcu_fd_sc_mcu7t5v0__aoi21_1
X_9135_ _9966_/Q _9327_/B _9135_/A3 _9135_/B _9139_/B1 PHY_9/VDD PHY_9/VDD VSUBS VSUBS
+ gf180mcu_fd_sc_mcu7t5v0__oai31_2
X_6278_ _9697_/Q _6288_/A2 _6288_/B1 _9713_/Q _6279_/A2 PHY_9/VDD PHY_9/VDD VSUBS
+ VSUBS gf180mcu_fd_sc_mcu7t5v0__aoi22_1
X_9066_ _9964_/Q _9066_/A2 _9343_/B PHY_9/VDD PHY_9/VDD VSUBS VSUBS gf180mcu_fd_sc_mcu7t5v0__nand2_4
X_5229_ _9461_/Q _5236_/A2 _9031_/B _5230_/B PHY_9/VDD PHY_9/VDD VSUBS VSUBS gf180mcu_fd_sc_mcu7t5v0__oai21_1
X_8017_ _8004_/B _8017_/A2 _9356_/C _8018_/B2 PHY_9/VDD PHY_9/VDD VSUBS VSUBS gf180mcu_fd_sc_mcu7t5v0__aoi21_1
X_9968_ _9968_/D _9974_/CLK _9968_/Q PHY_9/VDD PHY_9/VDD VSUBS VSUBS gf180mcu_fd_sc_mcu7t5v0__dffq_4
X_8919_ _8919_/A1 _8866_/Z _8918_/Z _8991_/A2 PHY_9/VDD PHY_9/VDD VSUBS VSUBS gf180mcu_fd_sc_mcu7t5v0__nor3_2
X_9899_ _9899_/D _9901_/CLK _9899_/Q PHY_9/VDD PHY_9/VDD VSUBS VSUBS gf180mcu_fd_sc_mcu7t5v0__dffq_2
X_5580_ _9414_/Q _9317_/C _5592_/B1 _9404_/Q _5580_/C _5582_/A2 PHY_9/VDD PHY_9/VDD
+ VSUBS VSUBS gf180mcu_fd_sc_mcu7t5v0__aoi221_2
X_7250_ _7250_/A1 _7250_/A2 _7306_/A1 _7296_/A1 PHY_9/VDD PHY_9/VDD VSUBS VSUBS gf180mcu_fd_sc_mcu7t5v0__xnor3_1
X_6201_ _6201_/A1 _6201_/A2 _6204_/B1 PHY_9/VDD PHY_9/VDD VSUBS VSUBS gf180mcu_fd_sc_mcu7t5v0__nand2_1
X_7181_ _7314_/I0 _7247_/A2 _7182_/A2 PHY_9/VDD PHY_9/VDD VSUBS VSUBS gf180mcu_fd_sc_mcu7t5v0__nand2_1
X_6132_ _9700_/Q _6287_/A2 _6287_/B1 _9601_/Q _6134_/A1 PHY_9/VDD PHY_9/VDD VSUBS
+ VSUBS gf180mcu_fd_sc_mcu7t5v0__aoi22_1
X_6063_ _9754_/Q _6287_/A2 _6287_/B1 _9738_/Q _6065_/A1 PHY_9/VDD PHY_9/VDD VSUBS
+ VSUBS gf180mcu_fd_sc_mcu7t5v0__aoi22_1
X_5014_ _9619_/Q _5801_/B2 PHY_9/VDD PHY_9/VDD VSUBS VSUBS gf180mcu_fd_sc_mcu7t5v0__clkinv_1
X_9822_ _9822_/D _9907_/CLK _9822_/Q PHY_9/VDD PHY_9/VDD VSUBS VSUBS gf180mcu_fd_sc_mcu7t5v0__dffq_1
X_9753_ _9753_/D _9948_/CLK _9753_/Q PHY_9/VDD PHY_9/VDD VSUBS VSUBS gf180mcu_fd_sc_mcu7t5v0__dffq_1
X_6965_ _9814_/Q _6680_/Z _6968_/A2 PHY_9/VDD PHY_9/VDD VSUBS VSUBS gf180mcu_fd_sc_mcu7t5v0__nand2_1
X_9684_ _9684_/D _9972_/CLK _9684_/Q PHY_9/VDD PHY_9/VDD VSUBS VSUBS gf180mcu_fd_sc_mcu7t5v0__dffq_1
X_5916_ _9664_/Q _5913_/Z _5916_/Z PHY_9/VDD PHY_9/VDD VSUBS VSUBS gf180mcu_fd_sc_mcu7t5v0__and2_1
X_8704_ _9366_/Q _9036_/A2 _8706_/B _8705_/B PHY_9/VDD PHY_9/VDD VSUBS VSUBS gf180mcu_fd_sc_mcu7t5v0__oai21_1
X_6896_ _6948_/B _6846_/Z _6897_/A2 PHY_9/VDD PHY_9/VDD VSUBS VSUBS gf180mcu_fd_sc_mcu7t5v0__nand2_1
X_8635_ _9813_/Q _8669_/A2 _8635_/B _8636_/A4 PHY_9/VDD PHY_9/VDD VSUBS VSUBS gf180mcu_fd_sc_mcu7t5v0__oai21_1
X_5847_ _5847_/A1 _5847_/A2 _9642_/D PHY_9/VDD PHY_9/VDD VSUBS VSUBS gf180mcu_fd_sc_mcu7t5v0__nor2_1
X_5778_ _8693_/A1 _5782_/A2 _5782_/B1 _5778_/B2 _9602_/D PHY_9/VDD PHY_9/VDD VSUBS
+ VSUBS gf180mcu_fd_sc_mcu7t5v0__oai22_1
X_8566_ _8591_/A1 _8591_/A2 _8568_/A2 PHY_9/VDD PHY_9/VDD VSUBS VSUBS gf180mcu_fd_sc_mcu7t5v0__xnor2_1
X_7517_ _7482_/B _7516_/Z _7532_/B PHY_9/VDD PHY_9/VDD VSUBS VSUBS gf180mcu_fd_sc_mcu7t5v0__nand2_1
X_8497_ _8647_/A2 _9502_/Q _9923_/Q _8498_/C PHY_9/VDD PHY_9/VDD VSUBS VSUBS gf180mcu_fd_sc_mcu7t5v0__aoi21_2
X_4729_ _9377_/Q _5272_/A1 PHY_9/VDD PHY_9/VDD VSUBS VSUBS gf180mcu_fd_sc_mcu7t5v0__clkinv_1
X_7448_ _7448_/A1 _7494_/A1 _7510_/A1 PHY_9/VDD PHY_9/VDD VSUBS VSUBS gf180mcu_fd_sc_mcu7t5v0__nor2_1
X_7379_ _7553_/B _9868_/Q _7379_/A3 _7411_/A2 PHY_9/VDD PHY_9/VDD VSUBS VSUBS gf180mcu_fd_sc_mcu7t5v0__nand3_1
X_9118_ _9103_/Z _9120_/A3 _9119_/A2 PHY_9/VDD PHY_9/VDD VSUBS VSUBS gf180mcu_fd_sc_mcu7t5v0__xnor2_1
X_9049_ _9964_/Q _9059_/A2 _9168_/A2 PHY_9/VDD PHY_9/VDD VSUBS VSUBS gf180mcu_fd_sc_mcu7t5v0__nand2_2
X_6750_ _9838_/Q _6748_/Z _6770_/B PHY_9/VDD PHY_9/VDD VSUBS VSUBS gf180mcu_fd_sc_mcu7t5v0__nand2_1
X_5701_ _9548_/Q _5696_/Z _5701_/B _9548_/D PHY_9/VDD PHY_9/VDD VSUBS VSUBS gf180mcu_fd_sc_mcu7t5v0__aoi21_1
X_6681_ _6824_/A2 _6824_/A3 _6752_/B2 PHY_9/VDD PHY_9/VDD VSUBS VSUBS gf180mcu_fd_sc_mcu7t5v0__nand2_2
X_8420_ _8420_/A1 _8420_/A2 _8420_/B1 _8420_/B2 _8420_/C _8424_/B PHY_9/VDD PHY_9/VDD
+ VSUBS VSUBS gf180mcu_fd_sc_mcu7t5v0__oai221_1
X_5632_ _9777_/Q _5561_/I _5634_/A1 PHY_9/VDD PHY_9/VDD VSUBS VSUBS gf180mcu_fd_sc_mcu7t5v0__nand2_1
X_8351_ _8695_/A1 _8353_/A2 _8353_/B1 _8351_/B2 _9917_/D PHY_9/VDD PHY_9/VDD VSUBS
+ VSUBS gf180mcu_fd_sc_mcu7t5v0__oai22_1
X_5563_ _9491_/Q _9490_/Q _9489_/Q _5563_/C _9489_/D PHY_9/VDD PHY_9/VDD VSUBS VSUBS
+ gf180mcu_fd_sc_mcu7t5v0__aoi211_1
X_7302_ _9808_/Q _7319_/A2 _7304_/A2 PHY_9/VDD PHY_9/VDD VSUBS VSUBS gf180mcu_fd_sc_mcu7t5v0__nand2_1
X_8282_ _8307_/A1 _8282_/A2 _8279_/Z _8284_/A2 PHY_9/VDD PHY_9/VDD VSUBS VSUBS gf180mcu_fd_sc_mcu7t5v0__xnor3_1
X_5494_ _5973_/C _5494_/A2 _9458_/D PHY_9/VDD PHY_9/VDD VSUBS VSUBS gf180mcu_fd_sc_mcu7t5v0__nor2_1
X_7233_ _7040_/B _7233_/A2 _7233_/A3 _7233_/A4 _7234_/B PHY_9/VDD PHY_9/VDD VSUBS
+ VSUBS gf180mcu_fd_sc_mcu7t5v0__nand4_1
X_7164_ _7165_/A1 _7165_/A2 _7218_/A1 PHY_9/VDD PHY_9/VDD VSUBS VSUBS gf180mcu_fd_sc_mcu7t5v0__nor2_1
X_6115_ _6656_/A2 _6115_/A2 _6115_/B1 _6291_/B2 _6118_/A1 PHY_9/VDD PHY_9/VDD VSUBS
+ VSUBS gf180mcu_fd_sc_mcu7t5v0__aoi22_1
X_7095_ _7278_/C _7095_/A2 _7102_/A2 PHY_9/VDD PHY_9/VDD VSUBS VSUBS gf180mcu_fd_sc_mcu7t5v0__nand2_1
X_6046_ _5399_/Z _6049_/A2 _6049_/B1 _6046_/B2 _9758_/D PHY_9/VDD PHY_9/VDD VSUBS
+ VSUBS gf180mcu_fd_sc_mcu7t5v0__oai22_1
X_9805_ _9805_/D _9907_/CLK _9805_/Q PHY_9/VDD PHY_9/VDD VSUBS VSUBS gf180mcu_fd_sc_mcu7t5v0__dffq_2
X_7997_ _9808_/Q _8011_/A2 _7998_/A3 PHY_9/VDD PHY_9/VDD VSUBS VSUBS gf180mcu_fd_sc_mcu7t5v0__nand2_1
X_6948_ _6846_/Z _6977_/A2 _6948_/B _6992_/A1 PHY_9/VDD PHY_9/VDD VSUBS VSUBS gf180mcu_fd_sc_mcu7t5v0__oai21_1
X_9736_ _9736_/D _9800_/CLK _9736_/Q PHY_9/VDD PHY_9/VDD VSUBS VSUBS gf180mcu_fd_sc_mcu7t5v0__dffq_1
X_6879_ _6880_/A1 _6978_/A1 _6926_/A2 PHY_9/VDD PHY_9/VDD VSUBS VSUBS gf180mcu_fd_sc_mcu7t5v0__nand2_1
X_9667_ _9667_/D _9972_/CLK _9667_/Q PHY_9/VDD PHY_9/VDD VSUBS VSUBS gf180mcu_fd_sc_mcu7t5v0__dffq_1
X_8618_ _8620_/A1 _8617_/Z _8641_/B PHY_9/VDD PHY_9/VDD VSUBS VSUBS gf180mcu_fd_sc_mcu7t5v0__nand2_1
X_9598_ _9598_/D _9800_/CLK _9598_/Q PHY_9/VDD PHY_9/VDD VSUBS VSUBS gf180mcu_fd_sc_mcu7t5v0__dffq_1
X_8549_ _9809_/Q _8645_/A2 _8657_/A1 PHY_9/VDD PHY_9/VDD VSUBS VSUBS gf180mcu_fd_sc_mcu7t5v0__nand2_1
X_7920_ _7920_/A1 _7918_/Z _7920_/Z PHY_9/VDD PHY_9/VDD VSUBS VSUBS gf180mcu_fd_sc_mcu7t5v0__or2_1
X_7851_ _7806_/Z _7852_/A2 _7850_/B _7851_/Z PHY_9/VDD PHY_9/VDD VSUBS VSUBS gf180mcu_fd_sc_mcu7t5v0__and3_1
X_6802_ _6995_/C _6802_/A2 _6809_/A2 PHY_9/VDD PHY_9/VDD VSUBS VSUBS gf180mcu_fd_sc_mcu7t5v0__nand2_1
X_4994_ _9709_/Q _6004_/B2 PHY_9/VDD PHY_9/VDD VSUBS VSUBS gf180mcu_fd_sc_mcu7t5v0__clkinv_1
X_7782_ _7782_/A1 _7780_/Z _7796_/A2 PHY_9/VDD PHY_9/VDD VSUBS VSUBS gf180mcu_fd_sc_mcu7t5v0__xnor2_1
X_6733_ _6700_/C _6732_/Z _6733_/B _6735_/A2 PHY_9/VDD PHY_9/VDD VSUBS VSUBS gf180mcu_fd_sc_mcu7t5v0__oai21_1
X_9521_ _9521_/D _9801_/CLK _9521_/Q PHY_9/VDD PHY_9/VDD VSUBS VSUBS gf180mcu_fd_sc_mcu7t5v0__dffq_1
X_6664_ _5404_/Z _6665_/A2 _6665_/B1 _6664_/B2 _9829_/D PHY_9/VDD PHY_9/VDD VSUBS
+ VSUBS gf180mcu_fd_sc_mcu7t5v0__oai22_1
X_9452_ _9452_/D _9800_/CLK _9452_/Q PHY_9/VDD PHY_9/VDD VSUBS VSUBS gf180mcu_fd_sc_mcu7t5v0__dffq_1
X_8403_ _9920_/Q _8403_/A2 _8444_/B PHY_9/VDD PHY_9/VDD VSUBS VSUBS gf180mcu_fd_sc_mcu7t5v0__nand2_2
X_5615_ _9507_/Q _5633_/A2 _5616_/A2 PHY_9/VDD PHY_9/VDD VSUBS VSUBS gf180mcu_fd_sc_mcu7t5v0__nand2_1
X_6595_ _6596_/A1 _6596_/A2 _6640_/S PHY_9/VDD PHY_9/VDD VSUBS VSUBS gf180mcu_fd_sc_mcu7t5v0__nor2_1
X_9383_ _9383_/D _9907_/CLK _9383_/Q PHY_9/VDD PHY_9/VDD VSUBS VSUBS gf180mcu_fd_sc_mcu7t5v0__dffq_1
X_5546_ _6066_/A1 _6019_/A2 _6283_/B2 PHY_9/VDD PHY_9/VDD VSUBS VSUBS gf180mcu_fd_sc_mcu7t5v0__nor2_4
X_8334_ _8334_/A1 _8334_/A2 _8335_/A3 PHY_9/VDD PHY_9/VDD VSUBS VSUBS gf180mcu_fd_sc_mcu7t5v0__nand2_1
X_8265_ _9808_/Q _8316_/A2 _8314_/B2 PHY_9/VDD PHY_9/VDD VSUBS VSUBS gf180mcu_fd_sc_mcu7t5v0__nand2_1
X_5477_ _9450_/Q _5493_/B _5770_/B _5478_/B PHY_9/VDD PHY_9/VDD VSUBS VSUBS gf180mcu_fd_sc_mcu7t5v0__oai21_1
X_7216_ _7266_/A1 _7266_/A2 _7216_/Z PHY_9/VDD PHY_9/VDD VSUBS VSUBS gf180mcu_fd_sc_mcu7t5v0__xor2_1
X_8196_ _9811_/Q _8194_/Z _8197_/I PHY_9/VDD PHY_9/VDD VSUBS VSUBS gf180mcu_fd_sc_mcu7t5v0__xor2_1
X_7147_ _7147_/A1 _7299_/A2 _7147_/B1 _7147_/B2 _7247_/A2 PHY_9/VDD PHY_9/VDD VSUBS
+ VSUBS gf180mcu_fd_sc_mcu7t5v0__aoi22_4
X_7078_ _9807_/Q _7290_/A2 _7078_/Z PHY_9/VDD PHY_9/VDD VSUBS VSUBS gf180mcu_fd_sc_mcu7t5v0__and2_1
X_6029_ _5406_/Z _6029_/A2 _6029_/B1 _6029_/B2 _9745_/D PHY_9/VDD PHY_9/VDD VSUBS
+ VSUBS gf180mcu_fd_sc_mcu7t5v0__oai22_1
X_9719_ _9719_/D _9830_/CLK _9719_/Q PHY_9/VDD PHY_9/VDD VSUBS VSUBS gf180mcu_fd_sc_mcu7t5v0__dffq_1
X_6380_ _9815_/Q _6408_/A2 _6380_/B _6381_/A2 PHY_9/VDD PHY_9/VDD VSUBS VSUBS gf180mcu_fd_sc_mcu7t5v0__aoi21_1
X_5400_ _5400_/A1 _5407_/A2 _5399_/Z _5407_/B2 _9422_/D PHY_9/VDD PHY_9/VDD VSUBS
+ VSUBS gf180mcu_fd_sc_mcu7t5v0__oai22_1
X_5331_ _5853_/A1 _5331_/A2 _5331_/B _5973_/C _9402_/D PHY_9/VDD PHY_9/VDD VSUBS VSUBS
+ gf180mcu_fd_sc_mcu7t5v0__aoi211_1
X_8050_ _8151_/B _8199_/B PHY_9/VDD PHY_9/VDD VSUBS VSUBS gf180mcu_fd_sc_mcu7t5v0__clkinv_1
X_7001_ _9843_/Q _9317_/C _9100_/B _7002_/A2 PHY_9/VDD PHY_9/VDD VSUBS VSUBS gf180mcu_fd_sc_mcu7t5v0__oai21_1
X_5262_ _5262_/A1 _5261_/Z _5272_/A2 PHY_9/VDD PHY_9/VDD VSUBS VSUBS gf180mcu_fd_sc_mcu7t5v0__nand2_4
X_5193_ _9524_/Q _5831_/A2 _5194_/A2 PHY_9/VDD PHY_9/VDD VSUBS VSUBS gf180mcu_fd_sc_mcu7t5v0__nand2_1
X_8952_ _8954_/A1 _8954_/A2 _9001_/B PHY_9/VDD PHY_9/VDD VSUBS VSUBS gf180mcu_fd_sc_mcu7t5v0__nor2_1
X_8883_ _9811_/Q _8850_/Z _8888_/B1 PHY_9/VDD PHY_9/VDD VSUBS VSUBS gf180mcu_fd_sc_mcu7t5v0__nor2_1
X_7903_ _7892_/Z _7903_/A2 _7900_/B _7904_/B PHY_9/VDD PHY_9/VDD VSUBS VSUBS gf180mcu_fd_sc_mcu7t5v0__xor3_1
X_7834_ _9357_/B _7834_/A2 _9894_/D PHY_9/VDD PHY_9/VDD VSUBS VSUBS gf180mcu_fd_sc_mcu7t5v0__nor2_1
X_7765_ _7770_/A1 _7764_/Z _8004_/B _7766_/B PHY_9/VDD PHY_9/VDD VSUBS VSUBS gf180mcu_fd_sc_mcu7t5v0__aoi21_1
X_4977_ _9741_/Q _6025_/B2 PHY_9/VDD PHY_9/VDD VSUBS VSUBS gf180mcu_fd_sc_mcu7t5v0__clkinv_1
X_6716_ _9808_/Q _6752_/B1 _6716_/A3 _6717_/B PHY_9/VDD PHY_9/VDD VSUBS VSUBS gf180mcu_fd_sc_mcu7t5v0__xor3_1
X_9504_ _9504_/D _9974_/CLK _9504_/Q PHY_9/VDD PHY_9/VDD VSUBS VSUBS gf180mcu_fd_sc_mcu7t5v0__dffq_1
X_7696_ _7994_/A1 _9034_/A2 _7696_/B _9890_/D PHY_9/VDD PHY_9/VDD VSUBS VSUBS gf180mcu_fd_sc_mcu7t5v0__aoi21_1
X_6647_ _6647_/A1 _6645_/Z _6647_/A3 _6647_/Z PHY_9/VDD PHY_9/VDD VSUBS VSUBS gf180mcu_fd_sc_mcu7t5v0__xor3_1
X_9435_ _9435_/D _9800_/CLK _9435_/Q PHY_9/VDD PHY_9/VDD VSUBS VSUBS gf180mcu_fd_sc_mcu7t5v0__dffq_1
X_6578_ _6578_/A1 _6578_/A2 _6578_/Z PHY_9/VDD PHY_9/VDD VSUBS VSUBS gf180mcu_fd_sc_mcu7t5v0__xor2_1
X_9366_ _9366_/D _9974_/CLK _9366_/Q PHY_9/VDD PHY_9/VDD VSUBS VSUBS gf180mcu_fd_sc_mcu7t5v0__dffq_1
X_5529_ _9442_/Q _5525_/Z _5530_/B1 PHY_9/VDD PHY_9/VDD VSUBS VSUBS gf180mcu_fd_sc_mcu7t5v0__nand2_1
X_8317_ _9513_/Q _8035_/Z _8317_/B1 _9856_/Q _8319_/B1 PHY_9/VDD PHY_9/VDD VSUBS VSUBS
+ gf180mcu_fd_sc_mcu7t5v0__aoi22_2
X_9297_ _9297_/A1 _9297_/A2 _9244_/Z _9245_/Z _9297_/B2 _9154_/Z _9299_/A2 PHY_9/VDD
+ PHY_9/VDD VSUBS VSUBS gf180mcu_fd_sc_mcu7t5v0__oai33_2
X_8248_ _9812_/Q _8300_/A2 _8300_/B1 _8249_/A2 _8300_/C _8249_/B PHY_9/VDD PHY_9/VDD
+ VSUBS VSUBS gf180mcu_fd_sc_mcu7t5v0__aoi221_1
X_8179_ _8115_/Z _8179_/A2 _8179_/A3 _8181_/A2 PHY_9/VDD PHY_9/VDD VSUBS VSUBS gf180mcu_fd_sc_mcu7t5v0__xnor3_1
X_4900_ _9690_/Q _5981_/B2 PHY_9/VDD PHY_9/VDD VSUBS VSUBS gf180mcu_fd_sc_mcu7t5v0__clkinv_1
X_5880_ _5961_/B _5880_/A2 _5880_/A3 _9651_/D PHY_9/VDD PHY_9/VDD VSUBS VSUBS gf180mcu_fd_sc_mcu7t5v0__nand3_1
X_4831_ _9499_/Q _9090_/A1 PHY_9/VDD PHY_9/VDD VSUBS VSUBS gf180mcu_fd_sc_mcu7t5v0__inv_2
X_4762_ _9866_/Q _7364_/A2 PHY_9/VDD PHY_9/VDD VSUBS VSUBS gf180mcu_fd_sc_mcu7t5v0__clkinv_2
X_7550_ _7551_/A2 _7594_/A1 _7549_/Z _7594_/A2 PHY_9/VDD PHY_9/VDD VSUBS VSUBS gf180mcu_fd_sc_mcu7t5v0__nor3_1
X_6501_ _9819_/Q _6516_/A2 _6501_/Z PHY_9/VDD PHY_9/VDD VSUBS VSUBS gf180mcu_fd_sc_mcu7t5v0__and2_1
X_7481_ _7667_/I1 _7601_/A1 _7668_/B _7483_/B1 PHY_9/VDD PHY_9/VDD VSUBS VSUBS gf180mcu_fd_sc_mcu7t5v0__aoi21_1
X_4693_ _9961_/Q _9026_/A1 PHY_9/VDD PHY_9/VDD VSUBS VSUBS gf180mcu_fd_sc_mcu7t5v0__inv_2
X_6432_ _6432_/A1 _6432_/A2 _6432_/B _6464_/A2 PHY_9/VDD PHY_9/VDD VSUBS VSUBS gf180mcu_fd_sc_mcu7t5v0__oai21_1
X_9220_ _9972_/Q _9356_/C _9265_/A1 PHY_9/VDD PHY_9/VDD VSUBS VSUBS gf180mcu_fd_sc_mcu7t5v0__nand2_1
X_9151_ _9153_/A2 _9153_/A3 _9177_/B PHY_9/VDD PHY_9/VDD VSUBS VSUBS gf180mcu_fd_sc_mcu7t5v0__and2_1
X_6363_ _9803_/Q _9802_/Q _6649_/B PHY_9/VDD PHY_9/VDD VSUBS VSUBS gf180mcu_fd_sc_mcu7t5v0__nand2_4
X_8102_ _8102_/A1 _8098_/Z _8175_/A1 _8102_/Z PHY_9/VDD PHY_9/VDD VSUBS VSUBS gf180mcu_fd_sc_mcu7t5v0__xor3_1
X_5314_ _5314_/A1 _5318_/A2 _5314_/B _9395_/D PHY_9/VDD PHY_9/VDD VSUBS VSUBS gf180mcu_fd_sc_mcu7t5v0__aoi21_1
X_6294_ _7677_/A1 _6656_/A2 _6303_/A2 PHY_9/VDD PHY_9/VDD VSUBS VSUBS gf180mcu_fd_sc_mcu7t5v0__nand2_4
X_9082_ _9072_/Z _9081_/Z _9095_/A1 PHY_9/VDD PHY_9/VDD VSUBS VSUBS gf180mcu_fd_sc_mcu7t5v0__nor2_1
X_5245_ _9463_/Q _5248_/A2 _8706_/B _5246_/B PHY_9/VDD PHY_9/VDD VSUBS VSUBS gf180mcu_fd_sc_mcu7t5v0__oai21_1
X_8033_ _8318_/A1 _8318_/B _8169_/A2 PHY_9/VDD PHY_9/VDD VSUBS VSUBS gf180mcu_fd_sc_mcu7t5v0__nand2_2
X_5176_ _9538_/Q _9540_/Q _5177_/A3 PHY_9/VDD PHY_9/VDD VSUBS VSUBS gf180mcu_fd_sc_mcu7t5v0__nand2_1
X_8935_ _8983_/A1 _8935_/A2 _8935_/B _8936_/B PHY_9/VDD PHY_9/VDD VSUBS VSUBS gf180mcu_fd_sc_mcu7t5v0__oai21_1
X_8866_ _8866_/A1 _8865_/B _8866_/Z PHY_9/VDD PHY_9/VDD VSUBS VSUBS gf180mcu_fd_sc_mcu7t5v0__xor2_1
X_8797_ _8784_/I _8799_/A3 _8797_/Z PHY_9/VDD PHY_9/VDD VSUBS VSUBS gf180mcu_fd_sc_mcu7t5v0__xor2_1
X_7817_ _9894_/Q _7825_/A2 _7835_/B PHY_9/VDD PHY_9/VDD VSUBS VSUBS gf180mcu_fd_sc_mcu7t5v0__nand2_1
X_7748_ _9091_/B _7948_/A2 _7748_/A3 _7748_/Z PHY_9/VDD PHY_9/VDD VSUBS VSUBS gf180mcu_fd_sc_mcu7t5v0__xor3_1
X_7679_ _5388_/Z _7686_/A2 _7686_/B1 _7679_/B2 _9878_/D PHY_9/VDD PHY_9/VDD VSUBS
+ VSUBS gf180mcu_fd_sc_mcu7t5v0__oai22_1
X_9418_ _9418_/D _9830_/CLK _9418_/Q PHY_9/VDD PHY_9/VDD VSUBS VSUBS gf180mcu_fd_sc_mcu7t5v0__dffq_1
X_9349_ _9349_/A1 _9349_/A2 _9349_/Z PHY_9/VDD PHY_9/VDD VSUBS VSUBS gf180mcu_fd_sc_mcu7t5v0__xor2_1
X_5030_ _9938_/Q _8685_/B2 PHY_9/VDD PHY_9/VDD VSUBS VSUBS gf180mcu_fd_sc_mcu7t5v0__clkinv_1
X_6981_ _6981_/A1 _6981_/A2 _6981_/B _6982_/A3 PHY_9/VDD PHY_9/VDD VSUBS VSUBS gf180mcu_fd_sc_mcu7t5v0__aoi21_1
X_5932_ _9669_/Q _5928_/Z _5932_/B _5933_/B PHY_9/VDD PHY_9/VDD VSUBS VSUBS gf180mcu_fd_sc_mcu7t5v0__oai21_1
X_8720_ _9953_/Q _8720_/A2 _8720_/B _8720_/C _8857_/A2 PHY_9/VDD PHY_9/VDD VSUBS VSUBS
+ gf180mcu_fd_sc_mcu7t5v0__oai211_4
X_8651_ _8651_/A1 _8651_/A2 _8650_/Z _8651_/Z PHY_9/VDD PHY_9/VDD VSUBS VSUBS gf180mcu_fd_sc_mcu7t5v0__xor3_1
X_5863_ _9646_/Q _5832_/Z _9031_/B _5866_/A1 PHY_9/VDD PHY_9/VDD VSUBS VSUBS gf180mcu_fd_sc_mcu7t5v0__oai21_1
X_5794_ _5406_/Z _5794_/A2 _5794_/B1 _5794_/B2 _9614_/D PHY_9/VDD PHY_9/VDD VSUBS
+ VSUBS gf180mcu_fd_sc_mcu7t5v0__oai22_1
X_7602_ _9821_/Q _7651_/A2 _7604_/C PHY_9/VDD PHY_9/VDD VSUBS VSUBS gf180mcu_fd_sc_mcu7t5v0__nor2_1
X_4814_ _9681_/Q _5958_/A1 PHY_9/VDD PHY_9/VDD VSUBS VSUBS gf180mcu_fd_sc_mcu7t5v0__clkinv_1
X_8582_ _8380_/Z _8582_/A2 _8587_/A3 PHY_9/VDD PHY_9/VDD VSUBS VSUBS gf180mcu_fd_sc_mcu7t5v0__nand2_1
X_7533_ _7533_/A1 _7533_/A2 _9357_/B _9874_/D PHY_9/VDD PHY_9/VDD VSUBS VSUBS gf180mcu_fd_sc_mcu7t5v0__aoi21_1
X_4745_ _9890_/Q _7994_/A1 PHY_9/VDD PHY_9/VDD VSUBS VSUBS gf180mcu_fd_sc_mcu7t5v0__clkinv_2
X_7464_ _7449_/Z _7462_/Z _7490_/B PHY_9/VDD PHY_9/VDD VSUBS VSUBS gf180mcu_fd_sc_mcu7t5v0__xnor2_1
X_7395_ _9807_/Q _7382_/Z _7397_/A2 PHY_9/VDD PHY_9/VDD VSUBS VSUBS gf180mcu_fd_sc_mcu7t5v0__nand2_1
X_6415_ _9838_/Q _9806_/Q _9805_/Q _6416_/B PHY_9/VDD PHY_9/VDD VSUBS VSUBS gf180mcu_fd_sc_mcu7t5v0__nand3_2
X_9203_ _9170_/C _9203_/A2 _9221_/B _9219_/B1 PHY_9/VDD PHY_9/VDD VSUBS VSUBS gf180mcu_fd_sc_mcu7t5v0__nand3_1
X_6346_ _9512_/Q _9034_/A2 _8706_/B _6347_/B PHY_9/VDD PHY_9/VDD VSUBS VSUBS gf180mcu_fd_sc_mcu7t5v0__oai21_1
X_9134_ _9966_/Q _9965_/Q _9509_/Q _9135_/B PHY_9/VDD PHY_9/VDD VSUBS VSUBS gf180mcu_fd_sc_mcu7t5v0__nand3_1
X_9065_ _9065_/A1 _9065_/A2 _9170_/C PHY_9/VDD PHY_9/VDD VSUBS VSUBS gf180mcu_fd_sc_mcu7t5v0__nor2_2
X_6277_ _9705_/Q _6287_/A2 _6287_/B1 _9606_/Q _6279_/A1 PHY_9/VDD PHY_9/VDD VSUBS
+ VSUBS gf180mcu_fd_sc_mcu7t5v0__aoi22_1
X_8016_ _8016_/A1 _8016_/A2 _8016_/B1 _8016_/B2 _8016_/C _8017_/A2 PHY_9/VDD PHY_9/VDD
+ VSUBS VSUBS gf180mcu_fd_sc_mcu7t5v0__oai221_1
X_5228_ _5228_/A1 _5236_/A2 _5228_/B _9358_/D PHY_9/VDD PHY_9/VDD VSUBS VSUBS gf180mcu_fd_sc_mcu7t5v0__aoi21_1
X_5159_ _9480_/Q _5158_/I _5951_/A2 PHY_9/VDD PHY_9/VDD VSUBS VSUBS gf180mcu_fd_sc_mcu7t5v0__nand2_4
X_9967_ _9967_/D _9974_/CLK _9967_/Q PHY_9/VDD PHY_9/VDD VSUBS VSUBS gf180mcu_fd_sc_mcu7t5v0__dffq_2
X_8918_ _8941_/A1 _8918_/A2 _8941_/A2 _8918_/Z PHY_9/VDD PHY_9/VDD VSUBS VSUBS gf180mcu_fd_sc_mcu7t5v0__xor3_1
X_9898_ _9898_/D _9957_/CLK _9898_/Q PHY_9/VDD PHY_9/VDD VSUBS VSUBS gf180mcu_fd_sc_mcu7t5v0__dffq_4
X_8849_ _8852_/A2 _8849_/A2 _8849_/B _8866_/A1 PHY_9/VDD PHY_9/VDD VSUBS VSUBS gf180mcu_fd_sc_mcu7t5v0__aoi21_1
X_6200_ _9750_/Q _6288_/A2 _6288_/B1 _9766_/Q _6201_/A2 PHY_9/VDD PHY_9/VDD VSUBS
+ VSUBS gf180mcu_fd_sc_mcu7t5v0__aoi22_1
X_7180_ _9811_/Q _7247_/A2 _7185_/B1 PHY_9/VDD PHY_9/VDD VSUBS VSUBS gf180mcu_fd_sc_mcu7t5v0__nor2_1
X_6131_ _6131_/A1 _6131_/A2 _6145_/B1 PHY_9/VDD PHY_9/VDD VSUBS VSUBS gf180mcu_fd_sc_mcu7t5v0__nand2_1
X_6062_ _6062_/A1 _6062_/A2 _6086_/A2 PHY_9/VDD PHY_9/VDD VSUBS VSUBS gf180mcu_fd_sc_mcu7t5v0__nand2_1
X_5013_ _9518_/Q _5643_/B2 PHY_9/VDD PHY_9/VDD VSUBS VSUBS gf180mcu_fd_sc_mcu7t5v0__clkinv_1
X_9821_ _9821_/D _9907_/CLK _9821_/Q PHY_9/VDD PHY_9/VDD VSUBS VSUBS gf180mcu_fd_sc_mcu7t5v0__dffq_2
X_6964_ _6964_/A1 _6936_/Z _6964_/B _6983_/A1 PHY_9/VDD PHY_9/VDD VSUBS VSUBS gf180mcu_fd_sc_mcu7t5v0__oai21_1
X_9752_ _9752_/D _9939_/CLK _9752_/Q PHY_9/VDD PHY_9/VDD VSUBS VSUBS gf180mcu_fd_sc_mcu7t5v0__dffq_1
X_6895_ _6946_/A1 _6891_/Z _6907_/A2 PHY_9/VDD PHY_9/VDD VSUBS VSUBS gf180mcu_fd_sc_mcu7t5v0__nand2_1
X_5915_ _5913_/Z _5915_/A2 _9663_/D PHY_9/VDD PHY_9/VDD VSUBS VSUBS gf180mcu_fd_sc_mcu7t5v0__nor2_1
X_8703_ _8768_/A1 _9036_/A2 _8703_/B _9951_/D PHY_9/VDD PHY_9/VDD VSUBS VSUBS gf180mcu_fd_sc_mcu7t5v0__aoi21_1
X_9683_ _9683_/D _9972_/CLK _9683_/Q PHY_9/VDD PHY_9/VDD VSUBS VSUBS gf180mcu_fd_sc_mcu7t5v0__dffq_1
X_8634_ _8634_/A1 _8634_/A2 _8634_/B _8635_/B PHY_9/VDD PHY_9/VDD VSUBS VSUBS gf180mcu_fd_sc_mcu7t5v0__oai21_1
X_5846_ _9462_/Q _5867_/A2 _5846_/B _5847_/A2 PHY_9/VDD PHY_9/VDD VSUBS VSUBS gf180mcu_fd_sc_mcu7t5v0__aoi21_1
X_5777_ _8692_/A1 _5782_/A2 _5782_/B1 _5777_/B2 _9601_/D PHY_9/VDD PHY_9/VDD VSUBS
+ VSUBS gf180mcu_fd_sc_mcu7t5v0__oai22_1
X_8565_ _8565_/A1 _8563_/Z _8591_/A2 PHY_9/VDD PHY_9/VDD VSUBS VSUBS gf180mcu_fd_sc_mcu7t5v0__xnor2_1
X_7516_ _9874_/Q _7534_/A1 _7518_/A2 _7516_/Z PHY_9/VDD PHY_9/VDD VSUBS VSUBS gf180mcu_fd_sc_mcu7t5v0__xor3_1
X_8496_ _8464_/Z _8496_/A2 _8496_/B _8516_/A1 PHY_9/VDD PHY_9/VDD VSUBS VSUBS gf180mcu_fd_sc_mcu7t5v0__aoi21_1
X_4728_ _9903_/Q _8318_/A1 PHY_9/VDD PHY_9/VDD VSUBS VSUBS gf180mcu_fd_sc_mcu7t5v0__clkinv_2
X_7447_ _9810_/Q _7382_/Z _7494_/A1 PHY_9/VDD PHY_9/VDD VSUBS VSUBS gf180mcu_fd_sc_mcu7t5v0__nand2_1
X_7378_ _9090_/C _7647_/A2 _7389_/A1 PHY_9/VDD PHY_9/VDD VSUBS VSUBS gf180mcu_fd_sc_mcu7t5v0__nand2_1
X_6329_ _6648_/A1 _9036_/A2 _6329_/B _9804_/D PHY_9/VDD PHY_9/VDD VSUBS VSUBS gf180mcu_fd_sc_mcu7t5v0__aoi21_1
X_9117_ _9331_/A2 _9285_/A2 _9251_/B _9120_/A3 PHY_9/VDD PHY_9/VDD VSUBS VSUBS gf180mcu_fd_sc_mcu7t5v0__oai21_1
X_9048_ _9807_/Q _9331_/A2 _9061_/B PHY_9/VDD PHY_9/VDD VSUBS VSUBS gf180mcu_fd_sc_mcu7t5v0__nand2_1
X_5700_ _9548_/Q _5696_/Z _5700_/B _5701_/B PHY_9/VDD PHY_9/VDD VSUBS VSUBS gf180mcu_fd_sc_mcu7t5v0__oai21_1
X_6680_ _6824_/A2 _6824_/A3 _6680_/Z PHY_9/VDD PHY_9/VDD VSUBS VSUBS gf180mcu_fd_sc_mcu7t5v0__and2_2
X_5631_ _5631_/A1 _5631_/A2 _5973_/C _9512_/D PHY_9/VDD PHY_9/VDD VSUBS VSUBS gf180mcu_fd_sc_mcu7t5v0__aoi21_1
X_8350_ _5399_/Z _8353_/A2 _8353_/B1 _8350_/B2 _9916_/D PHY_9/VDD PHY_9/VDD VSUBS
+ VSUBS gf180mcu_fd_sc_mcu7t5v0__oai22_1
X_5562_ _9035_/B _5562_/A2 _5563_/C PHY_9/VDD PHY_9/VDD VSUBS VSUBS gf180mcu_fd_sc_mcu7t5v0__nand2_1
X_7301_ _9807_/Q _7316_/A2 _7304_/A1 PHY_9/VDD PHY_9/VDD VSUBS VSUBS gf180mcu_fd_sc_mcu7t5v0__nand2_1
X_8281_ _8282_/A2 _8279_/Z _8281_/Z PHY_9/VDD PHY_9/VDD VSUBS VSUBS gf180mcu_fd_sc_mcu7t5v0__and2_1
X_7232_ _9812_/Q _7303_/A2 _7232_/B _7233_/A4 PHY_9/VDD PHY_9/VDD VSUBS VSUBS gf180mcu_fd_sc_mcu7t5v0__oai21_1
X_5493_ _5495_/A2 _9458_/Q _5493_/B _5494_/A2 PHY_9/VDD PHY_9/VDD VSUBS VSUBS gf180mcu_fd_sc_mcu7t5v0__aoi21_1
Xclkbuf_leaf_7_clk clkbuf_leaf_8_clk/I _9856_/CLK PHY_9/VDD PHY_9/VDD VSUBS VSUBS
+ gf180mcu_fd_sc_mcu7t5v0__clkbuf_16
X_7163_ _7163_/A1 _7161_/Z _7165_/A2 PHY_9/VDD PHY_9/VDD VSUBS VSUBS gf180mcu_fd_sc_mcu7t5v0__xnor2_1
X_7094_ _7094_/A1 _7094_/A2 _7093_/B _7095_/A2 PHY_9/VDD PHY_9/VDD VSUBS VSUBS gf180mcu_fd_sc_mcu7t5v0__nand3_1
X_6114_ _6114_/A1 _6114_/A2 _6116_/B1 PHY_9/VDD PHY_9/VDD VSUBS VSUBS gf180mcu_fd_sc_mcu7t5v0__nand2_1
X_6045_ _8693_/A1 _6049_/A2 _6049_/B1 _6045_/B2 _9757_/D PHY_9/VDD PHY_9/VDD VSUBS
+ VSUBS gf180mcu_fd_sc_mcu7t5v0__oai22_1
X_9804_ _9804_/D _9907_/CLK _9804_/Q PHY_9/VDD PHY_9/VDD VSUBS VSUBS gf180mcu_fd_sc_mcu7t5v0__dffq_2
X_9735_ _9735_/D _9800_/CLK _9735_/Q PHY_9/VDD PHY_9/VDD VSUBS VSUBS gf180mcu_fd_sc_mcu7t5v0__dffq_1
X_7996_ _9807_/Q _8013_/A2 _7998_/A2 PHY_9/VDD PHY_9/VDD VSUBS VSUBS gf180mcu_fd_sc_mcu7t5v0__nand2_1
X_6947_ _9812_/Q _6897_/Z _6947_/B _6988_/A1 PHY_9/VDD PHY_9/VDD VSUBS VSUBS gf180mcu_fd_sc_mcu7t5v0__aoi21_1
X_6878_ _6880_/A1 _6978_/A1 _6926_/B PHY_9/VDD PHY_9/VDD VSUBS VSUBS gf180mcu_fd_sc_mcu7t5v0__nor2_1
X_9666_ _9666_/D _9972_/CLK _9666_/Q PHY_9/VDD PHY_9/VDD VSUBS VSUBS gf180mcu_fd_sc_mcu7t5v0__dffq_1
X_9597_ _9597_/D _9939_/CLK _9597_/Q PHY_9/VDD PHY_9/VDD VSUBS VSUBS gf180mcu_fd_sc_mcu7t5v0__dffq_1
X_8617_ _8617_/A1 _8615_/Z _8617_/Z PHY_9/VDD PHY_9/VDD VSUBS VSUBS gf180mcu_fd_sc_mcu7t5v0__xor2_1
X_5829_ _5973_/C _5829_/A2 _9639_/D PHY_9/VDD PHY_9/VDD VSUBS VSUBS gf180mcu_fd_sc_mcu7t5v0__nor2_1
X_8548_ _9807_/Q _8644_/A2 _8554_/A1 PHY_9/VDD PHY_9/VDD VSUBS VSUBS gf180mcu_fd_sc_mcu7t5v0__nand2_1
X_8479_ _8495_/A1 _8478_/Z _8479_/Z PHY_9/VDD PHY_9/VDD VSUBS VSUBS gf180mcu_fd_sc_mcu7t5v0__xor2_1
X_7850_ _7806_/Z _7852_/A2 _7850_/B _7882_/B PHY_9/VDD PHY_9/VDD VSUBS VSUBS gf180mcu_fd_sc_mcu7t5v0__aoi21_1
X_6801_ _6795_/Z _6799_/Z _6802_/A2 PHY_9/VDD PHY_9/VDD VSUBS VSUBS gf180mcu_fd_sc_mcu7t5v0__nand2_1
X_7781_ _7782_/A1 _7780_/Z _7799_/B PHY_9/VDD PHY_9/VDD VSUBS VSUBS gf180mcu_fd_sc_mcu7t5v0__nor2_1
X_4993_ _9561_/Q _5723_/B2 PHY_9/VDD PHY_9/VDD VSUBS VSUBS gf180mcu_fd_sc_mcu7t5v0__clkinv_1
X_6732_ _7735_/A3 _6737_/A1 _6732_/A3 _6732_/Z PHY_9/VDD PHY_9/VDD VSUBS VSUBS gf180mcu_fd_sc_mcu7t5v0__xor3_1
X_9520_ _9520_/D _9801_/CLK _9520_/Q PHY_9/VDD PHY_9/VDD VSUBS VSUBS gf180mcu_fd_sc_mcu7t5v0__dffq_1
X_6663_ _8695_/A1 _6665_/A2 _6665_/B1 _6663_/B2 _9828_/D PHY_9/VDD PHY_9/VDD VSUBS
+ VSUBS gf180mcu_fd_sc_mcu7t5v0__oai22_1
X_9451_ _9451_/D _9800_/CLK _9451_/Q PHY_9/VDD PHY_9/VDD VSUBS VSUBS gf180mcu_fd_sc_mcu7t5v0__dffq_1
X_8402_ _9920_/Q _8403_/A2 _8402_/Z PHY_9/VDD PHY_9/VDD VSUBS VSUBS gf180mcu_fd_sc_mcu7t5v0__and2_1
X_5614_ _9771_/Q _5561_/I _5616_/A1 PHY_9/VDD PHY_9/VDD VSUBS VSUBS gf180mcu_fd_sc_mcu7t5v0__nand2_1
X_6594_ _6594_/A1 _6592_/Z _6596_/A2 PHY_9/VDD PHY_9/VDD VSUBS VSUBS gf180mcu_fd_sc_mcu7t5v0__xnor2_1
X_9382_ _9382_/D _9901_/CLK _9382_/Q PHY_9/VDD PHY_9/VDD VSUBS VSUBS gf180mcu_fd_sc_mcu7t5v0__dffq_1
X_5545_ _5783_/A1 _5367_/Z _6019_/A2 PHY_9/VDD PHY_9/VDD VSUBS VSUBS gf180mcu_fd_sc_mcu7t5v0__nand2_2
X_8333_ _8293_/B _8333_/A2 _8334_/A2 PHY_9/VDD PHY_9/VDD VSUBS VSUBS gf180mcu_fd_sc_mcu7t5v0__nand2_1
X_8264_ _8219_/Z _8228_/Z _8264_/B _8282_/A2 PHY_9/VDD PHY_9/VDD VSUBS VSUBS gf180mcu_fd_sc_mcu7t5v0__aoi21_1
X_5476_ _9459_/Q _5495_/A2 _9458_/Q _5493_/B PHY_9/VDD PHY_9/VDD VSUBS VSUBS gf180mcu_fd_sc_mcu7t5v0__nor3_4
X_7215_ _7266_/A1 _7266_/A2 _7267_/A1 PHY_9/VDD PHY_9/VDD VSUBS VSUBS gf180mcu_fd_sc_mcu7t5v0__nor2_1
X_8195_ _9811_/Q _8194_/Z _8240_/A1 PHY_9/VDD PHY_9/VDD VSUBS VSUBS gf180mcu_fd_sc_mcu7t5v0__nand2_1
X_7146_ _9848_/Q _9510_/Q _7147_/B2 PHY_9/VDD PHY_9/VDD VSUBS VSUBS gf180mcu_fd_sc_mcu7t5v0__nand2_1
X_7077_ _7077_/A1 _7299_/A2 _7077_/B1 _7077_/B2 _7290_/A2 PHY_9/VDD PHY_9/VDD VSUBS
+ VSUBS gf180mcu_fd_sc_mcu7t5v0__aoi22_4
X_6028_ _5404_/Z _6029_/A2 _6029_/B1 _6028_/B2 _9744_/D PHY_9/VDD PHY_9/VDD VSUBS
+ VSUBS gf180mcu_fd_sc_mcu7t5v0__oai22_1
X_7979_ _9897_/Q _9356_/C _7979_/B _7980_/A2 PHY_9/VDD PHY_9/VDD VSUBS VSUBS gf180mcu_fd_sc_mcu7t5v0__aoi21_1
X_9718_ _9718_/D _9830_/CLK _9718_/Q PHY_9/VDD PHY_9/VDD VSUBS VSUBS gf180mcu_fd_sc_mcu7t5v0__dffq_1
X_9649_ _9649_/D _9800_/CLK _9649_/Q PHY_9/VDD PHY_9/VDD VSUBS VSUBS gf180mcu_fd_sc_mcu7t5v0__dffq_1
X_5330_ _9402_/Q _5331_/A2 _5331_/B PHY_9/VDD PHY_9/VDD VSUBS VSUBS gf180mcu_fd_sc_mcu7t5v0__nor2_1
X_5261_ _9470_/Q _9469_/Q _5224_/Z _5261_/Z PHY_9/VDD PHY_9/VDD VSUBS VSUBS gf180mcu_fd_sc_mcu7t5v0__and3_2
X_7000_ _6700_/C _7000_/A2 _7000_/B _9356_/C _7002_/A1 PHY_9/VDD PHY_9/VDD VSUBS VSUBS
+ gf180mcu_fd_sc_mcu7t5v0__aoi211_1
X_5192_ _9522_/Q _5130_/I _5192_/A3 _5827_/A2 PHY_9/VDD PHY_9/VDD VSUBS VSUBS gf180mcu_fd_sc_mcu7t5v0__nand3_1
X_8951_ _9810_/Q _8850_/Z _9006_/A1 PHY_9/VDD PHY_9/VDD VSUBS VSUBS gf180mcu_fd_sc_mcu7t5v0__nand2_1
X_7902_ _7892_/Z _7955_/A1 _7901_/Z _7955_/A2 PHY_9/VDD PHY_9/VDD VSUBS VSUBS gf180mcu_fd_sc_mcu7t5v0__nor3_1
X_8882_ _8980_/B _8882_/A2 _8888_/A2 PHY_9/VDD PHY_9/VDD VSUBS VSUBS gf180mcu_fd_sc_mcu7t5v0__nand2_1
X_7833_ _9894_/Q _9356_/C _7833_/B _7834_/A2 PHY_9/VDD PHY_9/VDD VSUBS VSUBS gf180mcu_fd_sc_mcu7t5v0__aoi21_1
X_7764_ _9892_/Q _7764_/A2 _7764_/Z PHY_9/VDD PHY_9/VDD VSUBS VSUBS gf180mcu_fd_sc_mcu7t5v0__xor2_1
X_4976_ _9749_/Q _6035_/B2 PHY_9/VDD PHY_9/VDD VSUBS VSUBS gf180mcu_fd_sc_mcu7t5v0__clkinv_1
X_6715_ _9808_/Q _6714_/Z _6715_/Z PHY_9/VDD PHY_9/VDD VSUBS VSUBS gf180mcu_fd_sc_mcu7t5v0__and2_1
X_9503_ _9503_/D _9972_/CLK _9503_/Q PHY_9/VDD PHY_9/VDD VSUBS VSUBS gf180mcu_fd_sc_mcu7t5v0__dffq_1
X_7695_ _9382_/Q _9034_/A2 _7695_/B _7696_/B PHY_9/VDD PHY_9/VDD VSUBS VSUBS gf180mcu_fd_sc_mcu7t5v0__oai21_1
X_6646_ _6646_/A1 _6646_/A2 _6646_/B _6647_/A3 PHY_9/VDD PHY_9/VDD VSUBS VSUBS gf180mcu_fd_sc_mcu7t5v0__oai21_1
X_9434_ _9434_/D _9901_/CLK _9434_/Q PHY_9/VDD PHY_9/VDD VSUBS VSUBS gf180mcu_fd_sc_mcu7t5v0__dffq_1
X_6577_ _9810_/Q _6577_/A2 _6631_/A1 PHY_9/VDD PHY_9/VDD VSUBS VSUBS gf180mcu_fd_sc_mcu7t5v0__nand2_1
X_9365_ _9365_/D _9974_/CLK _9365_/Q PHY_9/VDD PHY_9/VDD VSUBS VSUBS gf180mcu_fd_sc_mcu7t5v0__dffq_1
X_8316_ _9809_/Q _8316_/A2 _8323_/A2 PHY_9/VDD PHY_9/VDD VSUBS VSUBS gf180mcu_fd_sc_mcu7t5v0__nand2_1
X_5528_ _9726_/Q _5527_/Z _5544_/A2 PHY_9/VDD PHY_9/VDD VSUBS VSUBS gf180mcu_fd_sc_mcu7t5v0__nor2_4
X_9296_ _9296_/A1 _9294_/Z _9296_/Z PHY_9/VDD PHY_9/VDD VSUBS VSUBS gf180mcu_fd_sc_mcu7t5v0__xor2_1
X_5459_ _5459_/A1 _9734_/Q _9458_/Q _5495_/B PHY_9/VDD PHY_9/VDD VSUBS VSUBS gf180mcu_fd_sc_mcu7t5v0__and3_4
X_8247_ _9812_/Q _8316_/A2 _8249_/A2 PHY_9/VDD PHY_9/VDD VSUBS VSUBS gf180mcu_fd_sc_mcu7t5v0__nand2_1
X_8178_ _6512_/B _8075_/B _8226_/A1 PHY_9/VDD PHY_9/VDD VSUBS VSUBS gf180mcu_fd_sc_mcu7t5v0__nor2_2
X_7129_ _9810_/Q _7129_/A2 _7178_/A1 PHY_9/VDD PHY_9/VDD VSUBS VSUBS gf180mcu_fd_sc_mcu7t5v0__nand2_1
X_4830_ _9500_/Q _5600_/A1 PHY_9/VDD PHY_9/VDD VSUBS VSUBS gf180mcu_fd_sc_mcu7t5v0__clkinv_1
X_4761_ _9385_/Q _5292_/A1 PHY_9/VDD PHY_9/VDD VSUBS VSUBS gf180mcu_fd_sc_mcu7t5v0__clkinv_1
X_6500_ _6500_/A1 _6498_/Z _6516_/A2 PHY_9/VDD PHY_9/VDD VSUBS VSUBS gf180mcu_fd_sc_mcu7t5v0__xnor2_1
X_7480_ _9810_/Q _7654_/A2 _7601_/A1 PHY_9/VDD PHY_9/VDD VSUBS VSUBS gf180mcu_fd_sc_mcu7t5v0__nand2_1
X_4692_ _9358_/Q _5228_/A1 PHY_9/VDD PHY_9/VDD VSUBS VSUBS gf180mcu_fd_sc_mcu7t5v0__clkinv_1
X_6431_ _6432_/A1 _6432_/A2 _6432_/B _6434_/A1 PHY_9/VDD PHY_9/VDD VSUBS VSUBS gf180mcu_fd_sc_mcu7t5v0__nor3_1
X_6362_ _6648_/A1 _9803_/Q _6376_/A3 _6400_/A2 PHY_9/VDD PHY_9/VDD VSUBS VSUBS gf180mcu_fd_sc_mcu7t5v0__nand3_2
X_9150_ _9150_/A1 _9184_/A1 _9150_/A3 _9153_/A3 PHY_9/VDD PHY_9/VDD VSUBS VSUBS gf180mcu_fd_sc_mcu7t5v0__xnor3_1
X_5313_ _9462_/Q _5318_/A2 _8027_/B _5314_/B PHY_9/VDD PHY_9/VDD VSUBS VSUBS gf180mcu_fd_sc_mcu7t5v0__oai21_1
X_8101_ _9227_/A1 _8309_/A2 _8075_/B _9091_/B _8130_/B1 PHY_9/VDD PHY_9/VDD VSUBS
+ VSUBS gf180mcu_fd_sc_mcu7t5v0__oai22_1
X_9081_ _9808_/Q _9285_/A2 _9081_/A3 _9081_/Z PHY_9/VDD PHY_9/VDD VSUBS VSUBS gf180mcu_fd_sc_mcu7t5v0__xor3_1
X_6293_ _9031_/B _6293_/A2 _9777_/D PHY_9/VDD PHY_9/VDD VSUBS VSUBS gf180mcu_fd_sc_mcu7t5v0__and2_1
X_5244_ _5244_/A1 _5248_/A2 _5244_/B _9365_/D PHY_9/VDD PHY_9/VDD VSUBS VSUBS gf180mcu_fd_sc_mcu7t5v0__aoi21_1
X_8032_ _9903_/Q _9902_/Q _8319_/A2 PHY_9/VDD PHY_9/VDD VSUBS VSUBS gf180mcu_fd_sc_mcu7t5v0__nor2_4
X_5175_ _5967_/B _5175_/A2 _9478_/D PHY_9/VDD PHY_9/VDD VSUBS VSUBS gf180mcu_fd_sc_mcu7t5v0__and2_1
X_8934_ _9812_/Q _8711_/B _8982_/B1 _8935_/A2 _8982_/C _8935_/B PHY_9/VDD PHY_9/VDD
+ VSUBS VSUBS gf180mcu_fd_sc_mcu7t5v0__aoi221_1
X_8865_ _8849_/B _8865_/A2 _8865_/B _8918_/A2 PHY_9/VDD PHY_9/VDD VSUBS VSUBS gf180mcu_fd_sc_mcu7t5v0__oai21_1
X_7816_ _9894_/Q _7825_/A2 _7835_/A2 PHY_9/VDD PHY_9/VDD VSUBS VSUBS gf180mcu_fd_sc_mcu7t5v0__nor2_1
X_8796_ _8832_/A1 _8752_/I _8796_/B _8799_/A3 PHY_9/VDD PHY_9/VDD VSUBS VSUBS gf180mcu_fd_sc_mcu7t5v0__aoi21_1
X_7747_ _7745_/Z _7747_/A2 _9091_/B _7783_/B PHY_9/VDD PHY_9/VDD VSUBS VSUBS gf180mcu_fd_sc_mcu7t5v0__aoi21_1
X_4959_ _9796_/Q _6318_/B2 PHY_9/VDD PHY_9/VDD VSUBS VSUBS gf180mcu_fd_sc_mcu7t5v0__clkinv_1
X_7678_ _8689_/A1 _7686_/A2 _7686_/B1 PHY_9/VDD PHY_9/VDD VSUBS VSUBS gf180mcu_fd_sc_mcu7t5v0__nand2_2
X_6629_ _7676_/A1 _6353_/Z _6629_/B _6650_/A3 PHY_9/VDD PHY_9/VDD VSUBS VSUBS gf180mcu_fd_sc_mcu7t5v0__oai21_4
X_9417_ _9417_/D _9901_/CLK _9417_/Q PHY_9/VDD PHY_9/VDD VSUBS VSUBS gf180mcu_fd_sc_mcu7t5v0__dffq_1
X_9348_ _9814_/Q _9348_/A2 _9348_/B _9348_/C _9355_/A2 PHY_9/VDD PHY_9/VDD VSUBS VSUBS
+ gf180mcu_fd_sc_mcu7t5v0__aoi211_1
X_9279_ _9809_/Q _9178_/Z _9279_/B _9335_/B1 PHY_9/VDD PHY_9/VDD VSUBS VSUBS gf180mcu_fd_sc_mcu7t5v0__aoi21_1
X_6980_ _6980_/A1 _6980_/A2 _6980_/B _6982_/A2 PHY_9/VDD PHY_9/VDD VSUBS VSUBS gf180mcu_fd_sc_mcu7t5v0__aoi21_1
X_5931_ _9669_/Q _5928_/Z _5934_/A2 PHY_9/VDD PHY_9/VDD VSUBS VSUBS gf180mcu_fd_sc_mcu7t5v0__nand2_1
X_8650_ _8657_/A2 _8650_/A2 _8650_/A3 _8650_/Z PHY_9/VDD PHY_9/VDD VSUBS VSUBS gf180mcu_fd_sc_mcu7t5v0__xor3_1
X_5862_ _9647_/Q _9523_/Q _5864_/A2 PHY_9/VDD PHY_9/VDD VSUBS VSUBS gf180mcu_fd_sc_mcu7t5v0__nand2_1
X_5793_ _5404_/Z _5794_/A2 _5794_/B1 _5793_/B2 _9613_/D PHY_9/VDD PHY_9/VDD VSUBS
+ VSUBS gf180mcu_fd_sc_mcu7t5v0__oai22_1
X_7601_ _7601_/A1 _7601_/A2 _7646_/B2 _7601_/Z PHY_9/VDD PHY_9/VDD VSUBS VSUBS gf180mcu_fd_sc_mcu7t5v0__xor3_1
X_4813_ _9682_/Q _5960_/A1 PHY_9/VDD PHY_9/VDD VSUBS VSUBS gf180mcu_fd_sc_mcu7t5v0__clkinv_1
X_8581_ _8581_/A1 _8580_/B _8582_/A2 PHY_9/VDD PHY_9/VDD VSUBS VSUBS gf180mcu_fd_sc_mcu7t5v0__xnor2_1
X_7532_ _7482_/B _7532_/A2 _7532_/B _9317_/C _7533_/A2 PHY_9/VDD PHY_9/VDD VSUBS VSUBS
+ gf180mcu_fd_sc_mcu7t5v0__oai211_1
X_4744_ _9891_/Q _8720_/A2 PHY_9/VDD PHY_9/VDD VSUBS VSUBS gf180mcu_fd_sc_mcu7t5v0__inv_2
X_7463_ _7449_/Z _7493_/B _7463_/A3 _7463_/Z PHY_9/VDD PHY_9/VDD VSUBS VSUBS gf180mcu_fd_sc_mcu7t5v0__or3_1
X_9202_ _9202_/A1 _9200_/Z _9221_/B PHY_9/VDD PHY_9/VDD VSUBS VSUBS gf180mcu_fd_sc_mcu7t5v0__or2_1
X_6414_ _7379_/A3 _6414_/A2 _6414_/B _6443_/A1 PHY_9/VDD PHY_9/VDD VSUBS VSUBS gf180mcu_fd_sc_mcu7t5v0__oai21_1
X_7394_ _9808_/Q _7647_/A2 _7397_/A1 PHY_9/VDD PHY_9/VDD VSUBS VSUBS gf180mcu_fd_sc_mcu7t5v0__nand2_1
X_9133_ _9133_/A1 _9133_/A2 _9133_/B _9176_/A1 PHY_9/VDD PHY_9/VDD VSUBS VSUBS gf180mcu_fd_sc_mcu7t5v0__oai21_1
X_6345_ _6558_/B _9034_/A2 _6345_/B _9812_/D PHY_9/VDD PHY_9/VDD VSUBS VSUBS gf180mcu_fd_sc_mcu7t5v0__aoi21_1
X_6276_ _6276_/A1 _6276_/A2 _6276_/B _6291_/C PHY_9/VDD PHY_9/VDD VSUBS VSUBS gf180mcu_fd_sc_mcu7t5v0__aoi21_1
X_9064_ _9064_/A1 _9064_/A2 _9067_/B PHY_9/VDD PHY_9/VDD VSUBS VSUBS gf180mcu_fd_sc_mcu7t5v0__nand2_1
X_5227_ _9460_/Q _5236_/A2 rst_n _5228_/B PHY_9/VDD PHY_9/VDD VSUBS VSUBS gf180mcu_fd_sc_mcu7t5v0__oai21_1
X_8015_ _7870_/B _8014_/Z _8016_/C PHY_9/VDD PHY_9/VDD VSUBS VSUBS gf180mcu_fd_sc_mcu7t5v0__nand2_1
X_5158_ _5158_/I _5164_/A2 PHY_9/VDD PHY_9/VDD VSUBS VSUBS gf180mcu_fd_sc_mcu7t5v0__clkinv_1
X_9966_ _9966_/D _9974_/CLK _9966_/Q PHY_9/VDD PHY_9/VDD VSUBS VSUBS gf180mcu_fd_sc_mcu7t5v0__dffq_4
X_5089_ _9564_/Q _5726_/B2 PHY_9/VDD PHY_9/VDD VSUBS VSUBS gf180mcu_fd_sc_mcu7t5v0__clkinv_1
X_8917_ _8918_/A2 _8917_/A2 _8971_/S PHY_9/VDD PHY_9/VDD VSUBS VSUBS gf180mcu_fd_sc_mcu7t5v0__nor2_1
X_9897_ _9897_/D _9957_/CLK _9897_/Q PHY_9/VDD PHY_9/VDD VSUBS VSUBS gf180mcu_fd_sc_mcu7t5v0__dffq_4
X_8848_ _8848_/A1 _8848_/A2 _8848_/B _8872_/A1 PHY_9/VDD PHY_9/VDD VSUBS VSUBS gf180mcu_fd_sc_mcu7t5v0__oai21_1
X_8779_ _8779_/A1 _8779_/A2 _8812_/A1 PHY_9/VDD PHY_9/VDD VSUBS VSUBS gf180mcu_fd_sc_mcu7t5v0__nand2_1
X_6130_ _9880_/Q _6288_/A2 _6288_/B1 _9943_/Q _6131_/A2 PHY_9/VDD PHY_9/VDD VSUBS
+ VSUBS gf180mcu_fd_sc_mcu7t5v0__aoi22_1
X_6061_ _9418_/Q _6288_/A2 _6288_/B1 _9550_/Q _6062_/A2 PHY_9/VDD PHY_9/VDD VSUBS
+ VSUBS gf180mcu_fd_sc_mcu7t5v0__aoi22_1
X_5012_ _9530_/Q _5653_/B2 PHY_9/VDD PHY_9/VDD VSUBS VSUBS gf180mcu_fd_sc_mcu7t5v0__clkinv_1
X_9820_ _9820_/D _9907_/CLK _9820_/Q PHY_9/VDD PHY_9/VDD VSUBS VSUBS gf180mcu_fd_sc_mcu7t5v0__dffq_2
X_6963_ _6963_/A1 _6963_/A2 _6985_/A1 PHY_9/VDD PHY_9/VDD VSUBS VSUBS gf180mcu_fd_sc_mcu7t5v0__nand2_1
X_9751_ _9751_/D _9948_/CLK _9751_/Q PHY_9/VDD PHY_9/VDD VSUBS VSUBS gf180mcu_fd_sc_mcu7t5v0__dffq_1
X_6894_ _9841_/Q _6910_/A1 _6891_/Z _6894_/Z PHY_9/VDD PHY_9/VDD VSUBS VSUBS gf180mcu_fd_sc_mcu7t5v0__xor3_1
X_9682_ _9682_/D _9972_/CLK _9682_/Q PHY_9/VDD PHY_9/VDD VSUBS VSUBS gf180mcu_fd_sc_mcu7t5v0__dffq_1
X_5914_ _9663_/Q _5909_/Z _5932_/B _5915_/A2 PHY_9/VDD PHY_9/VDD VSUBS VSUBS gf180mcu_fd_sc_mcu7t5v0__oai21_1
X_8702_ _9365_/Q _9036_/A2 rst_n _8703_/B PHY_9/VDD PHY_9/VDD VSUBS VSUBS gf180mcu_fd_sc_mcu7t5v0__oai21_1
X_8633_ _9813_/Q _8674_/A2 _8634_/A2 _8673_/I1 _8674_/B _8634_/B PHY_9/VDD PHY_9/VDD
+ VSUBS VSUBS gf180mcu_fd_sc_mcu7t5v0__aoi221_1
X_5845_ _5832_/Z _5845_/A2 _5846_/B PHY_9/VDD PHY_9/VDD VSUBS VSUBS gf180mcu_fd_sc_mcu7t5v0__nand2_1
X_5776_ _8691_/A1 _5782_/A2 _5782_/B1 _5776_/B2 _9600_/D PHY_9/VDD PHY_9/VDD VSUBS
+ VSUBS gf180mcu_fd_sc_mcu7t5v0__oai22_1
X_8564_ _8565_/A1 _8563_/Z _8591_/B PHY_9/VDD PHY_9/VDD VSUBS VSUBS gf180mcu_fd_sc_mcu7t5v0__or2_1
X_7515_ _9874_/Q _7518_/A2 _7534_/B PHY_9/VDD PHY_9/VDD VSUBS VSUBS gf180mcu_fd_sc_mcu7t5v0__nand2_1
X_8495_ _8495_/A1 _8478_/Z _8495_/B _8542_/A1 PHY_9/VDD PHY_9/VDD VSUBS VSUBS gf180mcu_fd_sc_mcu7t5v0__aoi21_1
X_4727_ _9907_/Q _9135_/A3 PHY_9/VDD PHY_9/VDD VSUBS VSUBS gf180mcu_fd_sc_mcu7t5v0__clkinv_1
X_7446_ _6471_/B _7446_/A2 _7446_/A3 _7446_/A4 _7449_/A2 PHY_9/VDD PHY_9/VDD VSUBS
+ VSUBS gf180mcu_fd_sc_mcu7t5v0__nor4_2
X_7377_ _7706_/A2 _9356_/C _9357_/B _7377_/C _9870_/D PHY_9/VDD PHY_9/VDD VSUBS VSUBS
+ gf180mcu_fd_sc_mcu7t5v0__aoi211_1
X_9116_ _9121_/A1 _9083_/Z _9122_/A1 PHY_9/VDD PHY_9/VDD VSUBS VSUBS gf180mcu_fd_sc_mcu7t5v0__nand2_1
X_6328_ _9400_/Q _9036_/A2 _7695_/B _6329_/B PHY_9/VDD PHY_9/VDD VSUBS VSUBS gf180mcu_fd_sc_mcu7t5v0__oai21_1
X_6259_ _6259_/A1 _6259_/A2 _6261_/C2 PHY_9/VDD PHY_9/VDD VSUBS VSUBS gf180mcu_fd_sc_mcu7t5v0__nand2_1
X_9047_ _9091_/A1 _9091_/A2 _9091_/C _9331_/A2 PHY_9/VDD PHY_9/VDD VSUBS VSUBS gf180mcu_fd_sc_mcu7t5v0__aoi21_4
X_9949_ _9949_/D _9974_/CLK _9949_/Q PHY_9/VDD PHY_9/VDD VSUBS VSUBS gf180mcu_fd_sc_mcu7t5v0__dffq_2
X_5630_ _9512_/Q _5633_/A2 _5631_/A2 PHY_9/VDD PHY_9/VDD VSUBS VSUBS gf180mcu_fd_sc_mcu7t5v0__nand2_1
X_5561_ _5561_/I _5633_/A2 PHY_9/VDD PHY_9/VDD VSUBS VSUBS gf180mcu_fd_sc_mcu7t5v0__clkinv_3
X_8280_ _8282_/A2 _8279_/Z _8307_/B PHY_9/VDD PHY_9/VDD VSUBS VSUBS gf180mcu_fd_sc_mcu7t5v0__or2_1
X_7300_ _7300_/A1 _7300_/A2 _7316_/A2 PHY_9/VDD PHY_9/VDD VSUBS VSUBS gf180mcu_fd_sc_mcu7t5v0__nand2_2
X_5492_ _5492_/A1 _5493_/B _5492_/B _9457_/D PHY_9/VDD PHY_9/VDD VSUBS VSUBS gf180mcu_fd_sc_mcu7t5v0__aoi21_1
X_7231_ _7281_/A1 _7231_/A2 _7231_/B _7232_/B PHY_9/VDD PHY_9/VDD VSUBS VSUBS gf180mcu_fd_sc_mcu7t5v0__oai21_1
X_7162_ _7163_/A1 _7161_/Z _7266_/A1 PHY_9/VDD PHY_9/VDD VSUBS VSUBS gf180mcu_fd_sc_mcu7t5v0__nand2_1
X_7093_ _7094_/A1 _7094_/A2 _7093_/B _7132_/A2 PHY_9/VDD PHY_9/VDD VSUBS VSUBS gf180mcu_fd_sc_mcu7t5v0__aoi21_2
X_6113_ _9527_/Q _6288_/A2 _6288_/B1 _9715_/Q _6114_/A2 PHY_9/VDD PHY_9/VDD VSUBS
+ VSUBS gf180mcu_fd_sc_mcu7t5v0__aoi22_1
X_6044_ _8692_/A1 _6049_/A2 _6049_/B1 _6044_/B2 _9756_/D PHY_9/VDD PHY_9/VDD VSUBS
+ VSUBS gf180mcu_fd_sc_mcu7t5v0__oai22_1
X_9803_ _9803_/D _9907_/CLK _9803_/Q PHY_9/VDD PHY_9/VDD VSUBS VSUBS gf180mcu_fd_sc_mcu7t5v0__dffq_2
X_7995_ _9026_/A1 _7738_/C _7995_/B1 _7995_/B2 _8013_/A2 PHY_9/VDD PHY_9/VDD VSUBS
+ VSUBS gf180mcu_fd_sc_mcu7t5v0__aoi22_2
X_6946_ _6946_/A1 _6942_/Z _6958_/A2 PHY_9/VDD PHY_9/VDD VSUBS VSUBS gf180mcu_fd_sc_mcu7t5v0__nand2_1
X_9734_ _9734_/D _9800_/CLK _9734_/Q PHY_9/VDD PHY_9/VDD VSUBS VSUBS gf180mcu_fd_sc_mcu7t5v0__dffq_1
X_6877_ _9812_/Q _6710_/Z _6931_/A1 PHY_9/VDD PHY_9/VDD VSUBS VSUBS gf180mcu_fd_sc_mcu7t5v0__nand2_1
X_9665_ _9665_/D _9972_/CLK _9665_/Q PHY_9/VDD PHY_9/VDD VSUBS VSUBS gf180mcu_fd_sc_mcu7t5v0__dffq_1
X_9596_ _9596_/D _9939_/CLK _9596_/Q PHY_9/VDD PHY_9/VDD VSUBS VSUBS gf180mcu_fd_sc_mcu7t5v0__dffq_1
X_8616_ _8617_/A1 _8615_/Z _8660_/A2 PHY_9/VDD PHY_9/VDD VSUBS VSUBS gf180mcu_fd_sc_mcu7t5v0__nand2_1
X_5828_ _9639_/Q _5828_/A2 _5828_/B _5829_/A2 PHY_9/VDD PHY_9/VDD VSUBS VSUBS gf180mcu_fd_sc_mcu7t5v0__aoi21_1
X_5759_ _5406_/Z _5759_/A2 _5759_/B1 _5759_/B2 _9589_/D PHY_9/VDD PHY_9/VDD VSUBS
+ VSUBS gf180mcu_fd_sc_mcu7t5v0__oai22_1
X_8547_ _8547_/A1 _8547_/A2 _8644_/A2 PHY_9/VDD PHY_9/VDD VSUBS VSUBS gf180mcu_fd_sc_mcu7t5v0__nand2_4
X_8478_ _9928_/Q _8487_/A2 _8478_/Z PHY_9/VDD PHY_9/VDD VSUBS VSUBS gf180mcu_fd_sc_mcu7t5v0__xor2_1
X_7429_ _7647_/A2 _7382_/Z _7473_/B _7430_/A2 PHY_9/VDD PHY_9/VDD VSUBS VSUBS gf180mcu_fd_sc_mcu7t5v0__oai21_1
X_6800_ _6795_/Z _6799_/Z _6809_/A1 PHY_9/VDD PHY_9/VDD VSUBS VSUBS gf180mcu_fd_sc_mcu7t5v0__nor2_1
X_4992_ _9781_/Q _6299_/B2 PHY_9/VDD PHY_9/VDD VSUBS VSUBS gf180mcu_fd_sc_mcu7t5v0__clkinv_1
X_7780_ _8781_/A3 _7779_/Z _7780_/Z PHY_9/VDD PHY_9/VDD VSUBS VSUBS gf180mcu_fd_sc_mcu7t5v0__xor2_1
X_6731_ _7735_/A3 _6732_/A3 _6737_/A2 PHY_9/VDD PHY_9/VDD VSUBS VSUBS gf180mcu_fd_sc_mcu7t5v0__nand2_1
X_9450_ _9450_/D _9800_/CLK _9450_/Q PHY_9/VDD PHY_9/VDD VSUBS VSUBS gf180mcu_fd_sc_mcu7t5v0__dffq_1
X_6662_ _5399_/Z _6665_/A2 _6665_/B1 _6662_/B2 _9827_/D PHY_9/VDD PHY_9/VDD VSUBS
+ VSUBS gf180mcu_fd_sc_mcu7t5v0__oai22_1
X_8401_ _8401_/A1 _8401_/A2 _8401_/A3 _8401_/Z PHY_9/VDD PHY_9/VDD VSUBS VSUBS gf180mcu_fd_sc_mcu7t5v0__or3_2
X_5613_ _5613_/A1 _5613_/A2 _5973_/C _9506_/D PHY_9/VDD PHY_9/VDD VSUBS VSUBS gf180mcu_fd_sc_mcu7t5v0__aoi21_1
X_9381_ _9381_/D _9901_/CLK _9381_/Q PHY_9/VDD PHY_9/VDD VSUBS VSUBS gf180mcu_fd_sc_mcu7t5v0__dffq_1
X_6593_ _6594_/A1 _6592_/Z _6639_/A2 PHY_9/VDD PHY_9/VDD VSUBS VSUBS gf180mcu_fd_sc_mcu7t5v0__nand2_1
X_8332_ _8332_/A1 _8332_/A2 _8332_/B _8336_/A1 PHY_9/VDD PHY_9/VDD VSUBS VSUBS gf180mcu_fd_sc_mcu7t5v0__oai21_1
X_5544_ _5544_/A1 _5544_/A2 _5544_/B1 _5525_/Z _5973_/C _9476_/D PHY_9/VDD PHY_9/VDD
+ VSUBS VSUBS gf180mcu_fd_sc_mcu7t5v0__aoi221_1
X_8263_ _8263_/A1 _8263_/A2 _8307_/A1 PHY_9/VDD PHY_9/VDD VSUBS VSUBS gf180mcu_fd_sc_mcu7t5v0__xnor2_1
X_5475_ _5492_/A1 _5495_/B _5475_/B _9449_/D PHY_9/VDD PHY_9/VDD VSUBS VSUBS gf180mcu_fd_sc_mcu7t5v0__aoi21_1
X_7214_ _7237_/A1 _7213_/Z _7266_/A2 PHY_9/VDD PHY_9/VDD VSUBS VSUBS gf180mcu_fd_sc_mcu7t5v0__xnor2_1
X_8194_ _8266_/A2 _8194_/A2 _8194_/Z PHY_9/VDD PHY_9/VDD VSUBS VSUBS gf180mcu_fd_sc_mcu7t5v0__xor2_1
X_7145_ _9908_/Q _9848_/Q _7145_/B _7147_/B1 PHY_9/VDD PHY_9/VDD VSUBS VSUBS gf180mcu_fd_sc_mcu7t5v0__oai21_2
X_7076_ _7145_/B _9508_/Q _9848_/Q _7077_/B2 PHY_9/VDD PHY_9/VDD VSUBS VSUBS gf180mcu_fd_sc_mcu7t5v0__oai21_2
X_6027_ _8695_/A1 _6029_/A2 _6029_/B1 _6027_/B2 _9743_/D PHY_9/VDD PHY_9/VDD VSUBS
+ VSUBS gf180mcu_fd_sc_mcu7t5v0__oai22_1
X_7978_ _7831_/C _7965_/Z _7978_/B _9356_/C _7979_/B PHY_9/VDD PHY_9/VDD VSUBS VSUBS
+ gf180mcu_fd_sc_mcu7t5v0__aoi211_1
X_6929_ _9813_/Q _6710_/Z _6978_/A2 PHY_9/VDD PHY_9/VDD VSUBS VSUBS gf180mcu_fd_sc_mcu7t5v0__nand2_1
X_9717_ _9717_/D _9830_/CLK _9717_/Q PHY_9/VDD PHY_9/VDD VSUBS VSUBS gf180mcu_fd_sc_mcu7t5v0__dffq_1
X_9648_ _9648_/D _9800_/CLK _9648_/Q PHY_9/VDD PHY_9/VDD VSUBS VSUBS gf180mcu_fd_sc_mcu7t5v0__dffq_1
X_9579_ _9579_/D _9940_/CLK _9579_/Q PHY_9/VDD PHY_9/VDD VSUBS VSUBS gf180mcu_fd_sc_mcu7t5v0__dffq_1
X_5260_ _5260_/A1 _5260_/A2 _5260_/B _9372_/D PHY_9/VDD PHY_9/VDD VSUBS VSUBS gf180mcu_fd_sc_mcu7t5v0__aoi21_1
X_5191_ _5130_/I _5192_/A3 _5208_/A2 PHY_9/VDD PHY_9/VDD VSUBS VSUBS gf180mcu_fd_sc_mcu7t5v0__nand2_1
X_8950_ _9808_/Q _8998_/A2 _8950_/Z PHY_9/VDD PHY_9/VDD VSUBS VSUBS gf180mcu_fd_sc_mcu7t5v0__and2_1
X_7901_ _7847_/Z _7901_/A2 _7900_/B _7901_/Z PHY_9/VDD PHY_9/VDD VSUBS VSUBS gf180mcu_fd_sc_mcu7t5v0__and3_1
X_8881_ _8881_/A1 _8879_/Z _8882_/A2 PHY_9/VDD PHY_9/VDD VSUBS VSUBS gf180mcu_fd_sc_mcu7t5v0__nand2_1
X_7832_ _7831_/C _7818_/Z _7832_/B1 _7832_/B2 _9356_/C _7833_/B PHY_9/VDD PHY_9/VDD
+ VSUBS VSUBS gf180mcu_fd_sc_mcu7t5v0__aoi221_2
X_4975_ _9757_/Q _6045_/B2 PHY_9/VDD PHY_9/VDD VSUBS VSUBS gf180mcu_fd_sc_mcu7t5v0__clkinv_1
X_7763_ _9892_/Q _7764_/A2 _7770_/B PHY_9/VDD PHY_9/VDD VSUBS VSUBS gf180mcu_fd_sc_mcu7t5v0__and2_1
X_6714_ _6710_/Z _6716_/A3 _6714_/Z PHY_9/VDD PHY_9/VDD VSUBS VSUBS gf180mcu_fd_sc_mcu7t5v0__xor2_1
X_9502_ _9502_/D _9974_/CLK _9502_/Q PHY_9/VDD PHY_9/VDD VSUBS VSUBS gf180mcu_fd_sc_mcu7t5v0__dffq_1
X_9433_ _9433_/D _9972_/CLK _9433_/Q PHY_9/VDD PHY_9/VDD VSUBS VSUBS gf180mcu_fd_sc_mcu7t5v0__dffq_1
X_7694_ _7994_/B _9034_/A2 _7694_/B _9889_/D PHY_9/VDD PHY_9/VDD VSUBS VSUBS gf180mcu_fd_sc_mcu7t5v0__aoi21_1
X_6645_ _9349_/A1 _6650_/A3 _6645_/Z PHY_9/VDD PHY_9/VDD VSUBS VSUBS gf180mcu_fd_sc_mcu7t5v0__xor2_1
X_6576_ _9808_/Q _6634_/A2 _6622_/B2 PHY_9/VDD PHY_9/VDD VSUBS VSUBS gf180mcu_fd_sc_mcu7t5v0__nand2_1
X_9364_ _9364_/D _9974_/CLK _9364_/Q PHY_9/VDD PHY_9/VDD VSUBS VSUBS gf180mcu_fd_sc_mcu7t5v0__dffq_1
X_8315_ _8315_/A1 _8315_/A2 _8315_/B _8326_/A2 PHY_9/VDD PHY_9/VDD VSUBS VSUBS gf180mcu_fd_sc_mcu7t5v0__oai21_1
X_9295_ _9296_/A1 _9294_/Z _9339_/A2 PHY_9/VDD PHY_9/VDD VSUBS VSUBS gf180mcu_fd_sc_mcu7t5v0__nand2_1
X_5527_ _9725_/Q _9729_/Q _5525_/Z _5531_/C _5527_/Z PHY_9/VDD PHY_9/VDD VSUBS VSUBS
+ gf180mcu_fd_sc_mcu7t5v0__or4_2
X_8246_ _8292_/A1 _8245_/I _8246_/Z PHY_9/VDD PHY_9/VDD VSUBS VSUBS gf180mcu_fd_sc_mcu7t5v0__xor2_1
X_5458_ _5492_/A1 _5458_/A2 _5458_/B _9441_/D PHY_9/VDD PHY_9/VDD VSUBS VSUBS gf180mcu_fd_sc_mcu7t5v0__aoi21_1
X_8177_ _6512_/B _8309_/A2 _8075_/B _6471_/B _8220_/A2 PHY_9/VDD PHY_9/VDD VSUBS VSUBS
+ gf180mcu_fd_sc_mcu7t5v0__oai22_1
X_5389_ _5389_/A1 _5407_/A2 _5388_/Z _5407_/B2 _9418_/D PHY_9/VDD PHY_9/VDD VSUBS
+ VSUBS gf180mcu_fd_sc_mcu7t5v0__oai22_1
X_7128_ _7293_/A2 _7130_/A3 _7129_/A2 PHY_9/VDD PHY_9/VDD VSUBS VSUBS gf180mcu_fd_sc_mcu7t5v0__xnor2_1
X_7059_ _9807_/Q _7254_/A2 _7062_/A1 PHY_9/VDD PHY_9/VDD VSUBS VSUBS gf180mcu_fd_sc_mcu7t5v0__nand2_1
X_4760_ _9867_/Q _7370_/A1 PHY_9/VDD PHY_9/VDD VSUBS VSUBS gf180mcu_fd_sc_mcu7t5v0__clkinv_3
X_4691_ _9962_/Q _9058_/A1 PHY_9/VDD PHY_9/VDD VSUBS VSUBS gf180mcu_fd_sc_mcu7t5v0__clkinv_2
X_6430_ _9809_/Q _6428_/Z _6432_/B PHY_9/VDD PHY_9/VDD VSUBS VSUBS gf180mcu_fd_sc_mcu7t5v0__xor2_1
X_6361_ _9804_/Q _6375_/A2 _6650_/A2 PHY_9/VDD PHY_9/VDD VSUBS VSUBS gf180mcu_fd_sc_mcu7t5v0__nor2_2
X_8100_ _9227_/A1 _8075_/B _8136_/A1 PHY_9/VDD PHY_9/VDD VSUBS VSUBS gf180mcu_fd_sc_mcu7t5v0__nor2_1
X_5312_ _5312_/A1 _5318_/A2 _5312_/B _9394_/D PHY_9/VDD PHY_9/VDD VSUBS VSUBS gf180mcu_fd_sc_mcu7t5v0__aoi21_1
X_6292_ _6292_/A1 _6292_/A2 _6292_/A3 _6293_/A2 PHY_9/VDD PHY_9/VDD VSUBS VSUBS gf180mcu_fd_sc_mcu7t5v0__nand3_1
X_9080_ _9808_/Q _9080_/A2 _9121_/A1 PHY_9/VDD PHY_9/VDD VSUBS VSUBS gf180mcu_fd_sc_mcu7t5v0__nand2_1
X_5243_ _9462_/Q _5248_/A2 rst_n _5244_/B PHY_9/VDD PHY_9/VDD VSUBS VSUBS gf180mcu_fd_sc_mcu7t5v0__oai21_1
X_8031_ _9901_/Q _8055_/A2 _8300_/C PHY_9/VDD PHY_9/VDD VSUBS VSUBS gf180mcu_fd_sc_mcu7t5v0__nor2_4
X_5174_ _5969_/A2 _5163_/Z _5170_/Z _5888_/A1 _5175_/A2 PHY_9/VDD PHY_9/VDD VSUBS
+ VSUBS gf180mcu_fd_sc_mcu7t5v0__oai22_1
X_8933_ _9812_/Q _8998_/A2 _8935_/A2 PHY_9/VDD PHY_9/VDD VSUBS VSUBS gf180mcu_fd_sc_mcu7t5v0__nand2_1
X_8864_ _8893_/A1 _8893_/A2 _8865_/B PHY_9/VDD PHY_9/VDD VSUBS VSUBS gf180mcu_fd_sc_mcu7t5v0__xor2_1
X_7815_ _7815_/A1 _7813_/Z _7825_/A2 PHY_9/VDD PHY_9/VDD VSUBS VSUBS gf180mcu_fd_sc_mcu7t5v0__xnor2_1
X_8795_ _9956_/Q _8812_/A1 _8792_/Z _8795_/Z PHY_9/VDD PHY_9/VDD VSUBS VSUBS gf180mcu_fd_sc_mcu7t5v0__xor3_1
X_7746_ _7988_/A2 _7785_/B _7746_/B _7747_/A2 PHY_9/VDD PHY_9/VDD VSUBS VSUBS gf180mcu_fd_sc_mcu7t5v0__oai21_1
X_4958_ _9825_/Q _6660_/B2 PHY_9/VDD PHY_9/VDD VSUBS VSUBS gf180mcu_fd_sc_mcu7t5v0__clkinv_1
X_7677_ _7677_/A1 _8688_/A2 _7686_/A2 PHY_9/VDD PHY_9/VDD VSUBS VSUBS gf180mcu_fd_sc_mcu7t5v0__nand2_4
X_4889_ _9623_/Q _5807_/B2 PHY_9/VDD PHY_9/VDD VSUBS VSUBS gf180mcu_fd_sc_mcu7t5v0__clkinv_1
X_6628_ _9843_/Q _6350_/Z _6629_/B PHY_9/VDD PHY_9/VDD VSUBS VSUBS gf180mcu_fd_sc_mcu7t5v0__nand2_1
X_9416_ _9416_/D _9901_/CLK _9416_/Q PHY_9/VDD PHY_9/VDD VSUBS VSUBS gf180mcu_fd_sc_mcu7t5v0__dffq_1
X_9347_ _9347_/I0 _9347_/I1 _9347_/S _9348_/B PHY_9/VDD PHY_9/VDD VSUBS VSUBS gf180mcu_fd_sc_mcu7t5v0__mux2_1
X_6559_ _9812_/Q _6634_/A2 _6614_/B _6560_/A3 PHY_9/VDD PHY_9/VDD VSUBS VSUBS gf180mcu_fd_sc_mcu7t5v0__aoi21_1
X_9278_ _9810_/Q _9178_/Z _9335_/A2 PHY_9/VDD PHY_9/VDD VSUBS VSUBS gf180mcu_fd_sc_mcu7t5v0__nand2_1
X_8229_ _8219_/Z _8228_/Z _8256_/B1 PHY_9/VDD PHY_9/VDD VSUBS VSUBS gf180mcu_fd_sc_mcu7t5v0__xnor2_1
X_5930_ _5928_/Z _5930_/A2 _9668_/D PHY_9/VDD PHY_9/VDD VSUBS VSUBS gf180mcu_fd_sc_mcu7t5v0__nor2_1
X_7600_ _7601_/A1 _7601_/A2 _7600_/Z PHY_9/VDD PHY_9/VDD VSUBS VSUBS gf180mcu_fd_sc_mcu7t5v0__and2_1
X_5861_ _5861_/A1 _5861_/A2 _9645_/D PHY_9/VDD PHY_9/VDD VSUBS VSUBS gf180mcu_fd_sc_mcu7t5v0__nor2_1
X_5792_ _8695_/A1 _5794_/A2 _5794_/B1 _5792_/B2 _9612_/D PHY_9/VDD PHY_9/VDD VSUBS
+ VSUBS gf180mcu_fd_sc_mcu7t5v0__oai22_1
X_4812_ _9683_/Q _5962_/A1 PHY_9/VDD PHY_9/VDD VSUBS VSUBS gf180mcu_fd_sc_mcu7t5v0__clkinv_1
X_8580_ _8580_/A1 _8580_/A2 _8580_/B _8625_/B PHY_9/VDD PHY_9/VDD VSUBS VSUBS gf180mcu_fd_sc_mcu7t5v0__aoi21_1
X_7531_ _7674_/C2 _7531_/A2 _7531_/B _7531_/C _7532_/A2 PHY_9/VDD PHY_9/VDD VSUBS
+ VSUBS gf180mcu_fd_sc_mcu7t5v0__oai211_1
X_4743_ _9892_/Q _8750_/A2 PHY_9/VDD PHY_9/VDD VSUBS VSUBS gf180mcu_fd_sc_mcu7t5v0__inv_2
X_7462_ _7493_/B _7463_/A3 _7462_/Z PHY_9/VDD PHY_9/VDD VSUBS VSUBS gf180mcu_fd_sc_mcu7t5v0__or2_1
X_6413_ _9817_/Q _9356_/C _6442_/A1 PHY_9/VDD PHY_9/VDD VSUBS VSUBS gf180mcu_fd_sc_mcu7t5v0__nand2_1
X_9201_ _9202_/A1 _9200_/Z _9203_/A2 PHY_9/VDD PHY_9/VDD VSUBS VSUBS gf180mcu_fd_sc_mcu7t5v0__nand2_1
X_7393_ _9808_/Q _7382_/Z _7393_/B _7400_/B PHY_9/VDD PHY_9/VDD VSUBS VSUBS gf180mcu_fd_sc_mcu7t5v0__oai21_1
X_9132_ _9970_/Q _9356_/C _9175_/A1 PHY_9/VDD PHY_9/VDD VSUBS VSUBS gf180mcu_fd_sc_mcu7t5v0__nand2_1
X_6344_ _9511_/Q _9034_/A2 _8706_/B _6345_/B PHY_9/VDD PHY_9/VDD VSUBS VSUBS gf180mcu_fd_sc_mcu7t5v0__oai21_1
X_6275_ _9589_/Q _6288_/A2 _6287_/A2 _9597_/Q _6276_/A2 PHY_9/VDD PHY_9/VDD VSUBS
+ VSUBS gf180mcu_fd_sc_mcu7t5v0__aoi22_1
X_9063_ _9807_/Q _9313_/A2 _9348_/C _9063_/C _9064_/A2 PHY_9/VDD PHY_9/VDD VSUBS VSUBS
+ gf180mcu_fd_sc_mcu7t5v0__aoi211_1
X_5226_ _5262_/A1 _5437_/A2 _5224_/Z _5236_/A2 PHY_9/VDD PHY_9/VDD VSUBS VSUBS gf180mcu_fd_sc_mcu7t5v0__nand3_4
X_8014_ _8014_/A1 _8013_/Z _8014_/Z PHY_9/VDD PHY_9/VDD VSUBS VSUBS gf180mcu_fd_sc_mcu7t5v0__xor2_1
X_5157_ _9660_/Q _5170_/A1 _5157_/A3 _5157_/A4 _5158_/I PHY_9/VDD PHY_9/VDD VSUBS
+ VSUBS gf180mcu_fd_sc_mcu7t5v0__nor4_4
X_9965_ _9965_/D _9974_/CLK _9965_/Q PHY_9/VDD PHY_9/VDD VSUBS VSUBS gf180mcu_fd_sc_mcu7t5v0__dffq_4
X_5088_ _9784_/Q _6302_/B2 PHY_9/VDD PHY_9/VDD VSUBS VSUBS gf180mcu_fd_sc_mcu7t5v0__clkinv_1
X_8916_ _8941_/A1 _8941_/A2 _8917_/A2 PHY_9/VDD PHY_9/VDD VSUBS VSUBS gf180mcu_fd_sc_mcu7t5v0__xnor2_1
X_9896_ _9896_/D _9957_/CLK _9896_/Q PHY_9/VDD PHY_9/VDD VSUBS VSUBS gf180mcu_fd_sc_mcu7t5v0__dffq_4
X_8847_ _9100_/B _8847_/A2 _9957_/D PHY_9/VDD PHY_9/VDD VSUBS VSUBS gf180mcu_fd_sc_mcu7t5v0__and2_1
X_8778_ _9956_/Q _9356_/C _8811_/A1 PHY_9/VDD PHY_9/VDD VSUBS VSUBS gf180mcu_fd_sc_mcu7t5v0__nand2_1
X_7729_ _7770_/A1 _7729_/A2 _9317_/C _7730_/A2 PHY_9/VDD PHY_9/VDD VSUBS VSUBS gf180mcu_fd_sc_mcu7t5v0__oai21_1
X_6060_ _9566_/Q _6287_/A2 _6287_/B1 _9786_/Q _6062_/A1 PHY_9/VDD PHY_9/VDD VSUBS
+ VSUBS gf180mcu_fd_sc_mcu7t5v0__aoi22_1
X_5011_ _9485_/Q _5555_/B2 PHY_9/VDD PHY_9/VDD VSUBS VSUBS gf180mcu_fd_sc_mcu7t5v0__clkinv_1
X_9750_ _9750_/D _9939_/CLK _9750_/Q PHY_9/VDD PHY_9/VDD VSUBS VSUBS gf180mcu_fd_sc_mcu7t5v0__dffq_1
X_6962_ _6962_/A1 _6962_/A2 _6962_/B _6986_/A2 PHY_9/VDD PHY_9/VDD VSUBS VSUBS gf180mcu_fd_sc_mcu7t5v0__oai21_1
X_6893_ _9841_/Q _6891_/Z _6910_/B PHY_9/VDD PHY_9/VDD VSUBS VSUBS gf180mcu_fd_sc_mcu7t5v0__and2_1
X_9681_ _9681_/D _9689_/CLK _9681_/Q PHY_9/VDD PHY_9/VDD VSUBS VSUBS gf180mcu_fd_sc_mcu7t5v0__dffq_1
X_8701_ _8725_/A2 _9036_/A2 _8701_/B _9950_/D PHY_9/VDD PHY_9/VDD VSUBS VSUBS gf180mcu_fd_sc_mcu7t5v0__aoi21_1
X_5913_ _9663_/Q _5909_/Z _5913_/Z PHY_9/VDD PHY_9/VDD VSUBS VSUBS gf180mcu_fd_sc_mcu7t5v0__and2_1
X_8632_ _9813_/Q _8669_/A2 _8634_/A2 PHY_9/VDD PHY_9/VDD VSUBS VSUBS gf180mcu_fd_sc_mcu7t5v0__nand2_1
X_5844_ _9642_/Q _5832_/Z _5961_/B _5847_/A1 PHY_9/VDD PHY_9/VDD VSUBS VSUBS gf180mcu_fd_sc_mcu7t5v0__oai21_1
X_8563_ _8598_/A1 _8563_/A2 _8561_/B _8563_/Z PHY_9/VDD PHY_9/VDD VSUBS VSUBS gf180mcu_fd_sc_mcu7t5v0__xor3_1
X_5775_ _5388_/Z _5782_/A2 _5782_/B1 _5775_/B2 _9599_/D PHY_9/VDD PHY_9/VDD VSUBS
+ VSUBS gf180mcu_fd_sc_mcu7t5v0__oai22_1
X_7514_ _9874_/Q _7518_/A2 _7534_/A2 PHY_9/VDD PHY_9/VDD VSUBS VSUBS gf180mcu_fd_sc_mcu7t5v0__nor2_1
X_8494_ _8494_/A1 _8494_/A2 _9357_/B _9928_/D PHY_9/VDD PHY_9/VDD VSUBS VSUBS gf180mcu_fd_sc_mcu7t5v0__aoi21_1
X_4726_ _9908_/Q _8207_/A1 PHY_9/VDD PHY_9/VDD VSUBS VSUBS gf180mcu_fd_sc_mcu7t5v0__clkinv_1
X_7445_ _7445_/A1 _7445_/A2 _7445_/B _7489_/A1 PHY_9/VDD PHY_9/VDD VSUBS VSUBS gf180mcu_fd_sc_mcu7t5v0__oai21_1
X_7376_ _7582_/C _7376_/A2 _7404_/A1 _7376_/B2 _9356_/C _7377_/C PHY_9/VDD PHY_9/VDD
+ VSUBS VSUBS gf180mcu_fd_sc_mcu7t5v0__aoi221_1
X_6327_ _6389_/A2 _9036_/A2 _6327_/B _9803_/D PHY_9/VDD PHY_9/VDD VSUBS VSUBS gf180mcu_fd_sc_mcu7t5v0__aoi21_1
X_9115_ _9170_/C _9114_/Z _9130_/B PHY_9/VDD PHY_9/VDD VSUBS VSUBS gf180mcu_fd_sc_mcu7t5v0__nand2_1
X_6258_ _9532_/Q _6288_/A2 _6288_/B1 _9720_/Q _6259_/A2 PHY_9/VDD PHY_9/VDD VSUBS
+ VSUBS gf180mcu_fd_sc_mcu7t5v0__aoi22_1
X_9046_ _9966_/Q _9327_/B _9326_/B1 PHY_9/VDD PHY_9/VDD VSUBS VSUBS gf180mcu_fd_sc_mcu7t5v0__nor2_2
X_6189_ _6189_/A1 _6189_/A2 _6286_/B _6203_/C PHY_9/VDD PHY_9/VDD VSUBS VSUBS gf180mcu_fd_sc_mcu7t5v0__aoi21_1
X_5209_ _5657_/A1 _5831_/A2 _5209_/B _5961_/B _9522_/D PHY_9/VDD PHY_9/VDD VSUBS VSUBS
+ gf180mcu_fd_sc_mcu7t5v0__oai211_1
X_9948_ _9948_/D _9948_/CLK _9948_/Q PHY_9/VDD PHY_9/VDD VSUBS VSUBS gf180mcu_fd_sc_mcu7t5v0__dffq_1
X_9879_ _9879_/D _9948_/CLK _9879_/Q PHY_9/VDD PHY_9/VDD VSUBS VSUBS gf180mcu_fd_sc_mcu7t5v0__dffq_1
X_5560_ _9491_/Q _5560_/A2 _9489_/Q _5561_/I PHY_9/VDD PHY_9/VDD VSUBS VSUBS gf180mcu_fd_sc_mcu7t5v0__nor3_4
X_5491_ _9457_/Q _5493_/B _5770_/B _5492_/B PHY_9/VDD PHY_9/VDD VSUBS VSUBS gf180mcu_fd_sc_mcu7t5v0__oai21_1
X_7230_ _9812_/Q _7315_/A2 _7231_/A2 _7314_/I1 _7315_/B _7231_/B PHY_9/VDD PHY_9/VDD
+ VSUBS VSUBS gf180mcu_fd_sc_mcu7t5v0__aoi221_1
X_7161_ _7151_/Z _7190_/A2 _7161_/Z PHY_9/VDD PHY_9/VDD VSUBS VSUBS gf180mcu_fd_sc_mcu7t5v0__xor2_1
X_7092_ _9227_/A1 _7290_/A2 _7092_/A3 _7093_/B PHY_9/VDD PHY_9/VDD VSUBS VSUBS gf180mcu_fd_sc_mcu7t5v0__xor3_1
X_6112_ _9482_/Q _6287_/A2 _6287_/B1 _9515_/Q _6114_/A1 PHY_9/VDD PHY_9/VDD VSUBS
+ VSUBS gf180mcu_fd_sc_mcu7t5v0__aoi22_1
X_6043_ _8691_/A1 _6049_/A2 _6049_/B1 _6043_/B2 _9755_/D PHY_9/VDD PHY_9/VDD VSUBS
+ VSUBS gf180mcu_fd_sc_mcu7t5v0__oai22_1
X_9802_ _9802_/D _9907_/CLK _9802_/Q PHY_9/VDD PHY_9/VDD VSUBS VSUBS gf180mcu_fd_sc_mcu7t5v0__dffq_2
X_7994_ _7994_/A1 _9877_/Q _7994_/B _7995_/B2 PHY_9/VDD PHY_9/VDD VSUBS VSUBS gf180mcu_fd_sc_mcu7t5v0__oai21_1
X_6945_ _9842_/Q _6962_/A1 _6942_/Z _6945_/Z PHY_9/VDD PHY_9/VDD VSUBS VSUBS gf180mcu_fd_sc_mcu7t5v0__xor3_1
X_9733_ _9733_/D _9800_/CLK _9733_/Q PHY_9/VDD PHY_9/VDD VSUBS VSUBS gf180mcu_fd_sc_mcu7t5v0__dffq_1
X_6876_ _9812_/Q _6680_/Z _6978_/A1 PHY_9/VDD PHY_9/VDD VSUBS VSUBS gf180mcu_fd_sc_mcu7t5v0__nand2_1
X_9664_ _9664_/D _9972_/CLK _9664_/Q PHY_9/VDD PHY_9/VDD VSUBS VSUBS gf180mcu_fd_sc_mcu7t5v0__dffq_1
X_9595_ _9595_/D _9948_/CLK _9595_/Q PHY_9/VDD PHY_9/VDD VSUBS VSUBS gf180mcu_fd_sc_mcu7t5v0__dffq_1
X_8615_ _8597_/Z _8615_/A2 _8615_/A3 _8615_/Z PHY_9/VDD PHY_9/VDD VSUBS VSUBS gf180mcu_fd_sc_mcu7t5v0__xor3_1
X_5827_ _9525_/Q _5827_/A2 _5828_/B PHY_9/VDD PHY_9/VDD VSUBS VSUBS gf180mcu_fd_sc_mcu7t5v0__nor2_1
X_5758_ _5404_/Z _5759_/A2 _5759_/B1 _5758_/B2 _9588_/D PHY_9/VDD PHY_9/VDD VSUBS
+ VSUBS gf180mcu_fd_sc_mcu7t5v0__oai22_1
X_8546_ _9875_/Q _8646_/A2 _8646_/B1 _9503_/Q _8547_/A2 PHY_9/VDD PHY_9/VDD VSUBS
+ VSUBS gf180mcu_fd_sc_mcu7t5v0__aoi22_2
X_4709_ _9932_/Q _8677_/A1 PHY_9/VDD PHY_9/VDD VSUBS VSUBS gf180mcu_fd_sc_mcu7t5v0__clkinv_1
X_8477_ _9928_/Q _8487_/A2 _8495_/B PHY_9/VDD PHY_9/VDD VSUBS VSUBS gf180mcu_fd_sc_mcu7t5v0__and2_1
X_7428_ _9808_/Q _7428_/A2 _7428_/B _7472_/A1 PHY_9/VDD PHY_9/VDD VSUBS VSUBS gf180mcu_fd_sc_mcu7t5v0__aoi21_1
X_5689_ _5687_/Z _5689_/A2 _9544_/D PHY_9/VDD PHY_9/VDD VSUBS VSUBS gf180mcu_fd_sc_mcu7t5v0__nor2_1
X_7359_ _7370_/A1 _9866_/Q _7371_/A3 _7636_/A1 PHY_9/VDD PHY_9/VDD VSUBS VSUBS gf180mcu_fd_sc_mcu7t5v0__nand3_4
X_9029_ _9359_/Q _9036_/A2 _9031_/B _9030_/B PHY_9/VDD PHY_9/VDD VSUBS VSUBS gf180mcu_fd_sc_mcu7t5v0__oai21_1
X_6730_ _7735_/A3 _6732_/A3 _6737_/B PHY_9/VDD PHY_9/VDD VSUBS VSUBS gf180mcu_fd_sc_mcu7t5v0__nor2_1
X_4991_ _9797_/Q _6319_/B2 PHY_9/VDD PHY_9/VDD VSUBS VSUBS gf180mcu_fd_sc_mcu7t5v0__clkinv_1
X_6661_ _8693_/A1 _6665_/A2 _6665_/B1 _6661_/B2 _9826_/D PHY_9/VDD PHY_9/VDD VSUBS
+ VSUBS gf180mcu_fd_sc_mcu7t5v0__oai22_1
X_6592_ _6592_/A1 _6579_/Z _6588_/Z _6592_/Z PHY_9/VDD PHY_9/VDD VSUBS VSUBS gf180mcu_fd_sc_mcu7t5v0__xor3_1
X_8400_ _8401_/A1 _8401_/A2 _8401_/A3 _8606_/A2 PHY_9/VDD PHY_9/VDD VSUBS VSUBS gf180mcu_fd_sc_mcu7t5v0__nor3_4
X_5612_ _9506_/Q _5633_/A2 _5613_/A2 PHY_9/VDD PHY_9/VDD VSUBS VSUBS gf180mcu_fd_sc_mcu7t5v0__nand2_1
X_9380_ _9380_/D _9974_/CLK _9380_/Q PHY_9/VDD PHY_9/VDD VSUBS VSUBS gf180mcu_fd_sc_mcu7t5v0__dffq_1
X_5543_ _9449_/Q _9725_/Q _9729_/Q _5531_/C _5544_/B1 PHY_9/VDD PHY_9/VDD VSUBS VSUBS
+ gf180mcu_fd_sc_mcu7t5v0__nor4_1
X_8331_ _8331_/A1 _8329_/Z _8331_/B _8343_/B1 PHY_9/VDD PHY_9/VDD VSUBS VSUBS gf180mcu_fd_sc_mcu7t5v0__oai21_1
X_8262_ _8263_/A1 _8263_/A2 _8262_/Z PHY_9/VDD PHY_9/VDD VSUBS VSUBS gf180mcu_fd_sc_mcu7t5v0__or2_1
X_5474_ _9449_/Q _5495_/B _5474_/B _5475_/B PHY_9/VDD PHY_9/VDD VSUBS VSUBS gf180mcu_fd_sc_mcu7t5v0__oai21_1
X_7213_ _7213_/A1 _7211_/Z _7213_/Z PHY_9/VDD PHY_9/VDD VSUBS VSUBS gf180mcu_fd_sc_mcu7t5v0__xor2_1
X_8193_ _8216_/A2 _8194_/A2 _8293_/A1 PHY_9/VDD PHY_9/VDD VSUBS VSUBS gf180mcu_fd_sc_mcu7t5v0__nand2_1
X_7144_ _7149_/A1 _7144_/A2 _7144_/B _7163_/A1 PHY_9/VDD PHY_9/VDD VSUBS VSUBS gf180mcu_fd_sc_mcu7t5v0__oai21_1
X_7075_ _9906_/Q _7145_/B _7077_/B1 PHY_9/VDD PHY_9/VDD VSUBS VSUBS gf180mcu_fd_sc_mcu7t5v0__nand2_1
X_6026_ _5399_/Z _6029_/A2 _6029_/B1 _6026_/B2 _9742_/D PHY_9/VDD PHY_9/VDD VSUBS
+ VSUBS gf180mcu_fd_sc_mcu7t5v0__oai22_1
X_7977_ _7977_/A1 _7962_/Z _7977_/B _7978_/B PHY_9/VDD PHY_9/VDD VSUBS VSUBS gf180mcu_fd_sc_mcu7t5v0__aoi21_1
X_6928_ _9813_/Q _6680_/Z _6931_/A3 PHY_9/VDD PHY_9/VDD VSUBS VSUBS gf180mcu_fd_sc_mcu7t5v0__nand2_1
X_9716_ _9716_/D _9830_/CLK _9716_/Q PHY_9/VDD PHY_9/VDD VSUBS VSUBS gf180mcu_fd_sc_mcu7t5v0__dffq_1
X_6859_ _6700_/C _6859_/A2 _9356_/C _6860_/B2 PHY_9/VDD PHY_9/VDD VSUBS VSUBS gf180mcu_fd_sc_mcu7t5v0__aoi21_1
X_9647_ _9647_/D _9972_/CLK _9647_/Q PHY_9/VDD PHY_9/VDD VSUBS VSUBS gf180mcu_fd_sc_mcu7t5v0__dffq_1
X_9578_ _9578_/D _9940_/CLK _9578_/Q PHY_9/VDD PHY_9/VDD VSUBS VSUBS gf180mcu_fd_sc_mcu7t5v0__dffq_1
X_8529_ _9811_/Q _8527_/Z _8529_/Z PHY_9/VDD PHY_9/VDD VSUBS VSUBS gf180mcu_fd_sc_mcu7t5v0__xor2_1
X_5190_ _9639_/Q _5567_/A2 _5192_/A3 PHY_9/VDD PHY_9/VDD VSUBS VSUBS gf180mcu_fd_sc_mcu7t5v0__nor2_1
X_7900_ _7847_/Z _7901_/A2 _7900_/B _7955_/A1 PHY_9/VDD PHY_9/VDD VSUBS VSUBS gf180mcu_fd_sc_mcu7t5v0__aoi21_1
X_8880_ _8881_/A1 _8879_/Z _8931_/A2 PHY_9/VDD PHY_9/VDD VSUBS VSUBS gf180mcu_fd_sc_mcu7t5v0__nor2_1
X_7831_ _7870_/B _7824_/Z _7831_/B _7831_/C _7832_/B2 PHY_9/VDD PHY_9/VDD VSUBS VSUBS
+ gf180mcu_fd_sc_mcu7t5v0__aoi211_2
X_4974_ _9765_/Q _6055_/B2 PHY_9/VDD PHY_9/VDD VSUBS VSUBS gf180mcu_fd_sc_mcu7t5v0__clkinv_1
X_7762_ _9808_/Q _8009_/A2 _7762_/B _7762_/C _7767_/A2 PHY_9/VDD PHY_9/VDD VSUBS VSUBS
+ gf180mcu_fd_sc_mcu7t5v0__aoi211_1
X_6713_ _6824_/A2 _6824_/A3 _6948_/B _6716_/A3 PHY_9/VDD PHY_9/VDD VSUBS VSUBS gf180mcu_fd_sc_mcu7t5v0__nand3_1
X_9501_ _9501_/D _9974_/CLK _9501_/Q PHY_9/VDD PHY_9/VDD VSUBS VSUBS gf180mcu_fd_sc_mcu7t5v0__dffq_2
X_7693_ _9381_/Q _9034_/A2 _7695_/B _7694_/B PHY_9/VDD PHY_9/VDD VSUBS VSUBS gf180mcu_fd_sc_mcu7t5v0__oai21_1
X_6644_ _6644_/A1 _6609_/Z _6644_/B _6647_/A1 PHY_9/VDD PHY_9/VDD VSUBS VSUBS gf180mcu_fd_sc_mcu7t5v0__aoi21_1
X_9432_ _9432_/D _9901_/CLK _9432_/Q PHY_9/VDD PHY_9/VDD VSUBS VSUBS gf180mcu_fd_sc_mcu7t5v0__dffq_1
X_6575_ _6529_/Z _6575_/A2 _6575_/B _6592_/A1 PHY_9/VDD PHY_9/VDD VSUBS VSUBS gf180mcu_fd_sc_mcu7t5v0__oai21_1
X_9363_ _9363_/D _9974_/CLK _9363_/Q PHY_9/VDD PHY_9/VDD VSUBS VSUBS gf180mcu_fd_sc_mcu7t5v0__dffq_1
X_8314_ _8314_/A1 _8314_/A2 _8314_/B1 _8314_/B2 _8325_/A1 PHY_9/VDD PHY_9/VDD VSUBS
+ VSUBS gf180mcu_fd_sc_mcu7t5v0__oai22_1
X_9294_ _9275_/Z _9320_/A2 _9294_/Z PHY_9/VDD PHY_9/VDD VSUBS VSUBS gf180mcu_fd_sc_mcu7t5v0__xor2_1
X_5526_ _9722_/Q _9727_/Q _5531_/C PHY_9/VDD PHY_9/VDD VSUBS VSUBS gf180mcu_fd_sc_mcu7t5v0__or2_1
X_5457_ _9441_/Q _5458_/A2 _9031_/B _5458_/B PHY_9/VDD PHY_9/VDD VSUBS VSUBS gf180mcu_fd_sc_mcu7t5v0__oai21_1
X_8245_ _8245_/I _8292_/A2 PHY_9/VDD PHY_9/VDD VSUBS VSUBS gf180mcu_fd_sc_mcu7t5v0__clkinv_1
X_8176_ _6512_/B _8309_/A2 _8179_/A3 PHY_9/VDD PHY_9/VDD VSUBS VSUBS gf180mcu_fd_sc_mcu7t5v0__nor2_1
X_5388_ _9071_/A1 _5502_/A1 _5559_/B _5388_/Z PHY_9/VDD PHY_9/VDD VSUBS VSUBS gf180mcu_fd_sc_mcu7t5v0__mux2_4
X_7127_ _7046_/Z _7172_/A2 _7130_/A3 PHY_9/VDD PHY_9/VDD VSUBS VSUBS gf180mcu_fd_sc_mcu7t5v0__nor2_1
X_7058_ _9808_/Q _7254_/A2 _7058_/B _7064_/A2 PHY_9/VDD PHY_9/VDD VSUBS VSUBS gf180mcu_fd_sc_mcu7t5v0__oai21_1
X_6009_ _6283_/B2 _8688_/A1 _6018_/A2 PHY_9/VDD PHY_9/VDD VSUBS VSUBS gf180mcu_fd_sc_mcu7t5v0__nand2_4
X_4690_ _9359_/Q _5230_/A1 PHY_9/VDD PHY_9/VDD VSUBS VSUBS gf180mcu_fd_sc_mcu7t5v0__clkinv_1
X_6360_ _9803_/Q _6376_/A3 _6375_/A2 PHY_9/VDD PHY_9/VDD VSUBS VSUBS gf180mcu_fd_sc_mcu7t5v0__nand2_2
X_5311_ _9461_/Q _5318_/A2 _8027_/B _5312_/B PHY_9/VDD PHY_9/VDD VSUBS VSUBS gf180mcu_fd_sc_mcu7t5v0__oai21_1
X_6291_ _8688_/A2 _6291_/A2 _6291_/B1 _6291_/B2 _6291_/C _6292_/A3 PHY_9/VDD PHY_9/VDD
+ VSUBS VSUBS gf180mcu_fd_sc_mcu7t5v0__aoi221_2
X_8030_ _9900_/Q _9899_/Q _8055_/A2 PHY_9/VDD PHY_9/VDD VSUBS VSUBS gf180mcu_fd_sc_mcu7t5v0__nand2_2
X_5242_ _5242_/A1 _5248_/A2 _5242_/B _9364_/D PHY_9/VDD PHY_9/VDD VSUBS VSUBS gf180mcu_fd_sc_mcu7t5v0__aoi21_1
X_5173_ _5899_/A1 _5173_/A2 _5973_/C _9479_/D PHY_9/VDD PHY_9/VDD VSUBS VSUBS gf180mcu_fd_sc_mcu7t5v0__aoi21_1
X_8932_ _8980_/B _8930_/Z _8975_/A2 _8937_/A3 PHY_9/VDD PHY_9/VDD VSUBS VSUBS gf180mcu_fd_sc_mcu7t5v0__nand3_1
X_8863_ _8863_/A1 _8861_/Z _8893_/A2 PHY_9/VDD PHY_9/VDD VSUBS VSUBS gf180mcu_fd_sc_mcu7t5v0__xnor2_1
X_7814_ _7814_/A1 _7814_/A2 _7813_/Z _7960_/A1 PHY_9/VDD PHY_9/VDD VSUBS VSUBS gf180mcu_fd_sc_mcu7t5v0__nand3_2
X_8794_ _9956_/Q _8792_/Z _8812_/B PHY_9/VDD PHY_9/VDD VSUBS VSUBS gf180mcu_fd_sc_mcu7t5v0__and2_1
X_4957_ _9859_/Q _7331_/B2 PHY_9/VDD PHY_9/VDD VSUBS VSUBS gf180mcu_fd_sc_mcu7t5v0__clkinv_1
X_7745_ _7988_/A2 _7746_/B _7785_/B _7745_/Z PHY_9/VDD PHY_9/VDD VSUBS VSUBS gf180mcu_fd_sc_mcu7t5v0__or3_1
X_4888_ _9631_/Q _5817_/B2 PHY_9/VDD PHY_9/VDD VSUBS VSUBS gf180mcu_fd_sc_mcu7t5v0__clkinv_1
X_7676_ _7676_/A1 _9356_/C _7676_/B1 _7676_/B2 _9357_/B _9877_/D PHY_9/VDD PHY_9/VDD
+ VSUBS VSUBS gf180mcu_fd_sc_mcu7t5v0__aoi221_1
X_6627_ _9812_/Q _6627_/A2 _6631_/A3 PHY_9/VDD PHY_9/VDD VSUBS VSUBS gf180mcu_fd_sc_mcu7t5v0__nand2_1
X_9415_ _9415_/D _9901_/CLK _9415_/Q PHY_9/VDD PHY_9/VDD VSUBS VSUBS gf180mcu_fd_sc_mcu7t5v0__dffq_1
X_6558_ _6649_/B _6558_/A2 _6558_/B _6560_/A2 PHY_9/VDD PHY_9/VDD VSUBS VSUBS gf180mcu_fd_sc_mcu7t5v0__aoi21_1
X_9346_ _9814_/Q _9349_/A2 _9347_/S PHY_9/VDD PHY_9/VDD VSUBS VSUBS gf180mcu_fd_sc_mcu7t5v0__nand2_1
X_6489_ _6495_/A1 _6495_/A2 _6496_/A2 PHY_9/VDD PHY_9/VDD VSUBS VSUBS gf180mcu_fd_sc_mcu7t5v0__nor2_1
X_9277_ _9808_/Q _9322_/A2 _9335_/B2 PHY_9/VDD PHY_9/VDD VSUBS VSUBS gf180mcu_fd_sc_mcu7t5v0__nand2_1
X_5509_ _9429_/Q _9725_/Q _5522_/A2 _5510_/C PHY_9/VDD PHY_9/VDD VSUBS VSUBS gf180mcu_fd_sc_mcu7t5v0__and3_1
X_8228_ _8228_/A1 _8226_/Z _8228_/Z PHY_9/VDD PHY_9/VDD VSUBS VSUBS gf180mcu_fd_sc_mcu7t5v0__xor2_1
X_8159_ _8156_/B _8144_/Z _8159_/B _9356_/C _8160_/B PHY_9/VDD PHY_9/VDD VSUBS VSUBS
+ gf180mcu_fd_sc_mcu7t5v0__aoi211_1
X_5860_ _9465_/Q _5867_/A2 _5860_/B _5861_/A2 PHY_9/VDD PHY_9/VDD VSUBS VSUBS gf180mcu_fd_sc_mcu7t5v0__aoi21_1
X_4811_ _9684_/Q _5964_/A1 PHY_9/VDD PHY_9/VDD VSUBS VSUBS gf180mcu_fd_sc_mcu7t5v0__clkinv_1
X_5791_ _5399_/Z _5794_/A2 _5794_/B1 _5791_/B2 _9611_/D PHY_9/VDD PHY_9/VDD VSUBS
+ VSUBS gf180mcu_fd_sc_mcu7t5v0__oai22_1
X_7530_ _9811_/Q _7599_/A2 _7530_/B _7531_/B PHY_9/VDD PHY_9/VDD VSUBS VSUBS gf180mcu_fd_sc_mcu7t5v0__oai21_1
X_4742_ _9893_/Q _8781_/A3 PHY_9/VDD PHY_9/VDD VSUBS VSUBS gf180mcu_fd_sc_mcu7t5v0__clkinv_3
X_7461_ _9808_/Q _7657_/A2 _7654_/A2 _9807_/Q _7463_/A3 PHY_9/VDD PHY_9/VDD VSUBS
+ VSUBS gf180mcu_fd_sc_mcu7t5v0__aoi22_1
X_6412_ _9317_/C _6412_/A2 _6412_/B _9816_/D PHY_9/VDD PHY_9/VDD VSUBS VSUBS gf180mcu_fd_sc_mcu7t5v0__aoi21_1
X_9200_ _9221_/A1 _9154_/Z _9297_/B2 _9200_/Z PHY_9/VDD PHY_9/VDD VSUBS VSUBS gf180mcu_fd_sc_mcu7t5v0__xor3_1
X_7392_ _7636_/A1 _7396_/A2 _7392_/B _7393_/B PHY_9/VDD PHY_9/VDD VSUBS VSUBS gf180mcu_fd_sc_mcu7t5v0__oai21_1
X_9131_ _9131_/A1 _9131_/A2 _9357_/B _9969_/D PHY_9/VDD PHY_9/VDD VSUBS VSUBS gf180mcu_fd_sc_mcu7t5v0__aoi21_1
X_6343_ _6512_/B _9034_/A2 _6343_/B _9811_/D PHY_9/VDD PHY_9/VDD VSUBS VSUBS gf180mcu_fd_sc_mcu7t5v0__aoi21_1
X_6274_ _9581_/Q _6287_/B1 _6288_/B1 _9940_/Q _6276_/A1 PHY_9/VDD PHY_9/VDD VSUBS
+ VSUBS gf180mcu_fd_sc_mcu7t5v0__aoi22_1
X_9062_ _9065_/A1 _9214_/A1 _9348_/A2 PHY_9/VDD PHY_9/VDD VSUBS VSUBS gf180mcu_fd_sc_mcu7t5v0__nor2_2
X_8013_ _9814_/Q _8013_/A2 _8013_/A3 _8013_/Z PHY_9/VDD PHY_9/VDD VSUBS VSUBS gf180mcu_fd_sc_mcu7t5v0__xor3_1
X_5225_ _5437_/A2 _5224_/Z _5321_/A1 PHY_9/VDD PHY_9/VDD VSUBS VSUBS gf180mcu_fd_sc_mcu7t5v0__nand2_2
X_5156_ _9659_/Q _5167_/A3 _5157_/A4 PHY_9/VDD PHY_9/VDD VSUBS VSUBS gf180mcu_fd_sc_mcu7t5v0__nand2_1
X_9964_ _9964_/D _9972_/CLK _9964_/Q PHY_9/VDD PHY_9/VDD VSUBS VSUBS gf180mcu_fd_sc_mcu7t5v0__dffq_2
X_5087_ _9800_/Q _6322_/B2 PHY_9/VDD PHY_9/VDD VSUBS VSUBS gf180mcu_fd_sc_mcu7t5v0__clkinv_1
X_8915_ _8915_/A1 _8913_/Z _8941_/A2 PHY_9/VDD PHY_9/VDD VSUBS VSUBS gf180mcu_fd_sc_mcu7t5v0__xnor2_1
X_9895_ _9895_/D _9957_/CLK _9895_/Q PHY_9/VDD PHY_9/VDD VSUBS VSUBS gf180mcu_fd_sc_mcu7t5v0__dffq_2
X_8846_ _9136_/A2 _9317_/C _8846_/B1 _8846_/B2 _8847_/A2 PHY_9/VDD PHY_9/VDD VSUBS
+ VSUBS gf180mcu_fd_sc_mcu7t5v0__oai22_1
X_5989_ _8344_/A1 _6283_/A1 _5998_/A2 PHY_9/VDD PHY_9/VDD VSUBS VSUBS gf180mcu_fd_sc_mcu7t5v0__nand2_4
X_8777_ _8777_/A1 _9356_/C _9357_/B _8777_/C _9955_/D PHY_9/VDD PHY_9/VDD VSUBS VSUBS
+ gf180mcu_fd_sc_mcu7t5v0__aoi211_1
X_7728_ _9891_/Q _7728_/A2 _7831_/C _7729_/A2 PHY_9/VDD PHY_9/VDD VSUBS VSUBS gf180mcu_fd_sc_mcu7t5v0__oai21_1
X_7659_ _7653_/Z _7656_/Z _7658_/Z _7659_/Z PHY_9/VDD PHY_9/VDD VSUBS VSUBS gf180mcu_fd_sc_mcu7t5v0__xor3_1
X_9329_ _9807_/Q _9349_/A2 _9330_/A3 PHY_9/VDD PHY_9/VDD VSUBS VSUBS gf180mcu_fd_sc_mcu7t5v0__nand2_1
X_5010_ _9718_/Q _6015_/B2 PHY_9/VDD PHY_9/VDD VSUBS VSUBS gf180mcu_fd_sc_mcu7t5v0__clkinv_1
X_6961_ _9357_/B _6961_/A2 _9842_/D PHY_9/VDD PHY_9/VDD VSUBS VSUBS gf180mcu_fd_sc_mcu7t5v0__nor2_1
X_8700_ _9364_/Q _9036_/A2 _8706_/B _8701_/B PHY_9/VDD PHY_9/VDD VSUBS VSUBS gf180mcu_fd_sc_mcu7t5v0__oai21_1
X_6892_ _9841_/Q _6891_/Z _6892_/Z PHY_9/VDD PHY_9/VDD VSUBS VSUBS gf180mcu_fd_sc_mcu7t5v0__or2_1
X_9680_ _9680_/D _9689_/CLK _9680_/Q PHY_9/VDD PHY_9/VDD VSUBS VSUBS gf180mcu_fd_sc_mcu7t5v0__dffq_1
X_5912_ _5912_/A1 _5909_/Z _5911_/I _9662_/D PHY_9/VDD PHY_9/VDD VSUBS VSUBS gf180mcu_fd_sc_mcu7t5v0__nor3_1
X_5843_ _9643_/Q _9523_/Q _5845_/A2 PHY_9/VDD PHY_9/VDD VSUBS VSUBS gf180mcu_fd_sc_mcu7t5v0__nand2_1
X_8631_ _8380_/Z _8630_/Z _8636_/A3 PHY_9/VDD PHY_9/VDD VSUBS VSUBS gf180mcu_fd_sc_mcu7t5v0__nand2_1
X_8562_ _8509_/Z _8510_/Z _8561_/B _8598_/A2 PHY_9/VDD PHY_9/VDD VSUBS VSUBS gf180mcu_fd_sc_mcu7t5v0__nand3_1
X_5774_ _7007_/B _5782_/A2 _5782_/B1 PHY_9/VDD PHY_9/VDD VSUBS VSUBS gf180mcu_fd_sc_mcu7t5v0__nand2_2
X_7513_ _7513_/A1 _7535_/A3 _7518_/A2 PHY_9/VDD PHY_9/VDD VSUBS VSUBS gf180mcu_fd_sc_mcu7t5v0__xnor2_1
X_8493_ _8391_/C _8479_/Z _8486_/Z _8493_/B2 _9317_/C _8494_/A2 PHY_9/VDD PHY_9/VDD
+ VSUBS VSUBS gf180mcu_fd_sc_mcu7t5v0__oai221_1
X_4725_ _9911_/Q _8343_/A1 PHY_9/VDD PHY_9/VDD VSUBS VSUBS gf180mcu_fd_sc_mcu7t5v0__clkinv_1
X_7444_ _9873_/Q _9356_/C _7487_/A1 PHY_9/VDD PHY_9/VDD VSUBS VSUBS gf180mcu_fd_sc_mcu7t5v0__nand2_1
X_7375_ _7706_/A2 _7396_/A1 _7582_/C _7376_/B2 PHY_9/VDD PHY_9/VDD VSUBS VSUBS gf180mcu_fd_sc_mcu7t5v0__aoi21_1
X_6326_ _9399_/Q _9036_/A2 _7695_/B _6327_/B PHY_9/VDD PHY_9/VDD VSUBS VSUBS gf180mcu_fd_sc_mcu7t5v0__oai21_1
X_9114_ _9969_/Q _9133_/A1 _9111_/Z _9114_/Z PHY_9/VDD PHY_9/VDD VSUBS VSUBS gf180mcu_fd_sc_mcu7t5v0__xor3_1
X_9045_ _9327_/A1 _9904_/Q _9506_/Q _9044_/Z _9270_/B _9091_/A2 PHY_9/VDD PHY_9/VDD
+ VSUBS VSUBS gf180mcu_fd_sc_mcu7t5v0__aoi221_4
X_6257_ _9487_/Q _6287_/A2 _6287_/B1 _9520_/Q _6259_/A1 PHY_9/VDD PHY_9/VDD VSUBS
+ VSUBS gf180mcu_fd_sc_mcu7t5v0__aoi22_1
X_6188_ _9422_/Q _6288_/A2 _6287_/A2 _9570_/Q _6189_/A2 PHY_9/VDD PHY_9/VDD VSUBS
+ VSUBS gf180mcu_fd_sc_mcu7t5v0__aoi22_1
X_5208_ _9522_/Q _5208_/A2 _5209_/B PHY_9/VDD PHY_9/VDD VSUBS VSUBS gf180mcu_fd_sc_mcu7t5v0__nand2_1
X_5139_ _9771_/Q _5439_/A2 _5202_/B1 _9492_/Q _5139_/C _5480_/A1 PHY_9/VDD PHY_9/VDD
+ VSUBS VSUBS gf180mcu_fd_sc_mcu7t5v0__aoi221_4
X_9947_ _9947_/D _9948_/CLK _9947_/Q PHY_9/VDD PHY_9/VDD VSUBS VSUBS gf180mcu_fd_sc_mcu7t5v0__dffq_1
X_9878_ _9878_/D _9948_/CLK _9878_/Q PHY_9/VDD PHY_9/VDD VSUBS VSUBS gf180mcu_fd_sc_mcu7t5v0__dffq_1
X_8829_ _9957_/Q _8844_/A2 _8848_/A2 PHY_9/VDD PHY_9/VDD VSUBS VSUBS gf180mcu_fd_sc_mcu7t5v0__nor2_1
X_5490_ _5490_/A1 _5493_/B _5490_/B _9456_/D PHY_9/VDD PHY_9/VDD VSUBS VSUBS gf180mcu_fd_sc_mcu7t5v0__aoi21_1
X_7160_ _7160_/A1 _7160_/A2 _7190_/A2 PHY_9/VDD PHY_9/VDD VSUBS VSUBS gf180mcu_fd_sc_mcu7t5v0__xnor2_1
X_6111_ _6111_/A1 _6111_/A2 _6115_/B1 PHY_9/VDD PHY_9/VDD VSUBS VSUBS gf180mcu_fd_sc_mcu7t5v0__nand2_1
X_7091_ _9227_/A1 _7091_/A2 _7132_/A1 PHY_9/VDD PHY_9/VDD VSUBS VSUBS gf180mcu_fd_sc_mcu7t5v0__nor2_1
X_6042_ _5388_/Z _6049_/A2 _6049_/B1 _6042_/B2 _9754_/D PHY_9/VDD PHY_9/VDD VSUBS
+ VSUBS gf180mcu_fd_sc_mcu7t5v0__oai22_1
X_9801_ _9801_/D _9801_/CLK _9801_/Q PHY_9/VDD PHY_9/VDD VSUBS VSUBS gf180mcu_fd_sc_mcu7t5v0__dffq_1
X_7993_ _9911_/Q _7703_/Z _7993_/B1 _9843_/Q _7995_/B1 PHY_9/VDD PHY_9/VDD VSUBS VSUBS
+ gf180mcu_fd_sc_mcu7t5v0__aoi22_1
X_6944_ _9842_/Q _6942_/Z _6962_/A2 PHY_9/VDD PHY_9/VDD VSUBS VSUBS gf180mcu_fd_sc_mcu7t5v0__nor2_1
X_9732_ _9732_/D _9800_/CLK _9732_/Q PHY_9/VDD PHY_9/VDD VSUBS VSUBS gf180mcu_fd_sc_mcu7t5v0__dffq_1
X_9663_ _9663_/D _9972_/CLK _9663_/Q PHY_9/VDD PHY_9/VDD VSUBS VSUBS gf180mcu_fd_sc_mcu7t5v0__dffq_1
X_6875_ _9810_/Q _6974_/A2 _6875_/Z PHY_9/VDD PHY_9/VDD VSUBS VSUBS gf180mcu_fd_sc_mcu7t5v0__and2_1
X_8614_ _8615_/A2 _8615_/A3 _8642_/A2 PHY_9/VDD PHY_9/VDD VSUBS VSUBS gf180mcu_fd_sc_mcu7t5v0__nand2_1
X_9594_ _9594_/D _9939_/CLK _9594_/Q PHY_9/VDD PHY_9/VDD VSUBS VSUBS gf180mcu_fd_sc_mcu7t5v0__dffq_1
X_5826_ _9525_/Q _9522_/Q _5826_/B _5828_/A2 PHY_9/VDD PHY_9/VDD VSUBS VSUBS gf180mcu_fd_sc_mcu7t5v0__oai21_1
X_5757_ _8695_/A1 _5759_/A2 _5759_/B1 _5757_/B2 _9587_/D PHY_9/VDD PHY_9/VDD VSUBS
+ VSUBS gf180mcu_fd_sc_mcu7t5v0__oai22_1
X_8545_ _9924_/Q _9923_/Q _8646_/B1 PHY_9/VDD PHY_9/VDD VSUBS VSUBS gf180mcu_fd_sc_mcu7t5v0__nor2_2
X_4708_ _9363_/Q _5240_/A1 PHY_9/VDD PHY_9/VDD VSUBS VSUBS gf180mcu_fd_sc_mcu7t5v0__clkinv_1
X_8476_ _8476_/A1 _8476_/A2 _8487_/A2 PHY_9/VDD PHY_9/VDD VSUBS VSUBS gf180mcu_fd_sc_mcu7t5v0__xnor2_1
X_7427_ _8430_/A1 _7445_/A1 _7424_/Z _7427_/Z PHY_9/VDD PHY_9/VDD VSUBS VSUBS gf180mcu_fd_sc_mcu7t5v0__xor3_1
X_5688_ _9544_/Q _5684_/Z _5700_/B _5689_/A2 PHY_9/VDD PHY_9/VDD VSUBS VSUBS gf180mcu_fd_sc_mcu7t5v0__oai21_1
X_7358_ _9867_/Q _7370_/A2 _7667_/I0 PHY_9/VDD PHY_9/VDD VSUBS VSUBS gf180mcu_fd_sc_mcu7t5v0__nor2_1
X_7289_ _7289_/A1 _7289_/A2 _7289_/B _7308_/A1 PHY_9/VDD PHY_9/VDD VSUBS VSUBS gf180mcu_fd_sc_mcu7t5v0__oai21_1
X_6309_ _8693_/A1 _6313_/A2 _6313_/B1 _6309_/B2 _9789_/D PHY_9/VDD PHY_9/VDD VSUBS
+ VSUBS gf180mcu_fd_sc_mcu7t5v0__oai22_1
X_9028_ _9058_/A1 _9036_/A2 _9028_/B _9962_/D PHY_9/VDD PHY_9/VDD VSUBS VSUBS gf180mcu_fd_sc_mcu7t5v0__aoi21_1
X_4990_ _9826_/Q _6661_/B2 PHY_9/VDD PHY_9/VDD VSUBS VSUBS gf180mcu_fd_sc_mcu7t5v0__clkinv_1
X_6660_ _8692_/A1 _6665_/A2 _6665_/B1 _6660_/B2 _9825_/D PHY_9/VDD PHY_9/VDD VSUBS
+ VSUBS gf180mcu_fd_sc_mcu7t5v0__oai22_1
X_6591_ _6592_/A1 _6589_/Z _6623_/A2 _6640_/I1 PHY_9/VDD PHY_9/VDD VSUBS VSUBS gf180mcu_fd_sc_mcu7t5v0__nand3_1
X_5611_ _9770_/Q _5561_/I _5613_/A1 PHY_9/VDD PHY_9/VDD VSUBS VSUBS gf180mcu_fd_sc_mcu7t5v0__nand2_1
X_5542_ _5973_/C _5542_/A2 _9475_/D PHY_9/VDD PHY_9/VDD VSUBS VSUBS gf180mcu_fd_sc_mcu7t5v0__nor2_1
X_8330_ _8331_/A1 _8329_/Z _8330_/B _8331_/B PHY_9/VDD PHY_9/VDD VSUBS VSUBS gf180mcu_fd_sc_mcu7t5v0__aoi21_1
X_8261_ _8214_/Z _8261_/A2 _8261_/B _8263_/A2 PHY_9/VDD PHY_9/VDD VSUBS VSUBS gf180mcu_fd_sc_mcu7t5v0__aoi21_1
X_5473_ _5490_/A1 _5495_/B _5473_/B _9448_/D PHY_9/VDD PHY_9/VDD VSUBS VSUBS gf180mcu_fd_sc_mcu7t5v0__aoi21_1
X_7212_ _7213_/A1 _7211_/Z _7237_/B PHY_9/VDD PHY_9/VDD VSUBS VSUBS gf180mcu_fd_sc_mcu7t5v0__and2_1
X_8192_ _8097_/Z _8192_/A2 _8311_/A2 _8293_/B _8194_/A2 PHY_9/VDD PHY_9/VDD VSUBS
+ VSUBS gf180mcu_fd_sc_mcu7t5v0__oai31_1
X_7143_ _7143_/A1 _7124_/Z _7143_/B _7189_/A1 PHY_9/VDD PHY_9/VDD VSUBS VSUBS gf180mcu_fd_sc_mcu7t5v0__aoi21_1
X_7074_ _7074_/A1 _7074_/A2 _7106_/A1 PHY_9/VDD PHY_9/VDD VSUBS VSUBS gf180mcu_fd_sc_mcu7t5v0__nor2_1
X_6025_ _8693_/A1 _6029_/A2 _6029_/B1 _6025_/B2 _9741_/D PHY_9/VDD PHY_9/VDD VSUBS
+ VSUBS gf180mcu_fd_sc_mcu7t5v0__oai22_1
X_9715_ _9715_/D _9830_/CLK _9715_/Q PHY_9/VDD PHY_9/VDD VSUBS VSUBS gf180mcu_fd_sc_mcu7t5v0__dffq_1
X_7976_ _8010_/B _7976_/A2 _7976_/B _8004_/B _7977_/B PHY_9/VDD PHY_9/VDD VSUBS VSUBS
+ gf180mcu_fd_sc_mcu7t5v0__oai211_1
X_6927_ _9811_/Q _6974_/A2 _6978_/B2 PHY_9/VDD PHY_9/VDD VSUBS VSUBS gf180mcu_fd_sc_mcu7t5v0__nand2_1
X_6858_ _6858_/A1 _6858_/A2 _6858_/B _6858_/C _6859_/A2 PHY_9/VDD PHY_9/VDD VSUBS
+ VSUBS gf180mcu_fd_sc_mcu7t5v0__oai211_1
X_9646_ _9646_/D _9972_/CLK _9646_/Q PHY_9/VDD PHY_9/VDD VSUBS VSUBS gf180mcu_fd_sc_mcu7t5v0__dffq_1
X_9577_ _9577_/D _9940_/CLK _9577_/Q PHY_9/VDD PHY_9/VDD VSUBS VSUBS gf180mcu_fd_sc_mcu7t5v0__dffq_1
X_5809_ _8692_/A1 _5814_/A2 _5814_/B1 _5809_/B2 _9625_/D PHY_9/VDD PHY_9/VDD VSUBS
+ VSUBS gf180mcu_fd_sc_mcu7t5v0__oai22_1
X_6789_ _6777_/I _6789_/A2 _6789_/Z PHY_9/VDD PHY_9/VDD VSUBS VSUBS gf180mcu_fd_sc_mcu7t5v0__xor2_1
X_8528_ _9811_/Q _8527_/Z _8580_/A1 PHY_9/VDD PHY_9/VDD VSUBS VSUBS gf180mcu_fd_sc_mcu7t5v0__nand2_1
X_8459_ _9357_/B _8459_/A2 _9927_/D PHY_9/VDD PHY_9/VDD VSUBS VSUBS gf180mcu_fd_sc_mcu7t5v0__nor2_1
X_7830_ _7974_/A1 _7944_/A1 _7830_/B1 _7830_/B2 _7830_/C _7831_/B PHY_9/VDD PHY_9/VDD
+ VSUBS VSUBS gf180mcu_fd_sc_mcu7t5v0__oai221_2
X_4973_ _9789_/Q _6309_/B2 PHY_9/VDD PHY_9/VDD VSUBS VSUBS gf180mcu_fd_sc_mcu7t5v0__clkinv_1
X_7761_ _7761_/A1 _7761_/A2 _7761_/B1 _7761_/B2 _7761_/C _7762_/C PHY_9/VDD PHY_9/VDD
+ VSUBS VSUBS gf180mcu_fd_sc_mcu7t5v0__oai221_1
X_6712_ _9831_/Q _6752_/A2 _6948_/B PHY_9/VDD PHY_9/VDD VSUBS VSUBS gf180mcu_fd_sc_mcu7t5v0__nand2_2
X_9500_ _9500_/D _9974_/CLK _9500_/Q PHY_9/VDD PHY_9/VDD VSUBS VSUBS gf180mcu_fd_sc_mcu7t5v0__dffq_2
X_7692_ _7724_/A1 _9034_/A2 _7692_/B _9888_/D PHY_9/VDD PHY_9/VDD VSUBS VSUBS gf180mcu_fd_sc_mcu7t5v0__aoi21_1
X_6643_ _7651_/A1 _6643_/A2 _6651_/A2 _6643_/Z PHY_9/VDD PHY_9/VDD VSUBS VSUBS gf180mcu_fd_sc_mcu7t5v0__xor3_1
X_9431_ _9431_/D _9901_/CLK _9431_/Q PHY_9/VDD PHY_9/VDD VSUBS VSUBS gf180mcu_fd_sc_mcu7t5v0__dffq_1
X_6574_ _6574_/A1 _6574_/A2 _6594_/A1 PHY_9/VDD PHY_9/VDD VSUBS VSUBS gf180mcu_fd_sc_mcu7t5v0__xnor2_1
X_9362_ _9362_/D _9972_/CLK _9362_/Q PHY_9/VDD PHY_9/VDD VSUBS VSUBS gf180mcu_fd_sc_mcu7t5v0__dffq_1
X_8313_ _8313_/A1 _8313_/A2 _8313_/B _8323_/A1 PHY_9/VDD PHY_9/VDD VSUBS VSUBS gf180mcu_fd_sc_mcu7t5v0__oai21_1
X_9293_ _9320_/B _9293_/A2 _9320_/A2 PHY_9/VDD PHY_9/VDD VSUBS VSUBS gf180mcu_fd_sc_mcu7t5v0__nand2_1
X_5525_ _9732_/Q _9736_/Q _9723_/Q _5525_/Z PHY_9/VDD PHY_9/VDD VSUBS VSUBS gf180mcu_fd_sc_mcu7t5v0__or3_2
X_5456_ _5490_/A1 _5458_/A2 _5456_/B _9440_/D PHY_9/VDD PHY_9/VDD VSUBS VSUBS gf180mcu_fd_sc_mcu7t5v0__aoi21_1
X_8244_ _6558_/B _8242_/Z _8245_/I PHY_9/VDD PHY_9/VDD VSUBS VSUBS gf180mcu_fd_sc_mcu7t5v0__xor2_1
X_8175_ _8175_/A1 _8179_/A2 _8175_/B1 _8175_/B2 _8181_/A1 PHY_9/VDD PHY_9/VDD VSUBS
+ VSUBS gf180mcu_fd_sc_mcu7t5v0__aoi22_1
X_5387_ _6089_/B _5407_/B2 _5407_/A2 PHY_9/VDD PHY_9/VDD VSUBS VSUBS gf180mcu_fd_sc_mcu7t5v0__nand2_2
X_7126_ _7019_/I _7254_/A2 _7290_/A2 _7172_/A2 PHY_9/VDD PHY_9/VDD VSUBS VSUBS gf180mcu_fd_sc_mcu7t5v0__nor3_1
X_7057_ _7281_/A1 _7084_/A2 _7057_/B _7058_/B PHY_9/VDD PHY_9/VDD VSUBS VSUBS gf180mcu_fd_sc_mcu7t5v0__oai21_1
X_6008_ _5406_/Z _6008_/A2 _6008_/B1 _6008_/B2 _9713_/D PHY_9/VDD PHY_9/VDD VSUBS
+ VSUBS gf180mcu_fd_sc_mcu7t5v0__oai22_1
X_7959_ _7959_/A1 _7957_/Z _7959_/Z PHY_9/VDD PHY_9/VDD VSUBS VSUBS gf180mcu_fd_sc_mcu7t5v0__xor2_1
X_9629_ _9629_/D _9948_/CLK _9629_/Q PHY_9/VDD PHY_9/VDD VSUBS VSUBS gf180mcu_fd_sc_mcu7t5v0__dffq_1
X_6290_ _6656_/A2 _6290_/A2 _6290_/B1 _6290_/B2 _6290_/C _6292_/A2 PHY_9/VDD PHY_9/VDD
+ VSUBS VSUBS gf180mcu_fd_sc_mcu7t5v0__aoi221_1
X_5310_ _5310_/A1 _5318_/A2 _5310_/B _9393_/D PHY_9/VDD PHY_9/VDD VSUBS VSUBS gf180mcu_fd_sc_mcu7t5v0__aoi21_1
X_5241_ _9461_/Q _5248_/A2 rst_n _5242_/B PHY_9/VDD PHY_9/VDD VSUBS VSUBS gf180mcu_fd_sc_mcu7t5v0__oai21_1
X_5172_ _5172_/A1 _9477_/Q _5173_/A2 PHY_9/VDD PHY_9/VDD VSUBS VSUBS gf180mcu_fd_sc_mcu7t5v0__nand2_1
X_8931_ _8878_/Z _8931_/A2 _8931_/B _8975_/A2 PHY_9/VDD PHY_9/VDD VSUBS VSUBS gf180mcu_fd_sc_mcu7t5v0__oai21_1
X_8862_ _8863_/A1 _8861_/Z _8893_/B PHY_9/VDD PHY_9/VDD VSUBS VSUBS gf180mcu_fd_sc_mcu7t5v0__or2_1
X_8793_ _9956_/Q _8792_/Z _8793_/Z PHY_9/VDD PHY_9/VDD VSUBS VSUBS gf180mcu_fd_sc_mcu7t5v0__or2_1
X_7813_ _7838_/A1 _7813_/A2 _7813_/Z PHY_9/VDD PHY_9/VDD VSUBS VSUBS gf180mcu_fd_sc_mcu7t5v0__xor2_1
X_7744_ _7988_/A2 _7785_/B _7748_/A3 PHY_9/VDD PHY_9/VDD VSUBS VSUBS gf180mcu_fd_sc_mcu7t5v0__nor2_1
X_4956_ _9880_/Q _7681_/B2 PHY_9/VDD PHY_9/VDD VSUBS VSUBS gf180mcu_fd_sc_mcu7t5v0__clkinv_1
X_4887_ _9607_/Q _5787_/B2 PHY_9/VDD PHY_9/VDD VSUBS VSUBS gf180mcu_fd_sc_mcu7t5v0__clkinv_1
X_7675_ _7582_/C _7675_/A2 _9356_/C _7676_/B2 PHY_9/VDD PHY_9/VDD VSUBS VSUBS gf180mcu_fd_sc_mcu7t5v0__aoi21_1
X_6626_ _9808_/Q _6646_/A1 _6633_/A1 PHY_9/VDD PHY_9/VDD VSUBS VSUBS gf180mcu_fd_sc_mcu7t5v0__nand2_1
X_9414_ _9414_/D _9901_/CLK _9414_/Q PHY_9/VDD PHY_9/VDD VSUBS VSUBS gf180mcu_fd_sc_mcu7t5v0__dffq_1
X_6557_ _6650_/A2 _6634_/A2 _6558_/A2 PHY_9/VDD PHY_9/VDD VSUBS VSUBS gf180mcu_fd_sc_mcu7t5v0__nand2_1
X_9345_ _9814_/Q _9349_/A2 _9355_/A1 PHY_9/VDD PHY_9/VDD VSUBS VSUBS gf180mcu_fd_sc_mcu7t5v0__nor2_1
X_5508_ _5973_/C _5508_/A2 _9462_/D PHY_9/VDD PHY_9/VDD VSUBS VSUBS gf180mcu_fd_sc_mcu7t5v0__nor2_1
X_6488_ _6488_/A1 _6572_/A1 _6521_/A1 PHY_9/VDD PHY_9/VDD VSUBS VSUBS gf180mcu_fd_sc_mcu7t5v0__xnor2_1
X_9276_ _9276_/A1 _9276_/A2 _9276_/B _9292_/A1 PHY_9/VDD PHY_9/VDD VSUBS VSUBS gf180mcu_fd_sc_mcu7t5v0__aoi21_1
X_8227_ _8228_/A1 _8226_/Z _8264_/B PHY_9/VDD PHY_9/VDD VSUBS VSUBS gf180mcu_fd_sc_mcu7t5v0__nor2_1
X_5439_ _9777_/Q _5439_/A2 _5439_/B1 _5130_/I _5492_/A1 PHY_9/VDD PHY_9/VDD VSUBS
+ VSUBS gf180mcu_fd_sc_mcu7t5v0__aoi22_4
X_8158_ _8291_/A1 _8141_/Z _8191_/A2 _8158_/B2 _8158_/C _8159_/B PHY_9/VDD PHY_9/VDD
+ VSUBS VSUBS gf180mcu_fd_sc_mcu7t5v0__aoi221_1
X_7109_ _7109_/A1 _7299_/A2 _7109_/B1 _7109_/B2 _7293_/A2 PHY_9/VDD PHY_9/VDD VSUBS
+ VSUBS gf180mcu_fd_sc_mcu7t5v0__aoi22_4
X_8089_ _8089_/I _8093_/A3 PHY_9/VDD PHY_9/VDD VSUBS VSUBS gf180mcu_fd_sc_mcu7t5v0__clkinv_1
X_4810_ _9685_/Q _5966_/A1 PHY_9/VDD PHY_9/VDD VSUBS VSUBS gf180mcu_fd_sc_mcu7t5v0__clkinv_1
X_5790_ _8693_/A1 _5794_/A2 _5794_/B1 _5790_/B2 _9610_/D PHY_9/VDD PHY_9/VDD VSUBS
+ VSUBS gf180mcu_fd_sc_mcu7t5v0__oai22_1
X_4741_ _9894_/Q _6775_/B2 PHY_9/VDD PHY_9/VDD VSUBS VSUBS gf180mcu_fd_sc_mcu7t5v0__clkinv_1
X_7460_ _9808_/Q _9807_/Q _7657_/A2 _7654_/A2 _7493_/B PHY_9/VDD PHY_9/VDD VSUBS VSUBS
+ gf180mcu_fd_sc_mcu7t5v0__and4_1
X_6411_ _9816_/Q _9317_/C _9100_/B _6412_/B PHY_9/VDD PHY_9/VDD VSUBS VSUBS gf180mcu_fd_sc_mcu7t5v0__oai21_1
X_7391_ _7667_/I1 _7396_/A2 _7668_/B _7392_/B PHY_9/VDD PHY_9/VDD VSUBS VSUBS gf180mcu_fd_sc_mcu7t5v0__aoi21_1
X_9130_ _9170_/C _9130_/A2 _9130_/B _9317_/C _9131_/A2 PHY_9/VDD PHY_9/VDD VSUBS VSUBS
+ gf180mcu_fd_sc_mcu7t5v0__oai211_1
X_6342_ _9510_/Q _9034_/A2 _8706_/B _6343_/B PHY_9/VDD PHY_9/VDD VSUBS VSUBS gf180mcu_fd_sc_mcu7t5v0__oai21_1
X_6273_ _6273_/A1 _6273_/A2 _6290_/B1 PHY_9/VDD PHY_9/VDD VSUBS VSUBS gf180mcu_fd_sc_mcu7t5v0__nand2_1
X_9061_ _9314_/A1 _9217_/A1 _9061_/B _9063_/C PHY_9/VDD PHY_9/VDD VSUBS VSUBS gf180mcu_fd_sc_mcu7t5v0__aoi21_1
X_5224_ _9473_/Q _9468_/Q _5224_/A3 _5224_/Z PHY_9/VDD PHY_9/VDD VSUBS VSUBS gf180mcu_fd_sc_mcu7t5v0__and3_4
X_8012_ _8012_/A1 _8012_/A2 _8013_/A3 PHY_9/VDD PHY_9/VDD VSUBS VSUBS gf180mcu_fd_sc_mcu7t5v0__nand2_1
X_5155_ _9656_/Q _9657_/Q _9661_/Q _5155_/A4 _5157_/A3 PHY_9/VDD PHY_9/VDD VSUBS VSUBS
+ gf180mcu_fd_sc_mcu7t5v0__nand4_2
X_9963_ _9963_/D _9972_/CLK _9963_/Q PHY_9/VDD PHY_9/VDD VSUBS VSUBS gf180mcu_fd_sc_mcu7t5v0__dffq_1
X_5086_ _9829_/Q _6664_/B2 PHY_9/VDD PHY_9/VDD VSUBS VSUBS gf180mcu_fd_sc_mcu7t5v0__clkinv_1
X_8914_ _8915_/A1 _8913_/Z _8941_/B PHY_9/VDD PHY_9/VDD VSUBS VSUBS gf180mcu_fd_sc_mcu7t5v0__nand2_1
X_9894_ _9894_/D _9957_/CLK _9894_/Q PHY_9/VDD PHY_9/VDD VSUBS VSUBS gf180mcu_fd_sc_mcu7t5v0__dffq_4
X_8845_ _8985_/C _8831_/Z _9317_/C _8846_/B2 PHY_9/VDD PHY_9/VDD VSUBS VSUBS gf180mcu_fd_sc_mcu7t5v0__oai21_1
X_5988_ _5406_/Z _5988_/A2 _5988_/B1 _5988_/B2 _9697_/D PHY_9/VDD PHY_9/VDD VSUBS
+ VSUBS gf180mcu_fd_sc_mcu7t5v0__oai22_1
X_8776_ _8985_/C _8776_/A2 _8779_/A2 _8776_/B2 _9356_/C _8777_/C PHY_9/VDD PHY_9/VDD
+ VSUBS VSUBS gf180mcu_fd_sc_mcu7t5v0__aoi221_1
X_4939_ _9568_/Q _5732_/B2 PHY_9/VDD PHY_9/VDD VSUBS VSUBS gf180mcu_fd_sc_mcu7t5v0__clkinv_1
X_7727_ _8720_/A2 _9090_/C _7988_/A2 _7770_/A1 PHY_9/VDD PHY_9/VDD VSUBS VSUBS gf180mcu_fd_sc_mcu7t5v0__nor3_2
X_7658_ _7658_/A1 _7658_/A2 _7658_/A3 _7658_/Z PHY_9/VDD PHY_9/VDD VSUBS VSUBS gf180mcu_fd_sc_mcu7t5v0__xor3_1
X_6609_ _9813_/Q _6609_/A2 _6609_/Z PHY_9/VDD PHY_9/VDD VSUBS VSUBS gf180mcu_fd_sc_mcu7t5v0__xor2_1
X_7589_ _7589_/A1 _7566_/Z _7589_/B _7642_/A1 PHY_9/VDD PHY_9/VDD VSUBS VSUBS gf180mcu_fd_sc_mcu7t5v0__aoi21_1
X_9328_ _9328_/A1 _9270_/B _9328_/B1 _9328_/B2 _9349_/A2 PHY_9/VDD PHY_9/VDD VSUBS
+ VSUBS gf180mcu_fd_sc_mcu7t5v0__aoi22_4
X_9259_ _9812_/Q _9322_/A2 _9261_/A2 PHY_9/VDD PHY_9/VDD VSUBS VSUBS gf180mcu_fd_sc_mcu7t5v0__nand2_1
X_6960_ _9842_/Q _9356_/C _6960_/B1 _6960_/B2 _6961_/A2 PHY_9/VDD PHY_9/VDD VSUBS
+ VSUBS gf180mcu_fd_sc_mcu7t5v0__aoi22_1
X_5911_ _5911_/I _5932_/B PHY_9/VDD PHY_9/VDD VSUBS VSUBS gf180mcu_fd_sc_mcu7t5v0__clkinv_2
X_6891_ _6941_/A1 _6941_/A2 _6891_/Z PHY_9/VDD PHY_9/VDD VSUBS VSUBS gf180mcu_fd_sc_mcu7t5v0__xor2_1
X_5842_ _5842_/A1 _5842_/A2 _9641_/D PHY_9/VDD PHY_9/VDD VSUBS VSUBS gf180mcu_fd_sc_mcu7t5v0__nor2_1
X_8630_ _8665_/A1 _8629_/Z _8630_/Z PHY_9/VDD PHY_9/VDD VSUBS VSUBS gf180mcu_fd_sc_mcu7t5v0__xor2_1
X_5773_ _7327_/A1 _6283_/A1 _5782_/A2 PHY_9/VDD PHY_9/VDD VSUBS VSUBS gf180mcu_fd_sc_mcu7t5v0__nand2_4
X_8561_ _8509_/Z _8510_/Z _8561_/B _8598_/B PHY_9/VDD PHY_9/VDD VSUBS VSUBS gf180mcu_fd_sc_mcu7t5v0__aoi21_1
X_7512_ _7512_/A1 _7510_/Z _7535_/A3 PHY_9/VDD PHY_9/VDD VSUBS VSUBS gf180mcu_fd_sc_mcu7t5v0__xnor2_1
X_4724_ _9368_/Q _5252_/A1 PHY_9/VDD PHY_9/VDD VSUBS VSUBS gf180mcu_fd_sc_mcu7t5v0__clkinv_1
X_8492_ _8492_/A1 _8492_/A2 _8492_/A3 _8493_/B2 PHY_9/VDD PHY_9/VDD VSUBS VSUBS gf180mcu_fd_sc_mcu7t5v0__nand3_1
X_7443_ _7443_/A1 _7443_/A2 _9357_/B _9872_/D PHY_9/VDD PHY_9/VDD VSUBS VSUBS gf180mcu_fd_sc_mcu7t5v0__aoi21_1
X_7374_ _9870_/Q _7369_/B _7404_/A1 PHY_9/VDD PHY_9/VDD VSUBS VSUBS gf180mcu_fd_sc_mcu7t5v0__nand2_1
X_6325_ _6376_/A3 _9036_/A2 _6325_/B _9802_/D PHY_9/VDD PHY_9/VDD VSUBS VSUBS gf180mcu_fd_sc_mcu7t5v0__aoi21_1
X_9113_ _9969_/Q _9111_/Z _9133_/B PHY_9/VDD PHY_9/VDD VSUBS VSUBS gf180mcu_fd_sc_mcu7t5v0__nand2_1
X_9044_ _9966_/Q _9965_/Q _9044_/Z PHY_9/VDD PHY_9/VDD VSUBS VSUBS gf180mcu_fd_sc_mcu7t5v0__and2_4
X_6256_ _6256_/A1 _6256_/A2 _6261_/B1 PHY_9/VDD PHY_9/VDD VSUBS VSUBS gf180mcu_fd_sc_mcu7t5v0__nand2_1
X_6187_ _9790_/Q _6287_/B1 _6288_/B1 _9554_/Q _6189_/A1 PHY_9/VDD PHY_9/VDD VSUBS
+ VSUBS gf180mcu_fd_sc_mcu7t5v0__aoi22_1
X_5207_ _5961_/B _5207_/A2 _9523_/D PHY_9/VDD PHY_9/VDD VSUBS VSUBS gf180mcu_fd_sc_mcu7t5v0__and2_1
X_5138_ _9470_/Q _5530_/A1 _5567_/A1 _5202_/B1 PHY_9/VDD PHY_9/VDD VSUBS VSUBS gf180mcu_fd_sc_mcu7t5v0__nor3_4
X_9946_ _9946_/D _9948_/CLK _9946_/Q PHY_9/VDD PHY_9/VDD VSUBS VSUBS gf180mcu_fd_sc_mcu7t5v0__dffq_1
X_5069_ _9792_/Q _6312_/B2 PHY_9/VDD PHY_9/VDD VSUBS VSUBS gf180mcu_fd_sc_mcu7t5v0__clkinv_1
X_9877_ _9877_/D _9907_/CLK _9877_/Q PHY_9/VDD PHY_9/VDD VSUBS VSUBS gf180mcu_fd_sc_mcu7t5v0__dffq_1
X_8828_ _8828_/A1 _8826_/Z _8844_/A2 PHY_9/VDD PHY_9/VDD VSUBS VSUBS gf180mcu_fd_sc_mcu7t5v0__xnor2_2
X_8759_ _8760_/A1 _8758_/Z _8759_/Z PHY_9/VDD PHY_9/VDD VSUBS VSUBS gf180mcu_fd_sc_mcu7t5v0__and2_1
X_6110_ _9632_/Q _6288_/A2 _6288_/B1 _9616_/Q _6111_/A2 PHY_9/VDD PHY_9/VDD VSUBS
+ VSUBS gf180mcu_fd_sc_mcu7t5v0__aoi22_1
X_7090_ _7290_/A2 _7092_/A3 _7091_/A2 PHY_9/VDD PHY_9/VDD VSUBS VSUBS gf180mcu_fd_sc_mcu7t5v0__xnor2_1
X_6041_ _6089_/B _6049_/A2 _6049_/B1 PHY_9/VDD PHY_9/VDD VSUBS VSUBS gf180mcu_fd_sc_mcu7t5v0__nand2_2
X_9800_ _9800_/D _9800_/CLK _9800_/Q PHY_9/VDD PHY_9/VDD VSUBS VSUBS gf180mcu_fd_sc_mcu7t5v0__dffq_1
X_7992_ _9809_/Q _7992_/A2 _7998_/A1 PHY_9/VDD PHY_9/VDD VSUBS VSUBS gf180mcu_fd_sc_mcu7t5v0__nand2_1
X_6943_ _9842_/Q _6942_/Z _6962_/B PHY_9/VDD PHY_9/VDD VSUBS VSUBS gf180mcu_fd_sc_mcu7t5v0__nand2_1
X_9731_ _9731_/D _9800_/CLK _9731_/Q PHY_9/VDD PHY_9/VDD VSUBS VSUBS gf180mcu_fd_sc_mcu7t5v0__dffq_4
X_6874_ _6760_/Z _6874_/A2 _6874_/B _6883_/A1 PHY_9/VDD PHY_9/VDD VSUBS VSUBS gf180mcu_fd_sc_mcu7t5v0__aoi21_2
X_9662_ _9662_/D _9972_/CLK _9662_/Q PHY_9/VDD PHY_9/VDD VSUBS VSUBS gf180mcu_fd_sc_mcu7t5v0__dffq_1
X_8613_ _8615_/A2 _8615_/A3 _8642_/B PHY_9/VDD PHY_9/VDD VSUBS VSUBS gf180mcu_fd_sc_mcu7t5v0__nor2_1
X_5825_ _9525_/Q _9522_/Q _5880_/A2 PHY_9/VDD PHY_9/VDD VSUBS VSUBS gf180mcu_fd_sc_mcu7t5v0__nor2_1
X_9593_ _9593_/D _9939_/CLK _9593_/Q PHY_9/VDD PHY_9/VDD VSUBS VSUBS gf180mcu_fd_sc_mcu7t5v0__dffq_1
X_5756_ _5399_/Z _5759_/A2 _5759_/B1 _5756_/B2 _9586_/D PHY_9/VDD PHY_9/VDD VSUBS
+ VSUBS gf180mcu_fd_sc_mcu7t5v0__oai22_1
X_8544_ _9959_/Q _9924_/Q _9923_/Q _8547_/A1 PHY_9/VDD PHY_9/VDD VSUBS VSUBS gf180mcu_fd_sc_mcu7t5v0__nand3_2
X_5687_ _9544_/Q _5684_/Z _5687_/Z PHY_9/VDD PHY_9/VDD VSUBS VSUBS gf180mcu_fd_sc_mcu7t5v0__and2_1
X_4707_ _9949_/Q _8740_/A3 PHY_9/VDD PHY_9/VDD VSUBS VSUBS gf180mcu_fd_sc_mcu7t5v0__inv_3
X_8475_ _8475_/A1 _8438_/Z _8476_/A2 _8519_/A1 PHY_9/VDD PHY_9/VDD VSUBS VSUBS gf180mcu_fd_sc_mcu7t5v0__nand3_1
X_7426_ _9872_/Q _7424_/Z _7445_/B PHY_9/VDD PHY_9/VDD VSUBS VSUBS gf180mcu_fd_sc_mcu7t5v0__nand2_1
X_7357_ _9866_/Q _7371_/A3 _7370_/A2 PHY_9/VDD PHY_9/VDD VSUBS VSUBS gf180mcu_fd_sc_mcu7t5v0__nand2_1
X_7288_ _7217_/Z _7288_/A2 _7288_/B _7310_/A1 PHY_9/VDD PHY_9/VDD VSUBS VSUBS gf180mcu_fd_sc_mcu7t5v0__aoi21_1
X_6308_ _8692_/A1 _6313_/A2 _6313_/B1 _6308_/B2 _9788_/D PHY_9/VDD PHY_9/VDD VSUBS
+ VSUBS gf180mcu_fd_sc_mcu7t5v0__oai22_1
X_6239_ _9704_/Q _6287_/A2 _6287_/B1 _9605_/Q _6241_/A1 PHY_9/VDD PHY_9/VDD VSUBS
+ VSUBS gf180mcu_fd_sc_mcu7t5v0__aoi22_1
X_9027_ _9358_/Q _9036_/A2 rst_n _9028_/B PHY_9/VDD PHY_9/VDD VSUBS VSUBS gf180mcu_fd_sc_mcu7t5v0__oai21_1
X_9929_ _9929_/D _9957_/CLK _9929_/Q PHY_9/VDD PHY_9/VDD VSUBS VSUBS gf180mcu_fd_sc_mcu7t5v0__dffq_2
X_6590_ _6579_/Z _6588_/Z _6623_/A2 PHY_9/VDD PHY_9/VDD VSUBS VSUBS gf180mcu_fd_sc_mcu7t5v0__nand2_1
X_5610_ _9328_/A1 _9036_/A2 _5610_/B _9505_/D PHY_9/VDD PHY_9/VDD VSUBS VSUBS gf180mcu_fd_sc_mcu7t5v0__aoi21_1
X_5541_ _9448_/Q _5525_/Z _5544_/A2 _9475_/Q _5542_/A2 PHY_9/VDD PHY_9/VDD VSUBS VSUBS
+ gf180mcu_fd_sc_mcu7t5v0__aoi22_1
X_8260_ _9807_/Q _8333_/A2 _8263_/A1 PHY_9/VDD PHY_9/VDD VSUBS VSUBS gf180mcu_fd_sc_mcu7t5v0__nand2_1
X_7211_ _7245_/A1 _7211_/A2 _7209_/B _7211_/Z PHY_9/VDD PHY_9/VDD VSUBS VSUBS gf180mcu_fd_sc_mcu7t5v0__xor3_1
X_5472_ _9448_/Q _5495_/B _5474_/B _5473_/B PHY_9/VDD PHY_9/VDD VSUBS VSUBS gf180mcu_fd_sc_mcu7t5v0__oai21_1
X_8191_ _8191_/A1 _8191_/A2 _8191_/Z PHY_9/VDD PHY_9/VDD VSUBS VSUBS gf180mcu_fd_sc_mcu7t5v0__and2_1
X_7142_ _7142_/A1 _7142_/A2 _9357_/B _9852_/D PHY_9/VDD PHY_9/VDD VSUBS VSUBS gf180mcu_fd_sc_mcu7t5v0__aoi21_1
X_7073_ _9851_/Q _9356_/C _7104_/A1 PHY_9/VDD PHY_9/VDD VSUBS VSUBS gf180mcu_fd_sc_mcu7t5v0__nand2_1
X_6024_ _8692_/A1 _6029_/A2 _6029_/B1 _6024_/B2 _9740_/D PHY_9/VDD PHY_9/VDD VSUBS
+ VSUBS gf180mcu_fd_sc_mcu7t5v0__oai22_1
X_7975_ _9813_/Q _8011_/A2 _7975_/B _7976_/B PHY_9/VDD PHY_9/VDD VSUBS VSUBS gf180mcu_fd_sc_mcu7t5v0__oai21_1
X_6926_ _6875_/Z _6926_/A2 _6926_/B _6934_/A2 PHY_9/VDD PHY_9/VDD VSUBS VSUBS gf180mcu_fd_sc_mcu7t5v0__aoi21_2
X_9714_ _9714_/D _9830_/CLK _9714_/Q PHY_9/VDD PHY_9/VDD VSUBS VSUBS gf180mcu_fd_sc_mcu7t5v0__dffq_1
X_6857_ _9811_/Q _6921_/A2 _6857_/B _6858_/B PHY_9/VDD PHY_9/VDD VSUBS VSUBS gf180mcu_fd_sc_mcu7t5v0__oai21_1
X_9645_ _9645_/D _9972_/CLK _9645_/Q PHY_9/VDD PHY_9/VDD VSUBS VSUBS gf180mcu_fd_sc_mcu7t5v0__dffq_1
X_6788_ _6777_/I _6789_/A2 _6834_/A2 PHY_9/VDD PHY_9/VDD VSUBS VSUBS gf180mcu_fd_sc_mcu7t5v0__nor2_1
X_9576_ _9576_/D _9940_/CLK _9576_/Q PHY_9/VDD PHY_9/VDD VSUBS VSUBS gf180mcu_fd_sc_mcu7t5v0__dffq_1
X_5808_ _8691_/A1 _5814_/A2 _5814_/B1 _5808_/B2 _9624_/D PHY_9/VDD PHY_9/VDD VSUBS
+ VSUBS gf180mcu_fd_sc_mcu7t5v0__oai22_1
X_5739_ _5739_/A1 _6066_/A1 _6276_/B PHY_9/VDD PHY_9/VDD VSUBS VSUBS gf180mcu_fd_sc_mcu7t5v0__nand2_2
X_8527_ _8600_/A2 _8577_/A1 _8527_/Z PHY_9/VDD PHY_9/VDD VSUBS VSUBS gf180mcu_fd_sc_mcu7t5v0__xor2_1
X_8458_ _9927_/Q _9356_/C _8458_/B _8459_/A2 PHY_9/VDD PHY_9/VDD VSUBS VSUBS gf180mcu_fd_sc_mcu7t5v0__aoi21_1
X_7409_ _7409_/A1 _7409_/A2 _7445_/A1 PHY_9/VDD PHY_9/VDD VSUBS VSUBS gf180mcu_fd_sc_mcu7t5v0__nor2_1
X_8389_ _8389_/A1 _8389_/A2 _8491_/C PHY_9/VDD PHY_9/VDD VSUBS VSUBS gf180mcu_fd_sc_mcu7t5v0__nor2_2
X_4972_ _9421_/Q _5398_/A1 PHY_9/VDD PHY_9/VDD VSUBS VSUBS gf180mcu_fd_sc_mcu7t5v0__clkinv_1
X_7760_ _7974_/A1 _7776_/B _7762_/B PHY_9/VDD PHY_9/VDD VSUBS VSUBS gf180mcu_fd_sc_mcu7t5v0__nor2_1
X_6711_ _6781_/A2 _6781_/A3 _6752_/B1 PHY_9/VDD PHY_9/VDD VSUBS VSUBS gf180mcu_fd_sc_mcu7t5v0__nand2_1
X_7691_ _9380_/Q _9034_/A2 _7695_/B _7692_/B PHY_9/VDD PHY_9/VDD VSUBS VSUBS gf180mcu_fd_sc_mcu7t5v0__oai21_1
X_6642_ _6642_/A1 _6642_/A2 _6651_/A2 PHY_9/VDD PHY_9/VDD VSUBS VSUBS gf180mcu_fd_sc_mcu7t5v0__xnor2_1
X_9430_ _9430_/D _9801_/CLK _9430_/Q PHY_9/VDD PHY_9/VDD VSUBS VSUBS gf180mcu_fd_sc_mcu7t5v0__dffq_1
X_9361_ _9361_/D _9972_/CLK _9361_/Q PHY_9/VDD PHY_9/VDD VSUBS VSUBS gf180mcu_fd_sc_mcu7t5v0__dffq_1
X_6573_ _9807_/Q _6646_/A1 _6574_/A2 _6637_/A1 PHY_9/VDD PHY_9/VDD VSUBS VSUBS gf180mcu_fd_sc_mcu7t5v0__nand3_1
X_8312_ _8314_/A2 _8312_/A2 _8312_/A3 _8324_/A2 PHY_9/VDD PHY_9/VDD VSUBS VSUBS gf180mcu_fd_sc_mcu7t5v0__xnor3_1
X_9292_ _9292_/A1 _9292_/A2 _9293_/A2 PHY_9/VDD PHY_9/VDD VSUBS VSUBS gf180mcu_fd_sc_mcu7t5v0__nand2_1
X_5524_ _5973_/C _5522_/B _9468_/D PHY_9/VDD PHY_9/VDD VSUBS VSUBS gf180mcu_fd_sc_mcu7t5v0__nor2_1
X_5455_ _9440_/Q _5458_/A2 _9035_/B _5456_/B PHY_9/VDD PHY_9/VDD VSUBS VSUBS gf180mcu_fd_sc_mcu7t5v0__oai21_1
X_8243_ _9812_/Q _8242_/Z _8292_/B PHY_9/VDD PHY_9/VDD VSUBS VSUBS gf180mcu_fd_sc_mcu7t5v0__and2_1
X_8174_ _8256_/A1 _8256_/A2 _8174_/Z PHY_9/VDD PHY_9/VDD VSUBS VSUBS gf180mcu_fd_sc_mcu7t5v0__xor2_1
X_7125_ _7143_/A1 _7124_/Z _7125_/Z PHY_9/VDD PHY_9/VDD VSUBS VSUBS gf180mcu_fd_sc_mcu7t5v0__xor2_1
X_5386_ _5372_/Z _7677_/A1 _5407_/B2 PHY_9/VDD PHY_9/VDD VSUBS VSUBS gf180mcu_fd_sc_mcu7t5v0__nand2_4
X_7056_ _7314_/I1 _7084_/A2 _7315_/B _7057_/B PHY_9/VDD PHY_9/VDD VSUBS VSUBS gf180mcu_fd_sc_mcu7t5v0__aoi21_1
X_6007_ _5404_/Z _6008_/A2 _6008_/B1 _6007_/B2 _9712_/D PHY_9/VDD PHY_9/VDD VSUBS
+ VSUBS gf180mcu_fd_sc_mcu7t5v0__oai22_1
X_7958_ _7959_/A1 _7957_/Z _8001_/A2 PHY_9/VDD PHY_9/VDD VSUBS VSUBS gf180mcu_fd_sc_mcu7t5v0__nand2_1
X_6909_ _6909_/A1 _6909_/A2 _9357_/B _9841_/D PHY_9/VDD PHY_9/VDD VSUBS VSUBS gf180mcu_fd_sc_mcu7t5v0__aoi21_1
X_7889_ _9809_/Q _7836_/Z _7944_/A2 PHY_9/VDD PHY_9/VDD VSUBS VSUBS gf180mcu_fd_sc_mcu7t5v0__nand2_1
X_9628_ _9628_/D _9948_/CLK _9628_/Q PHY_9/VDD PHY_9/VDD VSUBS VSUBS gf180mcu_fd_sc_mcu7t5v0__dffq_1
X_9559_ _9559_/D _9801_/CLK _9559_/Q PHY_9/VDD PHY_9/VDD VSUBS VSUBS gf180mcu_fd_sc_mcu7t5v0__dffq_1
X_5240_ _5240_/A1 _5248_/A2 _5240_/B _9363_/D PHY_9/VDD PHY_9/VDD VSUBS VSUBS gf180mcu_fd_sc_mcu7t5v0__aoi21_1
X_5171_ _9479_/Q _5170_/Z _5899_/A1 PHY_9/VDD PHY_9/VDD VSUBS VSUBS gf180mcu_fd_sc_mcu7t5v0__nand2_1
X_8930_ _8878_/Z _8931_/A2 _8931_/B _8930_/Z PHY_9/VDD PHY_9/VDD VSUBS VSUBS gf180mcu_fd_sc_mcu7t5v0__or3_1
X_8861_ _8904_/A1 _8861_/A2 _8858_/B _8861_/Z PHY_9/VDD PHY_9/VDD VSUBS VSUBS gf180mcu_fd_sc_mcu7t5v0__xor3_1
X_8792_ _8827_/A1 _8790_/Z _8792_/Z PHY_9/VDD PHY_9/VDD VSUBS VSUBS gf180mcu_fd_sc_mcu7t5v0__xor2_1
X_7812_ _7838_/A1 _7813_/A2 _7856_/A2 PHY_9/VDD PHY_9/VDD VSUBS VSUBS gf180mcu_fd_sc_mcu7t5v0__nor2_1
X_4955_ _9914_/Q _8348_/B2 PHY_9/VDD PHY_9/VDD VSUBS VSUBS gf180mcu_fd_sc_mcu7t5v0__clkinv_1
X_7743_ _9886_/Q _7743_/A2 _7966_/B PHY_9/VDD PHY_9/VDD VSUBS VSUBS gf180mcu_fd_sc_mcu7t5v0__nand2_2
X_4886_ _9615_/Q _5797_/B2 PHY_9/VDD PHY_9/VDD VSUBS VSUBS gf180mcu_fd_sc_mcu7t5v0__clkinv_1
X_7674_ _7674_/A1 _7662_/Z _7674_/B1 _7674_/B2 _7673_/Z _7674_/C2 _7675_/A2 PHY_9/VDD
+ PHY_9/VDD VSUBS VSUBS gf180mcu_fd_sc_mcu7t5v0__oai222_2
X_6625_ _9811_/Q _6625_/A2 _6631_/A2 PHY_9/VDD PHY_9/VDD VSUBS VSUBS gf180mcu_fd_sc_mcu7t5v0__nand2_1
X_9413_ _9413_/D _9901_/CLK _9413_/Q PHY_9/VDD PHY_9/VDD VSUBS VSUBS gf180mcu_fd_sc_mcu7t5v0__dffq_1
X_6556_ _6604_/A1 _6555_/Z _6556_/Z PHY_9/VDD PHY_9/VDD VSUBS VSUBS gf180mcu_fd_sc_mcu7t5v0__xor2_1
X_9344_ _9344_/A1 _9340_/Z _9355_/C PHY_9/VDD PHY_9/VDD VSUBS VSUBS gf180mcu_fd_sc_mcu7t5v0__nand2_1
X_9275_ _9275_/A1 _9275_/A2 _9275_/Z PHY_9/VDD PHY_9/VDD VSUBS VSUBS gf180mcu_fd_sc_mcu7t5v0__xor2_1
X_5507_ _9436_/Q _5498_/Z _5522_/B _9462_/Q _5507_/C _5508_/A2 PHY_9/VDD PHY_9/VDD
+ VSUBS VSUBS gf180mcu_fd_sc_mcu7t5v0__aoi221_1
X_6487_ _6487_/A1 _6529_/A1 _6567_/A1 PHY_9/VDD PHY_9/VDD VSUBS VSUBS gf180mcu_fd_sc_mcu7t5v0__nor2_1
X_8226_ _8226_/A1 _8270_/A1 _8274_/A1 _8226_/Z PHY_9/VDD PHY_9/VDD VSUBS VSUBS gf180mcu_fd_sc_mcu7t5v0__xor3_1
X_5438_ _5438_/I _5439_/B1 PHY_9/VDD PHY_9/VDD VSUBS VSUBS gf180mcu_fd_sc_mcu7t5v0__clkinv_1
X_5369_ _5369_/A1 _5201_/Z _5370_/B PHY_9/VDD PHY_9/VDD VSUBS VSUBS gf180mcu_fd_sc_mcu7t5v0__nor2_1
X_8157_ _8301_/A1 _8268_/A1 _8157_/B1 _8157_/B2 _8157_/C _8158_/C PHY_9/VDD PHY_9/VDD
+ VSUBS VSUBS gf180mcu_fd_sc_mcu7t5v0__oai221_1
X_7108_ _9848_/Q _9509_/Q _7109_/B2 PHY_9/VDD PHY_9/VDD VSUBS VSUBS gf180mcu_fd_sc_mcu7t5v0__nand2_1
X_8088_ _9808_/Q _8337_/B _8087_/Z _8291_/A1 _8156_/B _8089_/I PHY_9/VDD PHY_9/VDD
+ VSUBS VSUBS gf180mcu_fd_sc_mcu7t5v0__aoi221_1
X_7039_ _9849_/Q _7039_/A2 _7069_/A2 PHY_9/VDD PHY_9/VDD VSUBS VSUBS gf180mcu_fd_sc_mcu7t5v0__nand2_1
X_4740_ _9895_/Q _8166_/A2 PHY_9/VDD PHY_9/VDD VSUBS VSUBS gf180mcu_fd_sc_mcu7t5v0__clkinv_3
X_6410_ _6410_/A1 _6410_/A2 _6410_/B1 _6406_/C _6412_/A2 PHY_9/VDD PHY_9/VDD VSUBS
+ VSUBS gf180mcu_fd_sc_mcu7t5v0__oai22_1
X_7390_ _9808_/Q _7382_/Z _7396_/A2 PHY_9/VDD PHY_9/VDD VSUBS VSUBS gf180mcu_fd_sc_mcu7t5v0__nand2_1
X_6341_ _6471_/B _9034_/A2 _6341_/B _9810_/D PHY_9/VDD PHY_9/VDD VSUBS VSUBS gf180mcu_fd_sc_mcu7t5v0__aoi21_1
X_6272_ _9753_/Q _6288_/A2 _6288_/B1 _9769_/Q _6273_/A2 PHY_9/VDD PHY_9/VDD VSUBS
+ VSUBS gf180mcu_fd_sc_mcu7t5v0__aoi22_1
X_9060_ _9347_/I1 _9354_/A1 _9061_/B _9064_/A1 PHY_9/VDD PHY_9/VDD VSUBS VSUBS gf180mcu_fd_sc_mcu7t5v0__oai21_1
X_5223_ _5961_/B _9732_/Q _9728_/D PHY_9/VDD PHY_9/VDD VSUBS VSUBS gf180mcu_fd_sc_mcu7t5v0__and2_1
X_8011_ _7966_/B _8011_/A2 _8012_/A2 PHY_9/VDD PHY_9/VDD VSUBS VSUBS gf180mcu_fd_sc_mcu7t5v0__nand2_1
X_5154_ _9655_/Q _9658_/Q _5155_/A4 PHY_9/VDD PHY_9/VDD VSUBS VSUBS gf180mcu_fd_sc_mcu7t5v0__nor2_1
X_5085_ _9863_/Q _7335_/B2 PHY_9/VDD PHY_9/VDD VSUBS VSUBS gf180mcu_fd_sc_mcu7t5v0__clkinv_1
X_9962_ _9962_/D _9972_/CLK _9962_/Q PHY_9/VDD PHY_9/VDD VSUBS VSUBS gf180mcu_fd_sc_mcu7t5v0__dffq_2
X_8913_ _8903_/Z _8949_/A2 _8913_/Z PHY_9/VDD PHY_9/VDD VSUBS VSUBS gf180mcu_fd_sc_mcu7t5v0__xor2_1
X_9893_ _9893_/D _9957_/CLK _9893_/Q PHY_9/VDD PHY_9/VDD VSUBS VSUBS gf180mcu_fd_sc_mcu7t5v0__dffq_2
X_8844_ _8734_/I _8844_/A2 _8844_/B1 _8844_/B2 _8844_/C _8846_/B1 PHY_9/VDD PHY_9/VDD
+ VSUBS VSUBS gf180mcu_fd_sc_mcu7t5v0__aoi221_2
X_5987_ _5404_/Z _5988_/A2 _5988_/B1 _5987_/B2 _9696_/D PHY_9/VDD PHY_9/VDD VSUBS
+ VSUBS gf180mcu_fd_sc_mcu7t5v0__oai22_1
X_8775_ _8985_/C _8775_/A2 _8776_/B2 PHY_9/VDD PHY_9/VDD VSUBS VSUBS gf180mcu_fd_sc_mcu7t5v0__nor2_1
X_4938_ _9552_/Q _5710_/B2 PHY_9/VDD PHY_9/VDD VSUBS VSUBS gf180mcu_fd_sc_mcu7t5v0__clkinv_1
X_7726_ _9090_/C _7988_/A2 _7726_/B1 _7726_/B2 _7831_/C _7730_/A1 PHY_9/VDD PHY_9/VDD
+ VSUBS VSUBS gf180mcu_fd_sc_mcu7t5v0__aoi221_1
X_7657_ _9812_/Q _7657_/A2 _7658_/A3 PHY_9/VDD PHY_9/VDD VSUBS VSUBS gf180mcu_fd_sc_mcu7t5v0__nand2_1
X_4869_ _9523_/Q _5867_/A2 PHY_9/VDD PHY_9/VDD VSUBS VSUBS gf180mcu_fd_sc_mcu7t5v0__clkinv_4
X_6608_ _9813_/Q _6609_/A2 _6644_/B PHY_9/VDD PHY_9/VDD VSUBS VSUBS gf180mcu_fd_sc_mcu7t5v0__and2_1
X_7588_ _7588_/A1 _7568_/Z _7588_/B _7641_/A1 PHY_9/VDD PHY_9/VDD VSUBS VSUBS gf180mcu_fd_sc_mcu7t5v0__aoi21_1
X_6539_ _6540_/A1 _6540_/A2 _6567_/B PHY_9/VDD PHY_9/VDD VSUBS VSUBS gf180mcu_fd_sc_mcu7t5v0__and2_1
X_9327_ _9327_/A1 _9961_/Q _9327_/B _9328_/B2 PHY_9/VDD PHY_9/VDD VSUBS VSUBS gf180mcu_fd_sc_mcu7t5v0__oai21_2
X_9258_ _9354_/A1 _9256_/Z _9304_/A2 _9263_/A3 PHY_9/VDD PHY_9/VDD VSUBS VSUBS gf180mcu_fd_sc_mcu7t5v0__nand3_1
X_9189_ _9191_/A2 _9281_/A1 _9189_/Z PHY_9/VDD PHY_9/VDD VSUBS VSUBS gf180mcu_fd_sc_mcu7t5v0__or2_1
X_8209_ _8209_/A1 _8188_/Z _8209_/B _8255_/A1 PHY_9/VDD PHY_9/VDD VSUBS VSUBS gf180mcu_fd_sc_mcu7t5v0__aoi21_1
X_5910_ _9480_/Q _9478_/Q _9479_/Q _5967_/B _5911_/I PHY_9/VDD PHY_9/VDD VSUBS VSUBS
+ gf180mcu_fd_sc_mcu7t5v0__oai31_2
X_6890_ _6941_/A1 _6941_/A2 _6942_/A2 PHY_9/VDD PHY_9/VDD VSUBS VSUBS gf180mcu_fd_sc_mcu7t5v0__nand2_1
X_5841_ _9461_/Q _5867_/A2 _5841_/B _5842_/A2 PHY_9/VDD PHY_9/VDD VSUBS VSUBS gf180mcu_fd_sc_mcu7t5v0__aoi21_1
X_5772_ _6066_/A1 _5772_/A2 _6283_/A1 PHY_9/VDD PHY_9/VDD VSUBS VSUBS gf180mcu_fd_sc_mcu7t5v0__nor2_4
X_8560_ _8560_/A1 _8603_/B2 _8652_/A1 _8561_/B PHY_9/VDD PHY_9/VDD VSUBS VSUBS gf180mcu_fd_sc_mcu7t5v0__xor3_1
X_7511_ _7512_/A1 _7510_/Z _7535_/B PHY_9/VDD PHY_9/VDD VSUBS VSUBS gf180mcu_fd_sc_mcu7t5v0__nand2_1
X_4723_ _9920_/Q _8390_/A3 PHY_9/VDD PHY_9/VDD VSUBS VSUBS gf180mcu_fd_sc_mcu7t5v0__clkinv_3
X_8491_ _9810_/Q _8674_/A2 _8488_/Z _8673_/I0 _8491_/C _8492_/A3 PHY_9/VDD PHY_9/VDD
+ VSUBS VSUBS gf180mcu_fd_sc_mcu7t5v0__aoi221_1
X_7442_ _7582_/C _7427_/Z _7442_/B _9317_/C _7443_/A2 PHY_9/VDD PHY_9/VDD VSUBS VSUBS
+ gf180mcu_fd_sc_mcu7t5v0__oai211_1
X_7373_ _7373_/A1 _7373_/A2 _7376_/A2 PHY_9/VDD PHY_9/VDD VSUBS VSUBS gf180mcu_fd_sc_mcu7t5v0__nand2_1
X_6324_ _9398_/Q _9036_/A2 _7695_/B _6325_/B PHY_9/VDD PHY_9/VDD VSUBS VSUBS gf180mcu_fd_sc_mcu7t5v0__oai21_1
X_9112_ _9969_/Q _9111_/Z _9133_/A2 PHY_9/VDD PHY_9/VDD VSUBS VSUBS gf180mcu_fd_sc_mcu7t5v0__nor2_1
X_9043_ _9966_/Q _9327_/B _9954_/Q _9091_/A1 PHY_9/VDD PHY_9/VDD VSUBS VSUBS gf180mcu_fd_sc_mcu7t5v0__nand3_4
X_6255_ _9784_/Q _6288_/A2 _6288_/B1 _9829_/Q _6256_/A2 PHY_9/VDD PHY_9/VDD VSUBS
+ VSUBS gf180mcu_fd_sc_mcu7t5v0__aoi22_1
X_5206_ _5657_/A2 _5831_/A2 _5206_/B1 _5867_/A2 _5207_/A2 PHY_9/VDD PHY_9/VDD VSUBS
+ VSUBS gf180mcu_fd_sc_mcu7t5v0__oai22_1
X_6186_ _6186_/A1 _6186_/A2 _6202_/B1 PHY_9/VDD PHY_9/VDD VSUBS VSUBS gf180mcu_fd_sc_mcu7t5v0__nand2_1
X_5137_ _9474_/Q _5137_/A2 _5137_/A3 _5262_/A1 _5567_/A1 PHY_9/VDD PHY_9/VDD VSUBS
+ VSUBS gf180mcu_fd_sc_mcu7t5v0__nand4_4
X_9945_ _9945_/D _9948_/CLK _9945_/Q PHY_9/VDD PHY_9/VDD VSUBS VSUBS gf180mcu_fd_sc_mcu7t5v0__dffq_1
X_5068_ _9424_/Q _5405_/A1 PHY_9/VDD PHY_9/VDD VSUBS VSUBS gf180mcu_fd_sc_mcu7t5v0__clkinv_1
X_9876_ _9876_/D _9907_/CLK _9876_/Q PHY_9/VDD PHY_9/VDD VSUBS VSUBS gf180mcu_fd_sc_mcu7t5v0__dffq_2
X_8827_ _8827_/A1 _8790_/Z _8826_/Z _8919_/A1 PHY_9/VDD PHY_9/VDD VSUBS VSUBS gf180mcu_fd_sc_mcu7t5v0__nand3_2
X_8758_ _9808_/Q _8752_/I _8758_/A3 _8758_/Z PHY_9/VDD PHY_9/VDD VSUBS VSUBS gf180mcu_fd_sc_mcu7t5v0__xor3_1
X_7709_ _9090_/C _7988_/A2 _7728_/A2 PHY_9/VDD PHY_9/VDD VSUBS VSUBS gf180mcu_fd_sc_mcu7t5v0__nor2_1
X_8689_ _8689_/A1 _8697_/A2 _8697_/B1 PHY_9/VDD PHY_9/VDD VSUBS VSUBS gf180mcu_fd_sc_mcu7t5v0__nand2_2
X_6040_ _8344_/A1 _6290_/B2 _6049_/A2 PHY_9/VDD PHY_9/VDD VSUBS VSUBS gf180mcu_fd_sc_mcu7t5v0__nand2_4
X_7991_ _7991_/A1 _7991_/A2 _7991_/B _7999_/A2 PHY_9/VDD PHY_9/VDD VSUBS VSUBS gf180mcu_fd_sc_mcu7t5v0__aoi21_1
X_6942_ _6942_/A1 _6942_/A2 _6939_/Z _6942_/Z PHY_9/VDD PHY_9/VDD VSUBS VSUBS gf180mcu_fd_sc_mcu7t5v0__xor3_1
X_9730_ _9730_/D _9800_/CLK _9730_/Q PHY_9/VDD PHY_9/VDD VSUBS VSUBS gf180mcu_fd_sc_mcu7t5v0__dffq_1
X_6873_ _6916_/A1 _6871_/Z _6886_/A2 PHY_9/VDD PHY_9/VDD VSUBS VSUBS gf180mcu_fd_sc_mcu7t5v0__xnor2_1
X_9661_ _9661_/D _9972_/CLK _9661_/Q PHY_9/VDD PHY_9/VDD VSUBS VSUBS gf180mcu_fd_sc_mcu7t5v0__dffq_1
X_5824_ _5406_/Z _5824_/A2 _5824_/B1 _5824_/B2 _9638_/D PHY_9/VDD PHY_9/VDD VSUBS
+ VSUBS gf180mcu_fd_sc_mcu7t5v0__oai22_1
X_8612_ _8612_/I _8615_/A3 PHY_9/VDD PHY_9/VDD VSUBS VSUBS gf180mcu_fd_sc_mcu7t5v0__clkinv_1
X_9592_ _9592_/D _9939_/CLK _9592_/Q PHY_9/VDD PHY_9/VDD VSUBS VSUBS gf180mcu_fd_sc_mcu7t5v0__dffq_1
X_5755_ _8693_/A1 _5759_/A2 _5759_/B1 _5755_/B2 _9585_/D PHY_9/VDD PHY_9/VDD VSUBS
+ VSUBS gf180mcu_fd_sc_mcu7t5v0__oai22_1
X_8543_ _8503_/Z _8543_/A2 _8543_/B _8565_/A1 PHY_9/VDD PHY_9/VDD VSUBS VSUBS gf180mcu_fd_sc_mcu7t5v0__aoi21_1
X_5686_ _5684_/Z _5686_/A2 _9543_/D PHY_9/VDD PHY_9/VDD VSUBS VSUBS gf180mcu_fd_sc_mcu7t5v0__nor2_1
X_4706_ _9364_/Q _5242_/A1 PHY_9/VDD PHY_9/VDD VSUBS VSUBS gf180mcu_fd_sc_mcu7t5v0__clkinv_1
X_8474_ _8464_/Z _8474_/A2 _8472_/B _8476_/A2 PHY_9/VDD PHY_9/VDD VSUBS VSUBS gf180mcu_fd_sc_mcu7t5v0__xnor3_1
X_7425_ _9872_/Q _7424_/Z _7445_/A2 PHY_9/VDD PHY_9/VDD VSUBS VSUBS gf180mcu_fd_sc_mcu7t5v0__nor2_1
X_7356_ _9867_/Q _7364_/A2 _7371_/A3 _7369_/A1 PHY_9/VDD PHY_9/VDD VSUBS VSUBS gf180mcu_fd_sc_mcu7t5v0__nand3_1
X_7287_ _7287_/A1 _7287_/A2 _7287_/B _7311_/A2 PHY_9/VDD PHY_9/VDD VSUBS VSUBS gf180mcu_fd_sc_mcu7t5v0__oai21_1
X_6307_ _8691_/A1 _6313_/A2 _6313_/B1 _6307_/B2 _9787_/D PHY_9/VDD PHY_9/VDD VSUBS
+ VSUBS gf180mcu_fd_sc_mcu7t5v0__oai22_1
X_6238_ _6238_/A1 _6238_/A2 _6260_/A2 PHY_9/VDD PHY_9/VDD VSUBS VSUBS gf180mcu_fd_sc_mcu7t5v0__nand2_1
X_9026_ _9026_/A1 _9356_/C _9026_/B1 _9026_/B2 _9357_/B _9961_/D PHY_9/VDD PHY_9/VDD
+ VSUBS VSUBS gf180mcu_fd_sc_mcu7t5v0__aoi221_1
X_6169_ _6169_/A1 _6169_/A2 _6174_/B1 PHY_9/VDD PHY_9/VDD VSUBS VSUBS gf180mcu_fd_sc_mcu7t5v0__nand2_1
X_9928_ _9928_/D _9957_/CLK _9928_/Q PHY_9/VDD PHY_9/VDD VSUBS VSUBS gf180mcu_fd_sc_mcu7t5v0__dffq_2
X_9859_ _9859_/D _9948_/CLK _9859_/Q PHY_9/VDD PHY_9/VDD VSUBS VSUBS gf180mcu_fd_sc_mcu7t5v0__dffq_1
Xclkbuf_leaf_11_clk clkbuf_leaf_9_clk/I _9972_/CLK PHY_9/VDD PHY_9/VDD VSUBS VSUBS
+ gf180mcu_fd_sc_mcu7t5v0__clkbuf_16
X_5540_ _5973_/C _5540_/A2 _9474_/D PHY_9/VDD PHY_9/VDD VSUBS VSUBS gf180mcu_fd_sc_mcu7t5v0__nor2_1
X_5471_ _5488_/A1 _5495_/B _5471_/B _9447_/D PHY_9/VDD PHY_9/VDD VSUBS VSUBS gf180mcu_fd_sc_mcu7t5v0__aoi21_1
X_7210_ _7156_/Z _7210_/A2 _7209_/B _7245_/A2 PHY_9/VDD PHY_9/VDD VSUBS VSUBS gf180mcu_fd_sc_mcu7t5v0__nor3_1
X_8190_ _8156_/B _8189_/Z _8207_/B1 PHY_9/VDD PHY_9/VDD VSUBS VSUBS gf180mcu_fd_sc_mcu7t5v0__nand2_1
X_7141_ _7040_/B _7125_/Z _7141_/B _9317_/C _7142_/A2 PHY_9/VDD PHY_9/VDD VSUBS VSUBS
+ gf180mcu_fd_sc_mcu7t5v0__oai211_1
X_7072_ _9317_/C _7072_/A2 _7072_/B _9850_/D PHY_9/VDD PHY_9/VDD VSUBS VSUBS gf180mcu_fd_sc_mcu7t5v0__aoi21_1
X_6023_ _8691_/A1 _6029_/A2 _6029_/B1 _6023_/B2 _9739_/D PHY_9/VDD PHY_9/VDD VSUBS
+ VSUBS gf180mcu_fd_sc_mcu7t5v0__oai22_1
X_7974_ _7974_/A1 _7974_/A2 _7974_/B _7975_/B PHY_9/VDD PHY_9/VDD VSUBS VSUBS gf180mcu_fd_sc_mcu7t5v0__oai21_1
X_6925_ _6925_/I _6981_/A1 PHY_9/VDD PHY_9/VDD VSUBS VSUBS gf180mcu_fd_sc_mcu7t5v0__clkinv_1
X_9713_ _9713_/D _9939_/CLK _9713_/Q PHY_9/VDD PHY_9/VDD VSUBS VSUBS gf180mcu_fd_sc_mcu7t5v0__dffq_1
X_6856_ _6997_/B2 _6856_/A2 _6856_/B _6857_/B PHY_9/VDD PHY_9/VDD VSUBS VSUBS gf180mcu_fd_sc_mcu7t5v0__oai21_1
X_9644_ _9644_/D _9972_/CLK _9644_/Q PHY_9/VDD PHY_9/VDD VSUBS VSUBS gf180mcu_fd_sc_mcu7t5v0__dffq_1
X_6787_ _6787_/A1 _6787_/A2 _6789_/A2 PHY_9/VDD PHY_9/VDD VSUBS VSUBS gf180mcu_fd_sc_mcu7t5v0__xnor2_1
X_9575_ _9575_/D _9940_/CLK _9575_/Q PHY_9/VDD PHY_9/VDD VSUBS VSUBS gf180mcu_fd_sc_mcu7t5v0__dffq_1
X_5807_ _5388_/Z _5814_/A2 _5814_/B1 _5807_/B2 _9623_/D PHY_9/VDD PHY_9/VDD VSUBS
+ VSUBS gf180mcu_fd_sc_mcu7t5v0__oai22_1
X_5738_ _5366_/I _5367_/Z _5371_/Z _8678_/A2 PHY_9/VDD PHY_9/VDD VSUBS VSUBS gf180mcu_fd_sc_mcu7t5v0__nor3_4
X_8526_ _8444_/B _8645_/A2 _8526_/B _8577_/A1 PHY_9/VDD PHY_9/VDD VSUBS VSUBS gf180mcu_fd_sc_mcu7t5v0__aoi21_1
X_5669_ _9538_/Q _5667_/Z _5671_/A2 PHY_9/VDD PHY_9/VDD VSUBS VSUBS gf180mcu_fd_sc_mcu7t5v0__nor2_1
X_8457_ _8491_/C _8443_/Z _8457_/B1 _8457_/B2 _9356_/C _8458_/B PHY_9/VDD PHY_9/VDD
+ VSUBS VSUBS gf180mcu_fd_sc_mcu7t5v0__aoi221_1
X_7408_ _9872_/Q _9356_/C _7443_/A1 PHY_9/VDD PHY_9/VDD VSUBS VSUBS gf180mcu_fd_sc_mcu7t5v0__nand2_1
X_8388_ _8388_/A1 _8388_/A2 _8391_/B PHY_9/VDD PHY_9/VDD VSUBS VSUBS gf180mcu_fd_sc_mcu7t5v0__nand2_1
X_7339_ _9384_/Q _9036_/A2 _7695_/B _7340_/B PHY_9/VDD PHY_9/VDD VSUBS VSUBS gf180mcu_fd_sc_mcu7t5v0__oai21_1
X_9009_ _9000_/Z _9007_/Z _9008_/Z _9009_/Z PHY_9/VDD PHY_9/VDD VSUBS VSUBS gf180mcu_fd_sc_mcu7t5v0__xor3_1
Xclkbuf_leaf_0_clk clkbuf_leaf_9_clk/I _9800_/CLK PHY_9/VDD PHY_9/VDD VSUBS VSUBS
+ gf180mcu_fd_sc_mcu7t5v0__clkbuf_16
X_4971_ _9569_/Q _5733_/B2 PHY_9/VDD PHY_9/VDD VSUBS VSUBS gf180mcu_fd_sc_mcu7t5v0__clkinv_1
X_6710_ _6781_/A2 _6781_/A3 _6710_/Z PHY_9/VDD PHY_9/VDD VSUBS VSUBS gf180mcu_fd_sc_mcu7t5v0__and2_2
X_7690_ _7711_/A2 _9034_/A2 _7690_/B _9887_/D PHY_9/VDD PHY_9/VDD VSUBS VSUBS gf180mcu_fd_sc_mcu7t5v0__aoi21_1
X_6641_ _6638_/Z _6640_/Z _6642_/A2 PHY_9/VDD PHY_9/VDD VSUBS VSUBS gf180mcu_fd_sc_mcu7t5v0__xnor2_1
X_9360_ _9360_/D _9972_/CLK _9360_/Q PHY_9/VDD PHY_9/VDD VSUBS VSUBS gf180mcu_fd_sc_mcu7t5v0__dffq_1
X_6572_ _6572_/A1 _6578_/A2 _6528_/Z _6572_/B2 _6574_/A2 PHY_9/VDD PHY_9/VDD VSUBS
+ VSUBS gf180mcu_fd_sc_mcu7t5v0__oai22_2
X_8311_ _9811_/Q _8311_/A2 _8312_/A3 PHY_9/VDD PHY_9/VDD VSUBS VSUBS gf180mcu_fd_sc_mcu7t5v0__nand2_1
X_9291_ _9292_/A1 _9292_/A2 _9320_/B PHY_9/VDD PHY_9/VDD VSUBS VSUBS gf180mcu_fd_sc_mcu7t5v0__or2_1
X_5523_ _5523_/A1 _5522_/B _5523_/B1 _5523_/B2 _5973_/C _9467_/D PHY_9/VDD PHY_9/VDD
+ VSUBS VSUBS gf180mcu_fd_sc_mcu7t5v0__aoi221_1
X_5454_ _5488_/A1 _5458_/A2 _5454_/B _9439_/D PHY_9/VDD PHY_9/VDD VSUBS VSUBS gf180mcu_fd_sc_mcu7t5v0__aoi21_1
X_8242_ _8316_/A2 _8242_/A2 _8242_/Z PHY_9/VDD PHY_9/VDD VSUBS VSUBS gf180mcu_fd_sc_mcu7t5v0__xor2_1
X_8173_ _8129_/I _8219_/A1 _8232_/A1 PHY_9/VDD PHY_9/VDD VSUBS VSUBS gf180mcu_fd_sc_mcu7t5v0__nor2_1
X_5385_ _5705_/A1 _5381_/I _5636_/A3 _7677_/A1 PHY_9/VDD PHY_9/VDD VSUBS VSUBS gf180mcu_fd_sc_mcu7t5v0__nor3_4
X_7124_ _9852_/Q _7122_/Z _7124_/Z PHY_9/VDD PHY_9/VDD VSUBS VSUBS gf180mcu_fd_sc_mcu7t5v0__xor2_1
X_7055_ _9808_/Q _7254_/A2 _7084_/A2 PHY_9/VDD PHY_9/VDD VSUBS VSUBS gf180mcu_fd_sc_mcu7t5v0__nand2_2
X_6006_ _8695_/A1 _6008_/A2 _6008_/B1 _6006_/B2 _9711_/D PHY_9/VDD PHY_9/VDD VSUBS
+ VSUBS gf180mcu_fd_sc_mcu7t5v0__oai22_1
X_7957_ _7939_/Z _7956_/Z _7957_/Z PHY_9/VDD PHY_9/VDD VSUBS VSUBS gf180mcu_fd_sc_mcu7t5v0__xor2_1
X_6908_ _6700_/C _6894_/Z _6908_/B _9317_/C _6909_/A2 PHY_9/VDD PHY_9/VDD VSUBS VSUBS
+ gf180mcu_fd_sc_mcu7t5v0__oai211_1
X_7888_ _9809_/Q _7800_/Z _7989_/A1 PHY_9/VDD PHY_9/VDD VSUBS VSUBS gf180mcu_fd_sc_mcu7t5v0__nand2_1
X_6839_ _9840_/Q _6837_/Z _6862_/B PHY_9/VDD PHY_9/VDD VSUBS VSUBS gf180mcu_fd_sc_mcu7t5v0__nand2_1
X_9627_ _9627_/D _9830_/CLK _9627_/Q PHY_9/VDD PHY_9/VDD VSUBS VSUBS gf180mcu_fd_sc_mcu7t5v0__dffq_1
X_9558_ _9558_/D _9801_/CLK _9558_/Q PHY_9/VDD PHY_9/VDD VSUBS VSUBS gf180mcu_fd_sc_mcu7t5v0__dffq_1
X_8509_ _8511_/A2 _8603_/A1 _8509_/Z PHY_9/VDD PHY_9/VDD VSUBS VSUBS gf180mcu_fd_sc_mcu7t5v0__or2_1
X_9489_ _9489_/D _9972_/CLK _9489_/Q PHY_9/VDD PHY_9/VDD VSUBS VSUBS gf180mcu_fd_sc_mcu7t5v0__dffq_4
X_5170_ _5170_/A1 _5170_/A2 _5170_/A3 _5170_/Z PHY_9/VDD PHY_9/VDD VSUBS VSUBS gf180mcu_fd_sc_mcu7t5v0__or3_1
X_8860_ _6471_/B _8752_/I _8858_/B _8904_/B PHY_9/VDD PHY_9/VDD VSUBS VSUBS gf180mcu_fd_sc_mcu7t5v0__nor3_1
X_8791_ _8827_/A1 _8790_/Z _8828_/A1 PHY_9/VDD PHY_9/VDD VSUBS VSUBS gf180mcu_fd_sc_mcu7t5v0__nand2_1
X_7811_ _7811_/A1 _7809_/Z _7813_/A2 PHY_9/VDD PHY_9/VDD VSUBS VSUBS gf180mcu_fd_sc_mcu7t5v0__xnor2_1
X_4954_ _9943_/Q _8692_/B2 PHY_9/VDD PHY_9/VDD VSUBS VSUBS gf180mcu_fd_sc_mcu7t5v0__clkinv_1
X_7742_ _9886_/Q _7743_/A2 _7785_/B PHY_9/VDD PHY_9/VDD VSUBS VSUBS gf180mcu_fd_sc_mcu7t5v0__and2_1
X_7673_ _7673_/A1 _7672_/Z _7673_/Z PHY_9/VDD PHY_9/VDD VSUBS VSUBS gf180mcu_fd_sc_mcu7t5v0__xor2_1
X_9412_ _9412_/D _9901_/CLK _9412_/Q PHY_9/VDD PHY_9/VDD VSUBS VSUBS gf180mcu_fd_sc_mcu7t5v0__dffq_1
X_4885_ _9514_/Q _5639_/B2 PHY_9/VDD PHY_9/VDD VSUBS VSUBS gf180mcu_fd_sc_mcu7t5v0__clkinv_1
X_6624_ _9814_/Q _6624_/A2 _6632_/A2 PHY_9/VDD PHY_9/VDD VSUBS VSUBS gf180mcu_fd_sc_mcu7t5v0__nand2_1
X_6555_ _6558_/B _6553_/Z _6555_/Z PHY_9/VDD PHY_9/VDD VSUBS VSUBS gf180mcu_fd_sc_mcu7t5v0__xor2_1
X_9343_ _9343_/A1 _9341_/Z _9343_/B _9356_/A2 PHY_9/VDD PHY_9/VDD VSUBS VSUBS gf180mcu_fd_sc_mcu7t5v0__aoi21_1
X_9274_ _9807_/Q _9351_/A2 _9275_/A2 _9339_/A1 PHY_9/VDD PHY_9/VDD VSUBS VSUBS gf180mcu_fd_sc_mcu7t5v0__nand3_1
X_5506_ _9428_/Q _9725_/Q _5522_/A2 _5507_/C PHY_9/VDD PHY_9/VDD VSUBS VSUBS gf180mcu_fd_sc_mcu7t5v0__and3_1
X_6486_ _9808_/Q _6577_/A2 _6529_/A1 PHY_9/VDD PHY_9/VDD VSUBS VSUBS gf180mcu_fd_sc_mcu7t5v0__nand2_1
X_8225_ _8226_/A1 _8274_/A1 _8270_/A2 PHY_9/VDD PHY_9/VDD VSUBS VSUBS gf180mcu_fd_sc_mcu7t5v0__nor2_1
X_5437_ _9647_/Q _5437_/A2 _5883_/A3 _9678_/Q _5438_/I PHY_9/VDD PHY_9/VDD VSUBS VSUBS
+ gf180mcu_fd_sc_mcu7t5v0__aoi22_1
X_5368_ _5366_/I _5367_/Z _5739_/A1 PHY_9/VDD PHY_9/VDD VSUBS VSUBS gf180mcu_fd_sc_mcu7t5v0__nor2_2
X_8156_ _9810_/Q _8337_/B _8156_/B _8157_/C PHY_9/VDD PHY_9/VDD VSUBS VSUBS gf180mcu_fd_sc_mcu7t5v0__aoi21_1
X_5299_ _5502_/A1 _5307_/A2 _5299_/B _5973_/C _9388_/D PHY_9/VDD PHY_9/VDD VSUBS VSUBS
+ gf180mcu_fd_sc_mcu7t5v0__aoi211_1
X_8087_ _8087_/A1 _8130_/A1 _8087_/Z PHY_9/VDD PHY_9/VDD VSUBS VSUBS gf180mcu_fd_sc_mcu7t5v0__xor2_1
X_7107_ _9907_/Q _9848_/Q _7145_/B _7109_/B1 PHY_9/VDD PHY_9/VDD VSUBS VSUBS gf180mcu_fd_sc_mcu7t5v0__oai21_2
X_7038_ _9807_/Q _7019_/I _7038_/B _7040_/B _7042_/B1 PHY_9/VDD PHY_9/VDD VSUBS VSUBS
+ gf180mcu_fd_sc_mcu7t5v0__oai211_1
X_8989_ _9357_/B _8989_/A2 _9960_/D PHY_9/VDD PHY_9/VDD VSUBS VSUBS gf180mcu_fd_sc_mcu7t5v0__nor2_1
X_6340_ _9509_/Q _9034_/A2 _8706_/B _6341_/B PHY_9/VDD PHY_9/VDD VSUBS VSUBS gf180mcu_fd_sc_mcu7t5v0__oai21_1
X_6271_ _9761_/Q _6287_/A2 _6287_/B1 _9745_/Q _6273_/A1 PHY_9/VDD PHY_9/VDD VSUBS
+ VSUBS gf180mcu_fd_sc_mcu7t5v0__aoi22_1
X_5222_ _5222_/A1 _5222_/A2 _5222_/A3 _9729_/D PHY_9/VDD PHY_9/VDD VSUBS VSUBS gf180mcu_fd_sc_mcu7t5v0__nor3_1
X_8010_ _9813_/Q _7967_/Z _8010_/B _8014_/A1 PHY_9/VDD PHY_9/VDD VSUBS VSUBS gf180mcu_fd_sc_mcu7t5v0__aoi21_1
X_5153_ _5153_/A1 _5153_/A2 _5170_/A1 PHY_9/VDD PHY_9/VDD VSUBS VSUBS gf180mcu_fd_sc_mcu7t5v0__nand2_1
X_5084_ _9884_/Q _7685_/B2 PHY_9/VDD PHY_9/VDD VSUBS VSUBS gf180mcu_fd_sc_mcu7t5v0__clkinv_1
X_9961_ _9961_/D _9974_/CLK _9961_/Q PHY_9/VDD PHY_9/VDD VSUBS VSUBS gf180mcu_fd_sc_mcu7t5v0__dffq_1
X_8912_ _8912_/A1 _8910_/Z _8949_/A2 PHY_9/VDD PHY_9/VDD VSUBS VSUBS gf180mcu_fd_sc_mcu7t5v0__xnor2_1
X_9892_ _9892_/D _9957_/CLK _9892_/Q PHY_9/VDD PHY_9/VDD VSUBS VSUBS gf180mcu_fd_sc_mcu7t5v0__dffq_2
X_8843_ _8983_/A1 _8954_/A1 _8843_/B1 _8843_/B2 _8843_/C _8844_/C PHY_9/VDD PHY_9/VDD
+ VSUBS VSUBS gf180mcu_fd_sc_mcu7t5v0__oai221_2
X_5986_ _8695_/A1 _5988_/A2 _5988_/B1 _5986_/B2 _9695_/D PHY_9/VDD PHY_9/VDD VSUBS
+ VSUBS gf180mcu_fd_sc_mcu7t5v0__oai22_1
X_8774_ _8774_/A1 _8772_/Z _8779_/A2 PHY_9/VDD PHY_9/VDD VSUBS VSUBS gf180mcu_fd_sc_mcu7t5v0__nand2_1
X_4937_ _9576_/Q _5744_/B2 PHY_9/VDD PHY_9/VDD VSUBS VSUBS gf180mcu_fd_sc_mcu7t5v0__clkinv_1
X_7725_ _9888_/Q _9887_/Q _7725_/A3 _8004_/B PHY_9/VDD PHY_9/VDD VSUBS VSUBS gf180mcu_fd_sc_mcu7t5v0__nand3_2
X_4868_ _9524_/Q _5657_/A2 PHY_9/VDD PHY_9/VDD VSUBS VSUBS gf180mcu_fd_sc_mcu7t5v0__clkinv_1
X_7656_ _7656_/I0 _9809_/Q _7656_/S _7656_/Z PHY_9/VDD PHY_9/VDD VSUBS VSUBS gf180mcu_fd_sc_mcu7t5v0__mux2_1
X_6607_ _6646_/A1 _6646_/A2 _6609_/A2 PHY_9/VDD PHY_9/VDD VSUBS VSUBS gf180mcu_fd_sc_mcu7t5v0__xnor2_1
X_7587_ _9876_/Q _9356_/C _7640_/A1 PHY_9/VDD PHY_9/VDD VSUBS VSUBS gf180mcu_fd_sc_mcu7t5v0__nand2_1
X_9326_ _9513_/Q _9044_/Z _9326_/B1 _9911_/Q _9328_/B1 PHY_9/VDD PHY_9/VDD VSUBS VSUBS
+ gf180mcu_fd_sc_mcu7t5v0__aoi22_2
X_4799_ _9809_/Q _9227_/A1 PHY_9/VDD PHY_9/VDD VSUBS VSUBS gf180mcu_fd_sc_mcu7t5v0__clkinv_12
X_6538_ _6529_/Z _6538_/A2 _6538_/A3 _6540_/A2 PHY_9/VDD PHY_9/VDD VSUBS VSUBS gf180mcu_fd_sc_mcu7t5v0__xnor3_1
X_6469_ _6464_/Z _6468_/Z _6469_/Z PHY_9/VDD PHY_9/VDD VSUBS VSUBS gf180mcu_fd_sc_mcu7t5v0__or2_1
X_9257_ _9206_/Z _9210_/I _9257_/B _9304_/A2 PHY_9/VDD PHY_9/VDD VSUBS VSUBS gf180mcu_fd_sc_mcu7t5v0__oai21_1
X_9188_ _9811_/Q _9810_/Q _9331_/A2 _9285_/A2 _9188_/Z PHY_9/VDD PHY_9/VDD VSUBS VSUBS
+ gf180mcu_fd_sc_mcu7t5v0__and4_1
X_8208_ _9909_/Q _9356_/C _8253_/A1 PHY_9/VDD PHY_9/VDD VSUBS VSUBS gf180mcu_fd_sc_mcu7t5v0__nand2_1
X_8139_ _8163_/A1 _8139_/A2 _8136_/Z _8139_/Z PHY_9/VDD PHY_9/VDD VSUBS VSUBS gf180mcu_fd_sc_mcu7t5v0__xor3_1
X_5840_ _5832_/Z _5840_/A2 _5841_/B PHY_9/VDD PHY_9/VDD VSUBS VSUBS gf180mcu_fd_sc_mcu7t5v0__nand2_1
X_5771_ _5771_/I _9598_/D PHY_9/VDD PHY_9/VDD VSUBS VSUBS gf180mcu_fd_sc_mcu7t5v0__clkinv_1
X_7510_ _7510_/A1 _7510_/A2 _7510_/Z PHY_9/VDD PHY_9/VDD VSUBS VSUBS gf180mcu_fd_sc_mcu7t5v0__xor2_1
X_4722_ _9369_/Q _5254_/A1 PHY_9/VDD PHY_9/VDD VSUBS VSUBS gf180mcu_fd_sc_mcu7t5v0__clkinv_1
X_8490_ _9810_/Q _8645_/A2 _8490_/B1 _8674_/B _8492_/A2 PHY_9/VDD PHY_9/VDD VSUBS
+ VSUBS gf180mcu_fd_sc_mcu7t5v0__oai22_1
X_7441_ _7674_/C2 _7433_/Z _7441_/B _7442_/B PHY_9/VDD PHY_9/VDD VSUBS VSUBS gf180mcu_fd_sc_mcu7t5v0__oai21_1
X_7372_ _9807_/Q _7647_/A2 _7668_/B _7372_/B2 _7373_/A2 PHY_9/VDD PHY_9/VDD VSUBS
+ VSUBS gf180mcu_fd_sc_mcu7t5v0__oai22_1
X_9111_ _9111_/A1 _9109_/Z _9111_/Z PHY_9/VDD PHY_9/VDD VSUBS VSUBS gf180mcu_fd_sc_mcu7t5v0__xor2_1
X_6323_ _5406_/Z _6323_/A2 _6323_/B1 _6323_/B2 _9801_/D PHY_9/VDD PHY_9/VDD VSUBS
+ VSUBS gf180mcu_fd_sc_mcu7t5v0__oai22_1
X_9042_ _9498_/Q _9041_/Z _9091_/C PHY_9/VDD PHY_9/VDD VSUBS VSUBS gf180mcu_fd_sc_mcu7t5v0__nor2_4
X_6254_ _9800_/Q _6287_/A2 _6287_/B1 _9564_/Q _6256_/A1 PHY_9/VDD PHY_9/VDD VSUBS
+ VSUBS gf180mcu_fd_sc_mcu7t5v0__aoi22_1
X_5205_ _5478_/A1 _5205_/A2 _5205_/B _9727_/D PHY_9/VDD PHY_9/VDD VSUBS VSUBS gf180mcu_fd_sc_mcu7t5v0__oai21_1
X_6185_ _9635_/Q _6288_/A2 _6288_/B1 _9619_/Q _6186_/A2 PHY_9/VDD PHY_9/VDD VSUBS
+ VSUBS gf180mcu_fd_sc_mcu7t5v0__aoi22_1
X_5136_ _9476_/Q _9475_/Q _9474_/Q _5439_/A2 PHY_9/VDD PHY_9/VDD VSUBS VSUBS gf180mcu_fd_sc_mcu7t5v0__nor3_4
X_9944_ _9944_/D _9948_/CLK _9944_/Q PHY_9/VDD PHY_9/VDD VSUBS VSUBS gf180mcu_fd_sc_mcu7t5v0__dffq_1
X_5067_ _9572_/Q _5736_/B2 PHY_9/VDD PHY_9/VDD VSUBS VSUBS gf180mcu_fd_sc_mcu7t5v0__clkinv_1
X_9875_ _9875_/D _9907_/CLK _9875_/Q PHY_9/VDD PHY_9/VDD VSUBS VSUBS gf180mcu_fd_sc_mcu7t5v0__dffq_4
X_8826_ _8815_/I _8826_/A2 _8826_/Z PHY_9/VDD PHY_9/VDD VSUBS VSUBS gf180mcu_fd_sc_mcu7t5v0__xor2_1
X_5969_ _9477_/Q _5969_/A2 _5970_/B PHY_9/VDD PHY_9/VDD VSUBS VSUBS gf180mcu_fd_sc_mcu7t5v0__nand2_1
X_8757_ _9808_/Q _8756_/Z _8757_/Z PHY_9/VDD PHY_9/VDD VSUBS VSUBS gf180mcu_fd_sc_mcu7t5v0__and2_1
X_7708_ _7704_/Z _7708_/A2 _7708_/A3 _7708_/B _7988_/A2 PHY_9/VDD PHY_9/VDD VSUBS
+ VSUBS gf180mcu_fd_sc_mcu7t5v0__oai31_4
X_8688_ _8688_/A1 _8688_/A2 _8697_/A2 PHY_9/VDD PHY_9/VDD VSUBS VSUBS gf180mcu_fd_sc_mcu7t5v0__nand2_4
X_7639_ _7582_/C _7639_/A2 _7639_/B _9317_/C _7640_/A2 PHY_9/VDD PHY_9/VDD VSUBS VSUBS
+ gf180mcu_fd_sc_mcu7t5v0__oai211_1
X_9309_ _9311_/A1 _9308_/Z _9350_/A2 PHY_9/VDD PHY_9/VDD VSUBS VSUBS gf180mcu_fd_sc_mcu7t5v0__nand2_1
X_7990_ _7987_/Z _7990_/A2 _7990_/A3 _7990_/Z PHY_9/VDD PHY_9/VDD VSUBS VSUBS gf180mcu_fd_sc_mcu7t5v0__xor3_1
X_6941_ _6941_/A1 _6941_/A2 _6939_/Z _6963_/A2 PHY_9/VDD PHY_9/VDD VSUBS VSUBS gf180mcu_fd_sc_mcu7t5v0__nand3_1
X_6872_ _6916_/A1 _6871_/Z _6872_/Z PHY_9/VDD PHY_9/VDD VSUBS VSUBS gf180mcu_fd_sc_mcu7t5v0__xor2_1
X_9660_ _9660_/D _9689_/CLK _9660_/Q PHY_9/VDD PHY_9/VDD VSUBS VSUBS gf180mcu_fd_sc_mcu7t5v0__dffq_2
X_9591_ _9591_/D _9939_/CLK _9591_/Q PHY_9/VDD PHY_9/VDD VSUBS VSUBS gf180mcu_fd_sc_mcu7t5v0__dffq_1
X_5823_ _5404_/Z _5824_/A2 _5824_/B1 _5823_/B2 _9637_/D PHY_9/VDD PHY_9/VDD VSUBS
+ VSUBS gf180mcu_fd_sc_mcu7t5v0__oai22_1
X_8611_ _8602_/Z _8611_/A2 _8611_/A3 _8612_/I PHY_9/VDD PHY_9/VDD VSUBS VSUBS gf180mcu_fd_sc_mcu7t5v0__xnor3_1
X_8542_ _8542_/A1 _8542_/A2 _8542_/B _8590_/A1 PHY_9/VDD PHY_9/VDD VSUBS VSUBS gf180mcu_fd_sc_mcu7t5v0__oai21_1
X_5754_ _8692_/A1 _5759_/A2 _5759_/B1 _5754_/B2 _9584_/D PHY_9/VDD PHY_9/VDD VSUBS
+ VSUBS gf180mcu_fd_sc_mcu7t5v0__oai22_1
X_5685_ _9543_/Q _5681_/Z _5700_/B _5686_/A2 PHY_9/VDD PHY_9/VDD VSUBS VSUBS gf180mcu_fd_sc_mcu7t5v0__oai21_1
X_4705_ _9950_/Q _8725_/A2 PHY_9/VDD PHY_9/VDD VSUBS VSUBS gf180mcu_fd_sc_mcu7t5v0__clkinv_2
X_8473_ _8473_/A1 _8437_/Z _8472_/B _8496_/A2 PHY_9/VDD PHY_9/VDD VSUBS VSUBS gf180mcu_fd_sc_mcu7t5v0__nand3_1
X_7424_ _7424_/A1 _7424_/A2 _7424_/Z PHY_9/VDD PHY_9/VDD VSUBS VSUBS gf180mcu_fd_sc_mcu7t5v0__xor2_1
X_7355_ _9865_/Q _7363_/A2 _7667_/I1 PHY_9/VDD PHY_9/VDD VSUBS VSUBS gf180mcu_fd_sc_mcu7t5v0__nor2_2
X_6306_ _5388_/Z _6313_/A2 _6313_/B1 _6306_/B2 _9786_/D PHY_9/VDD PHY_9/VDD VSUBS
+ VSUBS gf180mcu_fd_sc_mcu7t5v0__oai22_1
X_7286_ _9357_/B _7286_/A2 _9855_/D PHY_9/VDD PHY_9/VDD VSUBS VSUBS gf180mcu_fd_sc_mcu7t5v0__nor2_1
X_6237_ _9424_/Q _6288_/A2 _6288_/B1 _9556_/Q _6238_/A2 PHY_9/VDD PHY_9/VDD VSUBS
+ VSUBS gf180mcu_fd_sc_mcu7t5v0__aoi22_1
X_9025_ _8985_/C _9025_/A2 _9356_/C _9026_/B2 PHY_9/VDD PHY_9/VDD VSUBS VSUBS gf180mcu_fd_sc_mcu7t5v0__aoi21_1
X_6168_ _9781_/Q _6288_/A2 _6288_/B1 _9826_/Q _6169_/A2 PHY_9/VDD PHY_9/VDD VSUBS
+ VSUBS gf180mcu_fd_sc_mcu7t5v0__aoi22_1
X_5119_ _9801_/Q _6323_/B2 PHY_9/VDD PHY_9/VDD VSUBS VSUBS gf180mcu_fd_sc_mcu7t5v0__clkinv_1
X_6099_ _6099_/A1 _6099_/A2 _6286_/B _6116_/C PHY_9/VDD PHY_9/VDD VSUBS VSUBS gf180mcu_fd_sc_mcu7t5v0__aoi21_1
X_9927_ _9927_/D _9957_/CLK _9927_/Q PHY_9/VDD PHY_9/VDD VSUBS VSUBS gf180mcu_fd_sc_mcu7t5v0__dffq_1
X_9858_ _9858_/D _9948_/CLK _9858_/Q PHY_9/VDD PHY_9/VDD VSUBS VSUBS gf180mcu_fd_sc_mcu7t5v0__dffq_1
X_8809_ _8809_/A1 _8809_/A2 _8809_/B _8810_/B PHY_9/VDD PHY_9/VDD VSUBS VSUBS gf180mcu_fd_sc_mcu7t5v0__oai21_1
X_9789_ _9789_/D _9940_/CLK _9789_/Q PHY_9/VDD PHY_9/VDD VSUBS VSUBS gf180mcu_fd_sc_mcu7t5v0__dffq_1
X_5470_ _9447_/Q _5495_/B _5474_/B _5471_/B PHY_9/VDD PHY_9/VDD VSUBS VSUBS gf180mcu_fd_sc_mcu7t5v0__oai21_1
X_7140_ _7140_/A1 _7140_/A2 _7140_/B _7141_/B PHY_9/VDD PHY_9/VDD VSUBS VSUBS gf180mcu_fd_sc_mcu7t5v0__oai21_1
X_7071_ _9850_/Q _9317_/C _9100_/B _7072_/B PHY_9/VDD PHY_9/VDD VSUBS VSUBS gf180mcu_fd_sc_mcu7t5v0__oai21_1
X_6022_ _5388_/Z _6029_/A2 _6029_/B1 _6022_/B2 _9738_/D PHY_9/VDD PHY_9/VDD VSUBS
+ VSUBS gf180mcu_fd_sc_mcu7t5v0__oai22_1
X_7973_ _9813_/Q _7973_/A2 _8008_/I1 _7974_/A2 _8009_/C _7974_/B PHY_9/VDD PHY_9/VDD
+ VSUBS VSUBS gf180mcu_fd_sc_mcu7t5v0__aoi221_1
X_9712_ _9712_/D _9939_/CLK _9712_/Q PHY_9/VDD PHY_9/VDD VSUBS VSUBS gf180mcu_fd_sc_mcu7t5v0__dffq_1
X_6924_ _6924_/A1 _6924_/A2 _6980_/A1 _6925_/I PHY_9/VDD PHY_9/VDD VSUBS VSUBS gf180mcu_fd_sc_mcu7t5v0__xnor3_1
X_9643_ _9643_/D _9972_/CLK _9643_/Q PHY_9/VDD PHY_9/VDD VSUBS VSUBS gf180mcu_fd_sc_mcu7t5v0__dffq_1
X_6855_ _9811_/Q _6696_/B _6856_/A2 _6996_/A1 _6955_/C _6856_/B PHY_9/VDD PHY_9/VDD
+ VSUBS VSUBS gf180mcu_fd_sc_mcu7t5v0__aoi221_1
X_6786_ _6787_/A1 _6787_/A2 _6813_/A2 PHY_9/VDD PHY_9/VDD VSUBS VSUBS gf180mcu_fd_sc_mcu7t5v0__nand2_1
X_9574_ _9574_/D _9940_/CLK _9574_/Q PHY_9/VDD PHY_9/VDD VSUBS VSUBS gf180mcu_fd_sc_mcu7t5v0__dffq_1
X_5806_ _8689_/A1 _5814_/A2 _5814_/B1 PHY_9/VDD PHY_9/VDD VSUBS VSUBS gf180mcu_fd_sc_mcu7t5v0__nand2_2
X_5737_ _5406_/Z _5737_/A2 _5737_/B1 _5737_/B2 _9573_/D PHY_9/VDD PHY_9/VDD VSUBS
+ VSUBS gf180mcu_fd_sc_mcu7t5v0__oai22_1
X_8525_ _6471_/B _8482_/Z _8525_/B _8531_/A1 PHY_9/VDD PHY_9/VDD VSUBS VSUBS gf180mcu_fd_sc_mcu7t5v0__oai21_1
X_8456_ _8380_/Z _8456_/A2 _8456_/B _8457_/B2 PHY_9/VDD PHY_9/VDD VSUBS VSUBS gf180mcu_fd_sc_mcu7t5v0__aoi21_1
X_7407_ _9317_/C _7407_/A2 _7407_/B _9871_/D PHY_9/VDD PHY_9/VDD VSUBS VSUBS gf180mcu_fd_sc_mcu7t5v0__aoi21_1
X_5668_ _5659_/I _5668_/A2 _5667_/Z _9537_/D PHY_9/VDD PHY_9/VDD VSUBS VSUBS gf180mcu_fd_sc_mcu7t5v0__nor3_1
X_8387_ _9807_/Q _8674_/A2 _8674_/B _8388_/A2 PHY_9/VDD PHY_9/VDD VSUBS VSUBS gf180mcu_fd_sc_mcu7t5v0__aoi21_1
X_5599_ _9772_/Q _9034_/A2 _8706_/B _5600_/B PHY_9/VDD PHY_9/VDD VSUBS VSUBS gf180mcu_fd_sc_mcu7t5v0__oai21_1
X_7338_ _7371_/A3 _9036_/A2 _7338_/B _9865_/D PHY_9/VDD PHY_9/VDD VSUBS VSUBS gf180mcu_fd_sc_mcu7t5v0__aoi21_1
X_7269_ _9855_/Q _7271_/A2 _7287_/A2 PHY_9/VDD PHY_9/VDD VSUBS VSUBS gf180mcu_fd_sc_mcu7t5v0__nor2_1
X_9008_ _9008_/A1 _9008_/A2 _9008_/A3 _9008_/Z PHY_9/VDD PHY_9/VDD VSUBS VSUBS gf180mcu_fd_sc_mcu7t5v0__xor3_1
X_4970_ _9553_/Q _5711_/B2 PHY_9/VDD PHY_9/VDD VSUBS VSUBS gf180mcu_fd_sc_mcu7t5v0__clkinv_1
X_6640_ _6640_/I0 _6640_/I1 _6640_/S _6640_/Z PHY_9/VDD PHY_9/VDD VSUBS VSUBS gf180mcu_fd_sc_mcu7t5v0__mux2_1
X_6571_ _9807_/Q _6646_/A1 _6574_/A1 PHY_9/VDD PHY_9/VDD VSUBS VSUBS gf180mcu_fd_sc_mcu7t5v0__nand2_1
X_8310_ _8310_/A1 _8310_/A2 _8310_/Z PHY_9/VDD PHY_9/VDD VSUBS VSUBS gf180mcu_fd_sc_mcu7t5v0__xor2_1
X_5522_ _9433_/Q _5522_/A2 _5522_/B _5523_/B2 PHY_9/VDD PHY_9/VDD VSUBS VSUBS gf180mcu_fd_sc_mcu7t5v0__aoi21_1
X_9290_ _9280_/Z _9290_/A2 _9292_/A2 PHY_9/VDD PHY_9/VDD VSUBS VSUBS gf180mcu_fd_sc_mcu7t5v0__xnor2_1
X_5453_ _9439_/Q _5458_/A2 _9035_/B _5454_/B PHY_9/VDD PHY_9/VDD VSUBS VSUBS gf180mcu_fd_sc_mcu7t5v0__oai21_1
X_8241_ _8293_/B _8293_/A1 _8242_/A2 PHY_9/VDD PHY_9/VDD VSUBS VSUBS gf180mcu_fd_sc_mcu7t5v0__nand2_1
X_8172_ _9808_/Q _8266_/A2 _8219_/A1 PHY_9/VDD PHY_9/VDD VSUBS VSUBS gf180mcu_fd_sc_mcu7t5v0__nand2_1
X_5384_ _5381_/I _5636_/A3 _6288_/A2 PHY_9/VDD PHY_9/VDD VSUBS VSUBS gf180mcu_fd_sc_mcu7t5v0__nor2_4
X_7123_ _9852_/Q _7122_/Z _7143_/B PHY_9/VDD PHY_9/VDD VSUBS VSUBS gf180mcu_fd_sc_mcu7t5v0__and2_1
X_7054_ _7278_/C _7094_/A2 _7053_/Z _7064_/A1 PHY_9/VDD PHY_9/VDD VSUBS VSUBS gf180mcu_fd_sc_mcu7t5v0__nand3_1
X_6005_ _5399_/Z _6008_/A2 _6008_/B1 _6005_/B2 _9710_/D PHY_9/VDD PHY_9/VDD VSUBS
+ VSUBS gf180mcu_fd_sc_mcu7t5v0__oai22_1
X_7956_ _7956_/A1 _7955_/B _7956_/Z PHY_9/VDD PHY_9/VDD VSUBS VSUBS gf180mcu_fd_sc_mcu7t5v0__xor2_1
X_6907_ _6700_/C _6907_/A2 _6907_/A3 _6907_/A4 _6908_/B PHY_9/VDD PHY_9/VDD VSUBS
+ VSUBS gf180mcu_fd_sc_mcu7t5v0__nand4_1
X_7887_ _7887_/I _7936_/A1 PHY_9/VDD PHY_9/VDD VSUBS VSUBS gf180mcu_fd_sc_mcu7t5v0__clkinv_1
X_6838_ _9840_/Q _6837_/Z _6862_/A2 PHY_9/VDD PHY_9/VDD VSUBS VSUBS gf180mcu_fd_sc_mcu7t5v0__nor2_1
X_9626_ _9626_/D _9830_/CLK _9626_/Q PHY_9/VDD PHY_9/VDD VSUBS VSUBS gf180mcu_fd_sc_mcu7t5v0__dffq_1
X_9557_ _9557_/D _9830_/CLK _9557_/Q PHY_9/VDD PHY_9/VDD VSUBS VSUBS gf180mcu_fd_sc_mcu7t5v0__dffq_1
X_6769_ _9839_/Q _9356_/C _6811_/A1 PHY_9/VDD PHY_9/VDD VSUBS VSUBS gf180mcu_fd_sc_mcu7t5v0__nand2_1
X_8508_ _6512_/B _6471_/B _8369_/Z _8401_/Z _8510_/A3 PHY_9/VDD PHY_9/VDD VSUBS VSUBS
+ gf180mcu_fd_sc_mcu7t5v0__nor4_1
X_9488_ _9488_/D _9801_/CLK _9488_/Q PHY_9/VDD PHY_9/VDD VSUBS VSUBS gf180mcu_fd_sc_mcu7t5v0__dffq_1
X_8439_ _8475_/A1 _8438_/Z _8476_/A1 PHY_9/VDD PHY_9/VDD VSUBS VSUBS gf180mcu_fd_sc_mcu7t5v0__nand2_1
X_7810_ _7811_/A1 _7809_/Z _7856_/A1 PHY_9/VDD PHY_9/VDD VSUBS VSUBS gf180mcu_fd_sc_mcu7t5v0__nor2_1
X_8790_ _8790_/A1 _8816_/B2 _8789_/B _8790_/Z PHY_9/VDD PHY_9/VDD VSUBS VSUBS gf180mcu_fd_sc_mcu7t5v0__xor3_1
X_4953_ _9625_/Q _5809_/B2 PHY_9/VDD PHY_9/VDD VSUBS VSUBS gf180mcu_fd_sc_mcu7t5v0__clkinv_1
X_7741_ _7805_/A1 _7805_/A2 _7805_/C _7746_/B PHY_9/VDD PHY_9/VDD VSUBS VSUBS gf180mcu_fd_sc_mcu7t5v0__oai21_4
X_7672_ _9814_/Q _7672_/A2 _7672_/A3 _7672_/Z PHY_9/VDD PHY_9/VDD VSUBS VSUBS gf180mcu_fd_sc_mcu7t5v0__xor3_1
X_6623_ _6623_/A1 _6623_/A2 _6638_/A2 PHY_9/VDD PHY_9/VDD VSUBS VSUBS gf180mcu_fd_sc_mcu7t5v0__nand2_1
X_9411_ _9411_/D _9901_/CLK _9411_/Q PHY_9/VDD PHY_9/VDD VSUBS VSUBS gf180mcu_fd_sc_mcu7t5v0__dffq_1
X_4884_ _9526_/Q _5649_/B2 PHY_9/VDD PHY_9/VDD VSUBS VSUBS gf180mcu_fd_sc_mcu7t5v0__clkinv_1
X_6554_ _9812_/Q _6553_/Z _6604_/B PHY_9/VDD PHY_9/VDD VSUBS VSUBS gf180mcu_fd_sc_mcu7t5v0__nand2_1
X_9342_ _9343_/A1 _9341_/Z _9342_/Z PHY_9/VDD PHY_9/VDD VSUBS VSUBS gf180mcu_fd_sc_mcu7t5v0__or2_1
X_6485_ _9808_/Q _6625_/A2 _6572_/A1 PHY_9/VDD PHY_9/VDD VSUBS VSUBS gf180mcu_fd_sc_mcu7t5v0__nand2_1
X_9273_ _9273_/A1 _9335_/A1 _9273_/B _9275_/A2 PHY_9/VDD PHY_9/VDD VSUBS VSUBS gf180mcu_fd_sc_mcu7t5v0__oai21_1
X_5505_ _5973_/C _5505_/A2 _9461_/D PHY_9/VDD PHY_9/VDD VSUBS VSUBS gf180mcu_fd_sc_mcu7t5v0__nor2_1
X_8224_ _8226_/A1 _8274_/A1 _8270_/B PHY_9/VDD PHY_9/VDD VSUBS VSUBS gf180mcu_fd_sc_mcu7t5v0__nand2_1
X_5436_ _9731_/Q _5490_/A1 _5436_/B _9432_/D PHY_9/VDD PHY_9/VDD VSUBS VSUBS gf180mcu_fd_sc_mcu7t5v0__aoi21_1
X_8155_ _8300_/B1 _8268_/A1 _8300_/C _8157_/B1 PHY_9/VDD PHY_9/VDD VSUBS VSUBS gf180mcu_fd_sc_mcu7t5v0__aoi21_1
X_5367_ _9496_/Q _9472_/Q _5559_/B _5367_/Z PHY_9/VDD PHY_9/VDD VSUBS VSUBS gf180mcu_fd_sc_mcu7t5v0__mux2_2
X_7106_ _7106_/A1 _7106_/A2 _7106_/B _7143_/A1 PHY_9/VDD PHY_9/VDD VSUBS VSUBS gf180mcu_fd_sc_mcu7t5v0__oai21_1
X_5298_ _9388_/Q _5307_/A2 _5299_/B PHY_9/VDD PHY_9/VDD VSUBS VSUBS gf180mcu_fd_sc_mcu7t5v0__nor2_1
X_8086_ _8086_/A1 _8102_/A1 _8086_/Z PHY_9/VDD PHY_9/VDD VSUBS VSUBS gf180mcu_fd_sc_mcu7t5v0__and2_1
X_7037_ _9846_/Q _9845_/Q _7037_/A3 _7040_/B PHY_9/VDD PHY_9/VDD VSUBS VSUBS gf180mcu_fd_sc_mcu7t5v0__nand3_4
X_8988_ _9960_/Q _9356_/C _8988_/B _8989_/A2 PHY_9/VDD PHY_9/VDD VSUBS VSUBS gf180mcu_fd_sc_mcu7t5v0__aoi21_1
X_7939_ _7935_/Z _7937_/I _7939_/Z PHY_9/VDD PHY_9/VDD VSUBS VSUBS gf180mcu_fd_sc_mcu7t5v0__xor2_1
X_9609_ _9609_/D _9948_/CLK _9609_/Q PHY_9/VDD PHY_9/VDD VSUBS VSUBS gf180mcu_fd_sc_mcu7t5v0__dffq_1
X_6270_ _6270_/A1 _6270_/A2 _6291_/A2 PHY_9/VDD PHY_9/VDD VSUBS VSUBS gf180mcu_fd_sc_mcu7t5v0__nand2_1
X_5221_ _5770_/B _9722_/Q _9730_/D PHY_9/VDD PHY_9/VDD VSUBS VSUBS gf180mcu_fd_sc_mcu7t5v0__and2_1
X_5152_ _9664_/Q _9663_/Q _9666_/Q _9665_/Q _5153_/A2 PHY_9/VDD PHY_9/VDD VSUBS VSUBS
+ gf180mcu_fd_sc_mcu7t5v0__nor4_1
X_5083_ _9918_/Q _8352_/B2 PHY_9/VDD PHY_9/VDD VSUBS VSUBS gf180mcu_fd_sc_mcu7t5v0__clkinv_1
X_9960_ _9960_/D _9974_/CLK _9960_/Q PHY_9/VDD PHY_9/VDD VSUBS VSUBS gf180mcu_fd_sc_mcu7t5v0__dffq_2
X_8911_ _8912_/A1 _8910_/Z _8949_/B PHY_9/VDD PHY_9/VDD VSUBS VSUBS gf180mcu_fd_sc_mcu7t5v0__or2_1
X_9891_ _9891_/D _9957_/CLK _9891_/Q PHY_9/VDD PHY_9/VDD VSUBS VSUBS gf180mcu_fd_sc_mcu7t5v0__dffq_2
X_8842_ _9810_/Q _9020_/B _8842_/B _8843_/C PHY_9/VDD PHY_9/VDD VSUBS VSUBS gf180mcu_fd_sc_mcu7t5v0__aoi21_1
X_8773_ _8774_/A1 _8772_/Z _8775_/A2 PHY_9/VDD PHY_9/VDD VSUBS VSUBS gf180mcu_fd_sc_mcu7t5v0__nor2_1
X_5985_ _5399_/Z _5988_/A2 _5988_/B1 _5985_/B2 _9694_/D PHY_9/VDD PHY_9/VDD VSUBS
+ VSUBS gf180mcu_fd_sc_mcu7t5v0__oai22_1
X_7724_ _7724_/A1 _7724_/A2 _7831_/C PHY_9/VDD PHY_9/VDD VSUBS VSUBS gf180mcu_fd_sc_mcu7t5v0__nor2_4
X_4936_ _9584_/Q _5754_/B2 PHY_9/VDD PHY_9/VDD VSUBS VSUBS gf180mcu_fd_sc_mcu7t5v0__clkinv_1
X_4867_ _9525_/Q _5657_/A1 PHY_9/VDD PHY_9/VDD VSUBS VSUBS gf180mcu_fd_sc_mcu7t5v0__clkinv_1
X_7655_ _9809_/Q _7655_/A2 _7656_/I0 PHY_9/VDD PHY_9/VDD VSUBS VSUBS gf180mcu_fd_sc_mcu7t5v0__nand2_1
X_6606_ _6606_/A1 _6606_/A2 _6646_/A2 PHY_9/VDD PHY_9/VDD VSUBS VSUBS gf180mcu_fd_sc_mcu7t5v0__nand2_1
X_7586_ _9357_/B _7586_/A2 _9875_/D PHY_9/VDD PHY_9/VDD VSUBS VSUBS gf180mcu_fd_sc_mcu7t5v0__nor2_1
X_6537_ _6538_/A2 _6538_/A3 _6575_/A2 PHY_9/VDD PHY_9/VDD VSUBS VSUBS gf180mcu_fd_sc_mcu7t5v0__nor2_1
X_9325_ _9812_/Q _9103_/Z _9330_/A2 PHY_9/VDD PHY_9/VDD VSUBS VSUBS gf180mcu_fd_sc_mcu7t5v0__nand2_1
X_4798_ _9810_/Q _6471_/B PHY_9/VDD PHY_9/VDD VSUBS VSUBS gf180mcu_fd_sc_mcu7t5v0__clkinv_12
X_6468_ _6471_/B _6466_/Z _6468_/Z PHY_9/VDD PHY_9/VDD VSUBS VSUBS gf180mcu_fd_sc_mcu7t5v0__xor2_1
X_9256_ _9206_/Z _9210_/I _9257_/B _9256_/Z PHY_9/VDD PHY_9/VDD VSUBS VSUBS gf180mcu_fd_sc_mcu7t5v0__or3_1
X_6399_ _6614_/B _6421_/A1 _6401_/B1 PHY_9/VDD PHY_9/VDD VSUBS VSUBS gf180mcu_fd_sc_mcu7t5v0__nand2_1
X_9187_ _9811_/Q _9285_/A2 _9238_/A1 PHY_9/VDD PHY_9/VDD VSUBS VSUBS gf180mcu_fd_sc_mcu7t5v0__nand2_1
X_5419_ _9773_/Q _5439_/A2 _5419_/B1 _5130_/I _5484_/A1 PHY_9/VDD PHY_9/VDD VSUBS
+ VSUBS gf180mcu_fd_sc_mcu7t5v0__aoi22_2
X_8207_ _8207_/A1 _9356_/C _8207_/B1 _8207_/B2 _9357_/B _9908_/D PHY_9/VDD PHY_9/VDD
+ VSUBS VSUBS gf180mcu_fd_sc_mcu7t5v0__aoi221_1
X_8138_ _8139_/A2 _8136_/Z _8163_/A2 PHY_9/VDD PHY_9/VDD VSUBS VSUBS gf180mcu_fd_sc_mcu7t5v0__nand2_1
X_8069_ _9903_/Q _8750_/A2 _9902_/Q _8070_/A3 PHY_9/VDD PHY_9/VDD VSUBS VSUBS gf180mcu_fd_sc_mcu7t5v0__aoi21_2
X_5770_ _9726_/Q _9736_/Q _5531_/C _5770_/B _5771_/I PHY_9/VDD PHY_9/VDD VSUBS VSUBS
+ gf180mcu_fd_sc_mcu7t5v0__oai31_1
X_4721_ _9921_/Q _8372_/A2 PHY_9/VDD PHY_9/VDD VSUBS VSUBS gf180mcu_fd_sc_mcu7t5v0__clkinv_1
X_7440_ _7625_/A1 _7424_/Z _7440_/B _7441_/B PHY_9/VDD PHY_9/VDD VSUBS VSUBS gf180mcu_fd_sc_mcu7t5v0__aoi21_1
X_7371_ _9867_/Q _9866_/Q _7371_/A3 _7582_/C PHY_9/VDD PHY_9/VDD VSUBS VSUBS gf180mcu_fd_sc_mcu7t5v0__nand3_4
X_9110_ _9111_/A1 _9109_/Z _9110_/Z PHY_9/VDD PHY_9/VDD VSUBS VSUBS gf180mcu_fd_sc_mcu7t5v0__or2_1
X_6322_ _5404_/Z _6323_/A2 _6323_/B1 _6322_/B2 _9800_/D PHY_9/VDD PHY_9/VDD VSUBS
+ VSUBS gf180mcu_fd_sc_mcu7t5v0__oai22_1
X_6253_ _6253_/A1 _6253_/A2 _6262_/B1 PHY_9/VDD PHY_9/VDD VSUBS VSUBS gf180mcu_fd_sc_mcu7t5v0__nand2_1
X_9041_ _9966_/Q _9965_/Q _9041_/Z PHY_9/VDD PHY_9/VDD VSUBS VSUBS gf180mcu_fd_sc_mcu7t5v0__or2_2
X_5204_ _5770_/B _9735_/Q _5205_/A2 PHY_9/VDD PHY_9/VDD VSUBS VSUBS gf180mcu_fd_sc_mcu7t5v0__nand2_1
X_6184_ _9611_/Q _6287_/A2 _6287_/B1 _9627_/Q _6186_/A1 PHY_9/VDD PHY_9/VDD VSUBS
+ VSUBS gf180mcu_fd_sc_mcu7t5v0__aoi22_1
X_5135_ _5135_/A1 _5135_/A2 _5139_/C PHY_9/VDD PHY_9/VDD VSUBS VSUBS gf180mcu_fd_sc_mcu7t5v0__nor2_1
X_9943_ _9943_/D _9948_/CLK _9943_/Q PHY_9/VDD PHY_9/VDD VSUBS VSUBS gf180mcu_fd_sc_mcu7t5v0__dffq_1
X_5066_ _9556_/Q _5714_/B2 PHY_9/VDD PHY_9/VDD VSUBS VSUBS gf180mcu_fd_sc_mcu7t5v0__clkinv_1
X_9874_ _9874_/D _9907_/CLK _9874_/Q PHY_9/VDD PHY_9/VDD VSUBS VSUBS gf180mcu_fd_sc_mcu7t5v0__dffq_2
X_8825_ _8815_/I _8826_/A2 _8865_/A2 PHY_9/VDD PHY_9/VDD VSUBS VSUBS gf180mcu_fd_sc_mcu7t5v0__nor2_1
X_5968_ _5968_/A1 _5973_/A2 _5968_/B _9686_/D PHY_9/VDD PHY_9/VDD VSUBS VSUBS gf180mcu_fd_sc_mcu7t5v0__aoi21_1
X_8756_ _8752_/I _8758_/A3 _8756_/Z PHY_9/VDD PHY_9/VDD VSUBS VSUBS gf180mcu_fd_sc_mcu7t5v0__xor2_1
X_4919_ _9608_/Q _5788_/B2 PHY_9/VDD PHY_9/VDD VSUBS VSUBS gf180mcu_fd_sc_mcu7t5v0__clkinv_1
X_7707_ _9890_/Q _7994_/B _7993_/B1 PHY_9/VDD PHY_9/VDD VSUBS VSUBS gf180mcu_fd_sc_mcu7t5v0__nor2_2
X_8687_ _5406_/Z _8687_/A2 _8687_/B1 _8687_/B2 _9940_/D PHY_9/VDD PHY_9/VDD VSUBS
+ VSUBS gf180mcu_fd_sc_mcu7t5v0__oai22_1
X_5899_ _5899_/A1 _5899_/A2 _5899_/B _5899_/C _9658_/D PHY_9/VDD PHY_9/VDD VSUBS VSUBS
+ gf180mcu_fd_sc_mcu7t5v0__aoi211_1
X_7638_ _7582_/C _7638_/A2 _7638_/A3 _7638_/A4 _7639_/B PHY_9/VDD PHY_9/VDD VSUBS
+ VSUBS gf180mcu_fd_sc_mcu7t5v0__nand4_1
X_7569_ _9875_/Q _7567_/Z _7588_/B PHY_9/VDD PHY_9/VDD VSUBS VSUBS gf180mcu_fd_sc_mcu7t5v0__and2_1
X_9308_ _9813_/Q _9306_/Z _9308_/Z PHY_9/VDD PHY_9/VDD VSUBS VSUBS gf180mcu_fd_sc_mcu7t5v0__xor2_1
X_9239_ _9189_/Z _9190_/Z _9239_/B _9276_/B PHY_9/VDD PHY_9/VDD VSUBS VSUBS gf180mcu_fd_sc_mcu7t5v0__aoi21_1
X_6940_ _6940_/A1 _6887_/Z _6939_/Z _6963_/A1 PHY_9/VDD PHY_9/VDD VSUBS VSUBS gf180mcu_fd_sc_mcu7t5v0__nand3_1
X_6871_ _6871_/A1 _6871_/A2 _6871_/Z PHY_9/VDD PHY_9/VDD VSUBS VSUBS gf180mcu_fd_sc_mcu7t5v0__xor2_1
X_9590_ _9590_/D _9940_/CLK _9590_/Q PHY_9/VDD PHY_9/VDD VSUBS VSUBS gf180mcu_fd_sc_mcu7t5v0__dffq_1
X_5822_ _8695_/A1 _5824_/A2 _5824_/B1 _5822_/B2 _9636_/D PHY_9/VDD PHY_9/VDD VSUBS
+ VSUBS gf180mcu_fd_sc_mcu7t5v0__oai22_1
X_8610_ _8611_/A2 _8611_/A3 _8643_/A2 PHY_9/VDD PHY_9/VDD VSUBS VSUBS gf180mcu_fd_sc_mcu7t5v0__nor2_1
X_5753_ _8691_/A1 _5759_/A2 _5759_/B1 _5753_/B2 _9583_/D PHY_9/VDD PHY_9/VDD VSUBS
+ VSUBS gf180mcu_fd_sc_mcu7t5v0__oai22_1
X_8541_ _9930_/Q _9356_/C _8589_/A1 PHY_9/VDD PHY_9/VDD VSUBS VSUBS gf180mcu_fd_sc_mcu7t5v0__nand2_1
X_4704_ _9365_/Q _5244_/A1 PHY_9/VDD PHY_9/VDD VSUBS VSUBS gf180mcu_fd_sc_mcu7t5v0__clkinv_1
X_5684_ _9543_/Q _5681_/Z _5684_/Z PHY_9/VDD PHY_9/VDD VSUBS VSUBS gf180mcu_fd_sc_mcu7t5v0__and2_1
X_8472_ _8473_/A1 _8437_/Z _8472_/B _8496_/B PHY_9/VDD PHY_9/VDD VSUBS VSUBS gf180mcu_fd_sc_mcu7t5v0__aoi21_1
X_7423_ _7424_/A1 _7424_/A2 _7535_/A1 PHY_9/VDD PHY_9/VDD VSUBS VSUBS gf180mcu_fd_sc_mcu7t5v0__nand2_1
X_7354_ _9867_/Q _7364_/A2 _7363_/A2 PHY_9/VDD PHY_9/VDD VSUBS VSUBS gf180mcu_fd_sc_mcu7t5v0__nand2_2
X_6305_ _7007_/B _6313_/A2 _6313_/B1 PHY_9/VDD PHY_9/VDD VSUBS VSUBS gf180mcu_fd_sc_mcu7t5v0__nand2_2
X_7285_ _9855_/Q _9356_/C _7285_/B1 _7285_/B2 _7286_/A2 PHY_9/VDD PHY_9/VDD VSUBS
+ VSUBS gf180mcu_fd_sc_mcu7t5v0__aoi22_1
X_9024_ _9024_/A1 _9012_/Z _9019_/Z _9024_/B2 _9024_/C _9025_/A2 PHY_9/VDD PHY_9/VDD
+ VSUBS VSUBS gf180mcu_fd_sc_mcu7t5v0__oai221_2
X_6236_ _9572_/Q _6287_/A2 _6287_/B1 _9792_/Q _6238_/A1 PHY_9/VDD PHY_9/VDD VSUBS
+ VSUBS gf180mcu_fd_sc_mcu7t5v0__aoi22_1
X_6167_ _9797_/Q _6287_/A2 _6287_/B1 _9561_/Q _6169_/A1 PHY_9/VDD PHY_9/VDD VSUBS
+ VSUBS gf180mcu_fd_sc_mcu7t5v0__aoi22_1
X_5118_ _9830_/Q _6665_/B2 PHY_9/VDD PHY_9/VDD VSUBS VSUBS gf180mcu_fd_sc_mcu7t5v0__clkinv_1
X_6098_ _9419_/Q _6288_/A2 _6287_/A2 _9567_/Q _6099_/A2 PHY_9/VDD PHY_9/VDD VSUBS
+ VSUBS gf180mcu_fd_sc_mcu7t5v0__aoi22_1
X_5049_ _9628_/Q _5812_/B2 PHY_9/VDD PHY_9/VDD VSUBS VSUBS gf180mcu_fd_sc_mcu7t5v0__clkinv_1
X_9926_ _9926_/D _9957_/CLK _9926_/Q PHY_9/VDD PHY_9/VDD VSUBS VSUBS gf180mcu_fd_sc_mcu7t5v0__dffq_2
X_9857_ _9857_/D _9948_/CLK _9857_/Q PHY_9/VDD PHY_9/VDD VSUBS VSUBS gf180mcu_fd_sc_mcu7t5v0__dffq_1
X_8808_ _8734_/I _8792_/Z _8808_/B _8809_/B PHY_9/VDD PHY_9/VDD VSUBS VSUBS gf180mcu_fd_sc_mcu7t5v0__aoi21_1
X_9788_ _9788_/D _9940_/CLK _9788_/Q PHY_9/VDD PHY_9/VDD VSUBS VSUBS gf180mcu_fd_sc_mcu7t5v0__dffq_1
X_8739_ _8768_/A1 _8739_/A2 _8842_/B PHY_9/VDD PHY_9/VDD VSUBS VSUBS gf180mcu_fd_sc_mcu7t5v0__nor2_2
X_7070_ _7040_/B _7070_/A2 _7070_/B _7072_/A2 PHY_9/VDD PHY_9/VDD VSUBS VSUBS gf180mcu_fd_sc_mcu7t5v0__oai21_1
X_6021_ _6089_/B _6029_/A2 _6029_/B1 PHY_9/VDD PHY_9/VDD VSUBS VSUBS gf180mcu_fd_sc_mcu7t5v0__nand2_2
X_7972_ _9813_/Q _8011_/A2 _7974_/A2 PHY_9/VDD PHY_9/VDD VSUBS VSUBS gf180mcu_fd_sc_mcu7t5v0__nand2_1
X_6923_ _6924_/A1 _6924_/A2 _6980_/A2 PHY_9/VDD PHY_9/VDD VSUBS VSUBS gf180mcu_fd_sc_mcu7t5v0__nand2_1
X_9711_ _9711_/D _9939_/CLK _9711_/Q PHY_9/VDD PHY_9/VDD VSUBS VSUBS gf180mcu_fd_sc_mcu7t5v0__dffq_1
X_9642_ _9642_/D _9689_/CLK _9642_/Q PHY_9/VDD PHY_9/VDD VSUBS VSUBS gf180mcu_fd_sc_mcu7t5v0__dffq_1
X_6854_ _9811_/Q _6921_/A2 _6856_/A2 PHY_9/VDD PHY_9/VDD VSUBS VSUBS gf180mcu_fd_sc_mcu7t5v0__nand2_1
X_6785_ _6787_/A1 _6787_/A2 _6813_/B PHY_9/VDD PHY_9/VDD VSUBS VSUBS gf180mcu_fd_sc_mcu7t5v0__nor2_1
X_5805_ _7327_/A1 _6291_/B2 _5814_/A2 PHY_9/VDD PHY_9/VDD VSUBS VSUBS gf180mcu_fd_sc_mcu7t5v0__nand2_4
X_9573_ _9573_/D _9901_/CLK _9573_/Q PHY_9/VDD PHY_9/VDD VSUBS VSUBS gf180mcu_fd_sc_mcu7t5v0__dffq_1
X_5736_ _5404_/Z _5737_/A2 _5737_/B1 _5736_/B2 _9572_/D PHY_9/VDD PHY_9/VDD VSUBS
+ VSUBS gf180mcu_fd_sc_mcu7t5v0__oai22_1
X_8524_ _8664_/A1 _8519_/Z _8538_/C PHY_9/VDD PHY_9/VDD VSUBS VSUBS gf180mcu_fd_sc_mcu7t5v0__nand2_1
X_5667_ _9537_/Q _5664_/Z _5667_/Z PHY_9/VDD PHY_9/VDD VSUBS VSUBS gf180mcu_fd_sc_mcu7t5v0__and2_1
X_8455_ _8455_/A1 _8455_/A2 _8511_/A1 _8634_/A1 _8455_/C _8456_/B PHY_9/VDD PHY_9/VDD
+ VSUBS VSUBS gf180mcu_fd_sc_mcu7t5v0__oai221_1
X_7406_ _9871_/Q _9317_/C _9100_/B _7407_/B PHY_9/VDD PHY_9/VDD VSUBS VSUBS gf180mcu_fd_sc_mcu7t5v0__oai21_1
X_8386_ _9922_/Q _8535_/A1 _8674_/B PHY_9/VDD PHY_9/VDD VSUBS VSUBS gf180mcu_fd_sc_mcu7t5v0__nor2_2
X_5598_ _9090_/A1 _9036_/A2 _5598_/B _9499_/D PHY_9/VDD PHY_9/VDD VSUBS VSUBS gf180mcu_fd_sc_mcu7t5v0__aoi21_1
X_7337_ _9383_/Q _9036_/A2 _7695_/B _7338_/B PHY_9/VDD PHY_9/VDD VSUBS VSUBS gf180mcu_fd_sc_mcu7t5v0__oai21_1
X_7268_ _9855_/Q _7271_/A2 _7287_/B PHY_9/VDD PHY_9/VDD VSUBS VSUBS gf180mcu_fd_sc_mcu7t5v0__nand2_1
X_6219_ _9759_/Q _6287_/A2 _6287_/B1 _9743_/Q _6221_/A1 PHY_9/VDD PHY_9/VDD VSUBS
+ VSUBS gf180mcu_fd_sc_mcu7t5v0__aoi22_1
X_9007_ _9007_/A1 _9007_/A2 _9006_/Z _9007_/Z PHY_9/VDD PHY_9/VDD VSUBS VSUBS gf180mcu_fd_sc_mcu7t5v0__xor3_1
X_7199_ _7200_/A1 _7200_/A3 _7242_/A2 PHY_9/VDD PHY_9/VDD VSUBS VSUBS gf180mcu_fd_sc_mcu7t5v0__nand2_1
X_9909_ _9909_/D _9957_/CLK _9909_/Q PHY_9/VDD PHY_9/VDD VSUBS VSUBS gf180mcu_fd_sc_mcu7t5v0__dffq_4
X_6570_ _6570_/A1 _6570_/A2 _6646_/A1 PHY_9/VDD PHY_9/VDD VSUBS VSUBS gf180mcu_fd_sc_mcu7t5v0__nand2_4
X_5521_ _9441_/Q _5498_/Z _5523_/B1 PHY_9/VDD PHY_9/VDD VSUBS VSUBS gf180mcu_fd_sc_mcu7t5v0__nand2_1
X_8240_ _8240_/A1 _8198_/Z _8292_/A1 PHY_9/VDD PHY_9/VDD VSUBS VSUBS gf180mcu_fd_sc_mcu7t5v0__nand2_1
X_5452_ _5486_/A1 _5458_/A2 _5452_/B _9438_/D PHY_9/VDD PHY_9/VDD VSUBS VSUBS gf180mcu_fd_sc_mcu7t5v0__aoi21_1
X_8171_ _9808_/Q _8311_/A2 _8256_/A2 PHY_9/VDD PHY_9/VDD VSUBS VSUBS gf180mcu_fd_sc_mcu7t5v0__nand2_1
X_5383_ _5383_/I _5636_/A3 PHY_9/VDD PHY_9/VDD VSUBS VSUBS gf180mcu_fd_sc_mcu7t5v0__inv_3
X_7122_ _7122_/A1 _7120_/Z _7122_/Z PHY_9/VDD PHY_9/VDD VSUBS VSUBS gf180mcu_fd_sc_mcu7t5v0__xor2_1
X_7053_ _9807_/Q _7053_/A2 _7052_/B _7053_/Z PHY_9/VDD PHY_9/VDD VSUBS VSUBS gf180mcu_fd_sc_mcu7t5v0__or3_1
X_6004_ _8693_/A1 _6008_/A2 _6008_/B1 _6004_/B2 _9709_/D PHY_9/VDD PHY_9/VDD VSUBS
+ VSUBS gf180mcu_fd_sc_mcu7t5v0__oai22_1
X_7955_ _7955_/A1 _7955_/A2 _7955_/B _7982_/B PHY_9/VDD PHY_9/VDD VSUBS VSUBS gf180mcu_fd_sc_mcu7t5v0__oai21_1
X_6906_ _9812_/Q _6977_/A2 _6906_/B _6907_/A4 PHY_9/VDD PHY_9/VDD VSUBS VSUBS gf180mcu_fd_sc_mcu7t5v0__oai21_1
X_7886_ _9807_/Q _7992_/A2 _7887_/I PHY_9/VDD PHY_9/VDD VSUBS VSUBS gf180mcu_fd_sc_mcu7t5v0__nand2_1
X_6837_ _6837_/A1 _6835_/Z _6837_/Z PHY_9/VDD PHY_9/VDD VSUBS VSUBS gf180mcu_fd_sc_mcu7t5v0__xor2_1
X_9625_ _9625_/D _9948_/CLK _9625_/Q PHY_9/VDD PHY_9/VDD VSUBS VSUBS gf180mcu_fd_sc_mcu7t5v0__dffq_1
X_9556_ _9556_/D _9948_/CLK _9556_/Q PHY_9/VDD PHY_9/VDD VSUBS VSUBS gf180mcu_fd_sc_mcu7t5v0__dffq_1
X_6768_ _6768_/A1 _6768_/A2 _9357_/B _9838_/D PHY_9/VDD PHY_9/VDD VSUBS VSUBS gf180mcu_fd_sc_mcu7t5v0__aoi21_1
X_8507_ _9811_/Q _8606_/A2 _8560_/A1 PHY_9/VDD PHY_9/VDD VSUBS VSUBS gf180mcu_fd_sc_mcu7t5v0__nand2_1
X_6699_ _9833_/Q _9832_/Q _6699_/A3 _6700_/C PHY_9/VDD PHY_9/VDD VSUBS VSUBS gf180mcu_fd_sc_mcu7t5v0__nand3_4
X_5719_ _5474_/B _5727_/A2 _5727_/B1 PHY_9/VDD PHY_9/VDD VSUBS VSUBS gf180mcu_fd_sc_mcu7t5v0__nand2_2
X_9487_ _9487_/D _9801_/CLK _9487_/Q PHY_9/VDD PHY_9/VDD VSUBS VSUBS gf180mcu_fd_sc_mcu7t5v0__dffq_1
X_8438_ _8438_/A1 _8437_/Z _8438_/Z PHY_9/VDD PHY_9/VDD VSUBS VSUBS gf180mcu_fd_sc_mcu7t5v0__and2_1
X_8369_ _8416_/A2 _8416_/A3 _8416_/A4 _8369_/Z PHY_9/VDD PHY_9/VDD VSUBS VSUBS gf180mcu_fd_sc_mcu7t5v0__or3_2
X_4952_ _9633_/Q _5819_/B2 PHY_9/VDD PHY_9/VDD VSUBS VSUBS gf180mcu_fd_sc_mcu7t5v0__clkinv_1
X_7740_ _8777_/A1 _7738_/C _7740_/B1 _7740_/B2 _7948_/A2 PHY_9/VDD PHY_9/VDD VSUBS
+ VSUBS gf180mcu_fd_sc_mcu7t5v0__aoi22_4
X_7671_ _7671_/A1 _7671_/A2 _7672_/A3 PHY_9/VDD PHY_9/VDD VSUBS VSUBS gf180mcu_fd_sc_mcu7t5v0__nand2_1
X_4883_ _9481_/Q _5551_/B2 PHY_9/VDD PHY_9/VDD VSUBS VSUBS gf180mcu_fd_sc_mcu7t5v0__clkinv_1
X_6622_ _6622_/A1 _6631_/A1 _6578_/Z _6622_/B2 _6638_/A1 PHY_9/VDD PHY_9/VDD VSUBS
+ VSUBS gf180mcu_fd_sc_mcu7t5v0__oai22_1
X_9410_ _9410_/D _9901_/CLK _9410_/Q PHY_9/VDD PHY_9/VDD VSUBS VSUBS gf180mcu_fd_sc_mcu7t5v0__dffq_1
X_6553_ _6634_/A2 _6606_/A1 _6553_/Z PHY_9/VDD PHY_9/VDD VSUBS VSUBS gf180mcu_fd_sc_mcu7t5v0__xor2_1
X_9341_ _9974_/Q _9340_/Z _9341_/Z PHY_9/VDD PHY_9/VDD VSUBS VSUBS gf180mcu_fd_sc_mcu7t5v0__xor2_1
X_6484_ _9807_/Q _6577_/A2 _6488_/A1 PHY_9/VDD PHY_9/VDD VSUBS VSUBS gf180mcu_fd_sc_mcu7t5v0__nand2_1
X_9272_ _9807_/Q _9351_/A2 _9275_/A1 PHY_9/VDD PHY_9/VDD VSUBS VSUBS gf180mcu_fd_sc_mcu7t5v0__nand2_1
X_5504_ _9435_/Q _5498_/Z _5522_/B _9461_/Q _5504_/C _5505_/A2 PHY_9/VDD PHY_9/VDD
+ VSUBS VSUBS gf180mcu_fd_sc_mcu7t5v0__aoi221_1
X_8223_ _6558_/B _8075_/B _8276_/A1 PHY_9/VDD PHY_9/VDD VSUBS VSUBS gf180mcu_fd_sc_mcu7t5v0__nor2_1
X_5435_ _9731_/Q _9432_/Q _9031_/B _5436_/B PHY_9/VDD PHY_9/VDD VSUBS VSUBS gf180mcu_fd_sc_mcu7t5v0__oai21_1
X_5366_ _5366_/I _5783_/A1 PHY_9/VDD PHY_9/VDD VSUBS VSUBS gf180mcu_fd_sc_mcu7t5v0__clkinv_1
X_8154_ _9810_/Q _8311_/A2 _8268_/A1 PHY_9/VDD PHY_9/VDD VSUBS VSUBS gf180mcu_fd_sc_mcu7t5v0__nand2_1
X_7105_ _9852_/Q _9356_/C _7142_/A1 PHY_9/VDD PHY_9/VDD VSUBS VSUBS gf180mcu_fd_sc_mcu7t5v0__nand2_1
X_8085_ _9091_/B _8309_/A2 _8130_/A1 PHY_9/VDD PHY_9/VDD VSUBS VSUBS gf180mcu_fd_sc_mcu7t5v0__nor2_1
X_5297_ _5343_/A1 _5297_/A2 _5307_/A2 PHY_9/VDD PHY_9/VDD VSUBS VSUBS gf180mcu_fd_sc_mcu7t5v0__nor2_4
X_7036_ _7036_/A1 _7028_/S _7139_/C PHY_9/VDD PHY_9/VDD VSUBS VSUBS gf180mcu_fd_sc_mcu7t5v0__nor2_4
X_8987_ _8842_/B _8987_/A2 _8987_/B _9356_/C _8988_/B PHY_9/VDD PHY_9/VDD VSUBS VSUBS
+ gf180mcu_fd_sc_mcu7t5v0__aoi211_1
X_7938_ _7935_/Z _7938_/A2 _8001_/A1 PHY_9/VDD PHY_9/VDD VSUBS VSUBS gf180mcu_fd_sc_mcu7t5v0__nand2_1
X_9608_ _9608_/D _9948_/CLK _9608_/Q PHY_9/VDD PHY_9/VDD VSUBS VSUBS gf180mcu_fd_sc_mcu7t5v0__dffq_1
X_7869_ _7869_/I _7913_/A2 PHY_9/VDD PHY_9/VDD VSUBS VSUBS gf180mcu_fd_sc_mcu7t5v0__clkinv_1
X_9539_ _9539_/D _9689_/CLK _9539_/Q PHY_9/VDD PHY_9/VDD VSUBS VSUBS gf180mcu_fd_sc_mcu7t5v0__dffq_1
X_5220_ _5961_/B _9723_/Q _9731_/D PHY_9/VDD PHY_9/VDD VSUBS VSUBS gf180mcu_fd_sc_mcu7t5v0__and2_1
X_5151_ _9668_/Q _9667_/Q _9670_/Q _9669_/Q _5153_/A1 PHY_9/VDD PHY_9/VDD VSUBS VSUBS
+ gf180mcu_fd_sc_mcu7t5v0__nor4_1
X_5082_ _9947_/Q _8696_/B2 PHY_9/VDD PHY_9/VDD VSUBS VSUBS gf180mcu_fd_sc_mcu7t5v0__clkinv_1
X_8910_ _8909_/B _8910_/A2 _8999_/B2 _8910_/Z PHY_9/VDD PHY_9/VDD VSUBS VSUBS gf180mcu_fd_sc_mcu7t5v0__xor3_1
X_9890_ _9890_/D _9957_/CLK _9890_/Q PHY_9/VDD PHY_9/VDD VSUBS VSUBS gf180mcu_fd_sc_mcu7t5v0__dffq_4
X_8841_ _8982_/B1 _8954_/A1 _8982_/C _8843_/B1 PHY_9/VDD PHY_9/VDD VSUBS VSUBS gf180mcu_fd_sc_mcu7t5v0__aoi21_1
X_8772_ _9955_/Q _8767_/Z _8772_/Z PHY_9/VDD PHY_9/VDD VSUBS VSUBS gf180mcu_fd_sc_mcu7t5v0__xor2_1
X_5984_ _8693_/A1 _5988_/A2 _5988_/B1 _5984_/B2 _9693_/D PHY_9/VDD PHY_9/VDD VSUBS
+ VSUBS gf180mcu_fd_sc_mcu7t5v0__oai22_1
X_7723_ _9807_/Q _7973_/A2 _7728_/A2 _7723_/B2 _8009_/C _7726_/B2 PHY_9/VDD PHY_9/VDD
+ VSUBS VSUBS gf180mcu_fd_sc_mcu7t5v0__aoi221_1
X_4935_ _9592_/Q _5764_/B2 PHY_9/VDD PHY_9/VDD VSUBS VSUBS gf180mcu_fd_sc_mcu7t5v0__clkinv_1
X_7654_ _9811_/Q _7654_/A2 _7658_/A2 PHY_9/VDD PHY_9/VDD VSUBS VSUBS gf180mcu_fd_sc_mcu7t5v0__nand2_1
X_4866_ _9479_/Q _5888_/A1 PHY_9/VDD PHY_9/VDD VSUBS VSUBS gf180mcu_fd_sc_mcu7t5v0__clkinv_1
X_6605_ _6646_/B _6634_/A2 _6606_/A2 PHY_9/VDD PHY_9/VDD VSUBS VSUBS gf180mcu_fd_sc_mcu7t5v0__nand2_1
X_7585_ _9875_/Q _9356_/C _7585_/B _7586_/A2 PHY_9/VDD PHY_9/VDD VSUBS VSUBS gf180mcu_fd_sc_mcu7t5v0__aoi21_1
X_4797_ _9811_/Q _6512_/B PHY_9/VDD PHY_9/VDD VSUBS VSUBS gf180mcu_fd_sc_mcu7t5v0__clkinv_8
X_6536_ _6538_/A2 _6538_/A3 _6575_/B PHY_9/VDD PHY_9/VDD VSUBS VSUBS gf180mcu_fd_sc_mcu7t5v0__nand2_1
X_9324_ _9808_/Q _9351_/A2 _9330_/A1 PHY_9/VDD PHY_9/VDD VSUBS VSUBS gf180mcu_fd_sc_mcu7t5v0__nand2_1
X_6467_ _9810_/Q _6466_/Z _6510_/A1 PHY_9/VDD PHY_9/VDD VSUBS VSUBS gf180mcu_fd_sc_mcu7t5v0__nand2_1
X_9255_ _9812_/Q _9253_/Z _9257_/B PHY_9/VDD PHY_9/VDD VSUBS VSUBS gf180mcu_fd_sc_mcu7t5v0__xor2_1
X_6398_ _9808_/Q _6584_/B1 _6421_/A1 PHY_9/VDD PHY_9/VDD VSUBS VSUBS gf180mcu_fd_sc_mcu7t5v0__nand2_1
X_9186_ _9811_/Q _9331_/A2 _9285_/A2 _9810_/Q _9190_/A2 PHY_9/VDD PHY_9/VDD VSUBS
+ VSUBS gf180mcu_fd_sc_mcu7t5v0__aoi22_1
X_5418_ _5418_/I _5419_/B1 PHY_9/VDD PHY_9/VDD VSUBS VSUBS gf180mcu_fd_sc_mcu7t5v0__clkinv_1
X_8206_ _9356_/C _8206_/A2 _8207_/B2 PHY_9/VDD PHY_9/VDD VSUBS VSUBS gf180mcu_fd_sc_mcu7t5v0__nor2_1
X_8137_ _8139_/A2 _8136_/Z _8163_/B PHY_9/VDD PHY_9/VDD VSUBS VSUBS gf180mcu_fd_sc_mcu7t5v0__nor2_1
X_5349_ _5393_/A1 _5353_/A2 _5349_/B _5973_/C _9410_/D PHY_9/VDD PHY_9/VDD VSUBS VSUBS
+ gf180mcu_fd_sc_mcu7t5v0__aoi211_1
X_8068_ _8318_/A1 _9902_/Q _9850_/Q _8068_/Z PHY_9/VDD PHY_9/VDD VSUBS VSUBS gf180mcu_fd_sc_mcu7t5v0__and3_1
X_7019_ _7019_/I _7053_/A2 PHY_9/VDD PHY_9/VDD VSUBS VSUBS gf180mcu_fd_sc_mcu7t5v0__clkinv_1
X_4720_ _9370_/Q _5256_/A1 PHY_9/VDD PHY_9/VDD VSUBS VSUBS gf180mcu_fd_sc_mcu7t5v0__clkinv_1
X_7370_ _7370_/A1 _7370_/A2 _7482_/B PHY_9/VDD PHY_9/VDD VSUBS VSUBS gf180mcu_fd_sc_mcu7t5v0__nor2_4
X_6321_ _8695_/A1 _6323_/A2 _6323_/B1 _6321_/B2 _9799_/D PHY_9/VDD PHY_9/VDD VSUBS
+ VSUBS gf180mcu_fd_sc_mcu7t5v0__oai22_1
X_6252_ _9752_/Q _6288_/A2 _6288_/B1 _9768_/Q _6253_/A2 PHY_9/VDD PHY_9/VDD VSUBS
+ VSUBS gf180mcu_fd_sc_mcu7t5v0__aoi22_1
X_9040_ _9966_/Q _9965_/Q _9270_/B PHY_9/VDD PHY_9/VDD VSUBS VSUBS gf180mcu_fd_sc_mcu7t5v0__nor2_4
X_6183_ _6183_/A1 _6183_/A2 _6204_/A2 PHY_9/VDD PHY_9/VDD VSUBS VSUBS gf180mcu_fd_sc_mcu7t5v0__nand2_1
X_5203_ _9731_/Q _5474_/B _5205_/B PHY_9/VDD PHY_9/VDD VSUBS VSUBS gf180mcu_fd_sc_mcu7t5v0__nand2_1
X_5134_ _9641_/Q _5437_/A2 _5132_/Z _9654_/Q _5883_/A3 _9672_/Q _5135_/A2 PHY_9/VDD
+ PHY_9/VDD VSUBS VSUBS gf180mcu_fd_sc_mcu7t5v0__aoi222_2
X_5065_ _9580_/Q _5748_/B2 PHY_9/VDD PHY_9/VDD VSUBS VSUBS gf180mcu_fd_sc_mcu7t5v0__clkinv_1
X_9942_ _9942_/D _9948_/CLK _9942_/Q PHY_9/VDD PHY_9/VDD VSUBS VSUBS gf180mcu_fd_sc_mcu7t5v0__dffq_1
X_9873_ _9873_/D _9907_/CLK _9873_/Q PHY_9/VDD PHY_9/VDD VSUBS VSUBS gf180mcu_fd_sc_mcu7t5v0__dffq_2
X_8824_ _8824_/A1 _8821_/Z _8826_/A2 PHY_9/VDD PHY_9/VDD VSUBS VSUBS gf180mcu_fd_sc_mcu7t5v0__xnor2_1
X_5967_ _9652_/Q _5973_/A2 _5967_/B _5968_/B PHY_9/VDD PHY_9/VDD VSUBS VSUBS gf180mcu_fd_sc_mcu7t5v0__oai21_1
X_8755_ _8755_/A1 _8719_/C _8755_/B1 _8755_/B2 _8796_/B _8758_/A3 PHY_9/VDD PHY_9/VDD
+ VSUBS VSUBS gf180mcu_fd_sc_mcu7t5v0__aoi221_4
X_8686_ _5404_/Z _8687_/A2 _8687_/B1 _8686_/B2 _9939_/D PHY_9/VDD PHY_9/VDD VSUBS
+ VSUBS gf180mcu_fd_sc_mcu7t5v0__oai22_1
X_4918_ _9616_/Q _5798_/B2 PHY_9/VDD PHY_9/VDD VSUBS VSUBS gf180mcu_fd_sc_mcu7t5v0__clkinv_1
X_7706_ _9889_/Q _7706_/A2 _7708_/A3 PHY_9/VDD PHY_9/VDD VSUBS VSUBS gf180mcu_fd_sc_mcu7t5v0__nor2_1
X_7637_ _9813_/Q _7670_/A2 _7637_/B _7638_/A4 PHY_9/VDD PHY_9/VDD VSUBS VSUBS gf180mcu_fd_sc_mcu7t5v0__oai21_1
X_5898_ _5967_/B _5901_/A2 _5899_/C PHY_9/VDD PHY_9/VDD VSUBS VSUBS gf180mcu_fd_sc_mcu7t5v0__nand2_1
X_4849_ _9734_/Q _5495_/A2 PHY_9/VDD PHY_9/VDD VSUBS VSUBS gf180mcu_fd_sc_mcu7t5v0__inv_2
X_7568_ _9875_/Q _7567_/Z _7568_/Z PHY_9/VDD PHY_9/VDD VSUBS VSUBS gf180mcu_fd_sc_mcu7t5v0__or2_1
X_6519_ _7497_/A2 _9356_/C _6519_/B _9819_/D PHY_9/VDD PHY_9/VDD VSUBS VSUBS gf180mcu_fd_sc_mcu7t5v0__aoi21_1
X_7499_ _8540_/A1 _7650_/B1 _7499_/B1 _7499_/B2 _7599_/A2 PHY_9/VDD PHY_9/VDD VSUBS
+ VSUBS gf180mcu_fd_sc_mcu7t5v0__aoi22_4
X_9307_ _9813_/Q _9306_/Z _9350_/A1 PHY_9/VDD PHY_9/VDD VSUBS VSUBS gf180mcu_fd_sc_mcu7t5v0__nand2_1
X_9238_ _9238_/A1 _9281_/B2 _9323_/A1 _9239_/B PHY_9/VDD PHY_9/VDD VSUBS VSUBS gf180mcu_fd_sc_mcu7t5v0__xor3_1
X_9169_ _9810_/Q _9333_/A2 _9169_/B1 _9348_/C _9171_/A1 PHY_9/VDD PHY_9/VDD VSUBS
+ VSUBS gf180mcu_fd_sc_mcu7t5v0__oai22_1
X_6870_ _6871_/A1 _6871_/A2 _6916_/B PHY_9/VDD PHY_9/VDD VSUBS VSUBS gf180mcu_fd_sc_mcu7t5v0__nor2_1
X_5821_ _5399_/Z _5824_/A2 _5824_/B1 _5821_/B2 _9635_/D PHY_9/VDD PHY_9/VDD VSUBS
+ VSUBS gf180mcu_fd_sc_mcu7t5v0__oai22_1
X_5752_ _5388_/Z _5759_/A2 _5759_/B1 _5752_/B2 _9582_/D PHY_9/VDD PHY_9/VDD VSUBS
+ VSUBS gf180mcu_fd_sc_mcu7t5v0__oai22_1
X_8540_ _8540_/A1 _9356_/C _9357_/B _8540_/C _9929_/D PHY_9/VDD PHY_9/VDD VSUBS VSUBS
+ gf180mcu_fd_sc_mcu7t5v0__aoi211_1
X_4703_ _9951_/Q _8768_/A1 PHY_9/VDD PHY_9/VDD VSUBS VSUBS gf180mcu_fd_sc_mcu7t5v0__inv_2
X_8471_ _8471_/A1 _8466_/Z _8471_/A3 _8472_/B PHY_9/VDD PHY_9/VDD VSUBS VSUBS gf180mcu_fd_sc_mcu7t5v0__xor3_1
X_5683_ _5681_/Z _5683_/A2 _9542_/D PHY_9/VDD PHY_9/VDD VSUBS VSUBS gf180mcu_fd_sc_mcu7t5v0__nor2_1
X_7422_ _7422_/I _7424_/A2 PHY_9/VDD PHY_9/VDD VSUBS VSUBS gf180mcu_fd_sc_mcu7t5v0__clkinv_1
X_7353_ _9807_/Q _7647_/A2 _7396_/A1 PHY_9/VDD PHY_9/VDD VSUBS VSUBS gf180mcu_fd_sc_mcu7t5v0__nand2_1
X_6304_ _5372_/Z _7327_/A1 _6313_/A2 PHY_9/VDD PHY_9/VDD VSUBS VSUBS gf180mcu_fd_sc_mcu7t5v0__nand2_4
X_7284_ _7139_/C _7270_/Z _9356_/C _7285_/B2 PHY_9/VDD PHY_9/VDD VSUBS VSUBS gf180mcu_fd_sc_mcu7t5v0__aoi21_1
X_9023_ _8982_/C _9023_/A2 _9023_/A3 _9023_/B1 _9814_/Q _9024_/C PHY_9/VDD PHY_9/VDD
+ VSUBS VSUBS gf180mcu_fd_sc_mcu7t5v0__oai32_1
X_6235_ _6089_/B _6235_/A2 _9775_/D PHY_9/VDD PHY_9/VDD VSUBS VSUBS gf180mcu_fd_sc_mcu7t5v0__and2_1
X_6166_ _6166_/A1 _6166_/A2 _6175_/B1 PHY_9/VDD PHY_9/VDD VSUBS VSUBS gf180mcu_fd_sc_mcu7t5v0__nand2_1
X_5117_ _9864_/Q _7336_/B2 PHY_9/VDD PHY_9/VDD VSUBS VSUBS gf180mcu_fd_sc_mcu7t5v0__clkinv_1
X_6097_ _9787_/Q _6287_/B1 _6288_/B1 _9551_/Q _6099_/A1 PHY_9/VDD PHY_9/VDD VSUBS
+ VSUBS gf180mcu_fd_sc_mcu7t5v0__aoi22_1
X_5048_ _9636_/Q _5822_/B2 PHY_9/VDD PHY_9/VDD VSUBS VSUBS gf180mcu_fd_sc_mcu7t5v0__clkinv_1
X_9925_ _9925_/D _9957_/CLK _9925_/Q PHY_9/VDD PHY_9/VDD VSUBS VSUBS gf180mcu_fd_sc_mcu7t5v0__dffq_2
X_9856_ _9856_/D _9856_/CLK _9856_/Q PHY_9/VDD PHY_9/VDD VSUBS VSUBS gf180mcu_fd_sc_mcu7t5v0__dffq_2
X_9787_ _9787_/D _9940_/CLK _9787_/Q PHY_9/VDD PHY_9/VDD VSUBS VSUBS gf180mcu_fd_sc_mcu7t5v0__dffq_1
X_8807_ _8807_/A1 _8807_/A2 _8808_/B PHY_9/VDD PHY_9/VDD VSUBS VSUBS gf180mcu_fd_sc_mcu7t5v0__nand2_1
X_6999_ _6999_/A1 _6985_/Z _6999_/B _6999_/C _7000_/A2 PHY_9/VDD PHY_9/VDD VSUBS VSUBS
+ gf180mcu_fd_sc_mcu7t5v0__oai211_1
X_8738_ _8736_/B _8738_/A2 _8738_/B _8738_/C _8741_/B PHY_9/VDD PHY_9/VDD VSUBS VSUBS
+ gf180mcu_fd_sc_mcu7t5v0__oai211_1
X_8669_ _8444_/B _8669_/A2 _8670_/A2 PHY_9/VDD PHY_9/VDD VSUBS VSUBS gf180mcu_fd_sc_mcu7t5v0__nand2_1
X_6020_ _7327_/A1 _6290_/B2 _6029_/A2 PHY_9/VDD PHY_9/VDD VSUBS VSUBS gf180mcu_fd_sc_mcu7t5v0__nand2_4
Xclkbuf_leaf_3_clk clkbuf_leaf_8_clk/I _9830_/CLK PHY_9/VDD PHY_9/VDD VSUBS VSUBS
+ gf180mcu_fd_sc_mcu7t5v0__clkbuf_16
X_7971_ _7870_/B _7971_/A2 _7976_/A2 PHY_9/VDD PHY_9/VDD VSUBS VSUBS gf180mcu_fd_sc_mcu7t5v0__nand2_1
X_6922_ _6924_/A1 _6924_/A2 _6980_/B PHY_9/VDD PHY_9/VDD VSUBS VSUBS gf180mcu_fd_sc_mcu7t5v0__nor2_1
X_9710_ _9710_/D _9939_/CLK _9710_/Q PHY_9/VDD PHY_9/VDD VSUBS VSUBS gf180mcu_fd_sc_mcu7t5v0__dffq_1
X_6853_ _6995_/C _6900_/A2 _6858_/A2 PHY_9/VDD PHY_9/VDD VSUBS VSUBS gf180mcu_fd_sc_mcu7t5v0__nand2_1
X_9641_ _9641_/D _9689_/CLK _9641_/Q PHY_9/VDD PHY_9/VDD VSUBS VSUBS gf180mcu_fd_sc_mcu7t5v0__dffq_1
X_5804_ _5406_/Z _5804_/A2 _5804_/B1 _5804_/B2 _9622_/D PHY_9/VDD PHY_9/VDD VSUBS
+ VSUBS gf180mcu_fd_sc_mcu7t5v0__oai22_1
X_6784_ _6784_/A1 _6779_/Z _6784_/A3 _6787_/A2 PHY_9/VDD PHY_9/VDD VSUBS VSUBS gf180mcu_fd_sc_mcu7t5v0__xnor3_1
X_9572_ _9572_/D _9830_/CLK _9572_/Q PHY_9/VDD PHY_9/VDD VSUBS VSUBS gf180mcu_fd_sc_mcu7t5v0__dffq_1
X_5735_ _8695_/A1 _5737_/A2 _5737_/B1 _5735_/B2 _9571_/D PHY_9/VDD PHY_9/VDD VSUBS
+ VSUBS gf180mcu_fd_sc_mcu7t5v0__oai22_1
X_8523_ _8391_/C _8522_/Z _8539_/B PHY_9/VDD PHY_9/VDD VSUBS VSUBS gf180mcu_fd_sc_mcu7t5v0__nor2_1
X_5666_ _9537_/Q _5664_/Z _5668_/A2 PHY_9/VDD PHY_9/VDD VSUBS VSUBS gf180mcu_fd_sc_mcu7t5v0__nor2_1
X_8454_ _9809_/Q _8674_/A2 _8491_/C _8455_/C PHY_9/VDD PHY_9/VDD VSUBS VSUBS gf180mcu_fd_sc_mcu7t5v0__aoi21_1
X_7405_ _7582_/C _7404_/Z _7405_/B _7407_/A2 PHY_9/VDD PHY_9/VDD VSUBS VSUBS gf180mcu_fd_sc_mcu7t5v0__oai21_1
X_8385_ _8389_/A1 _8535_/A1 _8674_/A2 PHY_9/VDD PHY_9/VDD VSUBS VSUBS gf180mcu_fd_sc_mcu7t5v0__nor2_2
X_5597_ _9771_/Q _9036_/A2 _9035_/B _5598_/B PHY_9/VDD PHY_9/VDD VSUBS VSUBS gf180mcu_fd_sc_mcu7t5v0__oai21_1
X_7336_ _5406_/Z _7336_/A2 _7336_/B1 _7336_/B2 _9864_/D PHY_9/VDD PHY_9/VDD VSUBS
+ VSUBS gf180mcu_fd_sc_mcu7t5v0__oai22_1
X_7267_ _7267_/A1 _7217_/Z _7266_/B _7271_/A2 PHY_9/VDD PHY_9/VDD VSUBS VSUBS gf180mcu_fd_sc_mcu7t5v0__xnor3_1
X_6218_ _6218_/A1 _6218_/A2 _6232_/A2 PHY_9/VDD PHY_9/VDD VSUBS VSUBS gf180mcu_fd_sc_mcu7t5v0__nand2_1
X_9006_ _9006_/A1 _9006_/A2 _9006_/A3 _9006_/Z PHY_9/VDD PHY_9/VDD VSUBS VSUBS gf180mcu_fd_sc_mcu7t5v0__xor3_1
X_7198_ _7200_/A1 _7200_/A3 _7242_/B PHY_9/VDD PHY_9/VDD VSUBS VSUBS gf180mcu_fd_sc_mcu7t5v0__nor2_1
X_6149_ _9569_/Q _6287_/A2 _6287_/B1 _9789_/Q _6151_/A1 PHY_9/VDD PHY_9/VDD VSUBS
+ VSUBS gf180mcu_fd_sc_mcu7t5v0__aoi22_1
X_9908_ _9908_/D _9957_/CLK _9908_/Q PHY_9/VDD PHY_9/VDD VSUBS VSUBS gf180mcu_fd_sc_mcu7t5v0__dffq_2
X_9839_ _9839_/D _9907_/CLK _9839_/Q PHY_9/VDD PHY_9/VDD VSUBS VSUBS gf180mcu_fd_sc_mcu7t5v0__dffq_2
X_5520_ _5520_/A1 _5522_/B _5520_/B1 _5520_/B2 _5973_/C _9466_/D PHY_9/VDD PHY_9/VDD
+ VSUBS VSUBS gf180mcu_fd_sc_mcu7t5v0__aoi221_1
X_5451_ _9438_/Q _5458_/A2 _9035_/B _5452_/B PHY_9/VDD PHY_9/VDD VSUBS VSUBS gf180mcu_fd_sc_mcu7t5v0__oai21_1
X_8170_ _9807_/Q _8266_/A2 _8256_/A1 PHY_9/VDD PHY_9/VDD VSUBS VSUBS gf180mcu_fd_sc_mcu7t5v0__nand2_1
X_5382_ _9494_/Q _9470_/Q _5559_/B _5383_/I PHY_9/VDD PHY_9/VDD VSUBS VSUBS gf180mcu_fd_sc_mcu7t5v0__mux2_4
X_7121_ _7122_/A1 _7120_/Z _7165_/A1 PHY_9/VDD PHY_9/VDD VSUBS VSUBS gf180mcu_fd_sc_mcu7t5v0__nand2_1
X_7052_ _9807_/Q _7053_/A2 _7052_/B _7094_/A2 PHY_9/VDD PHY_9/VDD VSUBS VSUBS gf180mcu_fd_sc_mcu7t5v0__oai21_2
X_6003_ _8692_/A1 _6008_/A2 _6008_/B1 _6003_/B2 _9708_/D PHY_9/VDD PHY_9/VDD VSUBS
+ VSUBS gf180mcu_fd_sc_mcu7t5v0__oai22_1
X_7954_ _7945_/I _7954_/A2 _7952_/B _7955_/B PHY_9/VDD PHY_9/VDD VSUBS VSUBS gf180mcu_fd_sc_mcu7t5v0__xor3_1
X_6905_ _6997_/B2 _6905_/A2 _6905_/B _6906_/B PHY_9/VDD PHY_9/VDD VSUBS VSUBS gf180mcu_fd_sc_mcu7t5v0__oai21_1
X_7885_ _7738_/C _7885_/A2 _7885_/B _7992_/A2 PHY_9/VDD PHY_9/VDD VSUBS VSUBS gf180mcu_fd_sc_mcu7t5v0__oai21_4
X_6836_ _6837_/A1 _6835_/Z _6941_/A1 PHY_9/VDD PHY_9/VDD VSUBS VSUBS gf180mcu_fd_sc_mcu7t5v0__nor2_1
X_9624_ _9624_/D _9948_/CLK _9624_/Q PHY_9/VDD PHY_9/VDD VSUBS VSUBS gf180mcu_fd_sc_mcu7t5v0__dffq_1
X_9555_ _9555_/D _9830_/CLK _9555_/Q PHY_9/VDD PHY_9/VDD VSUBS VSUBS gf180mcu_fd_sc_mcu7t5v0__dffq_1
X_6767_ _6700_/C _6751_/Z _6767_/B _9317_/C _6768_/A2 PHY_9/VDD PHY_9/VDD VSUBS VSUBS
+ gf180mcu_fd_sc_mcu7t5v0__oai211_1
X_8506_ _9811_/Q _8654_/A2 _8606_/A2 _9810_/Q _8510_/A2 PHY_9/VDD PHY_9/VDD VSUBS
+ VSUBS gf180mcu_fd_sc_mcu7t5v0__aoi22_1
X_5718_ _7327_/A1 _6656_/A2 _5727_/A2 PHY_9/VDD PHY_9/VDD VSUBS VSUBS gf180mcu_fd_sc_mcu7t5v0__nand2_4
X_6698_ _6698_/A1 _6698_/A2 _9831_/Q _6808_/C PHY_9/VDD PHY_9/VDD VSUBS VSUBS gf180mcu_fd_sc_mcu7t5v0__nor3_4
X_9486_ _9486_/D _9801_/CLK _9486_/Q PHY_9/VDD PHY_9/VDD VSUBS VSUBS gf180mcu_fd_sc_mcu7t5v0__dffq_1
X_5649_ _5388_/Z _5656_/A2 _5656_/B1 _5649_/B2 _9526_/D PHY_9/VDD PHY_9/VDD VSUBS
+ VSUBS gf180mcu_fd_sc_mcu7t5v0__oai22_1
X_8437_ _8436_/B _8433_/Z _8437_/A3 _8437_/Z PHY_9/VDD PHY_9/VDD VSUBS VSUBS gf180mcu_fd_sc_mcu7t5v0__or3_1
X_8368_ _8416_/A2 _8416_/A3 _8416_/A4 _8654_/A2 PHY_9/VDD PHY_9/VDD VSUBS VSUBS gf180mcu_fd_sc_mcu7t5v0__nor3_4
X_7319_ _7089_/B _7319_/A2 _7320_/A2 PHY_9/VDD PHY_9/VDD VSUBS VSUBS gf180mcu_fd_sc_mcu7t5v0__nand2_1
X_8299_ _9813_/Q _8333_/A2 _8301_/A2 PHY_9/VDD PHY_9/VDD VSUBS VSUBS gf180mcu_fd_sc_mcu7t5v0__nand2_1
X_4951_ _9609_/Q _5789_/B2 PHY_9/VDD PHY_9/VDD VSUBS VSUBS gf180mcu_fd_sc_mcu7t5v0__clkinv_1
X_7670_ _7473_/B _7670_/A2 _7671_/A2 PHY_9/VDD PHY_9/VDD VSUBS VSUBS gf180mcu_fd_sc_mcu7t5v0__nand2_1
X_4882_ _9714_/Q _6011_/B2 PHY_9/VDD PHY_9/VDD VSUBS VSUBS gf180mcu_fd_sc_mcu7t5v0__clkinv_1
X_6621_ _6621_/A1 _6621_/A2 _6642_/A1 PHY_9/VDD PHY_9/VDD VSUBS VSUBS gf180mcu_fd_sc_mcu7t5v0__nand2_1
X_9340_ _9340_/A1 _9340_/A2 _9340_/Z PHY_9/VDD PHY_9/VDD VSUBS VSUBS gf180mcu_fd_sc_mcu7t5v0__xor2_1
X_6552_ _6577_/A2 _6505_/Z _6646_/B _6606_/A1 PHY_9/VDD PHY_9/VDD VSUBS VSUBS gf180mcu_fd_sc_mcu7t5v0__oai21_1
X_6483_ _8498_/B1 _6353_/Z _6483_/B _6577_/A2 PHY_9/VDD PHY_9/VDD VSUBS VSUBS gf180mcu_fd_sc_mcu7t5v0__oai21_4
X_5503_ _9427_/Q _9725_/Q _5522_/A2 _5504_/C PHY_9/VDD PHY_9/VDD VSUBS VSUBS gf180mcu_fd_sc_mcu7t5v0__and3_1
X_9271_ _9271_/A1 _9270_/B _9271_/B1 _9271_/B2 _9351_/A2 PHY_9/VDD PHY_9/VDD VSUBS
+ VSUBS gf180mcu_fd_sc_mcu7t5v0__aoi22_4
X_8222_ _6558_/B _8309_/A2 _8274_/A1 PHY_9/VDD PHY_9/VDD VSUBS VSUBS gf180mcu_fd_sc_mcu7t5v0__nor2_2
X_5434_ _9776_/Q _5439_/A2 _5434_/B1 _5130_/I _5490_/A1 PHY_9/VDD PHY_9/VDD VSUBS
+ VSUBS gf180mcu_fd_sc_mcu7t5v0__aoi22_4
X_8153_ _9810_/Q _8311_/A2 _8157_/B2 PHY_9/VDD PHY_9/VDD VSUBS VSUBS gf180mcu_fd_sc_mcu7t5v0__nor2_1
X_7104_ _7104_/A1 _7104_/A2 _9357_/B _9851_/D PHY_9/VDD PHY_9/VDD VSUBS VSUBS gf180mcu_fd_sc_mcu7t5v0__aoi21_1
X_5365_ _9497_/Q _9473_/Q _5559_/B _5366_/I PHY_9/VDD PHY_9/VDD VSUBS VSUBS gf180mcu_fd_sc_mcu7t5v0__mux2_2
X_8084_ _9090_/C _8075_/B _8087_/A1 PHY_9/VDD PHY_9/VDD VSUBS VSUBS gf180mcu_fd_sc_mcu7t5v0__nor2_1
X_5296_ _5296_/A1 _5296_/A2 _5296_/B _9387_/D PHY_9/VDD PHY_9/VDD VSUBS VSUBS gf180mcu_fd_sc_mcu7t5v0__aoi21_1
X_7035_ _7035_/A1 _7035_/A2 _7035_/B _7038_/B PHY_9/VDD PHY_9/VDD VSUBS VSUBS gf180mcu_fd_sc_mcu7t5v0__oai21_1
X_8986_ _8734_/I _8971_/Z _8986_/B _8987_/B PHY_9/VDD PHY_9/VDD VSUBS VSUBS gf180mcu_fd_sc_mcu7t5v0__aoi21_1
X_7937_ _7937_/I _7938_/A2 PHY_9/VDD PHY_9/VDD VSUBS VSUBS gf180mcu_fd_sc_mcu7t5v0__clkinv_1
X_7868_ _9811_/Q _7866_/Z _7869_/I PHY_9/VDD PHY_9/VDD VSUBS VSUBS gf180mcu_fd_sc_mcu7t5v0__xor2_1
X_6819_ _9808_/Q _6921_/A2 _6871_/A1 PHY_9/VDD PHY_9/VDD VSUBS VSUBS gf180mcu_fd_sc_mcu7t5v0__nand2_1
X_9607_ _9607_/D _9830_/CLK _9607_/Q PHY_9/VDD PHY_9/VDD VSUBS VSUBS gf180mcu_fd_sc_mcu7t5v0__dffq_1
X_7799_ _9893_/Q _7779_/Z _7799_/B _7835_/A1 PHY_9/VDD PHY_9/VDD VSUBS VSUBS gf180mcu_fd_sc_mcu7t5v0__aoi21_1
X_9538_ _9538_/D _9689_/CLK _9538_/Q PHY_9/VDD PHY_9/VDD VSUBS VSUBS gf180mcu_fd_sc_mcu7t5v0__dffq_1
X_9469_ _9469_/D _9801_/CLK _9469_/Q PHY_9/VDD PHY_9/VDD VSUBS VSUBS gf180mcu_fd_sc_mcu7t5v0__dffq_2
X_5150_ _5150_/A1 _5150_/A2 _5150_/A3 _5150_/A4 _9722_/D PHY_9/VDD PHY_9/VDD VSUBS
+ VSUBS gf180mcu_fd_sc_mcu7t5v0__nand4_1
X_5081_ _9629_/Q _5813_/B2 PHY_9/VDD PHY_9/VDD VSUBS VSUBS gf180mcu_fd_sc_mcu7t5v0__clkinv_1
X_8840_ _9810_/Q _8813_/Z _8954_/A1 PHY_9/VDD PHY_9/VDD VSUBS VSUBS gf180mcu_fd_sc_mcu7t5v0__nand2_2
X_5983_ _8692_/A1 _5988_/A2 _5988_/B1 _5983_/B2 _9692_/D PHY_9/VDD PHY_9/VDD VSUBS
+ VSUBS gf180mcu_fd_sc_mcu7t5v0__oai22_1
X_8771_ _9955_/Q _8767_/Z _8779_/A1 PHY_9/VDD PHY_9/VDD VSUBS VSUBS gf180mcu_fd_sc_mcu7t5v0__nand2_1
X_4934_ _9935_/Q _8682_/B2 PHY_9/VDD PHY_9/VDD VSUBS VSUBS gf180mcu_fd_sc_mcu7t5v0__clkinv_1
X_7722_ _7724_/A1 _7722_/A2 _8009_/A2 PHY_9/VDD PHY_9/VDD VSUBS VSUBS gf180mcu_fd_sc_mcu7t5v0__nor2_2
X_4865_ _9478_/Q _5969_/A2 PHY_9/VDD PHY_9/VDD VSUBS VSUBS gf180mcu_fd_sc_mcu7t5v0__clkinv_1
X_7653_ _7653_/A1 _7653_/A2 _7653_/Z PHY_9/VDD PHY_9/VDD VSUBS VSUBS gf180mcu_fd_sc_mcu7t5v0__xor2_1
X_6604_ _6604_/A1 _6555_/Z _6604_/B _6644_/A1 PHY_9/VDD PHY_9/VDD VSUBS VSUBS gf180mcu_fd_sc_mcu7t5v0__oai21_1
X_4796_ _9812_/Q _6558_/B PHY_9/VDD PHY_9/VDD VSUBS VSUBS gf180mcu_fd_sc_mcu7t5v0__inv_8
X_7584_ _7482_/B _7584_/A2 _7584_/B _9356_/C _7585_/B PHY_9/VDD PHY_9/VDD VSUBS VSUBS
+ gf180mcu_fd_sc_mcu7t5v0__aoi211_1
X_6535_ _6535_/A1 _6580_/B2 _6635_/A1 _6538_/A3 PHY_9/VDD PHY_9/VDD VSUBS VSUBS gf180mcu_fd_sc_mcu7t5v0__xnor3_1
X_9323_ _9323_/A1 _9332_/A1 _9286_/Z _9323_/B2 _9337_/A2 PHY_9/VDD PHY_9/VDD VSUBS
+ VSUBS gf180mcu_fd_sc_mcu7t5v0__oai22_1
X_9254_ _9812_/Q _9253_/Z _9304_/A1 PHY_9/VDD PHY_9/VDD VSUBS VSUBS gf180mcu_fd_sc_mcu7t5v0__nand2_1
X_6466_ _6625_/A2 _6466_/A2 _6466_/Z PHY_9/VDD PHY_9/VDD VSUBS VSUBS gf180mcu_fd_sc_mcu7t5v0__xor2_1
X_8205_ _8156_/B _8205_/A2 _8206_/A2 PHY_9/VDD PHY_9/VDD VSUBS VSUBS gf180mcu_fd_sc_mcu7t5v0__nor2_1
X_6397_ _9808_/Q _6584_/B1 _6406_/A1 PHY_9/VDD PHY_9/VDD VSUBS VSUBS gf180mcu_fd_sc_mcu7t5v0__nor2_1
X_9185_ _9811_/Q _9331_/A2 _9281_/A1 PHY_9/VDD PHY_9/VDD VSUBS VSUBS gf180mcu_fd_sc_mcu7t5v0__nand2_1
X_5417_ _9643_/Q _5437_/A2 _5883_/A3 _9674_/Q _5418_/I PHY_9/VDD PHY_9/VDD VSUBS VSUBS
+ gf180mcu_fd_sc_mcu7t5v0__aoi22_1
X_8136_ _8136_/A1 _8132_/I _8220_/B2 _8136_/Z PHY_9/VDD PHY_9/VDD VSUBS VSUBS gf180mcu_fd_sc_mcu7t5v0__xor3_1
X_5348_ _9410_/Q _5353_/A2 _5349_/B PHY_9/VDD PHY_9/VDD VSUBS VSUBS gf180mcu_fd_sc_mcu7t5v0__nor2_1
X_8067_ _9507_/Q _8035_/Z _8067_/Z PHY_9/VDD PHY_9/VDD VSUBS VSUBS gf180mcu_fd_sc_mcu7t5v0__and2_1
X_7018_ _7048_/A1 _7048_/A2 _7019_/I PHY_9/VDD PHY_9/VDD VSUBS VSUBS gf180mcu_fd_sc_mcu7t5v0__and2_4
X_5279_ _5390_/A1 _5285_/A2 _5279_/B _5973_/C _9379_/D PHY_9/VDD PHY_9/VDD VSUBS VSUBS
+ gf180mcu_fd_sc_mcu7t5v0__aoi211_1
X_8969_ _8991_/B _8971_/I1 PHY_9/VDD PHY_9/VDD VSUBS VSUBS gf180mcu_fd_sc_mcu7t5v0__clkinv_1
X_6320_ _5399_/Z _6323_/A2 _6323_/B1 _6320_/B2 _9798_/D PHY_9/VDD PHY_9/VDD VSUBS
+ VSUBS gf180mcu_fd_sc_mcu7t5v0__oai22_1
X_6251_ _9760_/Q _6287_/A2 _6287_/B1 _9744_/Q _6253_/A1 PHY_9/VDD PHY_9/VDD VSUBS
+ VSUBS gf180mcu_fd_sc_mcu7t5v0__aoi22_1
X_6182_ _9694_/Q _6288_/A2 _6288_/B1 _9710_/Q _6183_/A2 PHY_9/VDD PHY_9/VDD VSUBS
+ VSUBS gf180mcu_fd_sc_mcu7t5v0__aoi22_1
X_5202_ _9770_/Q _5439_/A2 _5202_/B1 _5201_/Z _5202_/C _5478_/A1 PHY_9/VDD PHY_9/VDD
+ VSUBS VSUBS gf180mcu_fd_sc_mcu7t5v0__aoi221_4
X_5133_ _9470_/Q _5530_/A1 _5883_/A3 PHY_9/VDD PHY_9/VDD VSUBS VSUBS gf180mcu_fd_sc_mcu7t5v0__nor2_4
X_5064_ _9588_/Q _5758_/B2 PHY_9/VDD PHY_9/VDD VSUBS VSUBS gf180mcu_fd_sc_mcu7t5v0__clkinv_1
X_9941_ _9941_/D _9948_/CLK _9941_/Q PHY_9/VDD PHY_9/VDD VSUBS VSUBS gf180mcu_fd_sc_mcu7t5v0__dffq_1
X_9872_ _9872_/D _9907_/CLK _9872_/Q PHY_9/VDD PHY_9/VDD VSUBS VSUBS gf180mcu_fd_sc_mcu7t5v0__dffq_2
X_8823_ _8824_/A1 _8821_/Z _8849_/A2 PHY_9/VDD PHY_9/VDD VSUBS VSUBS gf180mcu_fd_sc_mcu7t5v0__nand2_1
X_8754_ _9949_/Q _8754_/A2 _8925_/B PHY_9/VDD PHY_9/VDD VSUBS VSUBS gf180mcu_fd_sc_mcu7t5v0__nand2_2
X_5966_ _5966_/A1 _5973_/A2 _5966_/B _9685_/D PHY_9/VDD PHY_9/VDD VSUBS VSUBS gf180mcu_fd_sc_mcu7t5v0__aoi21_1
X_8685_ _8695_/A1 _8687_/A2 _8687_/B1 _8685_/B2 _9938_/D PHY_9/VDD PHY_9/VDD VSUBS
+ VSUBS gf180mcu_fd_sc_mcu7t5v0__oai22_1
X_5897_ _9658_/Q _9657_/Q _5166_/Z _5901_/A2 PHY_9/VDD PHY_9/VDD VSUBS VSUBS gf180mcu_fd_sc_mcu7t5v0__nand3_2
X_4917_ _9515_/Q _5640_/B2 PHY_9/VDD PHY_9/VDD VSUBS VSUBS gf180mcu_fd_sc_mcu7t5v0__clkinv_1
X_7705_ _9889_/Q _7705_/A2 _9890_/Q _7708_/A2 PHY_9/VDD PHY_9/VDD VSUBS VSUBS gf180mcu_fd_sc_mcu7t5v0__aoi21_2
X_7636_ _7636_/A1 _7636_/A2 _7636_/B _7637_/B PHY_9/VDD PHY_9/VDD VSUBS VSUBS gf180mcu_fd_sc_mcu7t5v0__oai21_1
X_4848_ _9459_/Q _5459_/A1 PHY_9/VDD PHY_9/VDD VSUBS VSUBS gf180mcu_fd_sc_mcu7t5v0__clkinv_2
X_7567_ _7589_/A1 _7566_/Z _7567_/Z PHY_9/VDD PHY_9/VDD VSUBS VSUBS gf180mcu_fd_sc_mcu7t5v0__xor2_1
X_4779_ _9397_/Q _5318_/A1 PHY_9/VDD PHY_9/VDD VSUBS VSUBS gf180mcu_fd_sc_mcu7t5v0__clkinv_1
X_9306_ _9351_/A2 _9352_/A1 _9306_/Z PHY_9/VDD PHY_9/VDD VSUBS VSUBS gf180mcu_fd_sc_mcu7t5v0__xor2_1
X_6518_ _9100_/B _6518_/A2 _6519_/B PHY_9/VDD PHY_9/VDD VSUBS VSUBS gf180mcu_fd_sc_mcu7t5v0__nand2_1
X_7498_ _7604_/B1 _9819_/Q _7553_/B _7499_/B2 PHY_9/VDD PHY_9/VDD VSUBS VSUBS gf180mcu_fd_sc_mcu7t5v0__oai21_2
X_6449_ _9808_/Q _6627_/A2 _6455_/A2 PHY_9/VDD PHY_9/VDD VSUBS VSUBS gf180mcu_fd_sc_mcu7t5v0__nand2_1
X_9237_ _9812_/Q _9331_/A2 _9285_/A2 _9811_/Q _9281_/B1 PHY_9/VDD PHY_9/VDD VSUBS
+ VSUBS gf180mcu_fd_sc_mcu7t5v0__aoi22_1
X_9168_ _9962_/Q _9168_/A2 _9279_/B _9169_/B1 PHY_9/VDD PHY_9/VDD VSUBS VSUBS gf180mcu_fd_sc_mcu7t5v0__nor3_1
X_8119_ _8119_/I _8120_/C PHY_9/VDD PHY_9/VDD VSUBS VSUBS gf180mcu_fd_sc_mcu7t5v0__clkinv_1
X_9099_ _9343_/B _9098_/Z _9099_/B _9101_/A2 PHY_9/VDD PHY_9/VDD VSUBS VSUBS gf180mcu_fd_sc_mcu7t5v0__oai21_1
X_5820_ _8693_/A1 _5824_/A2 _5824_/B1 _5820_/B2 _9634_/D PHY_9/VDD PHY_9/VDD VSUBS
+ VSUBS gf180mcu_fd_sc_mcu7t5v0__oai22_1
X_5751_ _6089_/B _5759_/A2 _5759_/B1 PHY_9/VDD PHY_9/VDD VSUBS VSUBS gf180mcu_fd_sc_mcu7t5v0__nand2_2
X_8470_ _6471_/B _8369_/Z _8401_/Z _9227_/A1 _8504_/A2 PHY_9/VDD PHY_9/VDD VSUBS VSUBS
+ gf180mcu_fd_sc_mcu7t5v0__oai22_1
X_4702_ _9366_/Q _5246_/A1 PHY_9/VDD PHY_9/VDD VSUBS VSUBS gf180mcu_fd_sc_mcu7t5v0__clkinv_1
X_7421_ _7421_/A1 _7420_/Z _7422_/I PHY_9/VDD PHY_9/VDD VSUBS VSUBS gf180mcu_fd_sc_mcu7t5v0__nand2_1
X_5682_ _9542_/Q _5678_/Z _5700_/B _5683_/A2 PHY_9/VDD PHY_9/VDD VSUBS VSUBS gf180mcu_fd_sc_mcu7t5v0__oai21_1
X_7352_ _9807_/Q _7647_/A2 _7369_/B PHY_9/VDD PHY_9/VDD VSUBS VSUBS gf180mcu_fd_sc_mcu7t5v0__and2_1
X_7283_ _7040_/B _7283_/A2 _7283_/A3 _7283_/A4 _7285_/B1 PHY_9/VDD PHY_9/VDD VSUBS
+ VSUBS gf180mcu_fd_sc_mcu7t5v0__nand4_1
X_6303_ _5406_/Z _6303_/A2 _6303_/B1 _6303_/B2 _9785_/D PHY_9/VDD PHY_9/VDD VSUBS
+ VSUBS gf180mcu_fd_sc_mcu7t5v0__oai22_1
X_6234_ _6234_/A1 _6234_/A2 _6234_/A3 _6235_/A2 PHY_9/VDD PHY_9/VDD VSUBS VSUBS gf180mcu_fd_sc_mcu7t5v0__nand3_1
X_9022_ _9814_/Q _9023_/B1 _9022_/B _9949_/Q _9023_/A3 PHY_9/VDD PHY_9/VDD VSUBS VSUBS
+ gf180mcu_fd_sc_mcu7t5v0__aoi211_1
X_6165_ _9749_/Q _6288_/A2 _6288_/B1 _9765_/Q _6166_/A2 PHY_9/VDD PHY_9/VDD VSUBS
+ VSUBS gf180mcu_fd_sc_mcu7t5v0__aoi22_1
X_6096_ _6096_/A1 _6096_/A2 _6117_/A2 PHY_9/VDD PHY_9/VDD VSUBS VSUBS gf180mcu_fd_sc_mcu7t5v0__nand2_1
X_5116_ _9885_/Q _7686_/B2 PHY_9/VDD PHY_9/VDD VSUBS VSUBS gf180mcu_fd_sc_mcu7t5v0__clkinv_1
X_5047_ _9612_/Q _5792_/B2 PHY_9/VDD PHY_9/VDD VSUBS VSUBS gf180mcu_fd_sc_mcu7t5v0__clkinv_1
X_9924_ _9924_/D _9957_/CLK _9924_/Q PHY_9/VDD PHY_9/VDD VSUBS VSUBS gf180mcu_fd_sc_mcu7t5v0__dffq_4
X_9855_ _9855_/D _9856_/CLK _9855_/Q PHY_9/VDD PHY_9/VDD VSUBS VSUBS gf180mcu_fd_sc_mcu7t5v0__dffq_2
X_6998_ _6955_/C _6998_/A2 _6998_/B _6999_/C PHY_9/VDD PHY_9/VDD VSUBS VSUBS gf180mcu_fd_sc_mcu7t5v0__aoi21_1
X_9786_ _9786_/D _9940_/CLK _9786_/Q PHY_9/VDD PHY_9/VDD VSUBS VSUBS gf180mcu_fd_sc_mcu7t5v0__dffq_1
X_8806_ _9809_/Q _9020_/B _8904_/A1 _9020_/A1 _8842_/B _8807_/A2 PHY_9/VDD PHY_9/VDD
+ VSUBS VSUBS gf180mcu_fd_sc_mcu7t5v0__aoi221_1
X_8737_ _8768_/A1 _8885_/A1 _9020_/B PHY_9/VDD PHY_9/VDD VSUBS VSUBS gf180mcu_fd_sc_mcu7t5v0__nor2_1
X_5949_ _5949_/A1 _5951_/A2 _5949_/B _9677_/D PHY_9/VDD PHY_9/VDD VSUBS VSUBS gf180mcu_fd_sc_mcu7t5v0__aoi21_1
X_8668_ _9349_/A1 _8668_/A2 _8668_/Z PHY_9/VDD PHY_9/VDD VSUBS VSUBS gf180mcu_fd_sc_mcu7t5v0__xor2_1
X_7619_ _7620_/A1 _7563_/Z _7619_/B _7642_/B PHY_9/VDD PHY_9/VDD VSUBS VSUBS gf180mcu_fd_sc_mcu7t5v0__oai21_1
X_8599_ _9808_/Q _8644_/A2 _8657_/B2 PHY_9/VDD PHY_9/VDD VSUBS VSUBS gf180mcu_fd_sc_mcu7t5v0__nand2_1
X_7970_ _7970_/A1 _7970_/A2 _7969_/B _7971_/A2 PHY_9/VDD PHY_9/VDD VSUBS VSUBS gf180mcu_fd_sc_mcu7t5v0__nand3_1
X_6921_ _9810_/Q _6921_/A2 _6967_/A1 PHY_9/VDD PHY_9/VDD VSUBS VSUBS gf180mcu_fd_sc_mcu7t5v0__nand2_1
X_6852_ _6852_/A1 _6850_/Z _6900_/A2 PHY_9/VDD PHY_9/VDD VSUBS VSUBS gf180mcu_fd_sc_mcu7t5v0__nand2_1
X_9640_ _9640_/D _9972_/CLK _9640_/Q PHY_9/VDD PHY_9/VDD VSUBS VSUBS gf180mcu_fd_sc_mcu7t5v0__dffq_1
X_5803_ _5404_/Z _5804_/A2 _5804_/B1 _5803_/B2 _9621_/D PHY_9/VDD PHY_9/VDD VSUBS
+ VSUBS gf180mcu_fd_sc_mcu7t5v0__oai22_1
X_9571_ _9571_/D _9901_/CLK _9571_/Q PHY_9/VDD PHY_9/VDD VSUBS VSUBS gf180mcu_fd_sc_mcu7t5v0__dffq_1
X_6783_ _6784_/A1 _6784_/A3 _6823_/A2 PHY_9/VDD PHY_9/VDD VSUBS VSUBS gf180mcu_fd_sc_mcu7t5v0__nand2_1
X_8522_ _9929_/Q _8542_/A1 _8519_/Z _8522_/Z PHY_9/VDD PHY_9/VDD VSUBS VSUBS gf180mcu_fd_sc_mcu7t5v0__xor3_1
X_5734_ _5399_/Z _5737_/A2 _5737_/B1 _5734_/B2 _9570_/D PHY_9/VDD PHY_9/VDD VSUBS
+ VSUBS gf180mcu_fd_sc_mcu7t5v0__oai22_1
X_5665_ _5659_/I _5665_/A2 _5664_/Z _9536_/D PHY_9/VDD PHY_9/VDD VSUBS VSUBS gf180mcu_fd_sc_mcu7t5v0__nor3_1
X_8453_ _9809_/Q _8653_/A2 _8453_/B1 _8674_/B _8457_/B1 PHY_9/VDD PHY_9/VDD VSUBS
+ VSUBS gf180mcu_fd_sc_mcu7t5v0__oai22_1
X_7404_ _7404_/A1 _7402_/Z _7404_/Z PHY_9/VDD PHY_9/VDD VSUBS VSUBS gf180mcu_fd_sc_mcu7t5v0__xor2_1
X_8384_ _8422_/A2 _8673_/I1 _8380_/Z _8384_/B _8388_/A1 PHY_9/VDD PHY_9/VDD VSUBS
+ VSUBS gf180mcu_fd_sc_mcu7t5v0__oai31_1
X_7335_ _5404_/Z _7336_/A2 _7336_/B1 _7335_/B2 _9863_/D PHY_9/VDD PHY_9/VDD VSUBS
+ VSUBS gf180mcu_fd_sc_mcu7t5v0__oai22_1
X_5596_ _8755_/A1 _9036_/A2 _5596_/B _9498_/D PHY_9/VDD PHY_9/VDD VSUBS VSUBS gf180mcu_fd_sc_mcu7t5v0__aoi21_1
X_7266_ _7266_/A1 _7266_/A2 _7266_/B _7288_/A2 PHY_9/VDD PHY_9/VDD VSUBS VSUBS gf180mcu_fd_sc_mcu7t5v0__oai21_1
X_7197_ _9809_/Q _7247_/A2 _7250_/A2 PHY_9/VDD PHY_9/VDD VSUBS VSUBS gf180mcu_fd_sc_mcu7t5v0__nand2_1
X_6217_ _9883_/Q _6288_/A2 _6288_/B1 _9946_/Q _6218_/A2 PHY_9/VDD PHY_9/VDD VSUBS
+ VSUBS gf180mcu_fd_sc_mcu7t5v0__aoi22_1
X_9005_ _9811_/Q _8813_/Z _9006_/A3 PHY_9/VDD PHY_9/VDD VSUBS VSUBS gf180mcu_fd_sc_mcu7t5v0__nand2_1
X_6148_ _8689_/A1 _6148_/A2 _9772_/D PHY_9/VDD PHY_9/VDD VSUBS VSUBS gf180mcu_fd_sc_mcu7t5v0__and2_1
X_6079_ _9607_/Q _6287_/A2 _6287_/B1 _9623_/Q _6081_/A1 PHY_9/VDD PHY_9/VDD VSUBS
+ VSUBS gf180mcu_fd_sc_mcu7t5v0__aoi22_1
X_9907_ _9907_/D _9907_/CLK _9907_/Q PHY_9/VDD PHY_9/VDD VSUBS VSUBS gf180mcu_fd_sc_mcu7t5v0__dffq_2
X_9838_ _9838_/D _9907_/CLK _9838_/Q PHY_9/VDD PHY_9/VDD VSUBS VSUBS gf180mcu_fd_sc_mcu7t5v0__dffq_2
X_9769_ _9769_/D _9948_/CLK _9769_/Q PHY_9/VDD PHY_9/VDD VSUBS VSUBS gf180mcu_fd_sc_mcu7t5v0__dffq_1
X_5450_ _5484_/A1 _5458_/A2 _5450_/B _9437_/D PHY_9/VDD PHY_9/VDD VSUBS VSUBS gf180mcu_fd_sc_mcu7t5v0__aoi21_1
X_5381_ _5381_/I _5636_/A2 PHY_9/VDD PHY_9/VDD VSUBS VSUBS gf180mcu_fd_sc_mcu7t5v0__inv_3
X_7120_ _7149_/A1 _7120_/A2 _7118_/B _7120_/Z PHY_9/VDD PHY_9/VDD VSUBS VSUBS gf180mcu_fd_sc_mcu7t5v0__xor3_1
X_7051_ _9808_/Q _7254_/A2 _7051_/A3 _7052_/B PHY_9/VDD PHY_9/VDD VSUBS VSUBS gf180mcu_fd_sc_mcu7t5v0__xor3_1
X_6002_ _8691_/A1 _6008_/A2 _6008_/B1 _6002_/B2 _9707_/D PHY_9/VDD PHY_9/VDD VSUBS
+ VSUBS gf180mcu_fd_sc_mcu7t5v0__oai22_1
X_7953_ _7953_/A1 _7953_/A2 _7952_/B _7991_/A2 PHY_9/VDD PHY_9/VDD VSUBS VSUBS gf180mcu_fd_sc_mcu7t5v0__nand3_1
X_6904_ _9812_/Q _6696_/B _6905_/A2 _6996_/A1 _6955_/C _6905_/B PHY_9/VDD PHY_9/VDD
+ VSUBS VSUBS gf180mcu_fd_sc_mcu7t5v0__aoi221_1
X_7884_ _9959_/Q _7738_/C _7885_/B PHY_9/VDD PHY_9/VDD VSUBS VSUBS gf180mcu_fd_sc_mcu7t5v0__nand2_1
X_6835_ _6835_/A1 _6834_/B _6835_/Z PHY_9/VDD PHY_9/VDD VSUBS VSUBS gf180mcu_fd_sc_mcu7t5v0__xor2_1
X_9623_ _9623_/D _9830_/CLK _9623_/Q PHY_9/VDD PHY_9/VDD VSUBS VSUBS gf180mcu_fd_sc_mcu7t5v0__dffq_1
X_6766_ _6766_/A1 _6766_/A2 _6766_/B _6767_/B PHY_9/VDD PHY_9/VDD VSUBS VSUBS gf180mcu_fd_sc_mcu7t5v0__oai21_1
X_9554_ _9554_/D _9830_/CLK _9554_/Q PHY_9/VDD PHY_9/VDD VSUBS VSUBS gf180mcu_fd_sc_mcu7t5v0__dffq_1
X_5717_ _5371_/Z _5772_/A2 _6656_/A2 PHY_9/VDD PHY_9/VDD VSUBS VSUBS gf180mcu_fd_sc_mcu7t5v0__nor2_4
X_8505_ _9811_/Q _8654_/A2 _8603_/A1 PHY_9/VDD PHY_9/VDD VSUBS VSUBS gf180mcu_fd_sc_mcu7t5v0__nand2_1
X_6697_ _6697_/A1 _6697_/A2 _6700_/B PHY_9/VDD PHY_9/VDD VSUBS VSUBS gf180mcu_fd_sc_mcu7t5v0__nand2_1
X_9485_ _9485_/D _9801_/CLK _9485_/Q PHY_9/VDD PHY_9/VDD VSUBS VSUBS gf180mcu_fd_sc_mcu7t5v0__dffq_1
X_5648_ _8689_/A1 _5656_/A2 _5656_/B1 PHY_9/VDD PHY_9/VDD VSUBS VSUBS gf180mcu_fd_sc_mcu7t5v0__nand2_2
X_8436_ _8433_/Z _8437_/A3 _8436_/B _8438_/A1 PHY_9/VDD PHY_9/VDD VSUBS VSUBS gf180mcu_fd_sc_mcu7t5v0__oai21_1
X_8367_ _8647_/A2 _9498_/Q _9923_/Q _8416_/A4 PHY_9/VDD PHY_9/VDD VSUBS VSUBS gf180mcu_fd_sc_mcu7t5v0__aoi21_4
X_5579_ _9409_/Q _5591_/A2 _5580_/C PHY_9/VDD PHY_9/VDD VSUBS VSUBS gf180mcu_fd_sc_mcu7t5v0__and2_1
X_7318_ _7318_/A1 _7278_/B _7321_/A2 PHY_9/VDD PHY_9/VDD VSUBS VSUBS gf180mcu_fd_sc_mcu7t5v0__nand2_1
X_8298_ _8151_/B _8297_/Z _8303_/A3 PHY_9/VDD PHY_9/VDD VSUBS VSUBS gf180mcu_fd_sc_mcu7t5v0__nand2_1
X_7249_ _7250_/A1 _7250_/A2 _7306_/A2 PHY_9/VDD PHY_9/VDD VSUBS VSUBS gf180mcu_fd_sc_mcu7t5v0__nand2_1
X_4950_ _9617_/Q _5799_/B2 PHY_9/VDD PHY_9/VDD VSUBS VSUBS gf180mcu_fd_sc_mcu7t5v0__clkinv_1
X_4881_ _9738_/Q _6022_/B2 PHY_9/VDD PHY_9/VDD VSUBS VSUBS gf180mcu_fd_sc_mcu7t5v0__clkinv_1
X_6620_ _6566_/Z _6620_/A2 _6620_/B _6643_/A2 PHY_9/VDD PHY_9/VDD VSUBS VSUBS gf180mcu_fd_sc_mcu7t5v0__oai21_1
X_6551_ _9811_/Q _6507_/Z _6551_/B _6604_/A1 PHY_9/VDD PHY_9/VDD VSUBS VSUBS gf180mcu_fd_sc_mcu7t5v0__aoi21_1
X_5502_ _5502_/A1 _5522_/B _5502_/B1 _5502_/B2 _5973_/C _9460_/D PHY_9/VDD PHY_9/VDD
+ VSUBS VSUBS gf180mcu_fd_sc_mcu7t5v0__aoi221_1
X_6482_ _9840_/Q _6350_/Z _6483_/B PHY_9/VDD PHY_9/VDD VSUBS VSUBS gf180mcu_fd_sc_mcu7t5v0__nand2_1
X_9270_ _9512_/Q _9044_/Z _9270_/B _9271_/B2 PHY_9/VDD PHY_9/VDD VSUBS VSUBS gf180mcu_fd_sc_mcu7t5v0__aoi21_2
X_8221_ _9810_/Q _8097_/Z _8270_/A1 PHY_9/VDD PHY_9/VDD VSUBS VSUBS gf180mcu_fd_sc_mcu7t5v0__nand2_1
X_5433_ _5433_/I _5434_/B1 PHY_9/VDD PHY_9/VDD VSUBS VSUBS gf180mcu_fd_sc_mcu7t5v0__clkinv_1
X_5364_ _5853_/A1 _5364_/A2 _5364_/B _9035_/B _9417_/D PHY_9/VDD PHY_9/VDD VSUBS VSUBS
+ gf180mcu_fd_sc_mcu7t5v0__oai211_1
X_8152_ _8152_/I _8158_/B2 PHY_9/VDD PHY_9/VDD VSUBS VSUBS gf180mcu_fd_sc_mcu7t5v0__clkinv_1
X_7103_ _7040_/B _7103_/A2 _7103_/B _9317_/C _7104_/A2 PHY_9/VDD PHY_9/VDD VSUBS VSUBS
+ gf180mcu_fd_sc_mcu7t5v0__oai211_1
X_8083_ _9091_/B _8075_/B _8083_/B _8093_/A2 PHY_9/VDD PHY_9/VDD VSUBS VSUBS gf180mcu_fd_sc_mcu7t5v0__aoi21_1
X_5295_ _9464_/Q _5296_/A2 _7695_/B _5296_/B PHY_9/VDD PHY_9/VDD VSUBS VSUBS gf180mcu_fd_sc_mcu7t5v0__oai21_1
X_7034_ _9807_/Q _7315_/A2 _7315_/B _7035_/B PHY_9/VDD PHY_9/VDD VSUBS VSUBS gf180mcu_fd_sc_mcu7t5v0__aoi21_1
X_8985_ _9015_/B _8985_/A2 _8985_/B _8985_/C _8986_/B PHY_9/VDD PHY_9/VDD VSUBS VSUBS
+ gf180mcu_fd_sc_mcu7t5v0__oai211_1
X_7936_ _7936_/A1 _7936_/A2 _7936_/B _7937_/I PHY_9/VDD PHY_9/VDD VSUBS VSUBS gf180mcu_fd_sc_mcu7t5v0__aoi21_1
X_7867_ _9811_/Q _7866_/Z _7913_/B PHY_9/VDD PHY_9/VDD VSUBS VSUBS gf180mcu_fd_sc_mcu7t5v0__nand2_1
X_6818_ _9808_/Q _6966_/A2 _6821_/A2 PHY_9/VDD PHY_9/VDD VSUBS VSUBS gf180mcu_fd_sc_mcu7t5v0__nand2_1
X_9606_ _9606_/D _9940_/CLK _9606_/Q PHY_9/VDD PHY_9/VDD VSUBS VSUBS gf180mcu_fd_sc_mcu7t5v0__dffq_1
X_7798_ _9357_/B _7798_/A2 _9893_/D PHY_9/VDD PHY_9/VDD VSUBS VSUBS gf180mcu_fd_sc_mcu7t5v0__nor2_1
X_6749_ _9838_/Q _6748_/Z _6770_/A2 PHY_9/VDD PHY_9/VDD VSUBS VSUBS gf180mcu_fd_sc_mcu7t5v0__nor2_1
X_9537_ _9537_/D _9689_/CLK _9537_/Q PHY_9/VDD PHY_9/VDD VSUBS VSUBS gf180mcu_fd_sc_mcu7t5v0__dffq_1
X_9468_ _9468_/D _9901_/CLK _9468_/Q PHY_9/VDD PHY_9/VDD VSUBS VSUBS gf180mcu_fd_sc_mcu7t5v0__dffq_1
X_8419_ _9808_/Q _8674_/A2 _8418_/Z _8664_/A1 _8491_/C _8420_/C PHY_9/VDD PHY_9/VDD
+ VSUBS VSUBS gf180mcu_fd_sc_mcu7t5v0__aoi221_1
X_9399_ _9399_/D _9856_/CLK _9399_/Q PHY_9/VDD PHY_9/VDD VSUBS VSUBS gf180mcu_fd_sc_mcu7t5v0__dffq_1
X_5080_ _9637_/Q _5823_/B2 PHY_9/VDD PHY_9/VDD VSUBS VSUBS gf180mcu_fd_sc_mcu7t5v0__clkinv_1
X_5982_ _8691_/A1 _5988_/A2 _5988_/B1 _5982_/B2 _9691_/D PHY_9/VDD PHY_9/VDD VSUBS
+ VSUBS gf180mcu_fd_sc_mcu7t5v0__oai22_1
X_8770_ _8759_/Z _8770_/A2 _8770_/B _8776_/A2 PHY_9/VDD PHY_9/VDD VSUBS VSUBS gf180mcu_fd_sc_mcu7t5v0__oai21_1
X_4933_ _9600_/Q _5776_/B2 PHY_9/VDD PHY_9/VDD VSUBS VSUBS gf180mcu_fd_sc_mcu7t5v0__clkinv_1
X_7721_ _9090_/C _7988_/A2 _8008_/I1 _7870_/B _7726_/B1 PHY_9/VDD PHY_9/VDD VSUBS
+ VSUBS gf180mcu_fd_sc_mcu7t5v0__oai22_1
X_7652_ _9807_/Q _7672_/A2 _7653_/A2 PHY_9/VDD PHY_9/VDD VSUBS VSUBS gf180mcu_fd_sc_mcu7t5v0__nand2_1
X_4864_ _9662_/Q _5167_/A3 PHY_9/VDD PHY_9/VDD VSUBS VSUBS gf180mcu_fd_sc_mcu7t5v0__clkinv_1
X_4795_ _9813_/Q _6613_/B PHY_9/VDD PHY_9/VDD VSUBS VSUBS gf180mcu_fd_sc_mcu7t5v0__inv_4
X_6603_ _6603_/A1 _6599_/Z _6616_/A2 PHY_9/VDD PHY_9/VDD VSUBS VSUBS gf180mcu_fd_sc_mcu7t5v0__nand2_1
X_7583_ _7625_/A1 _7567_/Z _7583_/B _7584_/B PHY_9/VDD PHY_9/VDD VSUBS VSUBS gf180mcu_fd_sc_mcu7t5v0__aoi21_1
X_6534_ _6535_/A1 _6635_/A1 _6534_/Z PHY_9/VDD PHY_9/VDD VSUBS VSUBS gf180mcu_fd_sc_mcu7t5v0__and2_1
X_9322_ _9809_/Q _9322_/A2 _9337_/A1 PHY_9/VDD PHY_9/VDD VSUBS VSUBS gf180mcu_fd_sc_mcu7t5v0__nand2_1
X_6465_ _6624_/A2 _6584_/B1 _6627_/A2 _6646_/B _6466_/A2 PHY_9/VDD PHY_9/VDD VSUBS
+ VSUBS gf180mcu_fd_sc_mcu7t5v0__oai31_1
X_9253_ _9322_/A2 _9252_/I _9253_/Z PHY_9/VDD PHY_9/VDD VSUBS VSUBS gf180mcu_fd_sc_mcu7t5v0__xor2_1
X_5416_ _9731_/Q _5482_/A1 _5416_/B _9428_/D PHY_9/VDD PHY_9/VDD VSUBS VSUBS gf180mcu_fd_sc_mcu7t5v0__aoi21_1
X_8204_ _8291_/A1 _8186_/Z _8198_/Z _8204_/B2 _8204_/C1 _8204_/C2 _8205_/A2 PHY_9/VDD
+ PHY_9/VDD VSUBS VSUBS gf180mcu_fd_sc_mcu7t5v0__aoi222_1
X_6396_ _6470_/B _6432_/A2 _6395_/Z _6410_/A1 PHY_9/VDD PHY_9/VDD VSUBS VSUBS gf180mcu_fd_sc_mcu7t5v0__nor3_1
X_9184_ _9184_/A1 _9184_/A2 _9184_/B _9193_/A1 PHY_9/VDD PHY_9/VDD VSUBS VSUBS gf180mcu_fd_sc_mcu7t5v0__oai21_1
X_8135_ _6471_/B _8309_/A2 _8075_/B _9227_/A1 _8175_/B1 PHY_9/VDD PHY_9/VDD VSUBS
+ VSUBS gf180mcu_fd_sc_mcu7t5v0__oai22_1
X_5347_ _5390_/A1 _5353_/A2 _5347_/B _5973_/C _9409_/D PHY_9/VDD PHY_9/VDD VSUBS VSUBS
+ gf180mcu_fd_sc_mcu7t5v0__aoi211_1
X_8066_ _8066_/I _8108_/A1 PHY_9/VDD PHY_9/VDD VSUBS VSUBS gf180mcu_fd_sc_mcu7t5v0__clkinv_1
X_5278_ _9379_/Q _5285_/A2 _5279_/B PHY_9/VDD PHY_9/VDD VSUBS VSUBS gf180mcu_fd_sc_mcu7t5v0__nor2_1
X_7017_ _9847_/Q _7017_/A2 _7017_/B _7048_/A2 PHY_9/VDD PHY_9/VDD VSUBS VSUBS gf180mcu_fd_sc_mcu7t5v0__oai21_2
X_8968_ _8968_/A1 _8966_/Z _8991_/B PHY_9/VDD PHY_9/VDD VSUBS VSUBS gf180mcu_fd_sc_mcu7t5v0__xor2_1
X_7919_ _7920_/A1 _7918_/Z _7970_/A2 PHY_9/VDD PHY_9/VDD VSUBS VSUBS gf180mcu_fd_sc_mcu7t5v0__nand2_1
X_8899_ _9809_/Q _8813_/Z _8903_/A3 PHY_9/VDD PHY_9/VDD VSUBS VSUBS gf180mcu_fd_sc_mcu7t5v0__nand2_1
X_6250_ _6250_/A1 _6250_/A2 _6261_/A2 PHY_9/VDD PHY_9/VDD VSUBS VSUBS gf180mcu_fd_sc_mcu7t5v0__nand2_1
X_6181_ _9702_/Q _6287_/A2 _6287_/B1 _9603_/Q _6183_/A1 PHY_9/VDD PHY_9/VDD VSUBS
+ VSUBS gf180mcu_fd_sc_mcu7t5v0__aoi22_1
X_5201_ _9491_/Q _9490_/Q _9489_/Q _5201_/Z PHY_9/VDD PHY_9/VDD VSUBS VSUBS gf180mcu_fd_sc_mcu7t5v0__or3_4
X_5132_ _9470_/Q _5530_/A1 _5132_/Z PHY_9/VDD PHY_9/VDD VSUBS VSUBS gf180mcu_fd_sc_mcu7t5v0__and2_2
Xclkbuf_1_0__f_clk clkbuf_0_clk/Z clkbuf_leaf_9_clk/I PHY_9/VDD PHY_9/VDD VSUBS VSUBS
+ gf180mcu_fd_sc_mcu7t5v0__clkbuf_16
X_5063_ _9596_/Q _5768_/B2 PHY_9/VDD PHY_9/VDD VSUBS VSUBS gf180mcu_fd_sc_mcu7t5v0__clkinv_1
X_9940_ _9940_/D _9940_/CLK _9940_/Q PHY_9/VDD PHY_9/VDD VSUBS VSUBS gf180mcu_fd_sc_mcu7t5v0__dffq_1
X_9871_ _9871_/D _9907_/CLK _9871_/Q PHY_9/VDD PHY_9/VDD VSUBS VSUBS gf180mcu_fd_sc_mcu7t5v0__dffq_4
X_8822_ _8824_/A1 _8821_/Z _8849_/B PHY_9/VDD PHY_9/VDD VSUBS VSUBS gf180mcu_fd_sc_mcu7t5v0__nor2_1
X_8753_ _9949_/Q _8754_/A2 _8796_/B PHY_9/VDD PHY_9/VDD VSUBS VSUBS gf180mcu_fd_sc_mcu7t5v0__and2_1
X_5965_ _9686_/Q _5973_/A2 rst_n _5966_/B PHY_9/VDD PHY_9/VDD VSUBS VSUBS gf180mcu_fd_sc_mcu7t5v0__oai21_1
X_8684_ _5399_/Z _8687_/A2 _8687_/B1 _8684_/B2 _9937_/D PHY_9/VDD PHY_9/VDD VSUBS
+ VSUBS gf180mcu_fd_sc_mcu7t5v0__oai22_1
X_4916_ _9527_/Q _5650_/B2 PHY_9/VDD PHY_9/VDD VSUBS VSUBS gf180mcu_fd_sc_mcu7t5v0__clkinv_1
X_5896_ _9657_/Q _5166_/Z _9658_/Q _5899_/B PHY_9/VDD PHY_9/VDD VSUBS VSUBS gf180mcu_fd_sc_mcu7t5v0__aoi21_1
X_7704_ _9904_/Q _7703_/Z _7704_/Z PHY_9/VDD PHY_9/VDD VSUBS VSUBS gf180mcu_fd_sc_mcu7t5v0__and2_1
X_7635_ _9813_/Q _7668_/A2 _7636_/A2 _7667_/I1 _7668_/B _7636_/B PHY_9/VDD PHY_9/VDD
+ VSUBS VSUBS gf180mcu_fd_sc_mcu7t5v0__aoi221_1
X_4847_ _9460_/Q _5502_/A1 PHY_9/VDD PHY_9/VDD VSUBS VSUBS gf180mcu_fd_sc_mcu7t5v0__clkinv_2
X_4778_ _9835_/Q _6815_/A1 PHY_9/VDD PHY_9/VDD VSUBS VSUBS gf180mcu_fd_sc_mcu7t5v0__clkinv_3
X_7566_ _7566_/A1 _7566_/A2 _7566_/Z PHY_9/VDD PHY_9/VDD VSUBS VSUBS gf180mcu_fd_sc_mcu7t5v0__xor2_1
X_9305_ _9251_/B _9322_/A2 _9305_/B _9352_/A1 PHY_9/VDD PHY_9/VDD VSUBS VSUBS gf180mcu_fd_sc_mcu7t5v0__aoi21_1
X_6517_ _6503_/Z _6517_/A2 _6517_/B1 _6561_/B _9317_/C _6518_/A2 PHY_9/VDD PHY_9/VDD
+ VSUBS VSUBS gf180mcu_fd_sc_mcu7t5v0__oai221_1
X_7497_ _9868_/Q _7497_/A2 _9869_/Q _7500_/B2 PHY_9/VDD PHY_9/VDD VSUBS VSUBS gf180mcu_fd_sc_mcu7t5v0__aoi21_2
X_6448_ _6404_/B _6455_/A1 _6448_/B1 _6448_/B2 _6458_/A2 PHY_9/VDD PHY_9/VDD VSUBS
+ VSUBS gf180mcu_fd_sc_mcu7t5v0__oai22_2
X_9236_ _9812_/Q _9285_/A2 _9287_/A1 PHY_9/VDD PHY_9/VDD VSUBS VSUBS gf180mcu_fd_sc_mcu7t5v0__nand2_1
X_6379_ _9815_/Q _6408_/A2 _6561_/B _6380_/B PHY_9/VDD PHY_9/VDD VSUBS VSUBS gf180mcu_fd_sc_mcu7t5v0__oai21_1
X_9167_ _6471_/B _9227_/A2 _9279_/B PHY_9/VDD PHY_9/VDD VSUBS VSUBS gf180mcu_fd_sc_mcu7t5v0__nor2_2
X_8118_ _9809_/Q _8337_/B _8115_/Z _8337_/A1 _8156_/B _8119_/I PHY_9/VDD PHY_9/VDD
+ VSUBS VSUBS gf180mcu_fd_sc_mcu7t5v0__aoi221_1
X_9098_ _9098_/A1 _9098_/A2 _9098_/Z PHY_9/VDD PHY_9/VDD VSUBS VSUBS gf180mcu_fd_sc_mcu7t5v0__xor2_1
X_8049_ _8300_/A2 _8052_/A2 _8337_/A1 _8151_/B PHY_9/VDD PHY_9/VDD VSUBS VSUBS gf180mcu_fd_sc_mcu7t5v0__nor3_4
X_5750_ _7677_/A1 _8678_/A2 _5759_/A2 PHY_9/VDD PHY_9/VDD VSUBS VSUBS gf180mcu_fd_sc_mcu7t5v0__nand2_4
X_5681_ _9542_/Q _5678_/Z _5681_/Z PHY_9/VDD PHY_9/VDD VSUBS VSUBS gf180mcu_fd_sc_mcu7t5v0__and2_1
X_4701_ _9952_/Q _8994_/B PHY_9/VDD PHY_9/VDD VSUBS VSUBS gf180mcu_fd_sc_mcu7t5v0__inv_4
X_7420_ _7413_/I _7420_/A2 _7419_/B _7420_/Z PHY_9/VDD PHY_9/VDD VSUBS VSUBS gf180mcu_fd_sc_mcu7t5v0__or3_1
X_7351_ _7446_/A2 _7446_/A3 _7446_/A4 _7647_/A2 PHY_9/VDD PHY_9/VDD VSUBS VSUBS gf180mcu_fd_sc_mcu7t5v0__nor3_4
X_7282_ _9813_/Q _7319_/A2 _7282_/B _7283_/A4 PHY_9/VDD PHY_9/VDD VSUBS VSUBS gf180mcu_fd_sc_mcu7t5v0__oai21_1
X_6302_ _5404_/Z _6303_/A2 _6303_/B1 _6302_/B2 _9784_/D PHY_9/VDD PHY_9/VDD VSUBS
+ VSUBS gf180mcu_fd_sc_mcu7t5v0__oai22_1
X_6233_ _5372_/Z _6233_/A2 _6233_/B1 _6291_/B2 _6233_/C _6234_/A3 PHY_9/VDD PHY_9/VDD
+ VSUBS VSUBS gf180mcu_fd_sc_mcu7t5v0__aoi221_1
X_9021_ _9349_/A1 _9021_/A2 _9023_/A2 PHY_9/VDD PHY_9/VDD VSUBS VSUBS gf180mcu_fd_sc_mcu7t5v0__nor2_1
Xrepeater1 _9036_/A2 _9034_/A2 PHY_9/VDD PHY_9/VDD VSUBS VSUBS gf180mcu_fd_sc_mcu7t5v0__buf_16
X_6164_ _9757_/Q _6287_/A2 _6287_/B1 _9741_/Q _6166_/A1 PHY_9/VDD PHY_9/VDD VSUBS
+ VSUBS gf180mcu_fd_sc_mcu7t5v0__aoi22_1
X_6095_ _9747_/Q _6288_/A2 _6288_/B1 _9763_/Q _6096_/A2 PHY_9/VDD PHY_9/VDD VSUBS
+ VSUBS gf180mcu_fd_sc_mcu7t5v0__aoi22_1
X_5115_ _9919_/Q _8353_/B2 PHY_9/VDD PHY_9/VDD VSUBS VSUBS gf180mcu_fd_sc_mcu7t5v0__clkinv_1
X_5046_ _9620_/Q _5802_/B2 PHY_9/VDD PHY_9/VDD VSUBS VSUBS gf180mcu_fd_sc_mcu7t5v0__clkinv_1
X_9923_ _9923_/D _9957_/CLK _9923_/Q PHY_9/VDD PHY_9/VDD VSUBS VSUBS gf180mcu_fd_sc_mcu7t5v0__dffq_4
X_9854_ _9854_/D _9940_/CLK _9854_/Q PHY_9/VDD PHY_9/VDD VSUBS VSUBS gf180mcu_fd_sc_mcu7t5v0__dffq_4
X_6997_ _9349_/A1 _6997_/A2 _6997_/B1 _6997_/B2 _6997_/C _6998_/B PHY_9/VDD PHY_9/VDD
+ VSUBS VSUBS gf180mcu_fd_sc_mcu7t5v0__oai221_1
X_9785_ _9785_/D _9830_/CLK _9785_/Q PHY_9/VDD PHY_9/VDD VSUBS VSUBS gf180mcu_fd_sc_mcu7t5v0__dffq_1
X_8805_ _9809_/Q _9003_/A2 _8805_/B1 _8982_/C _8807_/A1 PHY_9/VDD PHY_9/VDD VSUBS
+ VSUBS gf180mcu_fd_sc_mcu7t5v0__oai22_1
X_5948_ _9685_/Q _5951_/A2 rst_n _5949_/B PHY_9/VDD PHY_9/VDD VSUBS VSUBS gf180mcu_fd_sc_mcu7t5v0__oai21_1
X_8736_ _8982_/B1 _8980_/B _8736_/B _8738_/B PHY_9/VDD PHY_9/VDD VSUBS VSUBS gf180mcu_fd_sc_mcu7t5v0__oai21_1
X_5879_ _9640_/Q _9523_/Q _5880_/A3 PHY_9/VDD PHY_9/VDD VSUBS VSUBS gf180mcu_fd_sc_mcu7t5v0__nand2_1
X_8667_ _9814_/Q _8668_/A2 _8673_/S PHY_9/VDD PHY_9/VDD VSUBS VSUBS gf180mcu_fd_sc_mcu7t5v0__nand2_1
X_7618_ _7559_/Z _7643_/A1 _7615_/I _7619_/B PHY_9/VDD PHY_9/VDD VSUBS VSUBS gf180mcu_fd_sc_mcu7t5v0__xor3_1
X_8598_ _8598_/A1 _8598_/A2 _8598_/B _8615_/A2 PHY_9/VDD PHY_9/VDD VSUBS VSUBS gf180mcu_fd_sc_mcu7t5v0__aoi21_2
X_7549_ _7551_/A1 _7646_/A1 _7549_/Z PHY_9/VDD PHY_9/VDD VSUBS VSUBS gf180mcu_fd_sc_mcu7t5v0__and2_1
X_9219_ _9221_/A1 _9356_/C _9219_/B1 _9219_/B2 _9357_/B _9971_/D PHY_9/VDD PHY_9/VDD
+ VSUBS VSUBS gf180mcu_fd_sc_mcu7t5v0__aoi221_1
X_6920_ _6920_/A1 _6920_/A2 _9091_/B _6980_/A1 PHY_9/VDD PHY_9/VDD VSUBS VSUBS gf180mcu_fd_sc_mcu7t5v0__aoi21_2
X_6851_ _6852_/A1 _6850_/Z _6858_/A1 PHY_9/VDD PHY_9/VDD VSUBS VSUBS gf180mcu_fd_sc_mcu7t5v0__nor2_1
X_5802_ _8695_/A1 _5804_/A2 _5804_/B1 _5802_/B2 _9620_/D PHY_9/VDD PHY_9/VDD VSUBS
+ VSUBS gf180mcu_fd_sc_mcu7t5v0__oai22_1
X_9570_ _9570_/D _9901_/CLK _9570_/Q PHY_9/VDD PHY_9/VDD VSUBS VSUBS gf180mcu_fd_sc_mcu7t5v0__dffq_1
X_6782_ _6784_/A1 _6784_/A3 _6823_/B PHY_9/VDD PHY_9/VDD VSUBS VSUBS gf180mcu_fd_sc_mcu7t5v0__nor2_1
X_8521_ _9929_/Q _8519_/Z _8542_/B PHY_9/VDD PHY_9/VDD VSUBS VSUBS gf180mcu_fd_sc_mcu7t5v0__nand2_1
X_5733_ _8693_/A1 _5737_/A2 _5737_/B1 _5733_/B2 _9569_/D PHY_9/VDD PHY_9/VDD VSUBS
+ VSUBS gf180mcu_fd_sc_mcu7t5v0__oai22_1
X_5664_ _9534_/Q _9535_/Q _9536_/Q _5664_/Z PHY_9/VDD PHY_9/VDD VSUBS VSUBS gf180mcu_fd_sc_mcu7t5v0__and3_1
X_8452_ _9809_/Q _8653_/A2 _8452_/B _8453_/B1 PHY_9/VDD PHY_9/VDD VSUBS VSUBS gf180mcu_fd_sc_mcu7t5v0__aoi21_1
X_7403_ _7404_/A1 _7402_/Z _7409_/A2 PHY_9/VDD PHY_9/VDD VSUBS VSUBS gf180mcu_fd_sc_mcu7t5v0__nor2_1
X_8383_ _8422_/A2 _8634_/A1 _8455_/A1 _8384_/B PHY_9/VDD PHY_9/VDD VSUBS VSUBS gf180mcu_fd_sc_mcu7t5v0__nand3_1
X_5595_ _9770_/Q _9036_/A2 _8706_/B _5596_/B PHY_9/VDD PHY_9/VDD VSUBS VSUBS gf180mcu_fd_sc_mcu7t5v0__oai21_1
X_7334_ _8695_/A1 _7336_/A2 _7336_/B1 _7334_/B2 _9862_/D PHY_9/VDD PHY_9/VDD VSUBS
+ VSUBS gf180mcu_fd_sc_mcu7t5v0__oai22_1
X_7265_ _7266_/A1 _7266_/A2 _7266_/B _7288_/B PHY_9/VDD PHY_9/VDD VSUBS VSUBS gf180mcu_fd_sc_mcu7t5v0__nor3_1
X_7196_ _9809_/Q _7293_/A2 _7200_/A3 PHY_9/VDD PHY_9/VDD VSUBS VSUBS gf180mcu_fd_sc_mcu7t5v0__nand2_1
X_6216_ _9917_/Q _6287_/A2 _6287_/B1 _9862_/Q _6218_/A1 PHY_9/VDD PHY_9/VDD VSUBS
+ VSUBS gf180mcu_fd_sc_mcu7t5v0__aoi22_1
X_9004_ _9814_/Q _9004_/A2 _9007_/A2 PHY_9/VDD PHY_9/VDD VSUBS VSUBS gf180mcu_fd_sc_mcu7t5v0__nand2_1
X_6147_ _6147_/A1 _6147_/A2 _6147_/A3 _6148_/A2 PHY_9/VDD PHY_9/VDD VSUBS VSUBS gf180mcu_fd_sc_mcu7t5v0__nand3_1
X_6078_ _6078_/A1 _6078_/A2 _6087_/C1 PHY_9/VDD PHY_9/VDD VSUBS VSUBS gf180mcu_fd_sc_mcu7t5v0__nand2_1
X_5029_ _9603_/Q _5779_/B2 PHY_9/VDD PHY_9/VDD VSUBS VSUBS gf180mcu_fd_sc_mcu7t5v0__clkinv_1
X_9906_ _9906_/D _9907_/CLK _9906_/Q PHY_9/VDD PHY_9/VDD VSUBS VSUBS gf180mcu_fd_sc_mcu7t5v0__dffq_2
X_9837_ _9837_/D _9907_/CLK _9837_/Q PHY_9/VDD PHY_9/VDD VSUBS VSUBS gf180mcu_fd_sc_mcu7t5v0__dffq_2
X_9768_ _9768_/D _9939_/CLK _9768_/Q PHY_9/VDD PHY_9/VDD VSUBS VSUBS gf180mcu_fd_sc_mcu7t5v0__dffq_1
X_9699_ _9699_/D _9940_/CLK _9699_/Q PHY_9/VDD PHY_9/VDD VSUBS VSUBS gf180mcu_fd_sc_mcu7t5v0__dffq_1
X_8719_ _8994_/A1 _9891_/Q _8717_/Z _9967_/Q _8719_/C _8755_/B2 PHY_9/VDD PHY_9/VDD
+ VSUBS VSUBS gf180mcu_fd_sc_mcu7t5v0__aoi221_4
X_5380_ _9493_/Q _9469_/Q _5559_/B _5381_/I PHY_9/VDD PHY_9/VDD VSUBS VSUBS gf180mcu_fd_sc_mcu7t5v0__mux2_4
X_7050_ _9808_/Q _7049_/Z _7094_/A1 PHY_9/VDD PHY_9/VDD VSUBS VSUBS gf180mcu_fd_sc_mcu7t5v0__nand2_1
X_6001_ _5388_/Z _6008_/A2 _6008_/B1 _6001_/B2 _9706_/D PHY_9/VDD PHY_9/VDD VSUBS
+ VSUBS gf180mcu_fd_sc_mcu7t5v0__oai22_1
X_7952_ _7953_/A1 _7953_/A2 _7952_/B _7991_/B PHY_9/VDD PHY_9/VDD VSUBS VSUBS gf180mcu_fd_sc_mcu7t5v0__aoi21_1
X_6903_ _9812_/Q _6977_/A2 _6905_/A2 PHY_9/VDD PHY_9/VDD VSUBS VSUBS gf180mcu_fd_sc_mcu7t5v0__nand2_1
X_9622_ _9622_/D _9948_/CLK _9622_/Q PHY_9/VDD PHY_9/VDD VSUBS VSUBS gf180mcu_fd_sc_mcu7t5v0__dffq_1
X_7883_ _7994_/B _9875_/Q _9841_/Q _7993_/B1 _7703_/Z _9909_/Q _7885_/A2 PHY_9/VDD
+ PHY_9/VDD VSUBS VSUBS gf180mcu_fd_sc_mcu7t5v0__aoi222_4
X_6834_ _6813_/B _6834_/A2 _6834_/B _6889_/A2 PHY_9/VDD PHY_9/VDD VSUBS VSUBS gf180mcu_fd_sc_mcu7t5v0__oai21_1
X_6765_ _6946_/A1 _6748_/Z _6765_/B _6766_/B PHY_9/VDD PHY_9/VDD VSUBS VSUBS gf180mcu_fd_sc_mcu7t5v0__aoi21_1
X_9553_ _9553_/D _9830_/CLK _9553_/Q PHY_9/VDD PHY_9/VDD VSUBS VSUBS gf180mcu_fd_sc_mcu7t5v0__dffq_1
X_5716_ _5366_/I _5367_/Z _5772_/A2 PHY_9/VDD PHY_9/VDD VSUBS VSUBS gf180mcu_fd_sc_mcu7t5v0__nand2_2
X_8504_ _8466_/Z _8504_/A2 _8504_/B _8514_/A2 PHY_9/VDD PHY_9/VDD VSUBS VSUBS gf180mcu_fd_sc_mcu7t5v0__aoi21_2
X_9484_ _9484_/D _9801_/CLK _9484_/Q PHY_9/VDD PHY_9/VDD VSUBS VSUBS gf180mcu_fd_sc_mcu7t5v0__dffq_1
X_6696_ _6698_/A1 _9807_/Q _6696_/B _6697_/A2 PHY_9/VDD PHY_9/VDD VSUBS VSUBS gf180mcu_fd_sc_mcu7t5v0__oai21_1
X_8435_ _9809_/Q _8654_/A2 _8606_/A2 _9808_/Q _8437_/A3 PHY_9/VDD PHY_9/VDD VSUBS
+ VSUBS gf180mcu_fd_sc_mcu7t5v0__aoi22_1
X_5647_ _7677_/A1 _6283_/B2 _5656_/A2 PHY_9/VDD PHY_9/VDD VSUBS VSUBS gf180mcu_fd_sc_mcu7t5v0__nand2_4
X_8366_ _9954_/Q _8647_/A2 _8416_/A3 PHY_9/VDD PHY_9/VDD VSUBS VSUBS gf180mcu_fd_sc_mcu7t5v0__nor2_4
X_5578_ _5594_/A1 _5578_/A2 _5578_/B _9493_/D PHY_9/VDD PHY_9/VDD VSUBS VSUBS gf180mcu_fd_sc_mcu7t5v0__aoi21_1
X_7317_ _7317_/A1 _7317_/A2 _7322_/C PHY_9/VDD PHY_9/VDD VSUBS VSUBS gf180mcu_fd_sc_mcu7t5v0__nor2_1
X_8297_ _6613_/B _8332_/A1 _8294_/Z _8297_/Z PHY_9/VDD PHY_9/VDD VSUBS VSUBS gf180mcu_fd_sc_mcu7t5v0__xor3_1
X_7248_ _7250_/A1 _7250_/A2 _7306_/B PHY_9/VDD PHY_9/VDD VSUBS VSUBS gf180mcu_fd_sc_mcu7t5v0__nor2_1
X_7179_ _7278_/C _7179_/A2 _7185_/A2 PHY_9/VDD PHY_9/VDD VSUBS VSUBS gf180mcu_fd_sc_mcu7t5v0__nand2_1
X_4880_ _9746_/Q _6032_/B2 PHY_9/VDD PHY_9/VDD VSUBS VSUBS gf180mcu_fd_sc_mcu7t5v0__clkinv_1
X_6550_ _6550_/A1 _6549_/B _6550_/Z PHY_9/VDD PHY_9/VDD VSUBS VSUBS gf180mcu_fd_sc_mcu7t5v0__xor2_1
X_5501_ _9426_/Q _5522_/A2 _5522_/B _5502_/B1 PHY_9/VDD PHY_9/VDD VSUBS VSUBS gf180mcu_fd_sc_mcu7t5v0__aoi21_1
X_6481_ _6487_/A1 _6481_/A2 _6481_/B _6498_/A1 PHY_9/VDD PHY_9/VDD VSUBS VSUBS gf180mcu_fd_sc_mcu7t5v0__oai21_1
X_8220_ _8115_/Z _8220_/A2 _8226_/A1 _8220_/B2 _8228_/A1 PHY_9/VDD PHY_9/VDD VSUBS
+ VSUBS gf180mcu_fd_sc_mcu7t5v0__aoi22_1
X_5432_ _9646_/Q _5437_/A2 _5883_/A3 _9677_/Q _5433_/I PHY_9/VDD PHY_9/VDD VSUBS VSUBS
+ gf180mcu_fd_sc_mcu7t5v0__aoi22_1
X_5363_ _9417_/Q _5364_/A2 _5364_/B PHY_9/VDD PHY_9/VDD VSUBS VSUBS gf180mcu_fd_sc_mcu7t5v0__nand2_1
X_8151_ _8151_/A1 _8149_/Z _8151_/B _8152_/I PHY_9/VDD PHY_9/VDD VSUBS VSUBS gf180mcu_fd_sc_mcu7t5v0__oai21_1
X_7102_ _7132_/A2 _7102_/A2 _7102_/B _7103_/B PHY_9/VDD PHY_9/VDD VSUBS VSUBS gf180mcu_fd_sc_mcu7t5v0__oai21_1
X_8082_ _8337_/A1 _8102_/A1 _8082_/B _8300_/C _8083_/B PHY_9/VDD PHY_9/VDD VSUBS VSUBS
+ gf180mcu_fd_sc_mcu7t5v0__aoi211_1
X_5294_ _5294_/A1 _5296_/A2 _5294_/B _9386_/D PHY_9/VDD PHY_9/VDD VSUBS VSUBS gf180mcu_fd_sc_mcu7t5v0__aoi21_1
X_7033_ _9846_/Q _7182_/A1 _7315_/B PHY_9/VDD PHY_9/VDD VSUBS VSUBS gf180mcu_fd_sc_mcu7t5v0__nor2_2
X_8984_ _9813_/Q _9017_/A2 _8984_/B _8985_/B PHY_9/VDD PHY_9/VDD VSUBS VSUBS gf180mcu_fd_sc_mcu7t5v0__oai21_1
X_7935_ _9807_/Q _8011_/A2 _7935_/Z PHY_9/VDD PHY_9/VDD VSUBS VSUBS gf180mcu_fd_sc_mcu7t5v0__and2_1
X_7866_ _7836_/Z _7865_/I _7866_/Z PHY_9/VDD PHY_9/VDD VSUBS VSUBS gf180mcu_fd_sc_mcu7t5v0__xor2_1
X_9605_ _9605_/D _9940_/CLK _9605_/Q PHY_9/VDD PHY_9/VDD VSUBS VSUBS gf180mcu_fd_sc_mcu7t5v0__dffq_1
X_6817_ _9807_/Q _6921_/A2 _6821_/A1 PHY_9/VDD PHY_9/VDD VSUBS VSUBS gf180mcu_fd_sc_mcu7t5v0__nand2_1
X_9536_ _9536_/D _9689_/CLK _9536_/Q PHY_9/VDD PHY_9/VDD VSUBS VSUBS gf180mcu_fd_sc_mcu7t5v0__dffq_1
X_7797_ _9893_/Q _9356_/C _7797_/B _7798_/A2 PHY_9/VDD PHY_9/VDD VSUBS VSUBS gf180mcu_fd_sc_mcu7t5v0__aoi21_1
X_6748_ _6748_/A1 _6748_/A2 _6748_/Z PHY_9/VDD PHY_9/VDD VSUBS VSUBS gf180mcu_fd_sc_mcu7t5v0__xor2_1
X_6679_ _8037_/A2 _6815_/A1 _9834_/Q _6679_/B2 _6824_/A3 PHY_9/VDD PHY_9/VDD VSUBS
+ VSUBS gf180mcu_fd_sc_mcu7t5v0__oai22_4
X_9467_ _9467_/D _9972_/CLK _9467_/Q PHY_9/VDD PHY_9/VDD VSUBS VSUBS gf180mcu_fd_sc_mcu7t5v0__dffq_1
X_9398_ _9398_/D _9856_/CLK _9398_/Q PHY_9/VDD PHY_9/VDD VSUBS VSUBS gf180mcu_fd_sc_mcu7t5v0__dffq_1
X_8418_ _8418_/A1 _8434_/A3 _8418_/Z PHY_9/VDD PHY_9/VDD VSUBS VSUBS gf180mcu_fd_sc_mcu7t5v0__xor2_1
X_8349_ _8693_/A1 _8353_/A2 _8353_/B1 _8349_/B2 _9915_/D PHY_9/VDD PHY_9/VDD VSUBS
+ VSUBS gf180mcu_fd_sc_mcu7t5v0__oai22_1
X_5981_ _5388_/Z _5988_/A2 _5988_/B1 _5981_/B2 _9690_/D PHY_9/VDD PHY_9/VDD VSUBS
+ VSUBS gf180mcu_fd_sc_mcu7t5v0__oai22_1
X_4932_ _9691_/Q _5982_/B2 PHY_9/VDD PHY_9/VDD VSUBS VSUBS gf180mcu_fd_sc_mcu7t5v0__clkinv_1
X_7720_ _7974_/A1 _8016_/A1 _7723_/B2 PHY_9/VDD PHY_9/VDD VSUBS VSUBS gf180mcu_fd_sc_mcu7t5v0__nand2_1
X_7651_ _7651_/A1 _7651_/A2 _7651_/B _7672_/A2 PHY_9/VDD PHY_9/VDD VSUBS VSUBS gf180mcu_fd_sc_mcu7t5v0__oai21_2
X_6602_ _9821_/Q _6566_/Z _6599_/Z _6602_/Z PHY_9/VDD PHY_9/VDD VSUBS VSUBS gf180mcu_fd_sc_mcu7t5v0__xor3_1
X_4863_ _9659_/Q _5900_/A1 PHY_9/VDD PHY_9/VDD VSUBS VSUBS gf180mcu_fd_sc_mcu7t5v0__clkinv_1
X_7582_ _7674_/C2 _7577_/Z _7582_/B _7582_/C _7583_/B PHY_9/VDD PHY_9/VDD VSUBS VSUBS
+ gf180mcu_fd_sc_mcu7t5v0__oai211_1
X_4794_ _9814_/Q _9349_/A1 PHY_9/VDD PHY_9/VDD VSUBS VSUBS gf180mcu_fd_sc_mcu7t5v0__clkinv_8
X_6533_ _9812_/Q _6584_/B1 _6580_/A2 PHY_9/VDD PHY_9/VDD VSUBS VSUBS gf180mcu_fd_sc_mcu7t5v0__nand2_1
X_9321_ _9321_/A1 _9287_/Z _9321_/B _9338_/A2 PHY_9/VDD PHY_9/VDD VSUBS VSUBS gf180mcu_fd_sc_mcu7t5v0__oai21_1
X_6464_ _6464_/A1 _6464_/A2 _6464_/Z PHY_9/VDD PHY_9/VDD VSUBS VSUBS gf180mcu_fd_sc_mcu7t5v0__and2_1
X_9252_ _9252_/I _9305_/B PHY_9/VDD PHY_9/VDD VSUBS VSUBS gf180mcu_fd_sc_mcu7t5v0__clkinv_1
X_5415_ _9731_/Q _9428_/Q _5474_/B _5416_/B PHY_9/VDD PHY_9/VDD VSUBS VSUBS gf180mcu_fd_sc_mcu7t5v0__oai21_1
X_8203_ _8301_/A1 _8203_/A2 _8203_/B _8204_/C2 PHY_9/VDD PHY_9/VDD VSUBS VSUBS gf180mcu_fd_sc_mcu7t5v0__oai21_1
X_6395_ _6395_/A1 _6393_/Z _6395_/Z PHY_9/VDD PHY_9/VDD VSUBS VSUBS gf180mcu_fd_sc_mcu7t5v0__and2_1
X_9183_ _9183_/A1 _9183_/A2 _9183_/Z PHY_9/VDD PHY_9/VDD VSUBS VSUBS gf180mcu_fd_sc_mcu7t5v0__xor2_1
X_8134_ _6471_/B _8075_/B _8179_/A2 PHY_9/VDD PHY_9/VDD VSUBS VSUBS gf180mcu_fd_sc_mcu7t5v0__nor2_1
X_5346_ _9409_/Q _5353_/A2 _5347_/B PHY_9/VDD PHY_9/VDD VSUBS VSUBS gf180mcu_fd_sc_mcu7t5v0__nor2_1
X_8065_ _9807_/Q _8309_/A2 _8066_/I PHY_9/VDD PHY_9/VDD VSUBS VSUBS gf180mcu_fd_sc_mcu7t5v0__nor2_1
X_5277_ _5502_/A1 _5285_/A2 _5277_/B _5973_/C _9378_/D PHY_9/VDD PHY_9/VDD VSUBS VSUBS
+ gf180mcu_fd_sc_mcu7t5v0__aoi211_1
X_7016_ _9848_/Q _9506_/Q _7017_/B PHY_9/VDD PHY_9/VDD VSUBS VSUBS gf180mcu_fd_sc_mcu7t5v0__nand2_1
X_8967_ _8968_/A1 _8966_/Z _9011_/A2 PHY_9/VDD PHY_9/VDD VSUBS VSUBS gf180mcu_fd_sc_mcu7t5v0__nand2_1
X_7918_ _9812_/Q _7915_/Z _7918_/Z PHY_9/VDD PHY_9/VDD VSUBS VSUBS gf180mcu_fd_sc_mcu7t5v0__xor2_1
X_8898_ _8898_/I _8946_/A1 PHY_9/VDD PHY_9/VDD VSUBS VSUBS gf180mcu_fd_sc_mcu7t5v0__clkinv_1
X_7849_ _7790_/Z _7845_/B _7849_/A3 _7850_/B PHY_9/VDD PHY_9/VDD VSUBS VSUBS gf180mcu_fd_sc_mcu7t5v0__xor3_1
X_9519_ _9519_/D _9801_/CLK _9519_/Q PHY_9/VDD PHY_9/VDD VSUBS VSUBS gf180mcu_fd_sc_mcu7t5v0__dffq_1
X_5200_ _9491_/Q _9490_/Q _9489_/Q _5559_/B PHY_9/VDD PHY_9/VDD VSUBS VSUBS gf180mcu_fd_sc_mcu7t5v0__nor3_4
X_6180_ _6180_/A1 _6180_/A2 _6202_/A2 PHY_9/VDD PHY_9/VDD VSUBS VSUBS gf180mcu_fd_sc_mcu7t5v0__nand2_1
X_5131_ _9470_/Q _9469_/Q _5437_/A2 PHY_9/VDD PHY_9/VDD VSUBS VSUBS gf180mcu_fd_sc_mcu7t5v0__nor2_4
X_5062_ _9939_/Q _8686_/B2 PHY_9/VDD PHY_9/VDD VSUBS VSUBS gf180mcu_fd_sc_mcu7t5v0__clkinv_1
X_9870_ _9870_/D _9907_/CLK _9870_/Q PHY_9/VDD PHY_9/VDD VSUBS VSUBS gf180mcu_fd_sc_mcu7t5v0__dffq_2
X_8821_ _8821_/A1 _8856_/B2 _8820_/B _8821_/Z PHY_9/VDD PHY_9/VDD VSUBS VSUBS gf180mcu_fd_sc_mcu7t5v0__xor3_1
X_8752_ _8752_/I _8958_/A2 PHY_9/VDD PHY_9/VDD VSUBS VSUBS gf180mcu_fd_sc_mcu7t5v0__clkinv_1
X_5964_ _5964_/A1 _5973_/A2 _5964_/B _9684_/D PHY_9/VDD PHY_9/VDD VSUBS VSUBS gf180mcu_fd_sc_mcu7t5v0__aoi21_1
X_7703_ _9890_/Q _9889_/Q _7703_/Z PHY_9/VDD PHY_9/VDD VSUBS VSUBS gf180mcu_fd_sc_mcu7t5v0__and2_2
X_8683_ _8693_/A1 _8687_/A2 _8687_/B1 _8683_/B2 _9936_/D PHY_9/VDD PHY_9/VDD VSUBS
+ VSUBS gf180mcu_fd_sc_mcu7t5v0__oai22_1
X_5895_ _5899_/A1 _5899_/A2 _5904_/A2 PHY_9/VDD PHY_9/VDD VSUBS VSUBS gf180mcu_fd_sc_mcu7t5v0__nand2_1
X_4915_ _9482_/Q _5552_/B2 PHY_9/VDD PHY_9/VDD VSUBS VSUBS gf180mcu_fd_sc_mcu7t5v0__clkinv_1
X_7634_ _9813_/Q _7670_/A2 _7636_/A2 PHY_9/VDD PHY_9/VDD VSUBS VSUBS gf180mcu_fd_sc_mcu7t5v0__nand2_1
X_4846_ _9461_/Q _5390_/A1 PHY_9/VDD PHY_9/VDD VSUBS VSUBS gf180mcu_fd_sc_mcu7t5v0__clkinv_2
X_7565_ _7566_/A1 _7566_/A2 _7589_/B PHY_9/VDD PHY_9/VDD VSUBS VSUBS gf180mcu_fd_sc_mcu7t5v0__nor2_1
X_6516_ _6603_/A1 _6516_/A2 _6516_/B _6517_/B1 PHY_9/VDD PHY_9/VDD VSUBS VSUBS gf180mcu_fd_sc_mcu7t5v0__aoi21_1
X_4777_ _9836_/Q _7705_/A2 PHY_9/VDD PHY_9/VDD VSUBS VSUBS gf180mcu_fd_sc_mcu7t5v0__inv_2
X_9304_ _9304_/A1 _9304_/A2 _9311_/A1 PHY_9/VDD PHY_9/VDD VSUBS VSUBS gf180mcu_fd_sc_mcu7t5v0__nand2_1
X_7496_ _9895_/Q _7450_/Z _7499_/B1 PHY_9/VDD PHY_9/VDD VSUBS VSUBS gf180mcu_fd_sc_mcu7t5v0__nand2_1
X_6447_ _9807_/Q _6625_/A2 _6487_/A1 PHY_9/VDD PHY_9/VDD VSUBS VSUBS gf180mcu_fd_sc_mcu7t5v0__nand2_1
X_9235_ _9812_/Q _9331_/A2 _9323_/A1 PHY_9/VDD PHY_9/VDD VSUBS VSUBS gf180mcu_fd_sc_mcu7t5v0__nand2_1
X_6378_ _9815_/Q _6408_/A2 _6409_/A1 PHY_9/VDD PHY_9/VDD VSUBS VSUBS gf180mcu_fd_sc_mcu7t5v0__nand2_1
X_9166_ _9354_/A1 _9209_/A2 _9173_/A2 PHY_9/VDD PHY_9/VDD VSUBS VSUBS gf180mcu_fd_sc_mcu7t5v0__nand2_1
X_5329_ _5396_/A1 _5331_/A2 _5329_/B _5973_/C _9401_/D PHY_9/VDD PHY_9/VDD VSUBS VSUBS
+ gf180mcu_fd_sc_mcu7t5v0__aoi211_1
X_8117_ _9809_/Q _8097_/Z _8117_/B1 _8300_/C _8121_/B1 PHY_9/VDD PHY_9/VDD VSUBS VSUBS
+ gf180mcu_fd_sc_mcu7t5v0__oai22_1
X_9097_ _9098_/A1 _9098_/A2 _9102_/B PHY_9/VDD PHY_9/VDD VSUBS VSUBS gf180mcu_fd_sc_mcu7t5v0__nor2_1
X_8048_ _9901_/Q _9900_/Q _8072_/A2 PHY_9/VDD PHY_9/VDD VSUBS VSUBS gf180mcu_fd_sc_mcu7t5v0__nor2_1
X_5680_ _5659_/I _5678_/Z _5680_/A3 _9541_/D PHY_9/VDD PHY_9/VDD VSUBS VSUBS gf180mcu_fd_sc_mcu7t5v0__nor3_1
X_4700_ _9367_/Q _5248_/A1 PHY_9/VDD PHY_9/VDD VSUBS VSUBS gf180mcu_fd_sc_mcu7t5v0__clkinv_1
X_7350_ _9925_/Q _7553_/B _9868_/Q _7446_/A4 PHY_9/VDD PHY_9/VDD VSUBS VSUBS gf180mcu_fd_sc_mcu7t5v0__aoi21_2
X_7281_ _7281_/A1 _7281_/A2 _7281_/B _7282_/B PHY_9/VDD PHY_9/VDD VSUBS VSUBS gf180mcu_fd_sc_mcu7t5v0__oai21_1
X_6301_ _8695_/A1 _6303_/A2 _6303_/B1 _6301_/B2 _9783_/D PHY_9/VDD PHY_9/VDD VSUBS
+ VSUBS gf180mcu_fd_sc_mcu7t5v0__oai22_1
Xclkbuf_leaf_6_clk clkbuf_leaf_8_clk/I _9940_/CLK PHY_9/VDD PHY_9/VDD VSUBS VSUBS
+ gf180mcu_fd_sc_mcu7t5v0__clkbuf_16
X_6232_ _8688_/A2 _6232_/A2 _6232_/B1 _6290_/B2 _6656_/A2 _6232_/C2 _6234_/A2 PHY_9/VDD
+ PHY_9/VDD VSUBS VSUBS gf180mcu_fd_sc_mcu7t5v0__aoi222_2
Xrepeater2 _5961_/B _5967_/B PHY_9/VDD PHY_9/VDD VSUBS VSUBS gf180mcu_fd_sc_mcu7t5v0__buf_8
X_9020_ _9020_/A1 _9023_/B1 _9020_/B _9021_/A2 PHY_9/VDD PHY_9/VDD VSUBS VSUBS gf180mcu_fd_sc_mcu7t5v0__aoi21_1
X_6163_ _6163_/A1 _6163_/A2 _6174_/A2 PHY_9/VDD PHY_9/VDD VSUBS VSUBS gf180mcu_fd_sc_mcu7t5v0__nand2_1
X_6094_ _9755_/Q _6287_/A2 _6287_/B1 _9739_/Q _6096_/A1 PHY_9/VDD PHY_9/VDD VSUBS
+ VSUBS gf180mcu_fd_sc_mcu7t5v0__aoi22_1
X_5114_ _9948_/Q _8697_/B2 PHY_9/VDD PHY_9/VDD VSUBS VSUBS gf180mcu_fd_sc_mcu7t5v0__clkinv_1
X_9922_ _9922_/D _9957_/CLK _9922_/Q PHY_9/VDD PHY_9/VDD VSUBS VSUBS gf180mcu_fd_sc_mcu7t5v0__dffq_2
X_5045_ _9519_/Q _5644_/B2 PHY_9/VDD PHY_9/VDD VSUBS VSUBS gf180mcu_fd_sc_mcu7t5v0__clkinv_1
X_9853_ _9853_/D _9940_/CLK _9853_/Q PHY_9/VDD PHY_9/VDD VSUBS VSUBS gf180mcu_fd_sc_mcu7t5v0__dffq_1
X_6996_ _6996_/A1 _6990_/Z _6997_/C PHY_9/VDD PHY_9/VDD VSUBS VSUBS gf180mcu_fd_sc_mcu7t5v0__nand2_1
X_8804_ _9949_/Q _9022_/B _8904_/A1 _8805_/B1 PHY_9/VDD PHY_9/VDD VSUBS VSUBS gf180mcu_fd_sc_mcu7t5v0__nor3_1
X_9784_ _9784_/D _9830_/CLK _9784_/Q PHY_9/VDD PHY_9/VDD VSUBS VSUBS gf180mcu_fd_sc_mcu7t5v0__dffq_1
X_8735_ _9020_/A1 _8734_/I _8738_/A2 PHY_9/VDD PHY_9/VDD VSUBS VSUBS gf180mcu_fd_sc_mcu7t5v0__nor2_1
X_5947_ _5947_/A1 _5951_/A2 _5947_/B _9676_/D PHY_9/VDD PHY_9/VDD VSUBS VSUBS gf180mcu_fd_sc_mcu7t5v0__aoi21_1
X_8666_ _9814_/Q _8668_/A2 _8675_/A1 PHY_9/VDD PHY_9/VDD VSUBS VSUBS gf180mcu_fd_sc_mcu7t5v0__nor2_1
X_7617_ _7559_/Z _7617_/A2 _7643_/A2 PHY_9/VDD PHY_9/VDD VSUBS VSUBS gf180mcu_fd_sc_mcu7t5v0__nor2_1
X_5878_ _5878_/A1 _5878_/A2 _9650_/D PHY_9/VDD PHY_9/VDD VSUBS VSUBS gf180mcu_fd_sc_mcu7t5v0__nor2_1
X_8597_ _8597_/A1 _8595_/Z _8597_/Z PHY_9/VDD PHY_9/VDD VSUBS VSUBS gf180mcu_fd_sc_mcu7t5v0__xor2_1
X_4829_ _9501_/Q _9138_/A1 PHY_9/VDD PHY_9/VDD VSUBS VSUBS gf180mcu_fd_sc_mcu7t5v0__inv_1
X_7548_ _7548_/A1 _7601_/A2 _7594_/A1 PHY_9/VDD PHY_9/VDD VSUBS VSUBS gf180mcu_fd_sc_mcu7t5v0__nor2_1
X_7479_ _9810_/Q _7654_/A2 _7483_/B2 PHY_9/VDD PHY_9/VDD VSUBS VSUBS gf180mcu_fd_sc_mcu7t5v0__nor2_1
X_9218_ _9343_/B _9218_/A2 _9356_/C _9219_/B2 PHY_9/VDD PHY_9/VDD VSUBS VSUBS gf180mcu_fd_sc_mcu7t5v0__aoi21_1
X_9149_ _9184_/A1 _9146_/Z _9184_/A2 _9149_/Z PHY_9/VDD PHY_9/VDD VSUBS VSUBS gf180mcu_fd_sc_mcu7t5v0__or3_1
X_6850_ _9811_/Q _6850_/A2 _6850_/Z PHY_9/VDD PHY_9/VDD VSUBS VSUBS gf180mcu_fd_sc_mcu7t5v0__xor2_1
X_6781_ _9810_/Q _6781_/A2 _6781_/A3 _6828_/A2 PHY_9/VDD PHY_9/VDD VSUBS VSUBS gf180mcu_fd_sc_mcu7t5v0__nand3_1
X_5801_ _5399_/Z _5804_/A2 _5804_/B1 _5801_/B2 _9619_/D PHY_9/VDD PHY_9/VDD VSUBS
+ VSUBS gf180mcu_fd_sc_mcu7t5v0__oai22_1
X_5732_ _8692_/A1 _5737_/A2 _5737_/B1 _5732_/B2 _9568_/D PHY_9/VDD PHY_9/VDD VSUBS
+ VSUBS gf180mcu_fd_sc_mcu7t5v0__oai22_1
X_8520_ _9929_/Q _8519_/Z _8542_/A2 PHY_9/VDD PHY_9/VDD VSUBS VSUBS gf180mcu_fd_sc_mcu7t5v0__nor2_1
X_8451_ _9809_/Q _8653_/A2 _8511_/A1 PHY_9/VDD PHY_9/VDD VSUBS VSUBS gf180mcu_fd_sc_mcu7t5v0__nand2_1
X_5663_ _9534_/Q _9535_/Q _9536_/Q _5665_/A2 PHY_9/VDD PHY_9/VDD VSUBS VSUBS gf180mcu_fd_sc_mcu7t5v0__aoi21_1
X_7402_ _9871_/Q _7398_/I _7402_/Z PHY_9/VDD PHY_9/VDD VSUBS VSUBS gf180mcu_fd_sc_mcu7t5v0__xor2_1
X_8382_ _9920_/Q _8382_/A2 _8455_/A1 PHY_9/VDD PHY_9/VDD VSUBS VSUBS gf180mcu_fd_sc_mcu7t5v0__nand2_1
X_5594_ _5594_/A1 _5594_/A2 _5594_/B _9497_/D PHY_9/VDD PHY_9/VDD VSUBS VSUBS gf180mcu_fd_sc_mcu7t5v0__aoi21_1
X_7333_ _5399_/Z _7336_/A2 _7336_/B1 _7333_/B2 _9861_/D PHY_9/VDD PHY_9/VDD VSUBS
+ VSUBS gf180mcu_fd_sc_mcu7t5v0__oai22_1
X_7264_ _7264_/A1 _7262_/Z _7266_/B PHY_9/VDD PHY_9/VDD VSUBS VSUBS gf180mcu_fd_sc_mcu7t5v0__xnor2_1
X_9003_ _9812_/Q _9003_/A2 _9006_/A2 PHY_9/VDD PHY_9/VDD VSUBS VSUBS gf180mcu_fd_sc_mcu7t5v0__nand2_1
X_6215_ _6215_/A1 _6215_/A2 _6231_/B1 PHY_9/VDD PHY_9/VDD VSUBS VSUBS gf180mcu_fd_sc_mcu7t5v0__nand2_1
X_7195_ _7246_/A1 _7246_/A2 _9090_/C _7242_/A1 PHY_9/VDD PHY_9/VDD VSUBS VSUBS gf180mcu_fd_sc_mcu7t5v0__aoi21_2
X_6146_ _6283_/A1 _6146_/A2 _6146_/B1 _6290_/B2 _6146_/C _6147_/A3 PHY_9/VDD PHY_9/VDD
+ VSUBS VSUBS gf180mcu_fd_sc_mcu7t5v0__aoi221_4
X_6077_ _9690_/Q _6288_/A2 _6288_/B1 _9706_/Q _6078_/A2 PHY_9/VDD PHY_9/VDD VSUBS
+ VSUBS gf180mcu_fd_sc_mcu7t5v0__aoi22_1
X_5028_ _9694_/Q _5985_/B2 PHY_9/VDD PHY_9/VDD VSUBS VSUBS gf180mcu_fd_sc_mcu7t5v0__clkinv_1
X_9905_ _9905_/D _9907_/CLK _9905_/Q PHY_9/VDD PHY_9/VDD VSUBS VSUBS gf180mcu_fd_sc_mcu7t5v0__dffq_4
X_9836_ _9836_/D _9907_/CLK _9836_/Q PHY_9/VDD PHY_9/VDD VSUBS VSUBS gf180mcu_fd_sc_mcu7t5v0__dffq_2
X_6979_ _6976_/Z _6979_/A2 _6979_/A3 _6979_/Z PHY_9/VDD PHY_9/VDD VSUBS VSUBS gf180mcu_fd_sc_mcu7t5v0__xor3_1
X_9767_ _9767_/D _9948_/CLK _9767_/Q PHY_9/VDD PHY_9/VDD VSUBS VSUBS gf180mcu_fd_sc_mcu7t5v0__dffq_1
X_9698_ _9698_/D _9940_/CLK _9698_/Q PHY_9/VDD PHY_9/VDD VSUBS VSUBS gf180mcu_fd_sc_mcu7t5v0__dffq_1
X_8718_ _9967_/Q _9953_/Q _9952_/Q _8720_/C PHY_9/VDD PHY_9/VDD VSUBS VSUBS gf180mcu_fd_sc_mcu7t5v0__nand3_2
X_8649_ _9808_/Q _8669_/A2 _8651_/A2 PHY_9/VDD PHY_9/VDD VSUBS VSUBS gf180mcu_fd_sc_mcu7t5v0__nand2_1
X_6000_ _7007_/B _6008_/A2 _6008_/B1 PHY_9/VDD PHY_9/VDD VSUBS VSUBS gf180mcu_fd_sc_mcu7t5v0__nand2_2
X_7951_ _7988_/B2 _7988_/B1 _7952_/B PHY_9/VDD PHY_9/VDD VSUBS VSUBS gf180mcu_fd_sc_mcu7t5v0__xnor2_1
X_6902_ _6995_/C _6902_/A2 _6907_/A3 PHY_9/VDD PHY_9/VDD VSUBS VSUBS gf180mcu_fd_sc_mcu7t5v0__nand2_1
X_7882_ _7882_/A1 _7882_/A2 _7882_/B _7905_/A1 PHY_9/VDD PHY_9/VDD VSUBS VSUBS gf180mcu_fd_sc_mcu7t5v0__aoi21_1
X_6833_ _6835_/A1 _6833_/A2 _6940_/A1 PHY_9/VDD PHY_9/VDD VSUBS VSUBS gf180mcu_fd_sc_mcu7t5v0__nor2_1
X_9621_ _9621_/D _9830_/CLK _9621_/Q PHY_9/VDD PHY_9/VDD VSUBS VSUBS gf180mcu_fd_sc_mcu7t5v0__dffq_1
X_6764_ _6997_/B2 _6828_/A1 _6764_/B1 _6764_/B2 _6764_/C _6765_/B PHY_9/VDD PHY_9/VDD
+ VSUBS VSUBS gf180mcu_fd_sc_mcu7t5v0__oai221_1
X_9552_ _9552_/D _9830_/CLK _9552_/Q PHY_9/VDD PHY_9/VDD VSUBS VSUBS gf180mcu_fd_sc_mcu7t5v0__dffq_1
X_6695_ _9833_/Q _6997_/A2 _6955_/C PHY_9/VDD PHY_9/VDD VSUBS VSUBS gf180mcu_fd_sc_mcu7t5v0__nor2_2
X_5715_ _5406_/Z _5715_/A2 _5715_/B1 _5715_/B2 _9557_/D PHY_9/VDD PHY_9/VDD VSUBS
+ VSUBS gf180mcu_fd_sc_mcu7t5v0__oai22_1
X_8503_ _8503_/A1 _8503_/A2 _8503_/Z PHY_9/VDD PHY_9/VDD VSUBS VSUBS gf180mcu_fd_sc_mcu7t5v0__xor2_1
X_9483_ _9483_/D _9801_/CLK _9483_/Q PHY_9/VDD PHY_9/VDD VSUBS VSUBS gf180mcu_fd_sc_mcu7t5v0__dffq_1
X_8434_ _9809_/Q _8606_/A2 _8434_/A3 _8473_/A1 PHY_9/VDD PHY_9/VDD VSUBS VSUBS gf180mcu_fd_sc_mcu7t5v0__nand3_1
X_5646_ _5406_/Z _5646_/A2 _5646_/B1 _5646_/B2 _9521_/D PHY_9/VDD PHY_9/VDD VSUBS
+ VSUBS gf180mcu_fd_sc_mcu7t5v0__oai22_1
X_8365_ _9924_/Q _8647_/A3 _9870_/Q _8416_/A2 PHY_9/VDD PHY_9/VDD VSUBS VSUBS gf180mcu_fd_sc_mcu7t5v0__nor3_4
X_5577_ _9493_/Q _5594_/A1 _9035_/B _5578_/B PHY_9/VDD PHY_9/VDD VSUBS VSUBS gf180mcu_fd_sc_mcu7t5v0__oai21_1
X_7316_ _9349_/A1 _7316_/A2 _7316_/Z PHY_9/VDD PHY_9/VDD VSUBS VSUBS gf180mcu_fd_sc_mcu7t5v0__xor2_1
X_8296_ _9813_/Q _8294_/Z _8332_/A2 PHY_9/VDD PHY_9/VDD VSUBS VSUBS gf180mcu_fd_sc_mcu7t5v0__nor2_1
X_7247_ _9810_/Q _7247_/A2 _7294_/A1 PHY_9/VDD PHY_9/VDD VSUBS VSUBS gf180mcu_fd_sc_mcu7t5v0__nand2_1
X_7178_ _7178_/A1 _7178_/A2 _7177_/B _7179_/A2 PHY_9/VDD PHY_9/VDD VSUBS VSUBS gf180mcu_fd_sc_mcu7t5v0__nand3_1
X_6129_ _9914_/Q _6287_/A2 _6287_/B1 _9859_/Q _6131_/A1 PHY_9/VDD PHY_9/VDD VSUBS
+ VSUBS gf180mcu_fd_sc_mcu7t5v0__aoi22_1
X_9819_ _9819_/D _9907_/CLK _9819_/Q PHY_9/VDD PHY_9/VDD VSUBS VSUBS gf180mcu_fd_sc_mcu7t5v0__dffq_2
X_5500_ _9725_/Q _5498_/Z _5522_/B PHY_9/VDD PHY_9/VDD VSUBS VSUBS gf180mcu_fd_sc_mcu7t5v0__nor2_4
X_6480_ _6480_/A1 _6480_/A2 _6480_/B _6504_/A1 PHY_9/VDD PHY_9/VDD VSUBS VSUBS gf180mcu_fd_sc_mcu7t5v0__oai21_1
X_5431_ _9731_/Q _5488_/A1 _5431_/B _9431_/D PHY_9/VDD PHY_9/VDD VSUBS VSUBS gf180mcu_fd_sc_mcu7t5v0__aoi21_1
X_5362_ _5362_/A1 _5364_/A2 _5362_/B _9416_/D PHY_9/VDD PHY_9/VDD VSUBS VSUBS gf180mcu_fd_sc_mcu7t5v0__aoi21_1
X_8150_ _8151_/A1 _8149_/Z _8191_/A2 PHY_9/VDD PHY_9/VDD VSUBS VSUBS gf180mcu_fd_sc_mcu7t5v0__nand2_1
X_7101_ _7322_/A1 _7101_/A2 _7101_/B _7102_/B PHY_9/VDD PHY_9/VDD VSUBS VSUBS gf180mcu_fd_sc_mcu7t5v0__aoi21_1
X_8081_ _9899_/Q _8339_/B _8102_/A1 _8082_/B PHY_9/VDD PHY_9/VDD VSUBS VSUBS gf180mcu_fd_sc_mcu7t5v0__nor3_1
X_7032_ _7036_/A1 _7182_/A1 _7315_/A2 PHY_9/VDD PHY_9/VDD VSUBS VSUBS gf180mcu_fd_sc_mcu7t5v0__nor2_2
X_5293_ _9463_/Q _5296_/A2 _7695_/B _5294_/B PHY_9/VDD PHY_9/VDD VSUBS VSUBS gf180mcu_fd_sc_mcu7t5v0__oai21_1
X_8983_ _8983_/A1 _8983_/A2 _8983_/B _8984_/B PHY_9/VDD PHY_9/VDD VSUBS VSUBS gf180mcu_fd_sc_mcu7t5v0__oai21_1
X_7934_ _8973_/A1 _7738_/C _7934_/B1 _7934_/B2 _8011_/A2 PHY_9/VDD PHY_9/VDD VSUBS
+ VSUBS gf180mcu_fd_sc_mcu7t5v0__aoi22_4
X_7865_ _7865_/I _7914_/B PHY_9/VDD PHY_9/VDD VSUBS VSUBS gf180mcu_fd_sc_mcu7t5v0__clkinv_1
X_9604_ _9604_/D _9940_/CLK _9604_/Q PHY_9/VDD PHY_9/VDD VSUBS VSUBS gf180mcu_fd_sc_mcu7t5v0__dffq_1
X_6816_ _8166_/A2 _6970_/B1 _6816_/B1 _6816_/B2 _6921_/A2 PHY_9/VDD PHY_9/VDD VSUBS
+ VSUBS gf180mcu_fd_sc_mcu7t5v0__aoi22_4
X_7796_ _7831_/C _7796_/A2 _7796_/B1 _7796_/B2 _9356_/C _7797_/B PHY_9/VDD PHY_9/VDD
+ VSUBS VSUBS gf180mcu_fd_sc_mcu7t5v0__aoi221_1
X_6747_ _6748_/A1 _6748_/A2 _6791_/A1 PHY_9/VDD PHY_9/VDD VSUBS VSUBS gf180mcu_fd_sc_mcu7t5v0__nor2_1
X_9535_ _9535_/D _9689_/CLK _9535_/Q PHY_9/VDD PHY_9/VDD VSUBS VSUBS gf180mcu_fd_sc_mcu7t5v0__dffq_1
X_6678_ _9891_/Q _9835_/Q _6679_/B2 PHY_9/VDD PHY_9/VDD VSUBS VSUBS gf180mcu_fd_sc_mcu7t5v0__nor2_1
X_9466_ _9466_/D _9972_/CLK _9466_/Q PHY_9/VDD PHY_9/VDD VSUBS VSUBS gf180mcu_fd_sc_mcu7t5v0__dffq_1
X_9397_ _9397_/D _9856_/CLK _9397_/Q PHY_9/VDD PHY_9/VDD VSUBS VSUBS gf180mcu_fd_sc_mcu7t5v0__dffq_1
X_8417_ _9090_/C _8369_/Z _8417_/A3 _8475_/A1 PHY_9/VDD PHY_9/VDD VSUBS VSUBS gf180mcu_fd_sc_mcu7t5v0__nor3_2
X_5629_ _9776_/Q _5561_/I _5631_/A1 PHY_9/VDD PHY_9/VDD VSUBS VSUBS gf180mcu_fd_sc_mcu7t5v0__nand2_1
X_8348_ _8692_/A1 _8353_/A2 _8353_/B1 _8348_/B2 _9914_/D PHY_9/VDD PHY_9/VDD VSUBS
+ VSUBS gf180mcu_fd_sc_mcu7t5v0__oai22_1
X_8279_ _8269_/I _8315_/A2 _8279_/Z PHY_9/VDD PHY_9/VDD VSUBS VSUBS gf180mcu_fd_sc_mcu7t5v0__xor2_1
X_5980_ _7007_/B _5988_/A2 _5988_/B1 PHY_9/VDD PHY_9/VDD VSUBS VSUBS gf180mcu_fd_sc_mcu7t5v0__nand2_2
X_4931_ _9699_/Q _5992_/B2 PHY_9/VDD PHY_9/VDD VSUBS VSUBS gf180mcu_fd_sc_mcu7t5v0__clkinv_1
X_4862_ _5967_/B _5973_/C PHY_9/VDD PHY_9/VDD VSUBS VSUBS gf180mcu_fd_sc_mcu7t5v0__clkinv_20
X_7650_ _9898_/Q _7450_/Z _7650_/B1 _9932_/Q _7651_/B PHY_9/VDD PHY_9/VDD VSUBS VSUBS
+ gf180mcu_fd_sc_mcu7t5v0__aoi22_1
X_6601_ _9821_/Q _6599_/Z _6620_/B PHY_9/VDD PHY_9/VDD VSUBS VSUBS gf180mcu_fd_sc_mcu7t5v0__nand2_1
X_4793_ _9815_/Q _6677_/A3 PHY_9/VDD PHY_9/VDD VSUBS VSUBS gf180mcu_fd_sc_mcu7t5v0__inv_1
X_7581_ _9812_/Q _7655_/A2 _7581_/B _7582_/B PHY_9/VDD PHY_9/VDD VSUBS VSUBS gf180mcu_fd_sc_mcu7t5v0__oai21_1
X_9320_ _9275_/Z _9320_/A2 _9320_/B _9338_/A1 PHY_9/VDD PHY_9/VDD VSUBS VSUBS gf180mcu_fd_sc_mcu7t5v0__oai21_1
X_6532_ _9812_/Q _6624_/A2 _6635_/A1 PHY_9/VDD PHY_9/VDD VSUBS VSUBS gf180mcu_fd_sc_mcu7t5v0__nand2_1
X_6463_ _9818_/Q _6480_/A1 _6460_/Z _6463_/Z PHY_9/VDD PHY_9/VDD VSUBS VSUBS gf180mcu_fd_sc_mcu7t5v0__xor3_1
X_9251_ _9333_/A2 _9159_/Z _9178_/Z _9251_/B _9252_/I PHY_9/VDD PHY_9/VDD VSUBS VSUBS
+ gf180mcu_fd_sc_mcu7t5v0__oai31_1
X_9182_ _9268_/A1 _9273_/A1 _9245_/A1 PHY_9/VDD PHY_9/VDD VSUBS VSUBS gf180mcu_fd_sc_mcu7t5v0__nor2_1
X_5414_ _9772_/Q _5439_/A2 _5414_/B1 _5130_/I _5482_/A1 PHY_9/VDD PHY_9/VDD VSUBS
+ VSUBS gf180mcu_fd_sc_mcu7t5v0__aoi22_2
X_8202_ _9811_/Q _8300_/A2 _8300_/B1 _8203_/A2 _8300_/C _8203_/B PHY_9/VDD PHY_9/VDD
+ VSUBS VSUBS gf180mcu_fd_sc_mcu7t5v0__aoi221_1
X_6394_ _6395_/A1 _6393_/Z _6432_/A2 PHY_9/VDD PHY_9/VDD VSUBS VSUBS gf180mcu_fd_sc_mcu7t5v0__nor2_1
X_8133_ _6471_/B _8309_/A2 _8220_/B2 PHY_9/VDD PHY_9/VDD VSUBS VSUBS gf180mcu_fd_sc_mcu7t5v0__nor2_1
X_5345_ _5575_/A2 _5353_/A2 _5345_/B _8027_/B _9408_/D PHY_9/VDD PHY_9/VDD VSUBS VSUBS
+ gf180mcu_fd_sc_mcu7t5v0__oai211_1
X_5276_ _9378_/Q _5285_/A2 _5277_/B PHY_9/VDD PHY_9/VDD VSUBS VSUBS gf180mcu_fd_sc_mcu7t5v0__nor2_1
X_8064_ _8064_/A1 _8064_/A2 _9904_/D PHY_9/VDD PHY_9/VDD VSUBS VSUBS gf180mcu_fd_sc_mcu7t5v0__nor2_1
X_7015_ _9904_/Q _9848_/Q _7017_/A2 PHY_9/VDD PHY_9/VDD VSUBS VSUBS gf180mcu_fd_sc_mcu7t5v0__nor2_1
X_8966_ _8992_/A1 _8992_/A2 _8966_/Z PHY_9/VDD PHY_9/VDD VSUBS VSUBS gf180mcu_fd_sc_mcu7t5v0__xor2_1
X_7917_ _7917_/I _7970_/A1 PHY_9/VDD PHY_9/VDD VSUBS VSUBS gf180mcu_fd_sc_mcu7t5v0__clkinv_1
X_8897_ _9807_/Q _8998_/A2 _8898_/I PHY_9/VDD PHY_9/VDD VSUBS VSUBS gf180mcu_fd_sc_mcu7t5v0__nand2_1
X_7848_ _7790_/Z _7848_/A2 _7847_/Z _7901_/A2 PHY_9/VDD PHY_9/VDD VSUBS VSUBS gf180mcu_fd_sc_mcu7t5v0__nand3_1
X_7779_ _7814_/A1 _7814_/A2 _7779_/Z PHY_9/VDD PHY_9/VDD VSUBS VSUBS gf180mcu_fd_sc_mcu7t5v0__xor2_1
X_9518_ _9518_/D _9801_/CLK _9518_/Q PHY_9/VDD PHY_9/VDD VSUBS VSUBS gf180mcu_fd_sc_mcu7t5v0__dffq_1
X_9449_ _9449_/D _9800_/CLK _9449_/Q PHY_9/VDD PHY_9/VDD VSUBS VSUBS gf180mcu_fd_sc_mcu7t5v0__dffq_1
X_5130_ _5130_/I _5135_/A1 PHY_9/VDD PHY_9/VDD VSUBS VSUBS gf180mcu_fd_sc_mcu7t5v0__clkinv_1
X_5061_ _9604_/Q _5780_/B2 PHY_9/VDD PHY_9/VDD VSUBS VSUBS gf180mcu_fd_sc_mcu7t5v0__clkinv_1
X_8820_ _9227_/A1 _8752_/I _8820_/B _8856_/B1 PHY_9/VDD PHY_9/VDD VSUBS VSUBS gf180mcu_fd_sc_mcu7t5v0__oai21_1
X_5963_ _9685_/Q _5973_/A2 rst_n _5964_/B PHY_9/VDD PHY_9/VDD VSUBS VSUBS gf180mcu_fd_sc_mcu7t5v0__oai21_1
X_8751_ _8748_/Z _8749_/Z _8751_/A3 _8720_/B _9499_/Q _8752_/I PHY_9/VDD PHY_9/VDD
+ VSUBS VSUBS gf180mcu_fd_sc_mcu7t5v0__oai32_4
X_4914_ _9715_/Q _6012_/B2 PHY_9/VDD PHY_9/VDD VSUBS VSUBS gf180mcu_fd_sc_mcu7t5v0__clkinv_1
X_7702_ _8742_/A1 _7738_/C _7708_/B PHY_9/VDD PHY_9/VDD VSUBS VSUBS gf180mcu_fd_sc_mcu7t5v0__nand2_1
X_8682_ _8692_/A1 _8687_/A2 _8687_/B1 _8682_/B2 _9935_/D PHY_9/VDD PHY_9/VDD VSUBS
+ VSUBS gf180mcu_fd_sc_mcu7t5v0__oai22_1
X_5894_ _9657_/Q _5166_/Z _5899_/A1 _5887_/Z _5894_/C _9657_/D PHY_9/VDD PHY_9/VDD
+ VSUBS VSUBS gf180mcu_fd_sc_mcu7t5v0__aoi221_1
X_4845_ _9462_/Q _5393_/A1 PHY_9/VDD PHY_9/VDD VSUBS VSUBS gf180mcu_fd_sc_mcu7t5v0__clkinv_2
X_7633_ _7669_/A2 _7633_/A2 _7638_/A3 PHY_9/VDD PHY_9/VDD VSUBS VSUBS gf180mcu_fd_sc_mcu7t5v0__nand2_1
X_7564_ _7564_/A1 _7564_/A2 _7566_/A2 PHY_9/VDD PHY_9/VDD VSUBS VSUBS gf180mcu_fd_sc_mcu7t5v0__xnor2_1
X_4776_ _9837_/Q _7735_/A3 PHY_9/VDD PHY_9/VDD VSUBS VSUBS gf180mcu_fd_sc_mcu7t5v0__inv_3
X_6515_ _6470_/B _6509_/Z _6551_/B _6515_/B _6516_/B PHY_9/VDD PHY_9/VDD VSUBS VSUBS
+ gf180mcu_fd_sc_mcu7t5v0__oai31_1
X_9303_ _9344_/A1 _9299_/Z _9316_/A2 PHY_9/VDD PHY_9/VDD VSUBS VSUBS gf180mcu_fd_sc_mcu7t5v0__nand2_1
X_7495_ _9895_/Q _7450_/Z _7495_/Z PHY_9/VDD PHY_9/VDD VSUBS VSUBS gf180mcu_fd_sc_mcu7t5v0__and2_1
X_6446_ _6471_/A1 _6471_/A2 _6625_/A2 PHY_9/VDD PHY_9/VDD VSUBS VSUBS gf180mcu_fd_sc_mcu7t5v0__nand2_4
X_9234_ _9810_/Q _9103_/Z _9281_/B2 PHY_9/VDD PHY_9/VDD VSUBS VSUBS gf180mcu_fd_sc_mcu7t5v0__nand2_1
X_6377_ _9807_/Q _6624_/A2 _6377_/B _6406_/C _6384_/B1 PHY_9/VDD PHY_9/VDD VSUBS VSUBS
+ gf180mcu_fd_sc_mcu7t5v0__oai211_1
X_9165_ _9165_/A1 _9165_/A2 _9164_/B _9173_/A1 PHY_9/VDD PHY_9/VDD VSUBS VSUBS gf180mcu_fd_sc_mcu7t5v0__nor3_1
X_5328_ _9401_/Q _5331_/A2 _5329_/B PHY_9/VDD PHY_9/VDD VSUBS VSUBS gf180mcu_fd_sc_mcu7t5v0__nor2_1
X_8116_ _9899_/Q _8339_/B _8115_/Z _8117_/B1 PHY_9/VDD PHY_9/VDD VSUBS VSUBS gf180mcu_fd_sc_mcu7t5v0__nor3_1
X_9096_ _9968_/Q _9093_/Z _9098_/A2 PHY_9/VDD PHY_9/VDD VSUBS VSUBS gf180mcu_fd_sc_mcu7t5v0__xnor2_1
X_8047_ _8057_/A1 _9900_/Q _8058_/A3 _8301_/A1 PHY_9/VDD PHY_9/VDD VSUBS VSUBS gf180mcu_fd_sc_mcu7t5v0__nand3_2
X_5259_ _9464_/Q _5260_/A2 _8706_/B _5260_/B PHY_9/VDD PHY_9/VDD VSUBS VSUBS gf180mcu_fd_sc_mcu7t5v0__oai21_1
X_8949_ _8903_/Z _8949_/A2 _8949_/B _8965_/A1 PHY_9/VDD PHY_9/VDD VSUBS VSUBS gf180mcu_fd_sc_mcu7t5v0__oai21_1
X_6300_ _5399_/Z _6303_/A2 _6303_/B1 _6300_/B2 _9782_/D PHY_9/VDD PHY_9/VDD VSUBS
+ VSUBS gf180mcu_fd_sc_mcu7t5v0__oai22_1
X_7280_ _9813_/Q _7315_/A2 _7281_/A2 _7314_/I1 _7315_/B _7281_/B PHY_9/VDD PHY_9/VDD
+ VSUBS VSUBS gf180mcu_fd_sc_mcu7t5v0__aoi221_1
X_6231_ _6283_/B2 _6231_/A2 _6231_/B1 _6283_/A1 _6234_/A1 PHY_9/VDD PHY_9/VDD VSUBS
+ VSUBS gf180mcu_fd_sc_mcu7t5v0__aoi22_1
Xrepeater3 rst_n _5961_/B PHY_9/VDD PHY_9/VDD VSUBS VSUBS gf180mcu_fd_sc_mcu7t5v0__buf_8
X_6162_ _9529_/Q _6288_/A2 _6288_/B1 _9717_/Q _6163_/A2 PHY_9/VDD PHY_9/VDD VSUBS
+ VSUBS gf180mcu_fd_sc_mcu7t5v0__aoi22_1
X_5113_ _9630_/Q _5814_/B2 PHY_9/VDD PHY_9/VDD VSUBS VSUBS gf180mcu_fd_sc_mcu7t5v0__clkinv_1
X_6093_ _6093_/A1 _6093_/A2 _6115_/A2 PHY_9/VDD PHY_9/VDD VSUBS VSUBS gf180mcu_fd_sc_mcu7t5v0__nand2_1
X_5044_ _9531_/Q _5654_/B2 PHY_9/VDD PHY_9/VDD VSUBS VSUBS gf180mcu_fd_sc_mcu7t5v0__clkinv_1
X_9921_ _9921_/D _9957_/CLK _9921_/Q PHY_9/VDD PHY_9/VDD VSUBS VSUBS gf180mcu_fd_sc_mcu7t5v0__dffq_2
X_9852_ _9852_/D _9940_/CLK _9852_/Q PHY_9/VDD PHY_9/VDD VSUBS VSUBS gf180mcu_fd_sc_mcu7t5v0__dffq_2
X_8803_ _9227_/A1 _8784_/I _8904_/A1 PHY_9/VDD PHY_9/VDD VSUBS VSUBS gf180mcu_fd_sc_mcu7t5v0__nor2_2
X_6995_ _6995_/A1 _6995_/A2 _6995_/B _6995_/C _6999_/B PHY_9/VDD PHY_9/VDD VSUBS VSUBS
+ gf180mcu_fd_sc_mcu7t5v0__oai211_1
X_9783_ _9783_/D _9830_/CLK _9783_/Q PHY_9/VDD PHY_9/VDD VSUBS VSUBS gf180mcu_fd_sc_mcu7t5v0__dffq_1
X_8734_ _8734_/I _9024_/A1 PHY_9/VDD PHY_9/VDD VSUBS VSUBS gf180mcu_fd_sc_mcu7t5v0__clkinv_1
X_5946_ _9684_/Q _5951_/A2 rst_n _5947_/B PHY_9/VDD PHY_9/VDD VSUBS VSUBS gf180mcu_fd_sc_mcu7t5v0__oai21_1
X_5877_ _9649_/Q _5871_/Z _9650_/Q _5878_/A2 PHY_9/VDD PHY_9/VDD VSUBS VSUBS gf180mcu_fd_sc_mcu7t5v0__aoi21_1
X_8665_ _8665_/A1 _8629_/Z _8665_/B _8671_/A1 PHY_9/VDD PHY_9/VDD VSUBS VSUBS gf180mcu_fd_sc_mcu7t5v0__oai21_1
X_7616_ _7559_/Z _7617_/A2 _7643_/B PHY_9/VDD PHY_9/VDD VSUBS VSUBS gf180mcu_fd_sc_mcu7t5v0__nand2_1
X_4828_ _9502_/Q _5604_/A1 PHY_9/VDD PHY_9/VDD VSUBS VSUBS gf180mcu_fd_sc_mcu7t5v0__clkinv_1
X_8596_ _8597_/A1 _8595_/Z _8660_/A1 PHY_9/VDD PHY_9/VDD VSUBS VSUBS gf180mcu_fd_sc_mcu7t5v0__nor2_1
X_4759_ _9386_/Q _5294_/A1 PHY_9/VDD PHY_9/VDD VSUBS VSUBS gf180mcu_fd_sc_mcu7t5v0__clkinv_1
X_7547_ _9809_/Q _7599_/A2 _7601_/A2 PHY_9/VDD PHY_9/VDD VSUBS VSUBS gf180mcu_fd_sc_mcu7t5v0__nand2_1
X_7478_ _7478_/A1 _7476_/Z _7478_/Z PHY_9/VDD PHY_9/VDD VSUBS VSUBS gf180mcu_fd_sc_mcu7t5v0__and2_1
X_6429_ _9809_/Q _6428_/Z _6464_/A1 PHY_9/VDD PHY_9/VDD VSUBS VSUBS gf180mcu_fd_sc_mcu7t5v0__nand2_1
X_9217_ _9217_/A1 _9221_/A2 _9217_/B1 _9217_/B2 _9217_/C _9218_/A2 PHY_9/VDD PHY_9/VDD
+ VSUBS VSUBS gf180mcu_fd_sc_mcu7t5v0__oai221_1
X_9148_ _9810_/Q _9331_/A2 _9285_/A2 _9809_/Q _9184_/A2 PHY_9/VDD PHY_9/VDD VSUBS
+ VSUBS gf180mcu_fd_sc_mcu7t5v0__aoi22_1
X_9079_ _9285_/A2 _9081_/A3 _9080_/A2 PHY_9/VDD PHY_9/VDD VSUBS VSUBS gf180mcu_fd_sc_mcu7t5v0__xnor2_1
X_6780_ _9810_/Q _6824_/A2 _6824_/A3 _6784_/A3 PHY_9/VDD PHY_9/VDD VSUBS VSUBS gf180mcu_fd_sc_mcu7t5v0__nand3_2
X_5800_ _8693_/A1 _5804_/A2 _5804_/B1 _5800_/B2 _9618_/D PHY_9/VDD PHY_9/VDD VSUBS
+ VSUBS gf180mcu_fd_sc_mcu7t5v0__oai22_1
X_5731_ _8691_/A1 _5737_/A2 _5737_/B1 _5731_/B2 _9567_/D PHY_9/VDD PHY_9/VDD VSUBS
+ VSUBS gf180mcu_fd_sc_mcu7t5v0__oai22_1
X_5662_ _5659_/I _5662_/A2 _9535_/D PHY_9/VDD PHY_9/VDD VSUBS VSUBS gf180mcu_fd_sc_mcu7t5v0__nor2_1
X_8450_ _8485_/A2 _8449_/Z _8456_/A2 PHY_9/VDD PHY_9/VDD VSUBS VSUBS gf180mcu_fd_sc_mcu7t5v0__nor2_1
X_7401_ _7739_/A2 _7398_/I _7409_/A1 PHY_9/VDD PHY_9/VDD VSUBS VSUBS gf180mcu_fd_sc_mcu7t5v0__nor2_1
X_8381_ _8390_/A3 _8381_/A2 _8664_/A1 PHY_9/VDD PHY_9/VDD VSUBS VSUBS gf180mcu_fd_sc_mcu7t5v0__nor2_2
X_5593_ _9497_/Q _5594_/A1 _9035_/B _5594_/B PHY_9/VDD PHY_9/VDD VSUBS VSUBS gf180mcu_fd_sc_mcu7t5v0__oai21_1
X_7332_ _8693_/A1 _7336_/A2 _7336_/B1 _7332_/B2 _9860_/D PHY_9/VDD PHY_9/VDD VSUBS
+ VSUBS gf180mcu_fd_sc_mcu7t5v0__oai22_1
X_7263_ _7264_/A1 _7262_/Z _7309_/A2 PHY_9/VDD PHY_9/VDD VSUBS VSUBS gf180mcu_fd_sc_mcu7t5v0__nor2_1
X_6214_ _9695_/Q _6288_/A2 _6288_/B1 _9711_/Q _6215_/A2 PHY_9/VDD PHY_9/VDD VSUBS
+ VSUBS gf180mcu_fd_sc_mcu7t5v0__aoi22_1
X_9002_ _9002_/A1 _9002_/A2 _9002_/B _9010_/A2 PHY_9/VDD PHY_9/VDD VSUBS VSUBS gf180mcu_fd_sc_mcu7t5v0__oai21_1
X_7194_ _7246_/A1 _7246_/A2 _7303_/A2 PHY_9/VDD PHY_9/VDD VSUBS VSUBS gf180mcu_fd_sc_mcu7t5v0__nand2_2
X_6145_ _6291_/B2 _6145_/A2 _6145_/B1 _8688_/A2 _6145_/C _6147_/A2 PHY_9/VDD PHY_9/VDD
+ VSUBS VSUBS gf180mcu_fd_sc_mcu7t5v0__aoi221_2
X_6076_ _9698_/Q _6287_/A2 _6287_/B1 _9599_/Q _6078_/A1 PHY_9/VDD PHY_9/VDD VSUBS
+ VSUBS gf180mcu_fd_sc_mcu7t5v0__aoi22_1
X_5027_ _9702_/Q _5995_/B2 PHY_9/VDD PHY_9/VDD VSUBS VSUBS gf180mcu_fd_sc_mcu7t5v0__clkinv_1
X_9904_ _9904_/D _9974_/CLK _9904_/Q PHY_9/VDD PHY_9/VDD VSUBS VSUBS gf180mcu_fd_sc_mcu7t5v0__dffq_2
X_9835_ _9835_/D _9856_/CLK _9835_/Q PHY_9/VDD PHY_9/VDD VSUBS VSUBS gf180mcu_fd_sc_mcu7t5v0__dffq_4
X_9766_ _9766_/D _9939_/CLK _9766_/Q PHY_9/VDD PHY_9/VDD VSUBS VSUBS gf180mcu_fd_sc_mcu7t5v0__dffq_1
X_6978_ _6978_/A1 _6978_/A2 _6930_/Z _6978_/B2 _6979_/A3 PHY_9/VDD PHY_9/VDD VSUBS
+ VSUBS gf180mcu_fd_sc_mcu7t5v0__oai22_1
X_8717_ _9953_/Q _9952_/Q _8717_/Z PHY_9/VDD PHY_9/VDD VSUBS VSUBS gf180mcu_fd_sc_mcu7t5v0__and2_2
X_9697_ _9697_/D _9939_/CLK _9697_/Q PHY_9/VDD PHY_9/VDD VSUBS VSUBS gf180mcu_fd_sc_mcu7t5v0__dffq_1
X_5929_ _9668_/Q _5925_/Z _5932_/B _5930_/A2 PHY_9/VDD PHY_9/VDD VSUBS VSUBS gf180mcu_fd_sc_mcu7t5v0__oai21_1
X_8648_ _9807_/Q _8668_/A2 _8651_/A1 PHY_9/VDD PHY_9/VDD VSUBS VSUBS gf180mcu_fd_sc_mcu7t5v0__nand2_1
X_8579_ _6558_/B _8625_/A2 _8580_/B PHY_9/VDD PHY_9/VDD VSUBS VSUBS gf180mcu_fd_sc_mcu7t5v0__xor2_1
X_7950_ _6558_/B _7988_/A2 _7988_/A3 _7950_/B _7988_/B1 PHY_9/VDD PHY_9/VDD VSUBS
+ VSUBS gf180mcu_fd_sc_mcu7t5v0__oai31_1
X_6901_ _6899_/Z _6947_/B _6902_/A2 PHY_9/VDD PHY_9/VDD VSUBS VSUBS gf180mcu_fd_sc_mcu7t5v0__nor2_1
X_7881_ _7881_/A1 _7860_/Z _7881_/B _7930_/A1 PHY_9/VDD PHY_9/VDD VSUBS VSUBS gf180mcu_fd_sc_mcu7t5v0__aoi21_1
X_6832_ _6834_/B _6833_/A2 PHY_9/VDD PHY_9/VDD VSUBS VSUBS gf180mcu_fd_sc_mcu7t5v0__clkinv_1
X_9620_ _9620_/D _9948_/CLK _9620_/Q PHY_9/VDD PHY_9/VDD VSUBS VSUBS gf180mcu_fd_sc_mcu7t5v0__dffq_1
X_6763_ _9809_/Q _6806_/A2 _6808_/C _6764_/C PHY_9/VDD PHY_9/VDD VSUBS VSUBS gf180mcu_fd_sc_mcu7t5v0__aoi21_1
X_9551_ _9551_/D _9940_/CLK _9551_/Q PHY_9/VDD PHY_9/VDD VSUBS VSUBS gf180mcu_fd_sc_mcu7t5v0__dffq_1
X_6694_ _6698_/A1 _6997_/A2 _6806_/A2 PHY_9/VDD PHY_9/VDD VSUBS VSUBS gf180mcu_fd_sc_mcu7t5v0__nor2_1
X_5714_ _5404_/Z _5715_/A2 _5715_/B1 _5714_/B2 _9556_/D PHY_9/VDD PHY_9/VDD VSUBS
+ VSUBS gf180mcu_fd_sc_mcu7t5v0__oai22_1
X_8502_ _9808_/Q _8464_/Z _8600_/A2 _8591_/A1 PHY_9/VDD PHY_9/VDD VSUBS VSUBS gf180mcu_fd_sc_mcu7t5v0__nand3_1
X_9482_ _9482_/D _9901_/CLK _9482_/Q PHY_9/VDD PHY_9/VDD VSUBS VSUBS gf180mcu_fd_sc_mcu7t5v0__dffq_1
X_8433_ _9809_/Q _8606_/A2 _8434_/A3 _8433_/Z PHY_9/VDD PHY_9/VDD VSUBS VSUBS gf180mcu_fd_sc_mcu7t5v0__and3_1
X_5645_ _5404_/Z _5646_/A2 _5646_/B1 _5645_/B2 _9520_/D PHY_9/VDD PHY_9/VDD VSUBS
+ VSUBS gf180mcu_fd_sc_mcu7t5v0__oai22_1
X_8364_ _9924_/Q _8647_/A3 _8646_/A2 PHY_9/VDD PHY_9/VDD VSUBS VSUBS gf180mcu_fd_sc_mcu7t5v0__nor2_4
X_5576_ _9413_/Q _9317_/C _5592_/B1 _9403_/Q _5576_/C _5578_/A2 PHY_9/VDD PHY_9/VDD
+ VSUBS VSUBS gf180mcu_fd_sc_mcu7t5v0__aoi221_2
X_7315_ _9814_/Q _7315_/A2 _7315_/B _7315_/C _7317_/A2 PHY_9/VDD PHY_9/VDD VSUBS VSUBS
+ gf180mcu_fd_sc_mcu7t5v0__aoi211_1
X_8295_ _9813_/Q _8294_/Z _8332_/B PHY_9/VDD PHY_9/VDD VSUBS VSUBS gf180mcu_fd_sc_mcu7t5v0__nand2_1
X_7246_ _7246_/A1 _7246_/A2 _9091_/B _7306_/A1 PHY_9/VDD PHY_9/VDD VSUBS VSUBS gf180mcu_fd_sc_mcu7t5v0__aoi21_1
X_7177_ _7178_/A1 _7178_/A2 _7177_/B _7227_/A2 PHY_9/VDD PHY_9/VDD VSUBS VSUBS gf180mcu_fd_sc_mcu7t5v0__aoi21_2
X_6128_ _6128_/A1 _6128_/A2 _6144_/A2 PHY_9/VDD PHY_9/VDD VSUBS VSUBS gf180mcu_fd_sc_mcu7t5v0__nand2_1
X_6059_ _5406_/Z _6059_/A2 _6059_/B1 _6059_/B2 _9769_/D PHY_9/VDD PHY_9/VDD VSUBS
+ VSUBS gf180mcu_fd_sc_mcu7t5v0__oai22_1
X_9818_ _9818_/D _9907_/CLK _9818_/Q PHY_9/VDD PHY_9/VDD VSUBS VSUBS gf180mcu_fd_sc_mcu7t5v0__dffq_2
X_9749_ _9749_/D _9939_/CLK _9749_/Q PHY_9/VDD PHY_9/VDD VSUBS VSUBS gf180mcu_fd_sc_mcu7t5v0__dffq_1
X_5430_ _9731_/Q _9431_/Q _9031_/B _5431_/B PHY_9/VDD PHY_9/VDD VSUBS VSUBS gf180mcu_fd_sc_mcu7t5v0__oai21_1
X_5361_ _9463_/Q _5364_/A2 _7007_/B _5362_/B PHY_9/VDD PHY_9/VDD VSUBS VSUBS gf180mcu_fd_sc_mcu7t5v0__oai21_1
X_7100_ _7281_/A1 _7158_/A1 _7100_/B1 _7100_/B2 _7100_/C _7101_/B PHY_9/VDD PHY_9/VDD
+ VSUBS VSUBS gf180mcu_fd_sc_mcu7t5v0__oai221_1
X_5292_ _5292_/A1 _5296_/A2 _5292_/B _9385_/D PHY_9/VDD PHY_9/VDD VSUBS VSUBS gf180mcu_fd_sc_mcu7t5v0__aoi21_1
X_8080_ _9091_/B _8075_/B _8102_/A1 PHY_9/VDD PHY_9/VDD VSUBS VSUBS gf180mcu_fd_sc_mcu7t5v0__nor2_1
X_7031_ _7084_/A1 _7314_/I0 _7322_/A1 _7035_/A2 PHY_9/VDD PHY_9/VDD VSUBS VSUBS gf180mcu_fd_sc_mcu7t5v0__nor3_1
X_8982_ _9813_/Q _8711_/B _8982_/B1 _8983_/A2 _8982_/C _8983_/B PHY_9/VDD PHY_9/VDD
+ VSUBS VSUBS gf180mcu_fd_sc_mcu7t5v0__aoi221_1
X_7933_ _7994_/A1 _9876_/Q _7994_/B _7934_/B2 PHY_9/VDD PHY_9/VDD VSUBS VSUBS gf180mcu_fd_sc_mcu7t5v0__oai21_2
X_7864_ _7771_/Z _7864_/A2 _7800_/Z _7966_/B _7865_/I PHY_9/VDD PHY_9/VDD VSUBS VSUBS
+ gf180mcu_fd_sc_mcu7t5v0__oai31_1
X_9603_ _9603_/D _9940_/CLK _9603_/Q PHY_9/VDD PHY_9/VDD VSUBS VSUBS gf180mcu_fd_sc_mcu7t5v0__dffq_1
X_6815_ _6815_/A1 _9819_/Q _6815_/B _6816_/B2 PHY_9/VDD PHY_9/VDD VSUBS VSUBS gf180mcu_fd_sc_mcu7t5v0__oai21_2
X_7795_ _7977_/A1 _7779_/Z _7789_/Z _7870_/B _7795_/C _7796_/B2 PHY_9/VDD PHY_9/VDD
+ VSUBS VSUBS gf180mcu_fd_sc_mcu7t5v0__aoi221_1
X_6746_ _6746_/A1 _6741_/Z _6746_/A3 _6748_/A2 PHY_9/VDD PHY_9/VDD VSUBS VSUBS gf180mcu_fd_sc_mcu7t5v0__xnor3_1
X_9534_ _9534_/D _9800_/CLK _9534_/Q PHY_9/VDD PHY_9/VDD VSUBS VSUBS gf180mcu_fd_sc_mcu7t5v0__dffq_1
X_6677_ _9835_/Q _6815_/B _6677_/A3 _6824_/A2 PHY_9/VDD PHY_9/VDD VSUBS VSUBS gf180mcu_fd_sc_mcu7t5v0__nand3_4
X_9465_ _9465_/D _9972_/CLK _9465_/Q PHY_9/VDD PHY_9/VDD VSUBS VSUBS gf180mcu_fd_sc_mcu7t5v0__dffq_1
X_9396_ _9396_/D _9856_/CLK _9396_/Q PHY_9/VDD PHY_9/VDD VSUBS VSUBS gf180mcu_fd_sc_mcu7t5v0__dffq_1
X_8416_ _9091_/B _8416_/A2 _8416_/A3 _8416_/A4 _8434_/A3 PHY_9/VDD PHY_9/VDD VSUBS
+ VSUBS gf180mcu_fd_sc_mcu7t5v0__nor4_4
X_5628_ _5628_/A1 _5628_/A2 _5973_/C _9511_/D PHY_9/VDD PHY_9/VDD VSUBS VSUBS gf180mcu_fd_sc_mcu7t5v0__aoi21_1
X_8347_ _8691_/A1 _8353_/A2 _8353_/B1 _8347_/B2 _9913_/D PHY_9/VDD PHY_9/VDD VSUBS
+ VSUBS gf180mcu_fd_sc_mcu7t5v0__oai22_1
X_5559_ _5567_/A1 _5567_/A2 _5559_/B _5562_/A2 PHY_9/VDD PHY_9/VDD VSUBS VSUBS gf180mcu_fd_sc_mcu7t5v0__oai21_1
X_8278_ _8278_/A1 _8278_/A2 _8315_/A2 PHY_9/VDD PHY_9/VDD VSUBS VSUBS gf180mcu_fd_sc_mcu7t5v0__xnor2_1
X_7229_ _9812_/Q _7303_/A2 _7231_/A2 PHY_9/VDD PHY_9/VDD VSUBS VSUBS gf180mcu_fd_sc_mcu7t5v0__nand2_1
X_4930_ _9707_/Q _6002_/B2 PHY_9/VDD PHY_9/VDD VSUBS VSUBS gf180mcu_fd_sc_mcu7t5v0__clkinv_1
X_4861_ _9403_/Q _5334_/A1 PHY_9/VDD PHY_9/VDD VSUBS VSUBS gf180mcu_fd_sc_mcu7t5v0__clkinv_1
X_6600_ _9821_/Q _6599_/Z _6620_/A2 PHY_9/VDD PHY_9/VDD VSUBS VSUBS gf180mcu_fd_sc_mcu7t5v0__nor2_1
X_4792_ _9816_/Q _7379_/A3 PHY_9/VDD PHY_9/VDD VSUBS VSUBS gf180mcu_fd_sc_mcu7t5v0__inv_2
X_7580_ _7636_/A1 _7580_/A2 _7580_/B _7581_/B PHY_9/VDD PHY_9/VDD VSUBS VSUBS gf180mcu_fd_sc_mcu7t5v0__oai21_1
X_6531_ _9810_/Q _6627_/A2 _6580_/B2 PHY_9/VDD PHY_9/VDD VSUBS VSUBS gf180mcu_fd_sc_mcu7t5v0__nand2_1
X_6462_ _9818_/Q _6460_/Z _6480_/B PHY_9/VDD PHY_9/VDD VSUBS VSUBS gf180mcu_fd_sc_mcu7t5v0__nand2_1
X_9250_ _9344_/A1 _9267_/A2 _9263_/A2 PHY_9/VDD PHY_9/VDD VSUBS VSUBS gf180mcu_fd_sc_mcu7t5v0__nand2_1
X_6393_ _9091_/B _6584_/B1 _6393_/A3 _6393_/Z PHY_9/VDD PHY_9/VDD VSUBS VSUBS gf180mcu_fd_sc_mcu7t5v0__xor3_1
X_9181_ _9808_/Q _9178_/Z _9273_/A1 PHY_9/VDD PHY_9/VDD VSUBS VSUBS gf180mcu_fd_sc_mcu7t5v0__nand2_1
X_5413_ _5413_/I _5414_/B1 PHY_9/VDD PHY_9/VDD VSUBS VSUBS gf180mcu_fd_sc_mcu7t5v0__clkinv_1
X_8201_ _9811_/Q _8266_/A2 _8203_/A2 PHY_9/VDD PHY_9/VDD VSUBS VSUBS gf180mcu_fd_sc_mcu7t5v0__nand2_1
X_8132_ _8132_/I _8175_/B2 PHY_9/VDD PHY_9/VDD VSUBS VSUBS gf180mcu_fd_sc_mcu7t5v0__clkinv_1
X_5344_ _9460_/Q _5353_/A2 _5345_/B PHY_9/VDD PHY_9/VDD VSUBS VSUBS gf180mcu_fd_sc_mcu7t5v0__nand2_1
X_8063_ _9904_/Q _9317_/C _9100_/B _8064_/A2 PHY_9/VDD PHY_9/VDD VSUBS VSUBS gf180mcu_fd_sc_mcu7t5v0__oai21_1
X_5275_ _5321_/A1 _5297_/A2 _5285_/A2 PHY_9/VDD PHY_9/VDD VSUBS VSUBS gf180mcu_fd_sc_mcu7t5v0__nor2_4
X_7014_ _9848_/Q _7145_/B _7705_/A2 _7048_/A1 PHY_9/VDD PHY_9/VDD VSUBS VSUBS gf180mcu_fd_sc_mcu7t5v0__nand3_2
X_8965_ _8965_/A1 _8965_/A2 _8992_/A2 PHY_9/VDD PHY_9/VDD VSUBS VSUBS gf180mcu_fd_sc_mcu7t5v0__xnor2_1
X_8896_ _8719_/C _8896_/A2 _8896_/B _8998_/A2 PHY_9/VDD PHY_9/VDD VSUBS VSUBS gf180mcu_fd_sc_mcu7t5v0__oai21_4
X_7916_ _9812_/Q _7915_/Z _7917_/I PHY_9/VDD PHY_9/VDD VSUBS VSUBS gf180mcu_fd_sc_mcu7t5v0__and2_1
X_7847_ _6512_/B _7988_/A2 _7845_/B _7847_/Z PHY_9/VDD PHY_9/VDD VSUBS VSUBS gf180mcu_fd_sc_mcu7t5v0__or3_1
X_7778_ _7814_/A1 _7814_/A2 _7815_/A1 PHY_9/VDD PHY_9/VDD VSUBS VSUBS gf180mcu_fd_sc_mcu7t5v0__nand2_1
X_6729_ _6757_/A2 _6729_/A2 _6729_/B _6729_/C _6733_/B PHY_9/VDD PHY_9/VDD VSUBS VSUBS
+ gf180mcu_fd_sc_mcu7t5v0__oai211_1
X_9517_ _9517_/D _9801_/CLK _9517_/Q PHY_9/VDD PHY_9/VDD VSUBS VSUBS gf180mcu_fd_sc_mcu7t5v0__dffq_1
X_9448_ _9448_/D _9800_/CLK _9448_/Q PHY_9/VDD PHY_9/VDD VSUBS VSUBS gf180mcu_fd_sc_mcu7t5v0__dffq_1
X_9379_ _9379_/D _9974_/CLK _9379_/Q PHY_9/VDD PHY_9/VDD VSUBS VSUBS gf180mcu_fd_sc_mcu7t5v0__dffq_1
X_5060_ _9695_/Q _5986_/B2 PHY_9/VDD PHY_9/VDD VSUBS VSUBS gf180mcu_fd_sc_mcu7t5v0__clkinv_1
X_5962_ _5962_/A1 _5973_/A2 _5962_/B _9683_/D PHY_9/VDD PHY_9/VDD VSUBS VSUBS gf180mcu_fd_sc_mcu7t5v0__aoi21_1
X_8750_ _9952_/Q _8750_/A2 _9953_/Q _8751_/A3 PHY_9/VDD PHY_9/VDD VSUBS VSUBS gf180mcu_fd_sc_mcu7t5v0__aoi21_2
X_4913_ _9739_/Q _6023_/B2 PHY_9/VDD PHY_9/VDD VSUBS VSUBS gf180mcu_fd_sc_mcu7t5v0__clkinv_1
X_7701_ _9890_/Q _9889_/Q _7739_/B PHY_9/VDD PHY_9/VDD VSUBS VSUBS gf180mcu_fd_sc_mcu7t5v0__or2_1
X_8681_ _8691_/A1 _8687_/A2 _8687_/B1 _8681_/B2 _9934_/D PHY_9/VDD PHY_9/VDD VSUBS
+ VSUBS gf180mcu_fd_sc_mcu7t5v0__oai22_1
X_5893_ _9657_/Q _5166_/Z _5967_/B _5894_/C PHY_9/VDD PHY_9/VDD VSUBS VSUBS gf180mcu_fd_sc_mcu7t5v0__oai21_1
X_4844_ _9463_/Q _5396_/A1 PHY_9/VDD PHY_9/VDD VSUBS VSUBS gf180mcu_fd_sc_mcu7t5v0__clkinv_2
X_7632_ _7674_/C2 _7632_/A2 _7633_/A2 PHY_9/VDD PHY_9/VDD VSUBS VSUBS gf180mcu_fd_sc_mcu7t5v0__nor2_1
X_4775_ _9838_/Q _7077_/A1 PHY_9/VDD PHY_9/VDD VSUBS VSUBS gf180mcu_fd_sc_mcu7t5v0__clkinv_2
X_7563_ _7564_/A1 _7564_/A2 _7563_/Z PHY_9/VDD PHY_9/VDD VSUBS VSUBS gf180mcu_fd_sc_mcu7t5v0__and2_1
X_6514_ _6401_/C _6514_/A2 _6514_/A3 _6577_/A2 _9811_/Q _6515_/B PHY_9/VDD PHY_9/VDD
+ VSUBS VSUBS gf180mcu_fd_sc_mcu7t5v0__oai32_1
X_9302_ _9319_/A1 _9301_/Z _9302_/Z PHY_9/VDD PHY_9/VDD VSUBS VSUBS gf180mcu_fd_sc_mcu7t5v0__xor2_1
X_7494_ _7494_/A1 _7493_/B _7538_/A1 _7561_/A1 PHY_9/VDD PHY_9/VDD VSUBS VSUBS gf180mcu_fd_sc_mcu7t5v0__xnor3_1
X_9233_ _9189_/Z _9190_/Z _9241_/A2 PHY_9/VDD PHY_9/VDD VSUBS VSUBS gf180mcu_fd_sc_mcu7t5v0__nand2_1
X_6445_ _9873_/Q _6569_/A2 _6471_/A2 PHY_9/VDD PHY_9/VDD VSUBS VSUBS gf180mcu_fd_sc_mcu7t5v0__nand2_2
X_6376_ _9804_/Q _9803_/Q _6376_/A3 _6406_/C PHY_9/VDD PHY_9/VDD VSUBS VSUBS gf180mcu_fd_sc_mcu7t5v0__nand3_2
X_9164_ _9165_/A1 _9165_/A2 _9164_/B _9209_/A2 PHY_9/VDD PHY_9/VDD VSUBS VSUBS gf180mcu_fd_sc_mcu7t5v0__oai21_1
X_8115_ _9809_/Q _8097_/Z _8115_/Z PHY_9/VDD PHY_9/VDD VSUBS VSUBS gf180mcu_fd_sc_mcu7t5v0__and2_1
X_5327_ _5393_/A1 _5331_/A2 _5327_/B _5973_/C _9400_/D PHY_9/VDD PHY_9/VDD VSUBS VSUBS
+ gf180mcu_fd_sc_mcu7t5v0__aoi211_1
X_9095_ _9095_/A1 _9095_/A2 _9095_/B1 _9095_/B2 _9095_/C _9099_/B PHY_9/VDD PHY_9/VDD
+ VSUBS VSUBS gf180mcu_fd_sc_mcu7t5v0__oai221_1
X_8046_ _9901_/Q _8057_/A2 _8337_/A1 PHY_9/VDD PHY_9/VDD VSUBS VSUBS gf180mcu_fd_sc_mcu7t5v0__nor2_2
X_5258_ _5258_/A1 _5260_/A2 _5258_/B _9371_/D PHY_9/VDD PHY_9/VDD VSUBS VSUBS gf180mcu_fd_sc_mcu7t5v0__aoi21_1
X_5189_ _9468_/Q _5437_/A2 _5567_/A2 PHY_9/VDD PHY_9/VDD VSUBS VSUBS gf180mcu_fd_sc_mcu7t5v0__nand2_1
X_8948_ _8948_/A1 _8948_/A2 _8992_/A1 PHY_9/VDD PHY_9/VDD VSUBS VSUBS gf180mcu_fd_sc_mcu7t5v0__xnor2_1
X_8879_ _6512_/B _8877_/Z _8879_/Z PHY_9/VDD PHY_9/VDD VSUBS VSUBS gf180mcu_fd_sc_mcu7t5v0__xor2_1
X_6230_ _6230_/A1 _6230_/A2 _6233_/B1 PHY_9/VDD PHY_9/VDD VSUBS VSUBS gf180mcu_fd_sc_mcu7t5v0__nand2_1
Xrepeater4 _5474_/B _5770_/B PHY_9/VDD PHY_9/VDD VSUBS VSUBS gf180mcu_fd_sc_mcu7t5v0__buf_8
X_6161_ _9484_/Q _6287_/A2 _6287_/B1 _9517_/Q _6163_/A1 PHY_9/VDD PHY_9/VDD VSUBS
+ VSUBS gf180mcu_fd_sc_mcu7t5v0__aoi22_1
X_5112_ _9638_/Q _5824_/B2 PHY_9/VDD PHY_9/VDD VSUBS VSUBS gf180mcu_fd_sc_mcu7t5v0__clkinv_1
X_6092_ _9779_/Q _6288_/A2 _6288_/B1 _9824_/Q _6093_/A2 PHY_9/VDD PHY_9/VDD VSUBS
+ VSUBS gf180mcu_fd_sc_mcu7t5v0__aoi22_1
X_9920_ _9920_/D _9957_/CLK _9920_/Q PHY_9/VDD PHY_9/VDD VSUBS VSUBS gf180mcu_fd_sc_mcu7t5v0__dffq_2
X_5043_ _9486_/Q _5556_/B2 PHY_9/VDD PHY_9/VDD VSUBS VSUBS gf180mcu_fd_sc_mcu7t5v0__clkinv_1
X_9851_ _9851_/D _9856_/CLK _9851_/Q PHY_9/VDD PHY_9/VDD VSUBS VSUBS gf180mcu_fd_sc_mcu7t5v0__dffq_2
X_8802_ _8980_/B _8837_/A2 _8809_/A2 PHY_9/VDD PHY_9/VDD VSUBS VSUBS gf180mcu_fd_sc_mcu7t5v0__nand2_1
X_6994_ _6995_/A1 _6995_/A2 _6995_/B PHY_9/VDD PHY_9/VDD VSUBS VSUBS gf180mcu_fd_sc_mcu7t5v0__nand2_1
X_9782_ _9782_/D _9801_/CLK _9782_/Q PHY_9/VDD PHY_9/VDD VSUBS VSUBS gf180mcu_fd_sc_mcu7t5v0__dffq_1
X_8733_ _8740_/A3 _9022_/B _8734_/I PHY_9/VDD PHY_9/VDD VSUBS VSUBS gf180mcu_fd_sc_mcu7t5v0__nor2_4
X_5945_ _5945_/A1 _5951_/A2 _5945_/B _9675_/D PHY_9/VDD PHY_9/VDD VSUBS VSUBS gf180mcu_fd_sc_mcu7t5v0__aoi21_1
X_5876_ _9649_/Q _5871_/Z _5876_/B _9649_/D PHY_9/VDD PHY_9/VDD VSUBS VSUBS gf180mcu_fd_sc_mcu7t5v0__aoi21_1
X_8664_ _8664_/A1 _8664_/A2 _8675_/C PHY_9/VDD PHY_9/VDD VSUBS VSUBS gf180mcu_fd_sc_mcu7t5v0__nand2_1
X_7615_ _7615_/I _7617_/A2 PHY_9/VDD PHY_9/VDD VSUBS VSUBS gf180mcu_fd_sc_mcu7t5v0__clkinv_1
X_4827_ _9503_/Q _5606_/A1 PHY_9/VDD PHY_9/VDD VSUBS VSUBS gf180mcu_fd_sc_mcu7t5v0__clkinv_1
X_8595_ _8595_/A1 _8595_/A2 _8595_/Z PHY_9/VDD PHY_9/VDD VSUBS VSUBS gf180mcu_fd_sc_mcu7t5v0__and2_1
X_4758_ _9868_/Q _7604_/B1 PHY_9/VDD PHY_9/VDD VSUBS VSUBS gf180mcu_fd_sc_mcu7t5v0__inv_4
X_7546_ _9809_/Q _7654_/A2 _7646_/A1 PHY_9/VDD PHY_9/VDD VSUBS VSUBS gf180mcu_fd_sc_mcu7t5v0__nand2_1
X_7477_ _7478_/A1 _7476_/Z _7485_/A2 PHY_9/VDD PHY_9/VDD VSUBS VSUBS gf180mcu_fd_sc_mcu7t5v0__nor2_1
X_4689_ _9963_/Q _9059_/A2 PHY_9/VDD PHY_9/VDD VSUBS VSUBS gf180mcu_fd_sc_mcu7t5v0__inv_2
X_6428_ _6627_/A2 _6428_/A2 _6428_/Z PHY_9/VDD PHY_9/VDD VSUBS VSUBS gf180mcu_fd_sc_mcu7t5v0__xor2_1
X_9216_ _9811_/Q _9216_/A2 _9216_/B1 _9347_/I1 _9348_/C _9217_/B2 PHY_9/VDD PHY_9/VDD
+ VSUBS VSUBS gf180mcu_fd_sc_mcu7t5v0__aoi221_1
X_9147_ _9810_/Q _9809_/Q _9331_/A2 _9285_/A2 _9184_/B PHY_9/VDD PHY_9/VDD VSUBS VSUBS
+ gf180mcu_fd_sc_mcu7t5v0__nand4_1
X_6359_ _6376_/A3 _6368_/A2 _6614_/B PHY_9/VDD PHY_9/VDD VSUBS VSUBS gf180mcu_fd_sc_mcu7t5v0__nand2_2
X_9078_ _9091_/A1 _9091_/A2 _9078_/B _9091_/C _9081_/A3 PHY_9/VDD PHY_9/VDD VSUBS
+ VSUBS gf180mcu_fd_sc_mcu7t5v0__aoi211_2
X_8029_ _8043_/A2 _8058_/A3 _8300_/A2 PHY_9/VDD PHY_9/VDD VSUBS VSUBS gf180mcu_fd_sc_mcu7t5v0__nor2_2
X_5730_ _5388_/Z _5737_/A2 _5737_/B1 _5730_/B2 _9566_/D PHY_9/VDD PHY_9/VDD VSUBS
+ VSUBS gf180mcu_fd_sc_mcu7t5v0__oai22_1
X_7400_ _7674_/C2 _7389_/Z _7400_/B _7400_/C _7405_/B PHY_9/VDD PHY_9/VDD VSUBS VSUBS
+ gf180mcu_fd_sc_mcu7t5v0__oai211_1
X_5661_ _9534_/Q _9535_/Q _5662_/A2 PHY_9/VDD PHY_9/VDD VSUBS VSUBS gf180mcu_fd_sc_mcu7t5v0__xnor2_1
X_8380_ _8381_/A2 _8634_/A1 _8535_/A1 _8380_/Z PHY_9/VDD PHY_9/VDD VSUBS VSUBS gf180mcu_fd_sc_mcu7t5v0__and3_2
X_5592_ _9417_/Q _9317_/C _5592_/B1 _9407_/Q _5592_/C _5594_/A2 PHY_9/VDD PHY_9/VDD
+ VSUBS VSUBS gf180mcu_fd_sc_mcu7t5v0__aoi221_1
X_7331_ _8692_/A1 _7336_/A2 _7336_/B1 _7331_/B2 _9859_/D PHY_9/VDD PHY_9/VDD VSUBS
+ VSUBS gf180mcu_fd_sc_mcu7t5v0__oai22_1
X_7262_ _7289_/A1 _7262_/A2 _7259_/Z _7262_/Z PHY_9/VDD PHY_9/VDD VSUBS VSUBS gf180mcu_fd_sc_mcu7t5v0__xor3_1
X_6213_ _9703_/Q _6287_/A2 _6287_/B1 _9604_/Q _6215_/A1 PHY_9/VDD PHY_9/VDD VSUBS
+ VSUBS gf180mcu_fd_sc_mcu7t5v0__aoi22_1
X_9001_ _8950_/Z _9001_/A2 _9001_/B _9008_/A3 PHY_9/VDD PHY_9/VDD VSUBS VSUBS gf180mcu_fd_sc_mcu7t5v0__aoi21_1
X_7193_ _9841_/Q _7299_/A2 _7299_/B1 _9909_/Q _7246_/A2 PHY_9/VDD PHY_9/VDD VSUBS
+ VSUBS gf180mcu_fd_sc_mcu7t5v0__aoi22_4
X_6144_ _6656_/A2 _6144_/A2 _6144_/B1 _6283_/B2 _6147_/A1 PHY_9/VDD PHY_9/VDD VSUBS
+ VSUBS gf180mcu_fd_sc_mcu7t5v0__aoi22_1
X_6075_ _6075_/A1 _6075_/A2 _6085_/A2 PHY_9/VDD PHY_9/VDD VSUBS VSUBS gf180mcu_fd_sc_mcu7t5v0__nand2_1
X_5026_ _9710_/Q _6005_/B2 PHY_9/VDD PHY_9/VDD VSUBS VSUBS gf180mcu_fd_sc_mcu7t5v0__clkinv_1
X_9903_ _9903_/D _9974_/CLK _9903_/Q PHY_9/VDD PHY_9/VDD VSUBS VSUBS gf180mcu_fd_sc_mcu7t5v0__dffq_4
X_9834_ _9834_/D _9856_/CLK _9834_/Q PHY_9/VDD PHY_9/VDD VSUBS VSUBS gf180mcu_fd_sc_mcu7t5v0__dffq_4
X_9765_ _9765_/D _9939_/CLK _9765_/Q PHY_9/VDD PHY_9/VDD VSUBS VSUBS gf180mcu_fd_sc_mcu7t5v0__dffq_1
X_6977_ _9809_/Q _6977_/A2 _6979_/A2 PHY_9/VDD PHY_9/VDD VSUBS VSUBS gf180mcu_fd_sc_mcu7t5v0__nand2_1
X_5928_ _9668_/Q _5925_/Z _5928_/Z PHY_9/VDD PHY_9/VDD VSUBS VSUBS gf180mcu_fd_sc_mcu7t5v0__and2_1
X_8716_ _9953_/Q _8994_/B _9925_/Q _8755_/B1 PHY_9/VDD PHY_9/VDD VSUBS VSUBS gf180mcu_fd_sc_mcu7t5v0__nand3_4
X_9696_ _9696_/D _9939_/CLK _9696_/Q PHY_9/VDD PHY_9/VDD VSUBS VSUBS gf180mcu_fd_sc_mcu7t5v0__dffq_1
X_5859_ _5832_/Z _5859_/A2 _5860_/B PHY_9/VDD PHY_9/VDD VSUBS VSUBS gf180mcu_fd_sc_mcu7t5v0__nand2_1
X_8647_ _9026_/A1 _8647_/A2 _8647_/A3 _8647_/B _8668_/A2 PHY_9/VDD PHY_9/VDD VSUBS
+ VSUBS gf180mcu_fd_sc_mcu7t5v0__oai31_4
X_8578_ _8644_/A2 _8626_/B _8625_/A2 PHY_9/VDD PHY_9/VDD VSUBS VSUBS gf180mcu_fd_sc_mcu7t5v0__xnor2_1
X_7529_ _7636_/A1 _7529_/A2 _7529_/B _7530_/B PHY_9/VDD PHY_9/VDD VSUBS VSUBS gf180mcu_fd_sc_mcu7t5v0__oai21_1
X_6900_ _6900_/A1 _6900_/A2 _6900_/B _6947_/B PHY_9/VDD PHY_9/VDD VSUBS VSUBS gf180mcu_fd_sc_mcu7t5v0__aoi21_1
X_7880_ _8166_/A2 _9356_/C _9357_/B _7880_/C _9895_/D PHY_9/VDD PHY_9/VDD VSUBS VSUBS
+ gf180mcu_fd_sc_mcu7t5v0__aoi211_1
X_6831_ _6863_/A1 _6831_/A2 _6828_/Z _6834_/B PHY_9/VDD PHY_9/VDD VSUBS VSUBS gf180mcu_fd_sc_mcu7t5v0__xor3_1
X_9550_ _9550_/D _9830_/CLK _9550_/Q PHY_9/VDD PHY_9/VDD VSUBS VSUBS gf180mcu_fd_sc_mcu7t5v0__dffq_1
X_6762_ _6996_/A1 _6828_/A1 _6955_/C _6764_/B1 PHY_9/VDD PHY_9/VDD VSUBS VSUBS gf180mcu_fd_sc_mcu7t5v0__aoi21_1
X_8501_ _9808_/Q _8600_/A2 _8552_/A1 PHY_9/VDD PHY_9/VDD VSUBS VSUBS gf180mcu_fd_sc_mcu7t5v0__nand2_1
X_6693_ _6724_/A2 _6996_/A1 _6995_/C _6693_/B _6697_/A1 PHY_9/VDD PHY_9/VDD VSUBS
+ VSUBS gf180mcu_fd_sc_mcu7t5v0__oai31_1
X_5713_ _8695_/A1 _5715_/A2 _5715_/B1 _5713_/B2 _9555_/D PHY_9/VDD PHY_9/VDD VSUBS
+ VSUBS gf180mcu_fd_sc_mcu7t5v0__oai22_1
X_9481_ _9481_/D _9801_/CLK _9481_/Q PHY_9/VDD PHY_9/VDD VSUBS VSUBS gf180mcu_fd_sc_mcu7t5v0__dffq_1
X_8432_ _9809_/Q _8606_/A2 _8471_/A1 PHY_9/VDD PHY_9/VDD VSUBS VSUBS gf180mcu_fd_sc_mcu7t5v0__nand2_1
X_5644_ _8695_/A1 _5646_/A2 _5646_/B1 _5644_/B2 _9519_/D PHY_9/VDD PHY_9/VDD VSUBS
+ VSUBS gf180mcu_fd_sc_mcu7t5v0__oai22_1
X_8363_ _8647_/A2 _9034_/A2 _8363_/B _9924_/D PHY_9/VDD PHY_9/VDD VSUBS VSUBS gf180mcu_fd_sc_mcu7t5v0__aoi21_1
X_7314_ _7314_/I0 _7314_/I1 _7314_/S _7315_/C PHY_9/VDD PHY_9/VDD VSUBS VSUBS gf180mcu_fd_sc_mcu7t5v0__mux2_1
X_5575_ _9491_/Q _5575_/A2 _5575_/A3 _5576_/C PHY_9/VDD PHY_9/VDD VSUBS VSUBS gf180mcu_fd_sc_mcu7t5v0__nor3_1
X_8294_ _8333_/A2 _8334_/A1 _8294_/Z PHY_9/VDD PHY_9/VDD VSUBS VSUBS gf180mcu_fd_sc_mcu7t5v0__xor2_1
X_7245_ _7245_/A1 _7245_/A2 _7245_/B _7262_/A2 PHY_9/VDD PHY_9/VDD VSUBS VSUBS gf180mcu_fd_sc_mcu7t5v0__oai21_1
X_7176_ _6512_/B _7176_/A2 _7177_/B PHY_9/VDD PHY_9/VDD VSUBS VSUBS gf180mcu_fd_sc_mcu7t5v0__xor2_1
X_6127_ _9780_/Q _6288_/A2 _6288_/B1 _9825_/Q _6128_/A2 PHY_9/VDD PHY_9/VDD VSUBS
+ VSUBS gf180mcu_fd_sc_mcu7t5v0__aoi22_1
X_6058_ _5404_/Z _6059_/A2 _6059_/B1 _6058_/B2 _9768_/D PHY_9/VDD PHY_9/VDD VSUBS
+ VSUBS gf180mcu_fd_sc_mcu7t5v0__oai22_1
X_5009_ _9742_/Q _6026_/B2 PHY_9/VDD PHY_9/VDD VSUBS VSUBS gf180mcu_fd_sc_mcu7t5v0__clkinv_1
X_9817_ _9817_/D _9907_/CLK _9817_/Q PHY_9/VDD PHY_9/VDD VSUBS VSUBS gf180mcu_fd_sc_mcu7t5v0__dffq_1
X_9748_ _9748_/D _9948_/CLK _9748_/Q PHY_9/VDD PHY_9/VDD VSUBS VSUBS gf180mcu_fd_sc_mcu7t5v0__dffq_1
X_9679_ _9679_/D _9689_/CLK _9679_/Q PHY_9/VDD PHY_9/VDD VSUBS VSUBS gf180mcu_fd_sc_mcu7t5v0__dffq_1
X_5360_ _5583_/A1 _5364_/A2 _5360_/B _9415_/D PHY_9/VDD PHY_9/VDD VSUBS VSUBS gf180mcu_fd_sc_mcu7t5v0__aoi21_1
X_5291_ _9462_/Q _5296_/A2 _7695_/B _5292_/B PHY_9/VDD PHY_9/VDD VSUBS VSUBS gf180mcu_fd_sc_mcu7t5v0__oai21_1
X_7030_ _7036_/A1 _9845_/Q _7037_/A3 _7322_/A1 PHY_9/VDD PHY_9/VDD VSUBS VSUBS gf180mcu_fd_sc_mcu7t5v0__nor3_4
X_8981_ _9813_/Q _9017_/A2 _8983_/A2 PHY_9/VDD PHY_9/VDD VSUBS VSUBS gf180mcu_fd_sc_mcu7t5v0__nand2_1
X_7932_ _9910_/Q _7703_/Z _7993_/B1 _9842_/Q _7934_/B1 PHY_9/VDD PHY_9/VDD VSUBS VSUBS
+ gf180mcu_fd_sc_mcu7t5v0__aoi22_2
X_7863_ _7863_/A1 _7823_/Z _7863_/B _7913_/A1 PHY_9/VDD PHY_9/VDD VSUBS VSUBS gf180mcu_fd_sc_mcu7t5v0__aoi21_2
X_9602_ _9602_/D _9940_/CLK _9602_/Q PHY_9/VDD PHY_9/VDD VSUBS VSUBS gf180mcu_fd_sc_mcu7t5v0__dffq_1
X_6814_ _9853_/Q _6771_/Z _6816_/B1 PHY_9/VDD PHY_9/VDD VSUBS VSUBS gf180mcu_fd_sc_mcu7t5v0__nand2_1
X_7794_ _7794_/I _7795_/C PHY_9/VDD PHY_9/VDD VSUBS VSUBS gf180mcu_fd_sc_mcu7t5v0__clkinv_1
X_6745_ _6746_/A1 _6746_/A3 _6778_/A2 PHY_9/VDD PHY_9/VDD VSUBS VSUBS gf180mcu_fd_sc_mcu7t5v0__nand2_1
X_9533_ _9533_/D _9901_/CLK _9533_/Q PHY_9/VDD PHY_9/VDD VSUBS VSUBS gf180mcu_fd_sc_mcu7t5v0__dffq_1
X_9464_ _9464_/D _9972_/CLK _9464_/Q PHY_9/VDD PHY_9/VDD VSUBS VSUBS gf180mcu_fd_sc_mcu7t5v0__dffq_4
X_6676_ _6815_/A1 _9834_/Q _6970_/A2 PHY_9/VDD PHY_9/VDD VSUBS VSUBS gf180mcu_fd_sc_mcu7t5v0__nor2_4
X_8415_ _9090_/C _8401_/Z _8418_/A1 PHY_9/VDD PHY_9/VDD VSUBS VSUBS gf180mcu_fd_sc_mcu7t5v0__nor2_1
X_9395_ _9395_/D _9856_/CLK _9395_/Q PHY_9/VDD PHY_9/VDD VSUBS VSUBS gf180mcu_fd_sc_mcu7t5v0__dffq_1
X_5627_ _9511_/Q _5633_/A2 _5628_/A2 PHY_9/VDD PHY_9/VDD VSUBS VSUBS gf180mcu_fd_sc_mcu7t5v0__nand2_1
X_8346_ _5388_/Z _8353_/A2 _8353_/B1 _8346_/B2 _9912_/D PHY_9/VDD PHY_9/VDD VSUBS
+ VSUBS gf180mcu_fd_sc_mcu7t5v0__oai22_1
X_5558_ _5406_/Z _5558_/A2 _5558_/B1 _5558_/B2 _9488_/D PHY_9/VDD PHY_9/VDD VSUBS
+ VSUBS gf180mcu_fd_sc_mcu7t5v0__oai22_1
X_8277_ _8278_/A1 _8278_/A2 _8315_/B PHY_9/VDD PHY_9/VDD VSUBS VSUBS gf180mcu_fd_sc_mcu7t5v0__nand2_1
X_7228_ _7278_/C _7272_/B _7227_/Z _7233_/A3 PHY_9/VDD PHY_9/VDD VSUBS VSUBS gf180mcu_fd_sc_mcu7t5v0__nand3_1
X_5489_ _9456_/Q _5493_/B _5770_/B _5490_/B PHY_9/VDD PHY_9/VDD VSUBS VSUBS gf180mcu_fd_sc_mcu7t5v0__oai21_1
X_7159_ _7160_/A1 _7160_/A2 _7190_/B PHY_9/VDD PHY_9/VDD VSUBS VSUBS gf180mcu_fd_sc_mcu7t5v0__nand2_1
X_4860_ _9404_/Q _5336_/A1 PHY_9/VDD PHY_9/VDD VSUBS VSUBS gf180mcu_fd_sc_mcu7t5v0__clkinv_1
X_6530_ _6530_/A1 _6530_/A2 _6535_/A1 _6530_/B2 _6538_/A2 PHY_9/VDD PHY_9/VDD VSUBS
+ VSUBS gf180mcu_fd_sc_mcu7t5v0__oai22_2
X_4791_ _9817_/Q _6740_/A1 PHY_9/VDD PHY_9/VDD VSUBS VSUBS gf180mcu_fd_sc_mcu7t5v0__clkinv_2
X_6461_ _9818_/Q _6460_/Z _6480_/A2 PHY_9/VDD PHY_9/VDD VSUBS VSUBS gf180mcu_fd_sc_mcu7t5v0__nor2_1
X_6392_ _9091_/B _6391_/Z _6432_/A1 PHY_9/VDD PHY_9/VDD VSUBS VSUBS gf180mcu_fd_sc_mcu7t5v0__nor2_1
X_9180_ _9808_/Q _9333_/A2 _9183_/A2 PHY_9/VDD PHY_9/VDD VSUBS VSUBS gf180mcu_fd_sc_mcu7t5v0__nand2_1
X_5412_ _9642_/Q _5437_/A2 _5883_/A3 _9673_/Q _5413_/I PHY_9/VDD PHY_9/VDD VSUBS VSUBS
+ gf180mcu_fd_sc_mcu7t5v0__aoi22_1
X_8200_ _6512_/B _8216_/A2 _8204_/C1 PHY_9/VDD PHY_9/VDD VSUBS VSUBS gf180mcu_fd_sc_mcu7t5v0__nand2_1
X_8131_ _9808_/Q _8097_/Z _8132_/I PHY_9/VDD PHY_9/VDD VSUBS VSUBS gf180mcu_fd_sc_mcu7t5v0__nand2_1
X_5343_ _5343_/A1 _5343_/A2 _5353_/A2 PHY_9/VDD PHY_9/VDD VSUBS VSUBS gf180mcu_fd_sc_mcu7t5v0__nor2_4
X_5274_ _5319_/A1 _9471_/Q _5297_/A2 PHY_9/VDD PHY_9/VDD VSUBS VSUBS gf180mcu_fd_sc_mcu7t5v0__nand2_2
X_8062_ _8156_/B _8061_/Z _8062_/B _9356_/C _8064_/A1 PHY_9/VDD PHY_9/VDD VSUBS VSUBS
+ gf180mcu_fd_sc_mcu7t5v0__aoi211_1
X_7013_ _7045_/B2 _9847_/Q _7299_/A2 PHY_9/VDD PHY_9/VDD VSUBS VSUBS gf180mcu_fd_sc_mcu7t5v0__nor2_4
X_8964_ _8965_/A1 _8965_/A2 _8992_/B PHY_9/VDD PHY_9/VDD VSUBS VSUBS gf180mcu_fd_sc_mcu7t5v0__nand2_1
X_8895_ _9503_/Q _8719_/C _8896_/B PHY_9/VDD PHY_9/VDD VSUBS VSUBS gf180mcu_fd_sc_mcu7t5v0__nand2_1
X_7915_ _7992_/A2 _7915_/A2 _7915_/Z PHY_9/VDD PHY_9/VDD VSUBS VSUBS gf180mcu_fd_sc_mcu7t5v0__xor2_1
X_7846_ _9811_/Q _7948_/A2 _7897_/B PHY_9/VDD PHY_9/VDD VSUBS VSUBS gf180mcu_fd_sc_mcu7t5v0__nand2_1
X_4989_ _9860_/Q _7332_/B2 PHY_9/VDD PHY_9/VDD VSUBS VSUBS gf180mcu_fd_sc_mcu7t5v0__clkinv_1
X_7777_ _7776_/B _7772_/Z _7777_/A3 _7814_/A2 PHY_9/VDD PHY_9/VDD VSUBS VSUBS gf180mcu_fd_sc_mcu7t5v0__xnor3_1
X_6728_ _9808_/Q _6806_/A2 _6808_/C _6728_/C _6729_/C PHY_9/VDD PHY_9/VDD VSUBS VSUBS
+ gf180mcu_fd_sc_mcu7t5v0__aoi211_1
X_9516_ _9516_/D _9801_/CLK _9516_/Q PHY_9/VDD PHY_9/VDD VSUBS VSUBS gf180mcu_fd_sc_mcu7t5v0__dffq_1
X_6659_ _8691_/A1 _6665_/A2 _6665_/B1 _6659_/B2 _9824_/D PHY_9/VDD PHY_9/VDD VSUBS
+ VSUBS gf180mcu_fd_sc_mcu7t5v0__oai22_1
X_9447_ _9447_/D _9800_/CLK _9447_/Q PHY_9/VDD PHY_9/VDD VSUBS VSUBS gf180mcu_fd_sc_mcu7t5v0__dffq_1
X_9378_ _9378_/D _9974_/CLK _9378_/Q PHY_9/VDD PHY_9/VDD VSUBS VSUBS gf180mcu_fd_sc_mcu7t5v0__dffq_1
X_8329_ _9911_/Q _8328_/Z _8329_/Z PHY_9/VDD PHY_9/VDD VSUBS VSUBS gf180mcu_fd_sc_mcu7t5v0__xor2_1
X_5961_ _9684_/Q _5973_/A2 _5961_/B _5962_/B PHY_9/VDD PHY_9/VDD VSUBS VSUBS gf180mcu_fd_sc_mcu7t5v0__oai21_1
X_4912_ _9747_/Q _6033_/B2 PHY_9/VDD PHY_9/VDD VSUBS VSUBS gf180mcu_fd_sc_mcu7t5v0__clkinv_1
X_8680_ _5388_/Z _8687_/A2 _8687_/B1 _8680_/B2 _9933_/D PHY_9/VDD PHY_9/VDD VSUBS
+ VSUBS gf180mcu_fd_sc_mcu7t5v0__oai22_1
X_7700_ _9890_/Q _9889_/Q _7738_/C PHY_9/VDD PHY_9/VDD VSUBS VSUBS gf180mcu_fd_sc_mcu7t5v0__nor2_4
X_7631_ _7574_/Z _7631_/A2 _7630_/B _7632_/A2 PHY_9/VDD PHY_9/VDD VSUBS VSUBS gf180mcu_fd_sc_mcu7t5v0__nor3_1
X_5892_ _5166_/Z _5907_/A1 _5892_/A3 _9656_/D PHY_9/VDD PHY_9/VDD VSUBS VSUBS gf180mcu_fd_sc_mcu7t5v0__nor3_1
X_4843_ _9464_/Q _5853_/A1 PHY_9/VDD PHY_9/VDD VSUBS VSUBS gf180mcu_fd_sc_mcu7t5v0__clkinv_3
X_7562_ _7562_/A1 _7560_/Z _7564_/A2 PHY_9/VDD PHY_9/VDD VSUBS VSUBS gf180mcu_fd_sc_mcu7t5v0__xnor2_1
X_4774_ _9839_/Q _7109_/A1 PHY_9/VDD PHY_9/VDD VSUBS VSUBS gf180mcu_fd_sc_mcu7t5v0__inv_1
X_6513_ _9811_/Q _6577_/A2 _6614_/B _6514_/A3 PHY_9/VDD PHY_9/VDD VSUBS VSUBS gf180mcu_fd_sc_mcu7t5v0__aoi21_1
X_7493_ _9810_/Q _7382_/Z _7493_/B _7538_/A2 PHY_9/VDD PHY_9/VDD VSUBS VSUBS gf180mcu_fd_sc_mcu7t5v0__aoi21_1
X_9301_ _9301_/A1 _9299_/Z _9301_/Z PHY_9/VDD PHY_9/VDD VSUBS VSUBS gf180mcu_fd_sc_mcu7t5v0__xor2_1
X_6444_ _9839_/Q _6350_/Z _6471_/A1 PHY_9/VDD PHY_9/VDD VSUBS VSUBS gf180mcu_fd_sc_mcu7t5v0__nand2_2
X_9232_ _9232_/A1 _9232_/A2 _9276_/A1 PHY_9/VDD PHY_9/VDD VSUBS VSUBS gf180mcu_fd_sc_mcu7t5v0__xnor2_1
Xclkbuf_leaf_9_clk clkbuf_leaf_9_clk/I _9957_/CLK PHY_9/VDD PHY_9/VDD VSUBS VSUBS
+ gf180mcu_fd_sc_mcu7t5v0__clkbuf_16
X_6375_ _6648_/A1 _6375_/A2 _6561_/B PHY_9/VDD PHY_9/VDD VSUBS VSUBS gf180mcu_fd_sc_mcu7t5v0__nor2_4
X_9163_ _6471_/B _9333_/A2 _9160_/Z _9164_/B PHY_9/VDD PHY_9/VDD VSUBS VSUBS gf180mcu_fd_sc_mcu7t5v0__xor3_1
X_5326_ _9400_/Q _5331_/A2 _5327_/B PHY_9/VDD PHY_9/VDD VSUBS VSUBS gf180mcu_fd_sc_mcu7t5v0__nor2_1
X_8114_ _8145_/A1 _8113_/Z _8114_/Z PHY_9/VDD PHY_9/VDD VSUBS VSUBS gf180mcu_fd_sc_mcu7t5v0__xor2_1
X_9094_ _9808_/Q _9348_/A2 _9093_/Z _9344_/A1 _9170_/C _9095_/C PHY_9/VDD PHY_9/VDD
+ VSUBS VSUBS gf180mcu_fd_sc_mcu7t5v0__aoi221_1
X_5257_ _9463_/Q _5260_/A2 _8706_/B _5258_/B PHY_9/VDD PHY_9/VDD VSUBS VSUBS gf180mcu_fd_sc_mcu7t5v0__oai21_1
X_8045_ _9900_/Q _8058_/A3 _8057_/A2 PHY_9/VDD PHY_9/VDD VSUBS VSUBS gf180mcu_fd_sc_mcu7t5v0__nand2_2
X_5188_ _5826_/B _5871_/A2 _5973_/C _9525_/D PHY_9/VDD PHY_9/VDD VSUBS VSUBS gf180mcu_fd_sc_mcu7t5v0__aoi21_1
X_8947_ _8948_/A1 _8948_/A2 _9011_/A1 PHY_9/VDD PHY_9/VDD VSUBS VSUBS gf180mcu_fd_sc_mcu7t5v0__nor2_1
X_8878_ _9811_/Q _8877_/Z _8878_/Z PHY_9/VDD PHY_9/VDD VSUBS VSUBS gf180mcu_fd_sc_mcu7t5v0__and2_1
X_7829_ _9810_/Q _8009_/A2 _7830_/C PHY_9/VDD PHY_9/VDD VSUBS VSUBS gf180mcu_fd_sc_mcu7t5v0__nand2_1
Xrepeater5 _9031_/B _5474_/B PHY_9/VDD PHY_9/VDD VSUBS VSUBS gf180mcu_fd_sc_mcu7t5v0__buf_8
X_6160_ _6160_/A1 _6160_/A2 _6175_/A2 PHY_9/VDD PHY_9/VDD VSUBS VSUBS gf180mcu_fd_sc_mcu7t5v0__nand2_1
X_5111_ _9614_/Q _5794_/B2 PHY_9/VDD PHY_9/VDD VSUBS VSUBS gf180mcu_fd_sc_mcu7t5v0__clkinv_1
X_6091_ _9795_/Q _6287_/A2 _6287_/B1 _9559_/Q _6093_/A1 PHY_9/VDD PHY_9/VDD VSUBS
+ VSUBS gf180mcu_fd_sc_mcu7t5v0__aoi22_1
X_5042_ _9719_/Q _6016_/B2 PHY_9/VDD PHY_9/VDD VSUBS VSUBS gf180mcu_fd_sc_mcu7t5v0__clkinv_1
X_9850_ _9850_/D _9856_/CLK _9850_/Q PHY_9/VDD PHY_9/VDD VSUBS VSUBS gf180mcu_fd_sc_mcu7t5v0__dffq_2
X_8801_ _8757_/Z _8759_/Z _8801_/B _8837_/A2 PHY_9/VDD PHY_9/VDD VSUBS VSUBS gf180mcu_fd_sc_mcu7t5v0__oai21_1
X_6993_ _6990_/Z _6993_/A2 _6995_/A2 PHY_9/VDD PHY_9/VDD VSUBS VSUBS gf180mcu_fd_sc_mcu7t5v0__xnor2_1
X_9781_ _9781_/D _9830_/CLK _9781_/Q PHY_9/VDD PHY_9/VDD VSUBS VSUBS gf180mcu_fd_sc_mcu7t5v0__dffq_1
X_8732_ _8885_/A1 _9022_/B _8983_/A1 _9024_/B2 PHY_9/VDD PHY_9/VDD VSUBS VSUBS gf180mcu_fd_sc_mcu7t5v0__nand3_2
X_5944_ _9683_/Q _5951_/A2 _5961_/B _5945_/B PHY_9/VDD PHY_9/VDD VSUBS VSUBS gf180mcu_fd_sc_mcu7t5v0__oai21_1
X_5875_ _9649_/Q _5871_/Z _5875_/B _5961_/B _5876_/B PHY_9/VDD PHY_9/VDD VSUBS VSUBS
+ gf180mcu_fd_sc_mcu7t5v0__oai211_1
X_8663_ _8491_/C _8662_/Z _8677_/B1 PHY_9/VDD PHY_9/VDD VSUBS VSUBS gf180mcu_fd_sc_mcu7t5v0__nand2_1
X_8594_ _9807_/Q _8669_/A2 _8597_/A1 PHY_9/VDD PHY_9/VDD VSUBS VSUBS gf180mcu_fd_sc_mcu7t5v0__nand2_1
X_4826_ _9504_/Q _9271_/A1 PHY_9/VDD PHY_9/VDD VSUBS VSUBS gf180mcu_fd_sc_mcu7t5v0__inv_2
X_7614_ _7614_/A1 _7612_/Z _7615_/I PHY_9/VDD PHY_9/VDD VSUBS VSUBS gf180mcu_fd_sc_mcu7t5v0__xnor2_1
X_7545_ _9810_/Q _7657_/A2 _7551_/A2 PHY_9/VDD PHY_9/VDD VSUBS VSUBS gf180mcu_fd_sc_mcu7t5v0__nand2_1
X_4757_ _9387_/Q _5296_/A1 PHY_9/VDD PHY_9/VDD VSUBS VSUBS gf180mcu_fd_sc_mcu7t5v0__clkinv_1
X_7476_ _9810_/Q _7474_/Z _7476_/Z PHY_9/VDD PHY_9/VDD VSUBS VSUBS gf180mcu_fd_sc_mcu7t5v0__xor2_1
X_4688_ _9360_/Q _5232_/A1 PHY_9/VDD PHY_9/VDD VSUBS VSUBS gf180mcu_fd_sc_mcu7t5v0__clkinv_1
X_6427_ _6624_/A2 _6584_/B1 _6646_/B _6428_/A2 PHY_9/VDD PHY_9/VDD VSUBS VSUBS gf180mcu_fd_sc_mcu7t5v0__oai21_1
X_9215_ _9811_/Q _9178_/Z _9216_/B1 PHY_9/VDD PHY_9/VDD VSUBS VSUBS gf180mcu_fd_sc_mcu7t5v0__nand2_1
X_6358_ _9804_/Q _6389_/A2 _6367_/A2 PHY_9/VDD PHY_9/VDD VSUBS VSUBS gf180mcu_fd_sc_mcu7t5v0__nand2_1
X_9146_ _9810_/Q _9809_/Q _9331_/A2 _9285_/A2 _9146_/Z PHY_9/VDD PHY_9/VDD VSUBS VSUBS
+ gf180mcu_fd_sc_mcu7t5v0__and4_1
X_5309_ _9460_/Q _5318_/A2 _8027_/B _5310_/B PHY_9/VDD PHY_9/VDD VSUBS VSUBS gf180mcu_fd_sc_mcu7t5v0__oai21_1
X_6289_ _6289_/A1 _6289_/A2 _6291_/B1 PHY_9/VDD PHY_9/VDD VSUBS VSUBS gf180mcu_fd_sc_mcu7t5v0__nand2_1
X_9077_ _9962_/Q _9077_/A2 _9251_/B PHY_9/VDD PHY_9/VDD VSUBS VSUBS gf180mcu_fd_sc_mcu7t5v0__nand2_2
X_8028_ _8318_/A1 _9036_/A2 _8028_/B _9903_/D PHY_9/VDD PHY_9/VDD VSUBS VSUBS gf180mcu_fd_sc_mcu7t5v0__aoi21_1
X_5660_ _9534_/Q _5659_/I _9534_/D PHY_9/VDD PHY_9/VDD VSUBS VSUBS gf180mcu_fd_sc_mcu7t5v0__nor2_1
X_5591_ _9412_/Q _5591_/A2 _5592_/C PHY_9/VDD PHY_9/VDD VSUBS VSUBS gf180mcu_fd_sc_mcu7t5v0__and2_1
X_7330_ _8691_/A1 _7336_/A2 _7336_/B1 _7330_/B2 _9858_/D PHY_9/VDD PHY_9/VDD VSUBS
+ VSUBS gf180mcu_fd_sc_mcu7t5v0__oai22_1
X_7261_ _7262_/A2 _7259_/Z _7289_/A2 PHY_9/VDD PHY_9/VDD VSUBS VSUBS gf180mcu_fd_sc_mcu7t5v0__nor2_1
X_6212_ _6212_/A1 _6212_/A2 _6276_/B _6233_/C PHY_9/VDD PHY_9/VDD VSUBS VSUBS gf180mcu_fd_sc_mcu7t5v0__aoi21_1
X_9000_ _9000_/A1 _9000_/A2 _9000_/Z PHY_9/VDD PHY_9/VDD VSUBS VSUBS gf180mcu_fd_sc_mcu7t5v0__xor2_1
X_7192_ _9848_/Q _9847_/Q _7299_/B1 PHY_9/VDD PHY_9/VDD VSUBS VSUBS gf180mcu_fd_sc_mcu7t5v0__nor2_2
X_6143_ _6143_/A1 _6143_/A2 _6144_/B1 PHY_9/VDD PHY_9/VDD VSUBS VSUBS gf180mcu_fd_sc_mcu7t5v0__nand2_1
X_6074_ _9526_/Q _6288_/A2 _6288_/B1 _9714_/Q _6075_/A2 PHY_9/VDD PHY_9/VDD VSUBS
+ VSUBS gf180mcu_fd_sc_mcu7t5v0__aoi22_1
X_9902_ _9902_/D _9974_/CLK _9902_/Q PHY_9/VDD PHY_9/VDD VSUBS VSUBS gf180mcu_fd_sc_mcu7t5v0__dffq_4
X_5025_ _9562_/Q _5724_/B2 PHY_9/VDD PHY_9/VDD VSUBS VSUBS gf180mcu_fd_sc_mcu7t5v0__clkinv_1
X_9833_ _9833_/D _9856_/CLK _9833_/Q PHY_9/VDD PHY_9/VDD VSUBS VSUBS gf180mcu_fd_sc_mcu7t5v0__dffq_2
X_9764_ _9764_/D _9948_/CLK _9764_/Q PHY_9/VDD PHY_9/VDD VSUBS VSUBS gf180mcu_fd_sc_mcu7t5v0__dffq_1
X_6976_ _6968_/Z _6975_/Z _6976_/Z PHY_9/VDD PHY_9/VDD VSUBS VSUBS gf180mcu_fd_sc_mcu7t5v0__xor2_1
X_5927_ _5925_/Z _5927_/A2 _9667_/D PHY_9/VDD PHY_9/VDD VSUBS VSUBS gf180mcu_fd_sc_mcu7t5v0__nor2_1
X_8715_ _8994_/A1 _9952_/Q _8715_/A3 _8857_/A1 PHY_9/VDD PHY_9/VDD VSUBS VSUBS gf180mcu_fd_sc_mcu7t5v0__nor3_4
X_9695_ _9695_/D _9939_/CLK _9695_/Q PHY_9/VDD PHY_9/VDD VSUBS VSUBS gf180mcu_fd_sc_mcu7t5v0__dffq_1
X_5858_ _9645_/Q _5832_/Z _9031_/B _5861_/A1 PHY_9/VDD PHY_9/VDD VSUBS VSUBS gf180mcu_fd_sc_mcu7t5v0__oai21_1
X_8646_ _9877_/Q _8646_/A2 _8646_/B1 _9505_/Q _8647_/B PHY_9/VDD PHY_9/VDD VSUBS VSUBS
+ gf180mcu_fd_sc_mcu7t5v0__aoi22_2
X_5789_ _8692_/A1 _5794_/A2 _5794_/B1 _5789_/B2 _9609_/D PHY_9/VDD PHY_9/VDD VSUBS
+ VSUBS gf180mcu_fd_sc_mcu7t5v0__oai22_1
X_4809_ _9652_/Q _5172_/A1 PHY_9/VDD PHY_9/VDD VSUBS VSUBS gf180mcu_fd_sc_mcu7t5v0__clkinv_1
X_8577_ _8577_/A1 _8577_/A2 _8626_/B PHY_9/VDD PHY_9/VDD VSUBS VSUBS gf180mcu_fd_sc_mcu7t5v0__nand2_1
X_7528_ _9811_/Q _7668_/A2 _7529_/A2 _7667_/I1 _7668_/B _7529_/B PHY_9/VDD PHY_9/VDD
+ VSUBS VSUBS gf180mcu_fd_sc_mcu7t5v0__aoi221_1
X_7459_ _9808_/Q _7654_/A2 _7548_/A1 PHY_9/VDD PHY_9/VDD VSUBS VSUBS gf180mcu_fd_sc_mcu7t5v0__nand2_1
X_9129_ _9969_/Q _9356_/C _9131_/A1 PHY_9/VDD PHY_9/VDD VSUBS VSUBS gf180mcu_fd_sc_mcu7t5v0__nand2_1
X_6830_ _6831_/A2 _6828_/Z _6863_/A2 PHY_9/VDD PHY_9/VDD VSUBS VSUBS gf180mcu_fd_sc_mcu7t5v0__nand2_1
X_6761_ _9809_/Q _6974_/A2 _6828_/A1 PHY_9/VDD PHY_9/VDD VSUBS VSUBS gf180mcu_fd_sc_mcu7t5v0__nand2_1
X_5712_ _5399_/Z _5715_/A2 _5715_/B1 _5712_/B2 _9554_/D PHY_9/VDD PHY_9/VDD VSUBS
+ VSUBS gf180mcu_fd_sc_mcu7t5v0__oai22_1
X_8500_ _9808_/Q _8645_/A2 _8503_/A2 PHY_9/VDD PHY_9/VDD VSUBS VSUBS gf180mcu_fd_sc_mcu7t5v0__nand2_1
X_6692_ _6724_/A2 _6997_/B2 _6999_/A1 _6693_/B PHY_9/VDD PHY_9/VDD VSUBS VSUBS gf180mcu_fd_sc_mcu7t5v0__nand3_1
X_9480_ _9480_/D _9689_/CLK _9480_/Q PHY_9/VDD PHY_9/VDD VSUBS VSUBS gf180mcu_fd_sc_mcu7t5v0__dffq_2
X_8431_ _9807_/Q _8653_/A2 _8436_/B PHY_9/VDD PHY_9/VDD VSUBS VSUBS gf180mcu_fd_sc_mcu7t5v0__nand2_1
X_5643_ _5399_/Z _5646_/A2 _5646_/B1 _5643_/B2 _9518_/D PHY_9/VDD PHY_9/VDD VSUBS
+ VSUBS gf180mcu_fd_sc_mcu7t5v0__oai22_1
X_8362_ _9372_/Q _9034_/A2 _8706_/B _8363_/B PHY_9/VDD PHY_9/VDD VSUBS VSUBS gf180mcu_fd_sc_mcu7t5v0__oai21_1
X_5574_ _5567_/Z _5592_/B1 _5594_/A1 PHY_9/VDD PHY_9/VDD VSUBS VSUBS gf180mcu_fd_sc_mcu7t5v0__nand2_4
X_7313_ _9814_/Q _7316_/A2 _7314_/S PHY_9/VDD PHY_9/VDD VSUBS VSUBS gf180mcu_fd_sc_mcu7t5v0__nand2_1
X_8293_ _8293_/A1 _8316_/A2 _8293_/B _8334_/A1 PHY_9/VDD PHY_9/VDD VSUBS VSUBS gf180mcu_fd_sc_mcu7t5v0__oai21_1
X_7244_ _7244_/A1 _7244_/A2 _7289_/A1 PHY_9/VDD PHY_9/VDD VSUBS VSUBS gf180mcu_fd_sc_mcu7t5v0__xnor2_1
X_7175_ _9811_/Q _7176_/A2 _7175_/Z PHY_9/VDD PHY_9/VDD VSUBS VSUBS gf180mcu_fd_sc_mcu7t5v0__and2_1
X_6126_ _9796_/Q _6287_/A2 _6287_/B1 _9560_/Q _6128_/A1 PHY_9/VDD PHY_9/VDD VSUBS
+ VSUBS gf180mcu_fd_sc_mcu7t5v0__aoi22_1
X_6057_ _8695_/A1 _6059_/A2 _6059_/B1 _6057_/B2 _9767_/D PHY_9/VDD PHY_9/VDD VSUBS
+ VSUBS gf180mcu_fd_sc_mcu7t5v0__oai22_1
X_5008_ _9750_/Q _6036_/B2 PHY_9/VDD PHY_9/VDD VSUBS VSUBS gf180mcu_fd_sc_mcu7t5v0__clkinv_1
X_9816_ _9816_/D _9856_/CLK _9816_/Q PHY_9/VDD PHY_9/VDD VSUBS VSUBS gf180mcu_fd_sc_mcu7t5v0__dffq_1
X_9747_ _9747_/D _9939_/CLK _9747_/Q PHY_9/VDD PHY_9/VDD VSUBS VSUBS gf180mcu_fd_sc_mcu7t5v0__dffq_1
X_6959_ _6808_/C _6945_/Z _9356_/C _6960_/B2 PHY_9/VDD PHY_9/VDD VSUBS VSUBS gf180mcu_fd_sc_mcu7t5v0__aoi21_1
X_9678_ _9678_/D _9972_/CLK _9678_/Q PHY_9/VDD PHY_9/VDD VSUBS VSUBS gf180mcu_fd_sc_mcu7t5v0__dffq_1
X_8629_ _6613_/B _8627_/Z _8629_/Z PHY_9/VDD PHY_9/VDD VSUBS VSUBS gf180mcu_fd_sc_mcu7t5v0__xor2_1
X_5290_ _5290_/A1 _5296_/A2 _5290_/B _9384_/D PHY_9/VDD PHY_9/VDD VSUBS VSUBS gf180mcu_fd_sc_mcu7t5v0__aoi21_1
X_8980_ _8980_/A1 _8978_/Z _8980_/B _8985_/A2 PHY_9/VDD PHY_9/VDD VSUBS VSUBS gf180mcu_fd_sc_mcu7t5v0__oai21_1
X_7931_ _7838_/Z _7905_/Z _7931_/B _7959_/A1 PHY_9/VDD PHY_9/VDD VSUBS VSUBS gf180mcu_fd_sc_mcu7t5v0__oai21_1
X_9601_ _9601_/D _9940_/CLK _9601_/Q PHY_9/VDD PHY_9/VDD VSUBS VSUBS gf180mcu_fd_sc_mcu7t5v0__dffq_1
X_7862_ _9895_/Q _7881_/A1 _7859_/Z _7862_/Z PHY_9/VDD PHY_9/VDD VSUBS VSUBS gf180mcu_fd_sc_mcu7t5v0__xor3_1
X_6813_ _6820_/A2 _6813_/A2 _6813_/B _6835_/A1 PHY_9/VDD PHY_9/VDD VSUBS VSUBS gf180mcu_fd_sc_mcu7t5v0__aoi21_1
X_7793_ _9809_/Q _8009_/A2 _7790_/Z _8008_/I0 _7831_/C _7794_/I PHY_9/VDD PHY_9/VDD
+ VSUBS VSUBS gf180mcu_fd_sc_mcu7t5v0__aoi221_1
X_6744_ _6746_/A1 _6746_/A3 _6778_/B PHY_9/VDD PHY_9/VDD VSUBS VSUBS gf180mcu_fd_sc_mcu7t5v0__nor2_1
X_9532_ _9532_/D _9830_/CLK _9532_/Q PHY_9/VDD PHY_9/VDD VSUBS VSUBS gf180mcu_fd_sc_mcu7t5v0__dffq_1
X_6675_ _6815_/A1 _9036_/A2 _6675_/B _9835_/D PHY_9/VDD PHY_9/VDD VSUBS VSUBS gf180mcu_fd_sc_mcu7t5v0__aoi21_1
X_9463_ _9463_/D _9972_/CLK _9463_/Q PHY_9/VDD PHY_9/VDD VSUBS VSUBS gf180mcu_fd_sc_mcu7t5v0__dffq_4
X_8414_ _8673_/I1 _8417_/A3 _8414_/B _8674_/B _8420_/B2 PHY_9/VDD PHY_9/VDD VSUBS
+ VSUBS gf180mcu_fd_sc_mcu7t5v0__aoi211_1
X_5626_ _9775_/Q _5561_/I _5628_/A1 PHY_9/VDD PHY_9/VDD VSUBS VSUBS gf180mcu_fd_sc_mcu7t5v0__nand2_1
X_9394_ _9394_/D _9856_/CLK _9394_/Q PHY_9/VDD PHY_9/VDD VSUBS VSUBS gf180mcu_fd_sc_mcu7t5v0__dffq_1
X_8345_ _6089_/B _8353_/A2 _8353_/B1 PHY_9/VDD PHY_9/VDD VSUBS VSUBS gf180mcu_fd_sc_mcu7t5v0__nand2_2
X_5557_ _5404_/Z _5558_/A2 _5558_/B1 _5557_/B2 _9487_/D PHY_9/VDD PHY_9/VDD VSUBS
+ VSUBS gf180mcu_fd_sc_mcu7t5v0__oai22_1
X_8276_ _8276_/A1 _8313_/A1 _8276_/A3 _8278_/A2 PHY_9/VDD PHY_9/VDD VSUBS VSUBS gf180mcu_fd_sc_mcu7t5v0__xnor3_1
X_5488_ _5488_/A1 _5493_/B _5488_/B _9455_/D PHY_9/VDD PHY_9/VDD VSUBS VSUBS gf180mcu_fd_sc_mcu7t5v0__aoi21_1
X_7227_ _7175_/Z _7227_/A2 _7226_/B _7227_/Z PHY_9/VDD PHY_9/VDD VSUBS VSUBS gf180mcu_fd_sc_mcu7t5v0__or3_1
X_7158_ _7158_/A1 _7158_/A2 _7158_/A3 _7160_/A2 PHY_9/VDD PHY_9/VDD VSUBS VSUBS gf180mcu_fd_sc_mcu7t5v0__xnor3_1
X_7089_ _7019_/I _7254_/A2 _7089_/B _7092_/A3 PHY_9/VDD PHY_9/VDD VSUBS VSUBS gf180mcu_fd_sc_mcu7t5v0__oai21_1
X_6109_ _9608_/Q _6287_/A2 _6287_/B1 _9624_/Q _6111_/A1 PHY_9/VDD PHY_9/VDD VSUBS
+ VSUBS gf180mcu_fd_sc_mcu7t5v0__aoi22_1
X_4790_ _9818_/Q _7453_/A2 PHY_9/VDD PHY_9/VDD VSUBS VSUBS gf180mcu_fd_sc_mcu7t5v0__clkinv_1
X_6460_ _6499_/A1 _6499_/A2 _6460_/Z PHY_9/VDD PHY_9/VDD VSUBS VSUBS gf180mcu_fd_sc_mcu7t5v0__xor2_1
X_6391_ _6583_/A4 _6393_/A3 _6391_/Z PHY_9/VDD PHY_9/VDD VSUBS VSUBS gf180mcu_fd_sc_mcu7t5v0__xor2_1
X_5411_ _9731_/Q _5480_/A1 _5411_/B _9427_/D PHY_9/VDD PHY_9/VDD VSUBS VSUBS gf180mcu_fd_sc_mcu7t5v0__aoi21_1
X_8130_ _8130_/A1 _8136_/A1 _8130_/B1 _8098_/Z _8139_/A2 PHY_9/VDD PHY_9/VDD VSUBS
+ VSUBS gf180mcu_fd_sc_mcu7t5v0__aoi22_2
X_5342_ _5342_/A1 _5342_/A2 _5342_/B _9407_/D PHY_9/VDD PHY_9/VDD VSUBS VSUBS gf180mcu_fd_sc_mcu7t5v0__aoi21_1
X_8061_ _9904_/Q _8086_/A1 _8061_/Z PHY_9/VDD PHY_9/VDD VSUBS VSUBS gf180mcu_fd_sc_mcu7t5v0__xor2_1
X_7012_ _7045_/B2 _9036_/A2 _7012_/B _9848_/D PHY_9/VDD PHY_9/VDD VSUBS VSUBS gf180mcu_fd_sc_mcu7t5v0__aoi21_1
X_5273_ _9472_/Q _5369_/A1 _5308_/A2 PHY_9/VDD PHY_9/VDD VSUBS VSUBS gf180mcu_fd_sc_mcu7t5v0__nor2_4
X_8963_ _9002_/A1 _8963_/A2 _8960_/Z _8965_/A2 PHY_9/VDD PHY_9/VDD VSUBS VSUBS gf180mcu_fd_sc_mcu7t5v0__xnor3_1
X_8894_ _8994_/B _9930_/Q _9896_/Q _8993_/B1 _8717_/Z _9972_/Q _8896_/A2 PHY_9/VDD
+ PHY_9/VDD VSUBS VSUBS gf180mcu_fd_sc_mcu7t5v0__aoi222_4
X_7914_ _7966_/B _7836_/Z _7914_/B _7915_/A2 PHY_9/VDD PHY_9/VDD VSUBS VSUBS gf180mcu_fd_sc_mcu7t5v0__aoi21_1
X_7845_ _6512_/B _7988_/A2 _7845_/B _7848_/A2 PHY_9/VDD PHY_9/VDD VSUBS VSUBS gf180mcu_fd_sc_mcu7t5v0__oai21_1
X_4988_ _9881_/Q _7682_/B2 PHY_9/VDD PHY_9/VDD VSUBS VSUBS gf180mcu_fd_sc_mcu7t5v0__clkinv_1
X_7776_ _9227_/A1 _7988_/A2 _7776_/B _7802_/B1 PHY_9/VDD PHY_9/VDD VSUBS VSUBS gf180mcu_fd_sc_mcu7t5v0__oai21_1
X_9515_ _9515_/D _9830_/CLK _9515_/Q PHY_9/VDD PHY_9/VDD VSUBS VSUBS gf180mcu_fd_sc_mcu7t5v0__dffq_1
X_6727_ _6999_/A1 _6732_/A3 _6728_/C PHY_9/VDD PHY_9/VDD VSUBS VSUBS gf180mcu_fd_sc_mcu7t5v0__nor2_1
X_6658_ _5388_/Z _6665_/A2 _6665_/B1 _6658_/B2 _9823_/D PHY_9/VDD PHY_9/VDD VSUBS
+ VSUBS gf180mcu_fd_sc_mcu7t5v0__oai22_1
X_9446_ _9446_/D _9800_/CLK _9446_/Q PHY_9/VDD PHY_9/VDD VSUBS VSUBS gf180mcu_fd_sc_mcu7t5v0__dffq_1
X_5609_ _9777_/Q _9036_/A2 _8706_/B _5610_/B PHY_9/VDD PHY_9/VDD VSUBS VSUBS gf180mcu_fd_sc_mcu7t5v0__oai21_1
X_9377_ _9377_/D _9901_/CLK _9377_/Q PHY_9/VDD PHY_9/VDD VSUBS VSUBS gf180mcu_fd_sc_mcu7t5v0__dffq_1
X_6589_ _6579_/Z _6588_/Z _6589_/Z PHY_9/VDD PHY_9/VDD VSUBS VSUBS gf180mcu_fd_sc_mcu7t5v0__or2_1
X_8328_ _8328_/A1 _8328_/A2 _8328_/Z PHY_9/VDD PHY_9/VDD VSUBS VSUBS gf180mcu_fd_sc_mcu7t5v0__xor2_1
X_8259_ _9301_/A1 _8319_/A2 _8259_/B1 _8259_/B2 _8333_/A2 PHY_9/VDD PHY_9/VDD VSUBS
+ VSUBS gf180mcu_fd_sc_mcu7t5v0__aoi22_4
X_5960_ _5960_/A1 _5973_/A2 _5960_/B _9682_/D PHY_9/VDD PHY_9/VDD VSUBS VSUBS gf180mcu_fd_sc_mcu7t5v0__aoi21_1
X_4911_ _9755_/Q _6043_/B2 PHY_9/VDD PHY_9/VDD VSUBS VSUBS gf180mcu_fd_sc_mcu7t5v0__clkinv_1
X_5891_ _9656_/Q _9655_/Q _5892_/A3 PHY_9/VDD PHY_9/VDD VSUBS VSUBS gf180mcu_fd_sc_mcu7t5v0__nor2_1
X_7630_ _7574_/Z _7631_/A2 _7630_/B _7669_/A2 PHY_9/VDD PHY_9/VDD VSUBS VSUBS gf180mcu_fd_sc_mcu7t5v0__oai21_1
X_4842_ _9465_/Q _5517_/A1 PHY_9/VDD PHY_9/VDD VSUBS VSUBS gf180mcu_fd_sc_mcu7t5v0__clkinv_1
X_7561_ _7561_/A1 _7505_/Z _7560_/Z _7620_/A1 PHY_9/VDD PHY_9/VDD VSUBS VSUBS gf180mcu_fd_sc_mcu7t5v0__nor3_2
X_4773_ _9840_/Q _7147_/A1 PHY_9/VDD PHY_9/VDD VSUBS VSUBS gf180mcu_fd_sc_mcu7t5v0__clkinv_2
X_6512_ _6649_/B _6512_/A2 _6512_/B _6514_/A2 PHY_9/VDD PHY_9/VDD VSUBS VSUBS gf180mcu_fd_sc_mcu7t5v0__aoi21_1
X_7492_ _9810_/Q _7382_/Z _7493_/B _7538_/B PHY_9/VDD PHY_9/VDD VSUBS VSUBS gf180mcu_fd_sc_mcu7t5v0__nand3_1
X_9300_ _9973_/Q _9299_/Z _9319_/B PHY_9/VDD PHY_9/VDD VSUBS VSUBS gf180mcu_fd_sc_mcu7t5v0__nand2_1
X_6443_ _6443_/A1 _6443_/A2 _6443_/B _6480_/A1 PHY_9/VDD PHY_9/VDD VSUBS VSUBS gf180mcu_fd_sc_mcu7t5v0__aoi21_1
X_9231_ _9807_/Q _9322_/A2 _9232_/A2 _9273_/B PHY_9/VDD PHY_9/VDD VSUBS VSUBS gf180mcu_fd_sc_mcu7t5v0__nand3_1
X_6374_ _6374_/A1 _6374_/A2 _6377_/B PHY_9/VDD PHY_9/VDD VSUBS VSUBS gf180mcu_fd_sc_mcu7t5v0__nand2_1
X_9162_ _9810_/Q _9161_/Z _9209_/A1 PHY_9/VDD PHY_9/VDD VSUBS VSUBS gf180mcu_fd_sc_mcu7t5v0__nand2_1
X_5325_ _5390_/A1 _5331_/A2 _5325_/B _5973_/C _9399_/D PHY_9/VDD PHY_9/VDD VSUBS VSUBS
+ gf180mcu_fd_sc_mcu7t5v0__aoi211_1
X_8113_ _9227_/A1 _8113_/A2 _8113_/Z PHY_9/VDD PHY_9/VDD VSUBS VSUBS gf180mcu_fd_sc_mcu7t5v0__xor2_1
X_9093_ _9093_/A1 _9107_/A3 _9093_/Z PHY_9/VDD PHY_9/VDD VSUBS VSUBS gf180mcu_fd_sc_mcu7t5v0__xor2_1
X_5256_ _5256_/A1 _5260_/A2 _5256_/B _9370_/D PHY_9/VDD PHY_9/VDD VSUBS VSUBS gf180mcu_fd_sc_mcu7t5v0__aoi21_1
X_8044_ _9899_/Q _8339_/B _8300_/B1 PHY_9/VDD PHY_9/VDD VSUBS VSUBS gf180mcu_fd_sc_mcu7t5v0__nor2_2
X_5187_ _5867_/A2 _5831_/A2 _5872_/A2 PHY_9/VDD PHY_9/VDD VSUBS VSUBS gf180mcu_fd_sc_mcu7t5v0__nor2_1
X_8946_ _8946_/A1 _8946_/A2 _8946_/B _8948_/A2 PHY_9/VDD PHY_9/VDD VSUBS VSUBS gf180mcu_fd_sc_mcu7t5v0__aoi21_1
X_8877_ _8850_/Z _8877_/A2 _8877_/Z PHY_9/VDD PHY_9/VDD VSUBS VSUBS gf180mcu_fd_sc_mcu7t5v0__xor2_1
X_7828_ _8008_/I1 _7944_/A1 _8009_/C _7830_/B1 PHY_9/VDD PHY_9/VDD VSUBS VSUBS gf180mcu_fd_sc_mcu7t5v0__aoi21_1
X_7759_ _7977_/A1 _7764_/A2 _7761_/C PHY_9/VDD PHY_9/VDD VSUBS VSUBS gf180mcu_fd_sc_mcu7t5v0__nand2_1
X_9429_ _9429_/D _9800_/CLK _9429_/Q PHY_9/VDD PHY_9/VDD VSUBS VSUBS gf180mcu_fd_sc_mcu7t5v0__dffq_1
Xrepeater6 _6089_/B _8689_/A1 PHY_9/VDD PHY_9/VDD VSUBS VSUBS gf180mcu_fd_sc_mcu7t5v0__buf_8
X_5110_ _9622_/Q _5804_/B2 PHY_9/VDD PHY_9/VDD VSUBS VSUBS gf180mcu_fd_sc_mcu7t5v0__clkinv_1
X_6090_ _6090_/I _9770_/D PHY_9/VDD PHY_9/VDD VSUBS VSUBS gf180mcu_fd_sc_mcu7t5v0__clkinv_1
X_5041_ _9743_/Q _6027_/B2 PHY_9/VDD PHY_9/VDD VSUBS VSUBS gf180mcu_fd_sc_mcu7t5v0__clkinv_1
X_8800_ _8757_/Z _8759_/Z _8801_/B _8809_/A1 PHY_9/VDD PHY_9/VDD VSUBS VSUBS gf180mcu_fd_sc_mcu7t5v0__nor3_1
X_9780_ _9780_/D _9801_/CLK _9780_/Q PHY_9/VDD PHY_9/VDD VSUBS VSUBS gf180mcu_fd_sc_mcu7t5v0__dffq_1
X_6992_ _6992_/A1 _6992_/A2 _6993_/A2 PHY_9/VDD PHY_9/VDD VSUBS VSUBS gf180mcu_fd_sc_mcu7t5v0__nand2_1
X_8731_ _8885_/A1 _9022_/B _8983_/A1 _8980_/B PHY_9/VDD PHY_9/VDD VSUBS VSUBS gf180mcu_fd_sc_mcu7t5v0__and3_2
X_5943_ _5943_/A1 _5951_/A2 _5943_/B _9674_/D PHY_9/VDD PHY_9/VDD VSUBS VSUBS gf180mcu_fd_sc_mcu7t5v0__aoi21_1
X_5874_ _5961_/B _5875_/B _5878_/A1 PHY_9/VDD PHY_9/VDD VSUBS VSUBS gf180mcu_fd_sc_mcu7t5v0__nand2_1
X_8662_ _9932_/Q _8662_/A2 _8664_/A2 _8662_/Z PHY_9/VDD PHY_9/VDD VSUBS VSUBS gf180mcu_fd_sc_mcu7t5v0__xor3_1
X_4825_ _9505_/Q _9328_/A1 PHY_9/VDD PHY_9/VDD VSUBS VSUBS gf180mcu_fd_sc_mcu7t5v0__inv_2
X_8593_ _8973_/A1 _8647_/A2 _8647_/A3 _8593_/B _8669_/A2 PHY_9/VDD PHY_9/VDD VSUBS
+ VSUBS gf180mcu_fd_sc_mcu7t5v0__oai31_4
X_7613_ _7614_/A1 _7612_/Z _7644_/A2 PHY_9/VDD PHY_9/VDD VSUBS VSUBS gf180mcu_fd_sc_mcu7t5v0__nand2_1
X_7544_ _7539_/Z _7544_/A2 _7544_/A3 _7544_/Z PHY_9/VDD PHY_9/VDD VSUBS VSUBS gf180mcu_fd_sc_mcu7t5v0__xor3_1
X_4756_ _9869_/Q _7553_/B PHY_9/VDD PHY_9/VDD VSUBS VSUBS gf180mcu_fd_sc_mcu7t5v0__clkinv_4
X_7475_ _9810_/Q _7474_/Z _7475_/Z PHY_9/VDD PHY_9/VDD VSUBS VSUBS gf180mcu_fd_sc_mcu7t5v0__and2_1
X_4687_ _9964_/Q _9065_/A1 PHY_9/VDD PHY_9/VDD VSUBS VSUBS gf180mcu_fd_sc_mcu7t5v0__clkinv_2
X_6426_ _6740_/A1 _6443_/A1 _6440_/A2 _6426_/Z PHY_9/VDD PHY_9/VDD VSUBS VSUBS gf180mcu_fd_sc_mcu7t5v0__xor3_1
X_9214_ _9214_/A1 _9214_/A2 _9216_/A2 PHY_9/VDD PHY_9/VDD VSUBS VSUBS gf180mcu_fd_sc_mcu7t5v0__nand2_1
X_6357_ _6648_/A1 _9803_/Q _6368_/A2 PHY_9/VDD PHY_9/VDD VSUBS VSUBS gf180mcu_fd_sc_mcu7t5v0__nor2_1
X_9145_ _9810_/Q _9285_/A2 _9191_/A2 PHY_9/VDD PHY_9/VDD VSUBS VSUBS gf180mcu_fd_sc_mcu7t5v0__nand2_1
X_5308_ _5261_/Z _5308_/A2 _5318_/A2 PHY_9/VDD PHY_9/VDD VSUBS VSUBS gf180mcu_fd_sc_mcu7t5v0__nand2_4
X_6288_ _9638_/Q _6288_/A2 _6288_/B1 _9622_/Q _6289_/A2 PHY_9/VDD PHY_9/VDD VSUBS
+ VSUBS gf180mcu_fd_sc_mcu7t5v0__aoi22_1
X_9076_ _9962_/Q _9077_/A2 _9078_/B PHY_9/VDD PHY_9/VDD VSUBS VSUBS gf180mcu_fd_sc_mcu7t5v0__and2_1
X_5239_ _9460_/Q _5248_/A2 rst_n _5240_/B PHY_9/VDD PHY_9/VDD VSUBS VSUBS gf180mcu_fd_sc_mcu7t5v0__oai21_1
X_8027_ _9377_/Q _9036_/A2 _8027_/B _8028_/B PHY_9/VDD PHY_9/VDD VSUBS VSUBS gf180mcu_fd_sc_mcu7t5v0__oai21_1
X_8929_ _9812_/Q _8927_/Z _8931_/B PHY_9/VDD PHY_9/VDD VSUBS VSUBS gf180mcu_fd_sc_mcu7t5v0__xor2_1
X_5590_ _5594_/A1 _5590_/A2 _5590_/B _9496_/D PHY_9/VDD PHY_9/VDD VSUBS VSUBS gf180mcu_fd_sc_mcu7t5v0__aoi21_1
X_7260_ _7262_/A2 _7259_/Z _7289_/B PHY_9/VDD PHY_9/VDD VSUBS VSUBS gf180mcu_fd_sc_mcu7t5v0__nand2_1
X_6211_ _9587_/Q _6288_/A2 _6287_/A2 _9595_/Q _6212_/A2 PHY_9/VDD PHY_9/VDD VSUBS
+ VSUBS gf180mcu_fd_sc_mcu7t5v0__aoi22_1
X_7191_ _9848_/Q _9847_/Q _9511_/Q _7246_/A1 PHY_9/VDD PHY_9/VDD VSUBS VSUBS gf180mcu_fd_sc_mcu7t5v0__nand3_4
X_6142_ _9528_/Q _6288_/A2 _6288_/B1 _9716_/Q _6143_/A2 PHY_9/VDD PHY_9/VDD VSUBS
+ VSUBS gf180mcu_fd_sc_mcu7t5v0__aoi22_1
X_6073_ _9481_/Q _6287_/A2 _6287_/B1 _9514_/Q _6075_/A1 PHY_9/VDD PHY_9/VDD VSUBS
+ VSUBS gf180mcu_fd_sc_mcu7t5v0__aoi22_1
X_5024_ _9782_/Q _6300_/B2 PHY_9/VDD PHY_9/VDD VSUBS VSUBS gf180mcu_fd_sc_mcu7t5v0__clkinv_1
X_9901_ _9901_/D _9901_/CLK _9901_/Q PHY_9/VDD PHY_9/VDD VSUBS VSUBS gf180mcu_fd_sc_mcu7t5v0__dffq_2
X_9832_ _9832_/D _9856_/CLK _9832_/Q PHY_9/VDD PHY_9/VDD VSUBS VSUBS gf180mcu_fd_sc_mcu7t5v0__dffq_2
X_9763_ _9763_/D _9939_/CLK _9763_/Q PHY_9/VDD PHY_9/VDD VSUBS VSUBS gf180mcu_fd_sc_mcu7t5v0__dffq_1
X_6975_ _6975_/A1 _6975_/A2 _6975_/A3 _6975_/Z PHY_9/VDD PHY_9/VDD VSUBS VSUBS gf180mcu_fd_sc_mcu7t5v0__xor3_1
X_9694_ _9694_/D _9939_/CLK _9694_/Q PHY_9/VDD PHY_9/VDD VSUBS VSUBS gf180mcu_fd_sc_mcu7t5v0__dffq_1
X_5926_ _9667_/Q _5922_/Z _5932_/B _5927_/A2 PHY_9/VDD PHY_9/VDD VSUBS VSUBS gf180mcu_fd_sc_mcu7t5v0__oai21_1
X_8714_ _8755_/A1 _8719_/C _8857_/C PHY_9/VDD PHY_9/VDD VSUBS VSUBS gf180mcu_fd_sc_mcu7t5v0__nand2_2
X_8645_ _9811_/Q _8645_/A2 _8650_/A3 PHY_9/VDD PHY_9/VDD VSUBS VSUBS gf180mcu_fd_sc_mcu7t5v0__nand2_1
X_5857_ _9646_/Q _9523_/Q _5859_/A2 PHY_9/VDD PHY_9/VDD VSUBS VSUBS gf180mcu_fd_sc_mcu7t5v0__nand2_1
X_5788_ _8691_/A1 _5794_/A2 _5794_/B1 _5788_/B2 _9608_/D PHY_9/VDD PHY_9/VDD VSUBS
+ VSUBS gf180mcu_fd_sc_mcu7t5v0__oai22_1
X_4808_ _9686_/Q _5968_/A1 PHY_9/VDD PHY_9/VDD VSUBS VSUBS gf180mcu_fd_sc_mcu7t5v0__clkinv_1
X_8576_ _8444_/B _8600_/A2 _8577_/A2 PHY_9/VDD PHY_9/VDD VSUBS VSUBS gf180mcu_fd_sc_mcu7t5v0__nand2_1
X_7527_ _9811_/Q _7599_/A2 _7529_/A2 PHY_9/VDD PHY_9/VDD VSUBS VSUBS gf180mcu_fd_sc_mcu7t5v0__nand2_1
X_4739_ _9897_/Q _7965_/A1 PHY_9/VDD PHY_9/VDD VSUBS VSUBS gf180mcu_fd_sc_mcu7t5v0__inv_1
X_7458_ _7451_/Z _7458_/A2 _7500_/A2 _9928_/Q _7504_/A3 PHY_9/VDD PHY_9/VDD VSUBS
+ VSUBS gf180mcu_fd_sc_mcu7t5v0__oai22_2
X_6409_ _6409_/A1 _6407_/Z _6410_/B1 PHY_9/VDD PHY_9/VDD VSUBS VSUBS gf180mcu_fd_sc_mcu7t5v0__xnor2_1
X_7389_ _7389_/A1 _7388_/B _7389_/Z PHY_9/VDD PHY_9/VDD VSUBS VSUBS gf180mcu_fd_sc_mcu7t5v0__xor2_1
X_9128_ _9313_/A2 _9128_/A2 _9122_/Z _9128_/B _9130_/A2 PHY_9/VDD PHY_9/VDD VSUBS
+ VSUBS gf180mcu_fd_sc_mcu7t5v0__oai31_1
X_9059_ _9964_/Q _9059_/A2 _9962_/Q _9217_/A1 PHY_9/VDD PHY_9/VDD VSUBS VSUBS gf180mcu_fd_sc_mcu7t5v0__nand3_1
X_6760_ _9809_/Q _6974_/A2 _6760_/Z PHY_9/VDD PHY_9/VDD VSUBS VSUBS gf180mcu_fd_sc_mcu7t5v0__and2_1
X_5711_ _8693_/A1 _5715_/A2 _5715_/B1 _5711_/B2 _9553_/D PHY_9/VDD PHY_9/VDD VSUBS
+ VSUBS gf180mcu_fd_sc_mcu7t5v0__oai22_1
X_6691_ _9833_/Q _6698_/A2 _9831_/Q _6999_/A1 PHY_9/VDD PHY_9/VDD VSUBS VSUBS gf180mcu_fd_sc_mcu7t5v0__nand3_2
X_8430_ _8430_/A1 _8646_/A2 _8430_/B1 _8430_/B2 _8653_/A2 PHY_9/VDD PHY_9/VDD VSUBS
+ VSUBS gf180mcu_fd_sc_mcu7t5v0__aoi22_4
X_5642_ _8693_/A1 _5646_/A2 _5646_/B1 _5642_/B2 _9517_/D PHY_9/VDD PHY_9/VDD VSUBS
+ VSUBS gf180mcu_fd_sc_mcu7t5v0__oai22_1
X_8361_ _8647_/A3 _9034_/A2 _8361_/B _9923_/D PHY_9/VDD PHY_9/VDD VSUBS VSUBS gf180mcu_fd_sc_mcu7t5v0__aoi21_1
X_5573_ _5591_/A2 _9317_/C _5592_/B1 PHY_9/VDD PHY_9/VDD VSUBS VSUBS gf180mcu_fd_sc_mcu7t5v0__nor2_4
X_7312_ _9814_/Q _7316_/A2 _7317_/A1 PHY_9/VDD PHY_9/VDD VSUBS VSUBS gf180mcu_fd_sc_mcu7t5v0__nor2_1
X_8292_ _8292_/A1 _8292_/A2 _8292_/B _8332_/A1 PHY_9/VDD PHY_9/VDD VSUBS VSUBS gf180mcu_fd_sc_mcu7t5v0__aoi21_1
X_7243_ _7244_/A1 _7244_/A2 _7309_/A1 PHY_9/VDD PHY_9/VDD VSUBS VSUBS gf180mcu_fd_sc_mcu7t5v0__nor2_1
X_7174_ _7247_/A2 _7174_/A2 _7176_/A2 PHY_9/VDD PHY_9/VDD VSUBS VSUBS gf180mcu_fd_sc_mcu7t5v0__xnor2_1
X_6125_ _6125_/A1 _6125_/A2 _6145_/A2 PHY_9/VDD PHY_9/VDD VSUBS VSUBS gf180mcu_fd_sc_mcu7t5v0__nand2_1
X_6056_ _5399_/Z _6059_/A2 _6059_/B1 _6056_/B2 _9766_/D PHY_9/VDD PHY_9/VDD VSUBS
+ VSUBS gf180mcu_fd_sc_mcu7t5v0__oai22_1
X_5007_ _9758_/Q _6046_/B2 PHY_9/VDD PHY_9/VDD VSUBS VSUBS gf180mcu_fd_sc_mcu7t5v0__clkinv_1
X_9815_ _9815_/D _9856_/CLK _9815_/Q PHY_9/VDD PHY_9/VDD VSUBS VSUBS gf180mcu_fd_sc_mcu7t5v0__dffq_2
X_9746_ _9746_/D _9939_/CLK _9746_/Q PHY_9/VDD PHY_9/VDD VSUBS VSUBS gf180mcu_fd_sc_mcu7t5v0__dffq_1
X_6958_ _6700_/C _6958_/A2 _6958_/A3 _6958_/A4 _6960_/B1 PHY_9/VDD PHY_9/VDD VSUBS
+ VSUBS gf180mcu_fd_sc_mcu7t5v0__nand4_1
X_6889_ _6911_/B2 _6889_/A2 _6886_/Z _6941_/A2 PHY_9/VDD PHY_9/VDD VSUBS VSUBS gf180mcu_fd_sc_mcu7t5v0__xnor3_1
X_5909_ _9662_/Q _5905_/Z _5909_/Z PHY_9/VDD PHY_9/VDD VSUBS VSUBS gf180mcu_fd_sc_mcu7t5v0__and2_1
X_9677_ _9677_/D _9972_/CLK _9677_/Q PHY_9/VDD PHY_9/VDD VSUBS VSUBS gf180mcu_fd_sc_mcu7t5v0__dffq_1
X_8628_ _9813_/Q _8627_/Z _8665_/B PHY_9/VDD PHY_9/VDD VSUBS VSUBS gf180mcu_fd_sc_mcu7t5v0__nand2_1
X_8559_ _8560_/A1 _8652_/A1 _8559_/Z PHY_9/VDD PHY_9/VDD VSUBS VSUBS gf180mcu_fd_sc_mcu7t5v0__and2_1
X_7930_ _7930_/A1 _7930_/A2 _7930_/B _7981_/A1 PHY_9/VDD PHY_9/VDD VSUBS VSUBS gf180mcu_fd_sc_mcu7t5v0__oai21_1
X_7861_ _9895_/Q _7859_/Z _7881_/B PHY_9/VDD PHY_9/VDD VSUBS VSUBS gf180mcu_fd_sc_mcu7t5v0__and2_1
X_9600_ _9600_/D _9940_/CLK _9600_/Q PHY_9/VDD PHY_9/VDD VSUBS VSUBS gf180mcu_fd_sc_mcu7t5v0__dffq_1
X_6812_ _6812_/A1 _6793_/Z _6812_/B _6862_/A1 PHY_9/VDD PHY_9/VDD VSUBS VSUBS gf180mcu_fd_sc_mcu7t5v0__aoi21_1
X_7792_ _9809_/Q _7771_/Z _7792_/B1 _8009_/C _7796_/B1 PHY_9/VDD PHY_9/VDD VSUBS VSUBS
+ gf180mcu_fd_sc_mcu7t5v0__oai22_1
X_6743_ _9809_/Q _6781_/A2 _6781_/A3 _6784_/A1 PHY_9/VDD PHY_9/VDD VSUBS VSUBS gf180mcu_fd_sc_mcu7t5v0__nand3_1
X_9531_ _9531_/D _9901_/CLK _9531_/Q PHY_9/VDD PHY_9/VDD VSUBS VSUBS gf180mcu_fd_sc_mcu7t5v0__dffq_1
X_6674_ _9397_/Q _9036_/A2 _8027_/B _6675_/B PHY_9/VDD PHY_9/VDD VSUBS VSUBS gf180mcu_fd_sc_mcu7t5v0__oai21_1
X_9462_ _9462_/D _9801_/CLK _9462_/Q PHY_9/VDD PHY_9/VDD VSUBS VSUBS gf180mcu_fd_sc_mcu7t5v0__dffq_4
X_8413_ _8634_/A1 _8417_/A3 _8414_/B PHY_9/VDD PHY_9/VDD VSUBS VSUBS gf180mcu_fd_sc_mcu7t5v0__nor2_1
X_5625_ _5625_/A1 _5625_/A2 _5973_/C _9510_/D PHY_9/VDD PHY_9/VDD VSUBS VSUBS gf180mcu_fd_sc_mcu7t5v0__aoi21_1
X_9393_ _9393_/D _9856_/CLK _9393_/Q PHY_9/VDD PHY_9/VDD VSUBS VSUBS gf180mcu_fd_sc_mcu7t5v0__dffq_1
X_8344_ _8344_/A1 _8688_/A2 _8353_/A2 PHY_9/VDD PHY_9/VDD VSUBS VSUBS gf180mcu_fd_sc_mcu7t5v0__nand2_4
X_5556_ _8695_/A1 _5558_/A2 _5558_/B1 _5556_/B2 _9486_/D PHY_9/VDD PHY_9/VDD VSUBS
+ VSUBS gf180mcu_fd_sc_mcu7t5v0__oai22_1
X_8275_ _8276_/A1 _8276_/A3 _8313_/A2 PHY_9/VDD PHY_9/VDD VSUBS VSUBS gf180mcu_fd_sc_mcu7t5v0__nor2_1
X_5487_ _9455_/Q _5493_/B _5770_/B _5488_/B PHY_9/VDD PHY_9/VDD VSUBS VSUBS gf180mcu_fd_sc_mcu7t5v0__oai21_1
X_7226_ _7175_/Z _7227_/A2 _7226_/B _7272_/B PHY_9/VDD PHY_9/VDD VSUBS VSUBS gf180mcu_fd_sc_mcu7t5v0__oai21_1
X_7157_ _7158_/A1 _7157_/A2 _7156_/Z _7210_/A2 PHY_9/VDD PHY_9/VDD VSUBS VSUBS gf180mcu_fd_sc_mcu7t5v0__nor3_2
X_6108_ _6108_/A1 _6108_/A2 _6117_/B1 PHY_9/VDD PHY_9/VDD VSUBS VSUBS gf180mcu_fd_sc_mcu7t5v0__nand2_1
X_7088_ _9851_/Q _7106_/A1 _7101_/A2 _7103_/A2 PHY_9/VDD PHY_9/VDD VSUBS VSUBS gf180mcu_fd_sc_mcu7t5v0__xnor3_1
X_6039_ _5406_/Z _6039_/A2 _6039_/B1 _6039_/B2 _9753_/D PHY_9/VDD PHY_9/VDD VSUBS
+ VSUBS gf180mcu_fd_sc_mcu7t5v0__oai22_1
X_9729_ _9729_/D _9800_/CLK _9729_/Q PHY_9/VDD PHY_9/VDD VSUBS VSUBS gf180mcu_fd_sc_mcu7t5v0__dffq_2
X_6390_ _6624_/A2 _6646_/B _6393_/A3 PHY_9/VDD PHY_9/VDD VSUBS VSUBS gf180mcu_fd_sc_mcu7t5v0__nand2_1
X_5410_ _9731_/Q _9427_/Q _5961_/B _5411_/B PHY_9/VDD PHY_9/VDD VSUBS VSUBS gf180mcu_fd_sc_mcu7t5v0__oai21_1
X_5341_ _9464_/Q _5342_/A2 _9035_/B _5342_/B PHY_9/VDD PHY_9/VDD VSUBS VSUBS gf180mcu_fd_sc_mcu7t5v0__oai21_1
X_8060_ _9904_/Q _8086_/A1 _8060_/Z PHY_9/VDD PHY_9/VDD VSUBS VSUBS gf180mcu_fd_sc_mcu7t5v0__and2_1
X_7011_ _9392_/Q _9036_/A2 _8027_/B _7012_/B PHY_9/VDD PHY_9/VDD VSUBS VSUBS gf180mcu_fd_sc_mcu7t5v0__oai21_1
X_5272_ _5272_/A1 _5272_/A2 _5272_/B _9377_/D PHY_9/VDD PHY_9/VDD VSUBS VSUBS gf180mcu_fd_sc_mcu7t5v0__aoi21_1
X_8962_ _8963_/A2 _8960_/Z _9002_/A2 PHY_9/VDD PHY_9/VDD VSUBS VSUBS gf180mcu_fd_sc_mcu7t5v0__nor2_1
X_7913_ _7913_/A1 _7913_/A2 _7913_/B _7920_/A1 PHY_9/VDD PHY_9/VDD VSUBS VSUBS gf180mcu_fd_sc_mcu7t5v0__oai21_1
X_8893_ _8893_/A1 _8893_/A2 _8893_/B _8915_/A1 PHY_9/VDD PHY_9/VDD VSUBS VSUBS gf180mcu_fd_sc_mcu7t5v0__oai21_1
X_7844_ _6512_/B _7988_/A2 _7849_/A3 PHY_9/VDD PHY_9/VDD VSUBS VSUBS gf180mcu_fd_sc_mcu7t5v0__nor2_1
X_7775_ _7805_/A1 _7805_/A2 _9809_/Q _7805_/C _7807_/B PHY_9/VDD PHY_9/VDD VSUBS VSUBS
+ gf180mcu_fd_sc_mcu7t5v0__oai211_2
X_4987_ _9915_/Q _8349_/B2 PHY_9/VDD PHY_9/VDD VSUBS VSUBS gf180mcu_fd_sc_mcu7t5v0__clkinv_1
X_6726_ _6748_/A1 _6726_/A2 _6732_/A3 PHY_9/VDD PHY_9/VDD VSUBS VSUBS gf180mcu_fd_sc_mcu7t5v0__nand2_1
X_9514_ _9514_/D _9801_/CLK _9514_/Q PHY_9/VDD PHY_9/VDD VSUBS VSUBS gf180mcu_fd_sc_mcu7t5v0__dffq_1
X_9445_ _9445_/D _9800_/CLK _9445_/Q PHY_9/VDD PHY_9/VDD VSUBS VSUBS gf180mcu_fd_sc_mcu7t5v0__dffq_1
X_6657_ _5474_/B _6665_/A2 _6665_/B1 PHY_9/VDD PHY_9/VDD VSUBS VSUBS gf180mcu_fd_sc_mcu7t5v0__nand2_2
X_6588_ _6588_/A1 _6586_/Z _6588_/Z PHY_9/VDD PHY_9/VDD VSUBS VSUBS gf180mcu_fd_sc_mcu7t5v0__xor2_1
X_5608_ _9271_/A1 _9034_/A2 _5608_/B _9504_/D PHY_9/VDD PHY_9/VDD VSUBS VSUBS gf180mcu_fd_sc_mcu7t5v0__aoi21_1
X_9376_ _9376_/D _9974_/CLK _9376_/Q PHY_9/VDD PHY_9/VDD VSUBS VSUBS gf180mcu_fd_sc_mcu7t5v0__dffq_1
X_8327_ _8262_/Z _8327_/A2 _8326_/Z _8328_/A2 PHY_9/VDD PHY_9/VDD VSUBS VSUBS gf180mcu_fd_sc_mcu7t5v0__xnor3_1
X_5539_ _9447_/Q _5525_/Z _5544_/A2 _9474_/Q _9729_/Q _5540_/A2 PHY_9/VDD PHY_9/VDD
+ VSUBS VSUBS gf180mcu_fd_sc_mcu7t5v0__aoi221_1
X_8258_ _8318_/A1 _9897_/Q _8318_/B _8259_/B2 PHY_9/VDD PHY_9/VDD VSUBS VSUBS gf180mcu_fd_sc_mcu7t5v0__oai21_2
X_7209_ _7156_/Z _7210_/A2 _7209_/B _7245_/B PHY_9/VDD PHY_9/VDD VSUBS VSUBS gf180mcu_fd_sc_mcu7t5v0__oai21_1
X_8189_ _8209_/A1 _8188_/Z _8189_/Z PHY_9/VDD PHY_9/VDD VSUBS VSUBS gf180mcu_fd_sc_mcu7t5v0__xor2_1
X_4910_ _9763_/Q _6053_/B2 PHY_9/VDD PHY_9/VDD VSUBS VSUBS gf180mcu_fd_sc_mcu7t5v0__clkinv_1
X_5890_ _9655_/Q _5907_/A1 _9655_/D PHY_9/VDD PHY_9/VDD VSUBS VSUBS gf180mcu_fd_sc_mcu7t5v0__nor2_1
X_4841_ _9466_/Q _5520_/A1 PHY_9/VDD PHY_9/VDD VSUBS VSUBS gf180mcu_fd_sc_mcu7t5v0__clkinv_1
X_4772_ _9844_/Q _7037_/A3 PHY_9/VDD PHY_9/VDD VSUBS VSUBS gf180mcu_fd_sc_mcu7t5v0__clkinv_3
X_7560_ _7544_/Z _7558_/I _7560_/Z PHY_9/VDD PHY_9/VDD VSUBS VSUBS gf180mcu_fd_sc_mcu7t5v0__xor2_1
X_6511_ _6650_/A2 _6577_/A2 _6512_/A2 PHY_9/VDD PHY_9/VDD VSUBS VSUBS gf180mcu_fd_sc_mcu7t5v0__nand2_1
X_7491_ _9811_/Q _7647_/A2 _7538_/A1 PHY_9/VDD PHY_9/VDD VSUBS VSUBS gf180mcu_fd_sc_mcu7t5v0__nand2_1
X_6442_ _6442_/A1 _6442_/A2 _9357_/B _9817_/D PHY_9/VDD PHY_9/VDD VSUBS VSUBS gf180mcu_fd_sc_mcu7t5v0__aoi21_1
X_9230_ _9273_/A1 _9230_/A2 _9232_/A2 PHY_9/VDD PHY_9/VDD VSUBS VSUBS gf180mcu_fd_sc_mcu7t5v0__xnor2_1
X_9161_ _9227_/A2 _9160_/Z _9161_/Z PHY_9/VDD PHY_9/VDD VSUBS VSUBS gf180mcu_fd_sc_mcu7t5v0__xor2_1
X_6373_ _9807_/Q _6474_/A2 _6401_/C _6374_/A2 PHY_9/VDD PHY_9/VDD VSUBS VSUBS gf180mcu_fd_sc_mcu7t5v0__aoi21_1
X_8112_ _9809_/Q _8113_/A2 _8145_/B PHY_9/VDD PHY_9/VDD VSUBS VSUBS gf180mcu_fd_sc_mcu7t5v0__nand2_1
X_5324_ _9399_/Q _5331_/A2 _5325_/B PHY_9/VDD PHY_9/VDD VSUBS VSUBS gf180mcu_fd_sc_mcu7t5v0__nor2_1
X_9092_ _9093_/A1 _9107_/A3 _9111_/A1 PHY_9/VDD PHY_9/VDD VSUBS VSUBS gf180mcu_fd_sc_mcu7t5v0__nand2_1
X_5255_ _9462_/Q _5260_/A2 rst_n _5256_/B PHY_9/VDD PHY_9/VDD VSUBS VSUBS gf180mcu_fd_sc_mcu7t5v0__oai21_1
X_8043_ _9901_/Q _8043_/A2 _8339_/B PHY_9/VDD PHY_9/VDD VSUBS VSUBS gf180mcu_fd_sc_mcu7t5v0__nand2_2
X_5186_ _9523_/Q _5206_/B1 _5871_/A2 PHY_9/VDD PHY_9/VDD VSUBS VSUBS gf180mcu_fd_sc_mcu7t5v0__nand2_1
X_8945_ _9807_/Q _9017_/A2 _8948_/A1 PHY_9/VDD PHY_9/VDD VSUBS VSUBS gf180mcu_fd_sc_mcu7t5v0__nand2_1
X_8876_ _8813_/Z _8925_/A2 _8925_/B _8877_/A2 PHY_9/VDD PHY_9/VDD VSUBS VSUBS gf180mcu_fd_sc_mcu7t5v0__oai21_1
X_7827_ _9810_/Q _7800_/Z _7944_/A1 PHY_9/VDD PHY_9/VDD VSUBS VSUBS gf180mcu_fd_sc_mcu7t5v0__nand2_2
X_7758_ _7814_/A1 _7758_/A2 _7764_/A2 PHY_9/VDD PHY_9/VDD VSUBS VSUBS gf180mcu_fd_sc_mcu7t5v0__nor2_2
X_6709_ _9834_/Q _6709_/A2 _6709_/B _6781_/A3 PHY_9/VDD PHY_9/VDD VSUBS VSUBS gf180mcu_fd_sc_mcu7t5v0__oai21_4
X_7689_ _9379_/Q _9034_/A2 _7695_/B _7690_/B PHY_9/VDD PHY_9/VDD VSUBS VSUBS gf180mcu_fd_sc_mcu7t5v0__oai21_1
X_9428_ _9428_/D _9800_/CLK _9428_/Q PHY_9/VDD PHY_9/VDD VSUBS VSUBS gf180mcu_fd_sc_mcu7t5v0__dffq_1
X_9359_ _9359_/D _9972_/CLK _9359_/Q PHY_9/VDD PHY_9/VDD VSUBS VSUBS gf180mcu_fd_sc_mcu7t5v0__dffq_1
Xrepeater7 _7007_/B _6089_/B PHY_9/VDD PHY_9/VDD VSUBS VSUBS gf180mcu_fd_sc_mcu7t5v0__buf_12
X_5040_ _9751_/Q _6037_/B2 PHY_9/VDD PHY_9/VDD VSUBS VSUBS gf180mcu_fd_sc_mcu7t5v0__clkinv_1
X_6991_ _6948_/B _6991_/A2 _6992_/A2 PHY_9/VDD PHY_9/VDD VSUBS VSUBS gf180mcu_fd_sc_mcu7t5v0__nand2_1
X_5942_ _9682_/Q _5951_/A2 _5961_/B _5943_/B PHY_9/VDD PHY_9/VDD VSUBS VSUBS gf180mcu_fd_sc_mcu7t5v0__oai21_1
X_8730_ _9951_/Q _9950_/Q _8754_/A2 PHY_9/VDD PHY_9/VDD VSUBS VSUBS gf180mcu_fd_sc_mcu7t5v0__nor2_1
X_8661_ _8661_/A1 _8659_/Z _8661_/A3 _8664_/A2 PHY_9/VDD PHY_9/VDD VSUBS VSUBS gf180mcu_fd_sc_mcu7t5v0__xnor3_1
X_5873_ _5871_/Z _5873_/A2 _9648_/D PHY_9/VDD PHY_9/VDD VSUBS VSUBS gf180mcu_fd_sc_mcu7t5v0__nor2_1
X_4824_ _9671_/Q _5937_/A1 PHY_9/VDD PHY_9/VDD VSUBS VSUBS gf180mcu_fd_sc_mcu7t5v0__clkinv_1
X_8592_ _9876_/Q _8646_/A2 _8646_/B1 _9504_/Q _8593_/B PHY_9/VDD PHY_9/VDD VSUBS VSUBS
+ gf180mcu_fd_sc_mcu7t5v0__aoi22_2
X_7612_ _7612_/A1 _7610_/Z _7612_/Z PHY_9/VDD PHY_9/VDD VSUBS VSUBS gf180mcu_fd_sc_mcu7t5v0__xor2_1
X_4755_ _9870_/Q _7706_/A2 PHY_9/VDD PHY_9/VDD VSUBS VSUBS gf180mcu_fd_sc_mcu7t5v0__clkinv_2
X_7543_ _7544_/A2 _7544_/A3 _7591_/A2 PHY_9/VDD PHY_9/VDD VSUBS VSUBS gf180mcu_fd_sc_mcu7t5v0__nand2_1
X_7474_ _7654_/A2 _7474_/A2 _7474_/Z PHY_9/VDD PHY_9/VDD VSUBS VSUBS gf180mcu_fd_sc_mcu7t5v0__xor2_1
X_9213_ _9347_/I0 _9178_/Z _9214_/A2 PHY_9/VDD PHY_9/VDD VSUBS VSUBS gf180mcu_fd_sc_mcu7t5v0__nand2_1
X_4686_ _9361_/Q _5234_/A1 PHY_9/VDD PHY_9/VDD VSUBS VSUBS gf180mcu_fd_sc_mcu7t5v0__clkinv_1
X_6425_ _6740_/A1 _6440_/A2 _6443_/B PHY_9/VDD PHY_9/VDD VSUBS VSUBS gf180mcu_fd_sc_mcu7t5v0__nor2_1
X_6356_ _9090_/C _6583_/A3 _6408_/A2 PHY_9/VDD PHY_9/VDD VSUBS VSUBS gf180mcu_fd_sc_mcu7t5v0__nor2_4
X_9144_ _9810_/Q _9331_/A2 _9150_/A3 PHY_9/VDD PHY_9/VDD VSUBS VSUBS gf180mcu_fd_sc_mcu7t5v0__nand2_1
X_5307_ _5853_/A1 _5307_/A2 _5307_/B _5973_/C _9392_/D PHY_9/VDD PHY_9/VDD VSUBS VSUBS
+ gf180mcu_fd_sc_mcu7t5v0__aoi211_1
X_9075_ _9090_/A1 _9270_/B _9090_/B1 _9090_/B2 _9285_/A2 PHY_9/VDD PHY_9/VDD VSUBS
+ VSUBS gf180mcu_fd_sc_mcu7t5v0__aoi22_4
X_6287_ _9614_/Q _6287_/A2 _6287_/B1 _9630_/Q _6289_/A1 PHY_9/VDD PHY_9/VDD VSUBS
+ VSUBS gf180mcu_fd_sc_mcu7t5v0__aoi22_1
X_8026_ _8318_/B _9034_/A2 _8026_/B _9902_/D PHY_9/VDD PHY_9/VDD VSUBS VSUBS gf180mcu_fd_sc_mcu7t5v0__aoi21_1
X_5238_ _5262_/A1 _5237_/Z _5248_/A2 PHY_9/VDD PHY_9/VDD VSUBS VSUBS gf180mcu_fd_sc_mcu7t5v0__nand2_4
X_5169_ _9658_/Q _5169_/A2 _5170_/A3 PHY_9/VDD PHY_9/VDD VSUBS VSUBS gf180mcu_fd_sc_mcu7t5v0__nand2_1
X_8928_ _9812_/Q _8927_/Z _8975_/A1 PHY_9/VDD PHY_9/VDD VSUBS VSUBS gf180mcu_fd_sc_mcu7t5v0__nand2_1
X_8859_ _6512_/B _8752_/I _8909_/B PHY_9/VDD PHY_9/VDD VSUBS VSUBS gf180mcu_fd_sc_mcu7t5v0__nor2_1
Xclkbuf_leaf_10_clk clkbuf_leaf_9_clk/I _9974_/CLK PHY_9/VDD PHY_9/VDD VSUBS VSUBS
+ gf180mcu_fd_sc_mcu7t5v0__clkbuf_16
X_7190_ _7151_/Z _7190_/A2 _7190_/B _7213_/A1 PHY_9/VDD PHY_9/VDD VSUBS VSUBS gf180mcu_fd_sc_mcu7t5v0__oai21_1
X_6210_ _9579_/Q _6287_/B1 _6288_/B1 _9938_/Q _6212_/A1 PHY_9/VDD PHY_9/VDD VSUBS
+ VSUBS gf180mcu_fd_sc_mcu7t5v0__aoi22_1
X_6141_ _9483_/Q _6287_/A2 _6287_/B1 _9516_/Q _6143_/A1 PHY_9/VDD PHY_9/VDD VSUBS
+ VSUBS gf180mcu_fd_sc_mcu7t5v0__aoi22_1
X_6072_ _6072_/A1 _6072_/A2 _6086_/B1 PHY_9/VDD PHY_9/VDD VSUBS VSUBS gf180mcu_fd_sc_mcu7t5v0__nand2_1
X_5023_ _9798_/Q _6320_/B2 PHY_9/VDD PHY_9/VDD VSUBS VSUBS gf180mcu_fd_sc_mcu7t5v0__clkinv_1
X_9900_ _9900_/D _9901_/CLK _9900_/Q PHY_9/VDD PHY_9/VDD VSUBS VSUBS gf180mcu_fd_sc_mcu7t5v0__dffq_2
X_9831_ _9831_/D _9856_/CLK _9831_/Q PHY_9/VDD PHY_9/VDD VSUBS VSUBS gf180mcu_fd_sc_mcu7t5v0__dffq_4
X_9762_ _9762_/D _9939_/CLK _9762_/Q PHY_9/VDD PHY_9/VDD VSUBS VSUBS gf180mcu_fd_sc_mcu7t5v0__dffq_1
X_6974_ _9812_/Q _6974_/A2 _6975_/A3 PHY_9/VDD PHY_9/VDD VSUBS VSUBS gf180mcu_fd_sc_mcu7t5v0__nand2_1
X_9693_ _9693_/D _9939_/CLK _9693_/Q PHY_9/VDD PHY_9/VDD VSUBS VSUBS gf180mcu_fd_sc_mcu7t5v0__dffq_1
X_5925_ _9667_/Q _5922_/Z _5925_/Z PHY_9/VDD PHY_9/VDD VSUBS VSUBS gf180mcu_fd_sc_mcu7t5v0__and2_1
X_8713_ _9953_/Q _9952_/Q _8720_/B PHY_9/VDD PHY_9/VDD VSUBS VSUBS gf180mcu_fd_sc_mcu7t5v0__or2_2
X_8644_ _9809_/Q _8644_/A2 _8650_/A2 PHY_9/VDD PHY_9/VDD VSUBS VSUBS gf180mcu_fd_sc_mcu7t5v0__nand2_1
X_5856_ _5832_/Z _5856_/A2 _5856_/B _9644_/D PHY_9/VDD PHY_9/VDD VSUBS VSUBS gf180mcu_fd_sc_mcu7t5v0__aoi21_1
X_4807_ _9687_/Q _5973_/A1 PHY_9/VDD PHY_9/VDD VSUBS VSUBS gf180mcu_fd_sc_mcu7t5v0__clkinv_1
X_5787_ _5388_/Z _5794_/A2 _5794_/B1 _5787_/B2 _9607_/D PHY_9/VDD PHY_9/VDD VSUBS
+ VSUBS gf180mcu_fd_sc_mcu7t5v0__oai22_1
X_8575_ _8580_/A1 _8580_/A2 _8581_/A1 PHY_9/VDD PHY_9/VDD VSUBS VSUBS gf180mcu_fd_sc_mcu7t5v0__nand2_1
X_7526_ _7576_/A2 _7525_/Z _7531_/A2 PHY_9/VDD PHY_9/VDD VSUBS VSUBS gf180mcu_fd_sc_mcu7t5v0__nand2_1
X_4738_ _9898_/Q _8018_/A1 PHY_9/VDD PHY_9/VDD VSUBS VSUBS gf180mcu_fd_sc_mcu7t5v0__clkinv_1
X_7457_ _7457_/A1 _7457_/A2 _7650_/B1 _7457_/B2 _7654_/A2 PHY_9/VDD PHY_9/VDD VSUBS
+ VSUBS gf180mcu_fd_sc_mcu7t5v0__aoi22_4
X_6408_ _9815_/Q _6408_/A2 _6407_/Z _6414_/B PHY_9/VDD PHY_9/VDD VSUBS VSUBS gf180mcu_fd_sc_mcu7t5v0__nand3_1
X_7388_ _9090_/C _7647_/A2 _7388_/B _7428_/B PHY_9/VDD PHY_9/VDD VSUBS VSUBS gf180mcu_fd_sc_mcu7t5v0__aoi21_1
X_9127_ _9809_/Q _9348_/A2 _9111_/Z _9344_/A1 _9127_/C _9128_/B PHY_9/VDD PHY_9/VDD
+ VSUBS VSUBS gf180mcu_fd_sc_mcu7t5v0__aoi221_1
Xclkbuf_1_1__f_clk clkbuf_0_clk/Z clkbuf_leaf_8_clk/I PHY_9/VDD PHY_9/VDD VSUBS VSUBS
+ gf180mcu_fd_sc_mcu7t5v0__clkbuf_16
X_6339_ _9227_/A1 _9034_/A2 _6339_/B _9809_/D PHY_9/VDD PHY_9/VDD VSUBS VSUBS gf180mcu_fd_sc_mcu7t5v0__aoi21_1
X_9058_ _9058_/A1 _9168_/A2 _9344_/A1 PHY_9/VDD PHY_9/VDD VSUBS VSUBS gf180mcu_fd_sc_mcu7t5v0__nor2_2
X_8009_ _9814_/Q _8009_/A2 _8009_/B _8009_/C _8016_/B2 PHY_9/VDD PHY_9/VDD VSUBS VSUBS
+ gf180mcu_fd_sc_mcu7t5v0__aoi211_1
X_5710_ _8692_/A1 _5715_/A2 _5715_/B1 _5710_/B2 _9552_/D PHY_9/VDD PHY_9/VDD VSUBS
+ VSUBS gf180mcu_fd_sc_mcu7t5v0__oai22_1
X_6690_ _6699_/A3 _6690_/A2 _6946_/A1 PHY_9/VDD PHY_9/VDD VSUBS VSUBS gf180mcu_fd_sc_mcu7t5v0__nor2_2
X_5641_ _8692_/A1 _5646_/A2 _5646_/B1 _5641_/B2 _9516_/D PHY_9/VDD PHY_9/VDD VSUBS
+ VSUBS gf180mcu_fd_sc_mcu7t5v0__oai22_1
X_5572_ _9489_/Q _5572_/A2 _9356_/C PHY_9/VDD PHY_9/VDD VSUBS VSUBS gf180mcu_fd_sc_mcu7t5v0__or2_4
X_8360_ _9371_/Q _9034_/A2 _8706_/B _8361_/B PHY_9/VDD PHY_9/VDD VSUBS VSUBS gf180mcu_fd_sc_mcu7t5v0__oai21_1
X_7311_ _9856_/Q _7311_/A2 _7310_/Z _7311_/Z PHY_9/VDD PHY_9/VDD VSUBS VSUBS gf180mcu_fd_sc_mcu7t5v0__xor3_1
X_8291_ _8291_/A1 _8287_/Z _8303_/A2 PHY_9/VDD PHY_9/VDD VSUBS VSUBS gf180mcu_fd_sc_mcu7t5v0__nand2_1
X_7242_ _7242_/A1 _7242_/A2 _7242_/B _7244_/A2 PHY_9/VDD PHY_9/VDD VSUBS VSUBS gf180mcu_fd_sc_mcu7t5v0__aoi21_1
X_7173_ _7247_/A2 _7174_/A2 _7223_/A2 PHY_9/VDD PHY_9/VDD VSUBS VSUBS gf180mcu_fd_sc_mcu7t5v0__nor2_1
X_6124_ _9633_/Q _6288_/A2 _6288_/B1 _9617_/Q _6125_/A2 PHY_9/VDD PHY_9/VDD VSUBS
+ VSUBS gf180mcu_fd_sc_mcu7t5v0__aoi22_1
X_6055_ _8693_/A1 _6059_/A2 _6059_/B1 _6055_/B2 _9765_/D PHY_9/VDD PHY_9/VDD VSUBS
+ VSUBS gf180mcu_fd_sc_mcu7t5v0__oai22_1
X_5006_ _9766_/Q _6056_/B2 PHY_9/VDD PHY_9/VDD VSUBS VSUBS gf180mcu_fd_sc_mcu7t5v0__clkinv_1
X_9814_ _9814_/D _9974_/CLK _9814_/Q PHY_9/VDD PHY_9/VDD VSUBS VSUBS gf180mcu_fd_sc_mcu7t5v0__dffq_4
X_9745_ _9745_/D _9939_/CLK _9745_/Q PHY_9/VDD PHY_9/VDD VSUBS VSUBS gf180mcu_fd_sc_mcu7t5v0__dffq_1
X_6957_ _9813_/Q _6991_/A2 _6957_/B _6958_/A4 PHY_9/VDD PHY_9/VDD VSUBS VSUBS gf180mcu_fd_sc_mcu7t5v0__oai21_1
X_6888_ _6940_/A1 _6887_/Z _6942_/A1 PHY_9/VDD PHY_9/VDD VSUBS VSUBS gf180mcu_fd_sc_mcu7t5v0__nand2_1
X_9676_ _9676_/D _9972_/CLK _9676_/Q PHY_9/VDD PHY_9/VDD VSUBS VSUBS gf180mcu_fd_sc_mcu7t5v0__dffq_1
X_5908_ _9662_/Q _5905_/Z _5912_/A1 PHY_9/VDD PHY_9/VDD VSUBS VSUBS gf180mcu_fd_sc_mcu7t5v0__nor2_1
X_5839_ _9641_/Q _5832_/Z _5961_/B _5842_/A1 PHY_9/VDD PHY_9/VDD VSUBS VSUBS gf180mcu_fd_sc_mcu7t5v0__oai21_1
X_8627_ _8669_/A2 _8670_/A1 _8627_/Z PHY_9/VDD PHY_9/VDD VSUBS VSUBS gf180mcu_fd_sc_mcu7t5v0__xor2_1
X_8558_ _9812_/Q _8606_/A2 _8608_/A1 PHY_9/VDD PHY_9/VDD VSUBS VSUBS gf180mcu_fd_sc_mcu7t5v0__nand2_1
X_7509_ _7510_/A1 _7510_/A2 _7536_/B PHY_9/VDD PHY_9/VDD VSUBS VSUBS gf180mcu_fd_sc_mcu7t5v0__nand2_1
X_8489_ _8452_/B _8488_/Z _8490_/B1 PHY_9/VDD PHY_9/VDD VSUBS VSUBS gf180mcu_fd_sc_mcu7t5v0__nor2_1
X_7860_ _9895_/Q _7859_/Z _7860_/Z PHY_9/VDD PHY_9/VDD VSUBS VSUBS gf180mcu_fd_sc_mcu7t5v0__or2_1
X_6811_ _6811_/A1 _6811_/A2 _9357_/B _9839_/D PHY_9/VDD PHY_9/VDD VSUBS VSUBS gf180mcu_fd_sc_mcu7t5v0__aoi21_1
X_7791_ _9886_/Q _7791_/A2 _7790_/Z _7792_/B1 PHY_9/VDD PHY_9/VDD VSUBS VSUBS gf180mcu_fd_sc_mcu7t5v0__nor3_1
X_6742_ _9809_/Q _6824_/A2 _6824_/A3 _6746_/A3 PHY_9/VDD PHY_9/VDD VSUBS VSUBS gf180mcu_fd_sc_mcu7t5v0__nand3_2
X_9530_ _9530_/D _9901_/CLK _9530_/Q PHY_9/VDD PHY_9/VDD VSUBS VSUBS gf180mcu_fd_sc_mcu7t5v0__dffq_1
X_6673_ _6815_/B _9036_/A2 _6673_/B _9834_/D PHY_9/VDD PHY_9/VDD VSUBS VSUBS gf180mcu_fd_sc_mcu7t5v0__aoi21_1
X_9461_ _9461_/D _9972_/CLK _9461_/Q PHY_9/VDD PHY_9/VDD VSUBS VSUBS gf180mcu_fd_sc_mcu7t5v0__dffq_4
X_9392_ _9392_/D _9901_/CLK _9392_/Q PHY_9/VDD PHY_9/VDD VSUBS VSUBS gf180mcu_fd_sc_mcu7t5v0__dffq_1
X_8412_ _9808_/Q _8606_/A2 _8417_/A3 PHY_9/VDD PHY_9/VDD VSUBS VSUBS gf180mcu_fd_sc_mcu7t5v0__nand2_1
X_5624_ _9510_/Q _5633_/A2 _5625_/A2 PHY_9/VDD PHY_9/VDD VSUBS VSUBS gf180mcu_fd_sc_mcu7t5v0__nand2_1
X_8343_ _8343_/A1 _9356_/C _8343_/B1 _8343_/B2 _9357_/B _9911_/D PHY_9/VDD PHY_9/VDD
+ VSUBS VSUBS gf180mcu_fd_sc_mcu7t5v0__aoi221_1
X_5555_ _5399_/Z _5558_/A2 _5558_/B1 _5555_/B2 _9485_/D PHY_9/VDD PHY_9/VDD VSUBS
+ VSUBS gf180mcu_fd_sc_mcu7t5v0__oai22_1
X_8274_ _8274_/A1 _8310_/A1 _8313_/B PHY_9/VDD PHY_9/VDD VSUBS VSUBS gf180mcu_fd_sc_mcu7t5v0__nand2_1
X_5486_ _5486_/A1 _5493_/B _5486_/B _9454_/D PHY_9/VDD PHY_9/VDD VSUBS VSUBS gf180mcu_fd_sc_mcu7t5v0__aoi21_1
X_7225_ _6558_/B _7303_/A2 _7273_/B _7226_/B PHY_9/VDD PHY_9/VDD VSUBS VSUBS gf180mcu_fd_sc_mcu7t5v0__xor3_1
X_7156_ _9811_/Q _9810_/Q _7019_/I _7254_/A2 _7156_/Z PHY_9/VDD PHY_9/VDD VSUBS VSUBS
+ gf180mcu_fd_sc_mcu7t5v0__and4_1
X_6107_ _9691_/Q _6288_/A2 _6288_/B1 _9707_/Q _6108_/A2 PHY_9/VDD PHY_9/VDD VSUBS
+ VSUBS gf180mcu_fd_sc_mcu7t5v0__aoi22_1
X_7087_ _9851_/Q _7101_/A2 _7106_/B PHY_9/VDD PHY_9/VDD VSUBS VSUBS gf180mcu_fd_sc_mcu7t5v0__nand2_1
X_6038_ _5404_/Z _6039_/A2 _6039_/B1 _6038_/B2 _9752_/D PHY_9/VDD PHY_9/VDD VSUBS
+ VSUBS gf180mcu_fd_sc_mcu7t5v0__oai22_1
X_7989_ _7989_/A1 _7989_/A2 _7943_/Z _7989_/B2 _7990_/A3 PHY_9/VDD PHY_9/VDD VSUBS
+ VSUBS gf180mcu_fd_sc_mcu7t5v0__oai22_1
X_9728_ _9728_/D _9800_/CLK _9728_/Q PHY_9/VDD PHY_9/VDD VSUBS VSUBS gf180mcu_fd_sc_mcu7t5v0__dffq_1
X_9659_ _9659_/D _9972_/CLK _9659_/Q PHY_9/VDD PHY_9/VDD VSUBS VSUBS gf180mcu_fd_sc_mcu7t5v0__dffq_1
X_5340_ _5340_/A1 _5342_/A2 _5340_/B _9406_/D PHY_9/VDD PHY_9/VDD VSUBS VSUBS gf180mcu_fd_sc_mcu7t5v0__aoi21_1
X_5271_ _9464_/Q _5272_/A2 _8027_/B _5272_/B PHY_9/VDD PHY_9/VDD VSUBS VSUBS gf180mcu_fd_sc_mcu7t5v0__oai21_1
X_7010_ _7145_/B _9036_/A2 _7010_/B _9847_/D PHY_9/VDD PHY_9/VDD VSUBS VSUBS gf180mcu_fd_sc_mcu7t5v0__aoi21_1
X_8961_ _8963_/A2 _8960_/Z _9002_/B PHY_9/VDD PHY_9/VDD VSUBS VSUBS gf180mcu_fd_sc_mcu7t5v0__nand2_1
X_7912_ _7977_/A1 _7912_/A2 _7926_/A2 PHY_9/VDD PHY_9/VDD VSUBS VSUBS gf180mcu_fd_sc_mcu7t5v0__nand2_1
X_8892_ _8892_/A1 _8892_/A2 _8940_/A1 PHY_9/VDD PHY_9/VDD VSUBS VSUBS gf180mcu_fd_sc_mcu7t5v0__nand2_1
X_7843_ _7806_/Z _7852_/A2 _7854_/A2 PHY_9/VDD PHY_9/VDD VSUBS VSUBS gf180mcu_fd_sc_mcu7t5v0__nand2_1
X_4986_ _9944_/Q _8693_/B2 PHY_9/VDD PHY_9/VDD VSUBS VSUBS gf180mcu_fd_sc_mcu7t5v0__clkinv_1
X_7774_ _9227_/A1 _7746_/B _7809_/A1 PHY_9/VDD PHY_9/VDD VSUBS VSUBS gf180mcu_fd_sc_mcu7t5v0__nor2_1
X_6725_ _9091_/B _6752_/B2 _6752_/B1 _9090_/C _6726_/A2 PHY_9/VDD PHY_9/VDD VSUBS
+ VSUBS gf180mcu_fd_sc_mcu7t5v0__oai22_1
X_9513_ _9513_/D _9974_/CLK _9513_/Q PHY_9/VDD PHY_9/VDD VSUBS VSUBS gf180mcu_fd_sc_mcu7t5v0__dffq_2
X_9444_ _9444_/D _9801_/CLK _9444_/Q PHY_9/VDD PHY_9/VDD VSUBS VSUBS gf180mcu_fd_sc_mcu7t5v0__dffq_1
X_6656_ _8688_/A1 _6656_/A2 _6665_/A2 PHY_9/VDD PHY_9/VDD VSUBS VSUBS gf180mcu_fd_sc_mcu7t5v0__nand2_4
X_6587_ _6588_/A1 _6586_/Z _6623_/A1 PHY_9/VDD PHY_9/VDD VSUBS VSUBS gf180mcu_fd_sc_mcu7t5v0__nand2_1
X_5607_ _9776_/Q _9034_/A2 _8706_/B _5608_/B PHY_9/VDD PHY_9/VDD VSUBS VSUBS gf180mcu_fd_sc_mcu7t5v0__oai21_1
X_9375_ _9375_/D _9901_/CLK _9375_/Q PHY_9/VDD PHY_9/VDD VSUBS VSUBS gf180mcu_fd_sc_mcu7t5v0__dffq_1
X_8326_ _8326_/A1 _8326_/A2 _8325_/Z _8326_/Z PHY_9/VDD PHY_9/VDD VSUBS VSUBS gf180mcu_fd_sc_mcu7t5v0__xor3_1
X_5538_ _5973_/C _5538_/A2 _9473_/D PHY_9/VDD PHY_9/VDD VSUBS VSUBS gf180mcu_fd_sc_mcu7t5v0__nor2_1
X_8257_ _9512_/Q _8035_/Z _8317_/B1 _9855_/Q _8259_/B1 PHY_9/VDD PHY_9/VDD VSUBS VSUBS
+ gf180mcu_fd_sc_mcu7t5v0__aoi22_2
X_7208_ _7208_/A1 _7208_/A2 _7297_/A1 _7209_/B PHY_9/VDD PHY_9/VDD VSUBS VSUBS gf180mcu_fd_sc_mcu7t5v0__xnor3_1
X_5469_ _5486_/A1 _5495_/B _5469_/B _9446_/D PHY_9/VDD PHY_9/VDD VSUBS VSUBS gf180mcu_fd_sc_mcu7t5v0__aoi21_1
X_8188_ _9908_/Q _8186_/Z _8188_/Z PHY_9/VDD PHY_9/VDD VSUBS VSUBS gf180mcu_fd_sc_mcu7t5v0__xor2_1
X_7139_ _7322_/A1 _7122_/Z _7139_/B _7139_/C _7140_/B PHY_9/VDD PHY_9/VDD VSUBS VSUBS
+ gf180mcu_fd_sc_mcu7t5v0__aoi211_1
X_4840_ _9467_/Q _5523_/A1 PHY_9/VDD PHY_9/VDD VSUBS VSUBS gf180mcu_fd_sc_mcu7t5v0__clkinv_1
X_6510_ _6510_/A1 _6469_/Z _6510_/B _6551_/B PHY_9/VDD PHY_9/VDD VSUBS VSUBS gf180mcu_fd_sc_mcu7t5v0__aoi21_1
X_4771_ _9845_/Q _7006_/A1 PHY_9/VDD PHY_9/VDD VSUBS VSUBS gf180mcu_fd_sc_mcu7t5v0__clkinv_1
X_7490_ _7490_/A1 _7420_/Z _7490_/B _7512_/A1 PHY_9/VDD PHY_9/VDD VSUBS VSUBS gf180mcu_fd_sc_mcu7t5v0__aoi21_1
X_6441_ _6406_/C _6426_/Z _6441_/B1 _6441_/B2 _9317_/C _6442_/A2 PHY_9/VDD PHY_9/VDD
+ VSUBS VSUBS gf180mcu_fd_sc_mcu7t5v0__oai221_1
X_6372_ _9804_/Q _6649_/B _6401_/C PHY_9/VDD PHY_9/VDD VSUBS VSUBS gf180mcu_fd_sc_mcu7t5v0__nor2_2
X_9160_ _9251_/B _9159_/Z _9160_/Z PHY_9/VDD PHY_9/VDD VSUBS VSUBS gf180mcu_fd_sc_mcu7t5v0__and2_1
X_5323_ _5502_/A1 _5331_/A2 _5323_/B _5973_/C _9398_/D PHY_9/VDD PHY_9/VDD VSUBS VSUBS
+ gf180mcu_fd_sc_mcu7t5v0__aoi211_1
X_8111_ _8097_/Z _8111_/A2 _8113_/A2 PHY_9/VDD PHY_9/VDD VSUBS VSUBS gf180mcu_fd_sc_mcu7t5v0__xnor2_1
X_9091_ _9091_/A1 _9091_/A2 _9091_/B _9091_/C _9107_/A3 PHY_9/VDD PHY_9/VDD VSUBS
+ VSUBS gf180mcu_fd_sc_mcu7t5v0__aoi211_4
X_5254_ _5254_/A1 _5260_/A2 _5254_/B _9369_/D PHY_9/VDD PHY_9/VDD VSUBS VSUBS gf180mcu_fd_sc_mcu7t5v0__aoi21_1
X_8042_ _8057_/A1 _9900_/Q _8052_/A2 PHY_9/VDD PHY_9/VDD VSUBS VSUBS gf180mcu_fd_sc_mcu7t5v0__nor2_2
X_5185_ _5831_/A2 _5185_/A2 _5206_/B1 PHY_9/VDD PHY_9/VDD VSUBS VSUBS gf180mcu_fd_sc_mcu7t5v0__nor2_1
X_8944_ _9271_/A1 _8719_/C _8944_/B1 _8944_/B2 _9017_/A2 PHY_9/VDD PHY_9/VDD VSUBS
+ VSUBS gf180mcu_fd_sc_mcu7t5v0__aoi22_4
X_8875_ _9810_/Q _8834_/Z _8875_/B _8881_/A1 PHY_9/VDD PHY_9/VDD VSUBS VSUBS gf180mcu_fd_sc_mcu7t5v0__aoi21_1
X_7826_ _9810_/Q _7800_/Z _7830_/B2 PHY_9/VDD PHY_9/VDD VSUBS VSUBS gf180mcu_fd_sc_mcu7t5v0__nor2_1
X_4969_ _9577_/Q _5745_/B2 PHY_9/VDD PHY_9/VDD VSUBS VSUBS gf180mcu_fd_sc_mcu7t5v0__clkinv_1
X_7757_ _9807_/Q _7948_/A2 _7757_/B _7758_/A2 PHY_9/VDD PHY_9/VDD VSUBS VSUBS gf180mcu_fd_sc_mcu7t5v0__aoi21_1
X_6708_ _9850_/Q _9835_/Q _6709_/B PHY_9/VDD PHY_9/VDD VSUBS VSUBS gf180mcu_fd_sc_mcu7t5v0__nand2_1
X_7688_ _7725_/A3 _9034_/A2 _7688_/B _9886_/D PHY_9/VDD PHY_9/VDD VSUBS VSUBS gf180mcu_fd_sc_mcu7t5v0__aoi21_1
X_6639_ _6640_/I1 _6639_/A2 _6640_/I0 PHY_9/VDD PHY_9/VDD VSUBS VSUBS gf180mcu_fd_sc_mcu7t5v0__nand2_1
X_9427_ _9427_/D _9800_/CLK _9427_/Q PHY_9/VDD PHY_9/VDD VSUBS VSUBS gf180mcu_fd_sc_mcu7t5v0__dffq_1
X_9358_ _9358_/D _9972_/CLK _9358_/Q PHY_9/VDD PHY_9/VDD VSUBS VSUBS gf180mcu_fd_sc_mcu7t5v0__dffq_1
X_8309_ _9349_/A1 _8309_/A2 _8310_/A2 PHY_9/VDD PHY_9/VDD VSUBS VSUBS gf180mcu_fd_sc_mcu7t5v0__nor2_1
X_9289_ _9280_/Z _9290_/A2 _9321_/B PHY_9/VDD PHY_9/VDD VSUBS VSUBS gf180mcu_fd_sc_mcu7t5v0__nand2_1
Xrepeater8 _9035_/B _7007_/B PHY_9/VDD PHY_9/VDD VSUBS VSUBS gf180mcu_fd_sc_mcu7t5v0__buf_8
X_6990_ _9814_/Q _6998_/A2 _6990_/Z PHY_9/VDD PHY_9/VDD VSUBS VSUBS gf180mcu_fd_sc_mcu7t5v0__xor2_1
X_5941_ _5941_/A1 _5951_/A2 _5941_/B _9673_/D PHY_9/VDD PHY_9/VDD VSUBS VSUBS gf180mcu_fd_sc_mcu7t5v0__aoi21_1
X_8660_ _8660_/A1 _8660_/A2 _8661_/A3 PHY_9/VDD PHY_9/VDD VSUBS VSUBS gf180mcu_fd_sc_mcu7t5v0__xnor2_1
X_5872_ _9648_/Q _5872_/A2 _5961_/B _5873_/A2 PHY_9/VDD PHY_9/VDD VSUBS VSUBS gf180mcu_fd_sc_mcu7t5v0__oai21_1
X_4823_ _9672_/Q _5939_/A1 PHY_9/VDD PHY_9/VDD VSUBS VSUBS gf180mcu_fd_sc_mcu7t5v0__clkinv_1
X_8591_ _8591_/A1 _8591_/A2 _8591_/B _8617_/A1 PHY_9/VDD PHY_9/VDD VSUBS VSUBS gf180mcu_fd_sc_mcu7t5v0__oai21_1
X_7611_ _7612_/A1 _7610_/Z _7644_/A1 PHY_9/VDD PHY_9/VDD VSUBS VSUBS gf180mcu_fd_sc_mcu7t5v0__nand2_1
X_4754_ _9871_/Q _7739_/A2 PHY_9/VDD PHY_9/VDD VSUBS VSUBS gf180mcu_fd_sc_mcu7t5v0__inv_2
X_7542_ _7544_/A2 _7544_/A3 _7591_/B PHY_9/VDD PHY_9/VDD VSUBS VSUBS gf180mcu_fd_sc_mcu7t5v0__nor2_1
X_7473_ _7647_/A2 _7382_/Z _7657_/A2 _7473_/B _7474_/A2 PHY_9/VDD PHY_9/VDD VSUBS
+ VSUBS gf180mcu_fd_sc_mcu7t5v0__oai31_1
X_9212_ _9811_/Q _9178_/Z _9217_/B1 PHY_9/VDD PHY_9/VDD VSUBS VSUBS gf180mcu_fd_sc_mcu7t5v0__nor2_1
X_4685_ _9965_/Q _9327_/B PHY_9/VDD PHY_9/VDD VSUBS VSUBS gf180mcu_fd_sc_mcu7t5v0__inv_4
X_6424_ _6740_/A1 _6440_/A2 _6443_/A2 PHY_9/VDD PHY_9/VDD VSUBS VSUBS gf180mcu_fd_sc_mcu7t5v0__nand2_1
X_6355_ _7706_/A2 _6353_/Z _6355_/B _6624_/A2 PHY_9/VDD PHY_9/VDD VSUBS VSUBS gf180mcu_fd_sc_mcu7t5v0__oai21_4
X_9143_ _9808_/Q _9103_/Z _9184_/A1 PHY_9/VDD PHY_9/VDD VSUBS VSUBS gf180mcu_fd_sc_mcu7t5v0__nand2_1
X_6286_ _6286_/A1 _6286_/A2 _6286_/B _6290_/C PHY_9/VDD PHY_9/VDD VSUBS VSUBS gf180mcu_fd_sc_mcu7t5v0__aoi21_1
X_5306_ _9392_/Q _5307_/A2 _5307_/B PHY_9/VDD PHY_9/VDD VSUBS VSUBS gf180mcu_fd_sc_mcu7t5v0__nor2_1
X_9074_ _9327_/B _9955_/Q _9507_/Q _9044_/Z _9270_/B _9090_/B2 PHY_9/VDD PHY_9/VDD
+ VSUBS VSUBS gf180mcu_fd_sc_mcu7t5v0__aoi221_4
X_5237_ _5883_/A3 _5224_/Z _5237_/Z PHY_9/VDD PHY_9/VDD VSUBS VSUBS gf180mcu_fd_sc_mcu7t5v0__and2_2
X_8025_ _9376_/Q _9034_/A2 _8027_/B _8026_/B PHY_9/VDD PHY_9/VDD VSUBS VSUBS gf180mcu_fd_sc_mcu7t5v0__oai21_1
X_5168_ _9657_/Q _9661_/Q _5169_/A2 PHY_9/VDD PHY_9/VDD VSUBS VSUBS gf180mcu_fd_sc_mcu7t5v0__nor2_1
X_5099_ _9573_/Q _5737_/B2 PHY_9/VDD PHY_9/VDD VSUBS VSUBS gf180mcu_fd_sc_mcu7t5v0__clkinv_1
X_8927_ _8998_/A2 _8926_/I _8927_/Z PHY_9/VDD PHY_9/VDD VSUBS VSUBS gf180mcu_fd_sc_mcu7t5v0__xor2_1
X_8858_ _6471_/B _8752_/I _8858_/B _8904_/A2 PHY_9/VDD PHY_9/VDD VSUBS VSUBS gf180mcu_fd_sc_mcu7t5v0__oai21_1
X_8789_ _9091_/B _8752_/I _8789_/B _8816_/B1 PHY_9/VDD PHY_9/VDD VSUBS VSUBS gf180mcu_fd_sc_mcu7t5v0__oai21_1
X_7809_ _7809_/A1 _7809_/A2 _7809_/A3 _7809_/Z PHY_9/VDD PHY_9/VDD VSUBS VSUBS gf180mcu_fd_sc_mcu7t5v0__xor3_1
X_6140_ _6140_/A1 _6140_/A2 _6276_/B _6145_/C PHY_9/VDD PHY_9/VDD VSUBS VSUBS gf180mcu_fd_sc_mcu7t5v0__aoi21_1
X_6071_ _9778_/Q _6288_/A2 _6288_/B1 _9823_/Q _6072_/A2 PHY_9/VDD PHY_9/VDD VSUBS
+ VSUBS gf180mcu_fd_sc_mcu7t5v0__aoi22_1
X_5022_ _9827_/Q _6662_/B2 PHY_9/VDD PHY_9/VDD VSUBS VSUBS gf180mcu_fd_sc_mcu7t5v0__clkinv_1
X_9830_ _9830_/D _9830_/CLK _9830_/Q PHY_9/VDD PHY_9/VDD VSUBS VSUBS gf180mcu_fd_sc_mcu7t5v0__dffq_1
X_9761_ _9761_/D _9939_/CLK _9761_/Q PHY_9/VDD PHY_9/VDD VSUBS VSUBS gf180mcu_fd_sc_mcu7t5v0__dffq_1
X_6973_ _9808_/Q _6991_/A2 _6975_/A2 PHY_9/VDD PHY_9/VDD VSUBS VSUBS gf180mcu_fd_sc_mcu7t5v0__nand2_1
X_9692_ _9692_/D _9939_/CLK _9692_/Q PHY_9/VDD PHY_9/VDD VSUBS VSUBS gf180mcu_fd_sc_mcu7t5v0__dffq_1
X_5924_ _5922_/Z _5924_/A2 _9666_/D PHY_9/VDD PHY_9/VDD VSUBS VSUBS gf180mcu_fd_sc_mcu7t5v0__nor2_1
X_8712_ _9953_/Q _9952_/Q _8719_/C PHY_9/VDD PHY_9/VDD VSUBS VSUBS gf180mcu_fd_sc_mcu7t5v0__nor2_4
X_8643_ _8602_/Z _8643_/A2 _8643_/B _8659_/A2 PHY_9/VDD PHY_9/VDD VSUBS VSUBS gf180mcu_fd_sc_mcu7t5v0__oai21_1
X_5855_ _9644_/Q _5832_/Z _9031_/B _5856_/B PHY_9/VDD PHY_9/VDD VSUBS VSUBS gf180mcu_fd_sc_mcu7t5v0__oai21_1
X_4806_ _9802_/Q _6376_/A3 PHY_9/VDD PHY_9/VDD VSUBS VSUBS gf180mcu_fd_sc_mcu7t5v0__clkinv_3
X_5786_ _8689_/A1 _5794_/A2 _5794_/B1 PHY_9/VDD PHY_9/VDD VSUBS VSUBS gf180mcu_fd_sc_mcu7t5v0__nand2_2
X_8574_ _8664_/A1 _8570_/Z _8587_/A2 PHY_9/VDD PHY_9/VDD VSUBS VSUBS gf180mcu_fd_sc_mcu7t5v0__nand2_1
X_7525_ _7475_/Z _7478_/Z _7524_/B _7525_/Z PHY_9/VDD PHY_9/VDD VSUBS VSUBS gf180mcu_fd_sc_mcu7t5v0__or3_1
X_4737_ _9373_/Q _5264_/A1 PHY_9/VDD PHY_9/VDD VSUBS VSUBS gf180mcu_fd_sc_mcu7t5v0__clkinv_1
X_7456_ _7553_/B _7604_/B1 _7500_/A2 PHY_9/VDD PHY_9/VDD VSUBS VSUBS gf180mcu_fd_sc_mcu7t5v0__nand2_2
X_6407_ _7379_/A3 _6414_/A2 _6407_/Z PHY_9/VDD PHY_9/VDD VSUBS VSUBS gf180mcu_fd_sc_mcu7t5v0__xor2_1
X_7387_ _9808_/Q _7382_/Z _7385_/Z _7388_/B PHY_9/VDD PHY_9/VDD VSUBS VSUBS gf180mcu_fd_sc_mcu7t5v0__xor3_1
X_9126_ _9314_/A1 _9191_/A1 _9126_/B1 _9126_/B2 _9127_/C PHY_9/VDD PHY_9/VDD VSUBS
+ VSUBS gf180mcu_fd_sc_mcu7t5v0__oai22_1
X_6338_ _9508_/Q _9034_/A2 _8706_/B _6339_/B PHY_9/VDD PHY_9/VDD VSUBS VSUBS gf180mcu_fd_sc_mcu7t5v0__oai21_1
X_6269_ _9885_/Q _6288_/A2 _6288_/B1 _9948_/Q _6270_/A2 PHY_9/VDD PHY_9/VDD VSUBS
+ VSUBS gf180mcu_fd_sc_mcu7t5v0__aoi22_1
X_9057_ _9313_/A2 _9128_/A2 _9354_/A1 PHY_9/VDD PHY_9/VDD VSUBS VSUBS gf180mcu_fd_sc_mcu7t5v0__nor2_4
X_8008_ _8008_/I0 _8008_/I1 _8008_/S _8009_/B PHY_9/VDD PHY_9/VDD VSUBS VSUBS gf180mcu_fd_sc_mcu7t5v0__mux2_1
X_9959_ _9959_/D _9974_/CLK _9959_/Q PHY_9/VDD PHY_9/VDD VSUBS VSUBS gf180mcu_fd_sc_mcu7t5v0__dffq_2
X_5640_ _8691_/A1 _5646_/A2 _5646_/B1 _5640_/B2 _9515_/D PHY_9/VDD PHY_9/VDD VSUBS
+ VSUBS gf180mcu_fd_sc_mcu7t5v0__oai22_1
X_5571_ _9489_/Q _5572_/A2 _9317_/C PHY_9/VDD PHY_9/VDD VSUBS VSUBS gf180mcu_fd_sc_mcu7t5v0__nor2_4
X_7310_ _7310_/A1 _7309_/Z _7310_/Z PHY_9/VDD PHY_9/VDD VSUBS VSUBS gf180mcu_fd_sc_mcu7t5v0__xor2_1
X_8290_ _9910_/Q _8306_/A1 _8287_/Z _8290_/Z PHY_9/VDD PHY_9/VDD VSUBS VSUBS gf180mcu_fd_sc_mcu7t5v0__xor3_1
X_7241_ _9807_/Q _7319_/A2 _7244_/A1 PHY_9/VDD PHY_9/VDD VSUBS VSUBS gf180mcu_fd_sc_mcu7t5v0__nand2_1
X_7172_ _7046_/Z _7172_/A2 _7172_/B _7174_/A2 PHY_9/VDD PHY_9/VDD VSUBS VSUBS gf180mcu_fd_sc_mcu7t5v0__oai21_1
X_6123_ _9609_/Q _6287_/A2 _6287_/B1 _9625_/Q _6125_/A1 PHY_9/VDD PHY_9/VDD VSUBS
+ VSUBS gf180mcu_fd_sc_mcu7t5v0__aoi22_1
X_6054_ _8692_/A1 _6059_/A2 _6059_/B1 _6054_/B2 _9764_/D PHY_9/VDD PHY_9/VDD VSUBS
+ VSUBS gf180mcu_fd_sc_mcu7t5v0__oai22_1
X_5005_ _9790_/Q _6310_/B2 PHY_9/VDD PHY_9/VDD VSUBS VSUBS gf180mcu_fd_sc_mcu7t5v0__clkinv_1
X_9813_ _9813_/D _9974_/CLK _9813_/Q PHY_9/VDD PHY_9/VDD VSUBS VSUBS gf180mcu_fd_sc_mcu7t5v0__dffq_4
X_9744_ _9744_/D _9939_/CLK _9744_/Q PHY_9/VDD PHY_9/VDD VSUBS VSUBS gf180mcu_fd_sc_mcu7t5v0__dffq_1
X_6956_ _6997_/B2 _6956_/A2 _6956_/B _6957_/B PHY_9/VDD PHY_9/VDD VSUBS VSUBS gf180mcu_fd_sc_mcu7t5v0__oai21_1
X_5907_ _5907_/A1 _5905_/Z _5907_/A3 _9661_/D PHY_9/VDD PHY_9/VDD VSUBS VSUBS gf180mcu_fd_sc_mcu7t5v0__nor3_1
X_6887_ _6911_/B2 _6886_/Z _6887_/Z PHY_9/VDD PHY_9/VDD VSUBS VSUBS gf180mcu_fd_sc_mcu7t5v0__xor2_1
X_9675_ _9675_/D _9972_/CLK _9675_/Q PHY_9/VDD PHY_9/VDD VSUBS VSUBS gf180mcu_fd_sc_mcu7t5v0__dffq_1
X_5838_ _9642_/Q _9523_/Q _5840_/A2 PHY_9/VDD PHY_9/VDD VSUBS VSUBS gf180mcu_fd_sc_mcu7t5v0__nand2_1
X_8626_ _8444_/B _8644_/A2 _8626_/B _8670_/A1 PHY_9/VDD PHY_9/VDD VSUBS VSUBS gf180mcu_fd_sc_mcu7t5v0__aoi21_1
X_5769_ _5406_/Z _5769_/A2 _5769_/B1 _5769_/B2 _9597_/D PHY_9/VDD PHY_9/VDD VSUBS
+ VSUBS gf180mcu_fd_sc_mcu7t5v0__oai22_1
X_8557_ _9812_/Q _8654_/A2 _8652_/A1 PHY_9/VDD PHY_9/VDD VSUBS VSUBS gf180mcu_fd_sc_mcu7t5v0__nand2_1
X_7508_ _7463_/Z _7561_/A1 _7505_/Z _7510_/A2 PHY_9/VDD PHY_9/VDD VSUBS VSUBS gf180mcu_fd_sc_mcu7t5v0__xnor3_1
X_8488_ _9810_/Q _8645_/A2 _8488_/Z PHY_9/VDD PHY_9/VDD VSUBS VSUBS gf180mcu_fd_sc_mcu7t5v0__and2_1
X_7439_ _7439_/A1 _7439_/A2 _7439_/B _7440_/B PHY_9/VDD PHY_9/VDD VSUBS VSUBS gf180mcu_fd_sc_mcu7t5v0__oai21_1
X_9109_ _9109_/A1 _9142_/A1 _9109_/A3 _9109_/Z PHY_9/VDD PHY_9/VDD VSUBS VSUBS gf180mcu_fd_sc_mcu7t5v0__xor3_1
X_6810_ _6700_/C _6794_/Z _6810_/B _9317_/C _6811_/A2 PHY_9/VDD PHY_9/VDD VSUBS VSUBS
+ gf180mcu_fd_sc_mcu7t5v0__oai211_1
X_7790_ _9809_/Q _7771_/Z _7790_/Z PHY_9/VDD PHY_9/VDD VSUBS VSUBS gf180mcu_fd_sc_mcu7t5v0__and2_1
X_6741_ _9807_/Q _6974_/A2 _6741_/Z PHY_9/VDD PHY_9/VDD VSUBS VSUBS gf180mcu_fd_sc_mcu7t5v0__and2_1
X_6672_ _9396_/Q _9036_/A2 _8027_/B _6673_/B PHY_9/VDD PHY_9/VDD VSUBS VSUBS gf180mcu_fd_sc_mcu7t5v0__oai21_1
X_9460_ _9460_/D _9901_/CLK _9460_/Q PHY_9/VDD PHY_9/VDD VSUBS VSUBS gf180mcu_fd_sc_mcu7t5v0__dffq_4
X_9391_ _9391_/D _9901_/CLK _9391_/Q PHY_9/VDD PHY_9/VDD VSUBS VSUBS gf180mcu_fd_sc_mcu7t5v0__dffq_1
X_8411_ _9808_/Q _8606_/A2 _8420_/B1 PHY_9/VDD PHY_9/VDD VSUBS VSUBS gf180mcu_fd_sc_mcu7t5v0__nor2_1
X_5623_ _9774_/Q _5561_/I _5625_/A1 PHY_9/VDD PHY_9/VDD VSUBS VSUBS gf180mcu_fd_sc_mcu7t5v0__nand2_1
X_8342_ _8330_/B _8342_/A2 _9356_/C _8343_/B2 PHY_9/VDD PHY_9/VDD VSUBS VSUBS gf180mcu_fd_sc_mcu7t5v0__aoi21_1
X_5554_ _8693_/A1 _5558_/A2 _5558_/B1 _5554_/B2 _9484_/D PHY_9/VDD PHY_9/VDD VSUBS
+ VSUBS gf180mcu_fd_sc_mcu7t5v0__oai22_1
X_8273_ _6613_/B _8075_/B _8310_/A1 PHY_9/VDD PHY_9/VDD VSUBS VSUBS gf180mcu_fd_sc_mcu7t5v0__nor2_1
X_5485_ _9454_/Q _5493_/B _5770_/B _5486_/B PHY_9/VDD PHY_9/VDD VSUBS VSUBS gf180mcu_fd_sc_mcu7t5v0__oai21_1
X_7224_ _7303_/A2 _7273_/B _7224_/Z PHY_9/VDD PHY_9/VDD VSUBS VSUBS gf180mcu_fd_sc_mcu7t5v0__xor2_1
X_7155_ _9811_/Q _7254_/A2 _7208_/A1 PHY_9/VDD PHY_9/VDD VSUBS VSUBS gf180mcu_fd_sc_mcu7t5v0__nand2_1
X_6106_ _9699_/Q _6287_/A2 _6287_/B1 _9600_/Q _6108_/A1 PHY_9/VDD PHY_9/VDD VSUBS
+ VSUBS gf180mcu_fd_sc_mcu7t5v0__aoi22_1
X_7086_ _9851_/Q _7101_/A2 _7106_/A2 PHY_9/VDD PHY_9/VDD VSUBS VSUBS gf180mcu_fd_sc_mcu7t5v0__nor2_1
X_6037_ _8695_/A1 _6039_/A2 _6039_/B1 _6037_/B2 _9751_/D PHY_9/VDD PHY_9/VDD VSUBS
+ VSUBS gf180mcu_fd_sc_mcu7t5v0__oai22_1
X_7988_ _6558_/B _7988_/A2 _7988_/A3 _7988_/B1 _7988_/B2 _7990_/A2 PHY_9/VDD PHY_9/VDD
+ VSUBS VSUBS gf180mcu_fd_sc_mcu7t5v0__oai32_1
X_6939_ _6939_/A1 _6937_/Z _6939_/Z PHY_9/VDD PHY_9/VDD VSUBS VSUBS gf180mcu_fd_sc_mcu7t5v0__xor2_1
X_9727_ _9727_/D _9800_/CLK _9727_/Q PHY_9/VDD PHY_9/VDD VSUBS VSUBS gf180mcu_fd_sc_mcu7t5v0__dffq_1
X_9658_ _9658_/D _9689_/CLK _9658_/Q PHY_9/VDD PHY_9/VDD VSUBS VSUBS gf180mcu_fd_sc_mcu7t5v0__dffq_1
X_8609_ _8611_/A2 _8611_/A3 _8643_/B PHY_9/VDD PHY_9/VDD VSUBS VSUBS gf180mcu_fd_sc_mcu7t5v0__nand2_1
X_9589_ _9589_/D _9939_/CLK _9589_/Q PHY_9/VDD PHY_9/VDD VSUBS VSUBS gf180mcu_fd_sc_mcu7t5v0__dffq_1
X_5270_ _5270_/A1 _5272_/A2 _5270_/B _9376_/D PHY_9/VDD PHY_9/VDD VSUBS VSUBS gf180mcu_fd_sc_mcu7t5v0__aoi21_1
X_8960_ _8959_/B _8960_/A2 _8960_/A3 _8960_/Z PHY_9/VDD PHY_9/VDD VSUBS VSUBS gf180mcu_fd_sc_mcu7t5v0__xor3_1
X_7911_ _9896_/Q _7930_/A1 _7912_/A2 _7911_/Z PHY_9/VDD PHY_9/VDD VSUBS VSUBS gf180mcu_fd_sc_mcu7t5v0__xor3_1
X_8891_ _9959_/Q _9356_/C _8939_/A1 PHY_9/VDD PHY_9/VDD VSUBS VSUBS gf180mcu_fd_sc_mcu7t5v0__nand2_1
X_7842_ _7842_/I _7882_/A1 PHY_9/VDD PHY_9/VDD VSUBS VSUBS gf180mcu_fd_sc_mcu7t5v0__clkinv_1
X_4985_ _9626_/Q _5810_/B2 PHY_9/VDD PHY_9/VDD VSUBS VSUBS gf180mcu_fd_sc_mcu7t5v0__clkinv_1
X_7773_ _9227_/A1 _7988_/A2 _7777_/A3 PHY_9/VDD PHY_9/VDD VSUBS VSUBS gf180mcu_fd_sc_mcu7t5v0__nor2_1
X_6724_ _9808_/Q _6724_/A2 _6710_/Z _6748_/A1 PHY_9/VDD PHY_9/VDD VSUBS VSUBS gf180mcu_fd_sc_mcu7t5v0__nand3_2
X_9512_ _9512_/D _9974_/CLK _9512_/Q PHY_9/VDD PHY_9/VDD VSUBS VSUBS gf180mcu_fd_sc_mcu7t5v0__dffq_2
X_9443_ _9443_/D _9800_/CLK _9443_/Q PHY_9/VDD PHY_9/VDD VSUBS VSUBS gf180mcu_fd_sc_mcu7t5v0__dffq_1
X_6655_ _7651_/A1 _9356_/C _9357_/B _6655_/C _9822_/D PHY_9/VDD PHY_9/VDD VSUBS VSUBS
+ gf180mcu_fd_sc_mcu7t5v0__aoi211_1
X_6586_ _6635_/B2 _6585_/Z _6586_/Z PHY_9/VDD PHY_9/VDD VSUBS VSUBS gf180mcu_fd_sc_mcu7t5v0__xor2_1
X_5606_ _5606_/A1 _9036_/A2 _5606_/B _9503_/D PHY_9/VDD PHY_9/VDD VSUBS VSUBS gf180mcu_fd_sc_mcu7t5v0__aoi21_1
X_9374_ _9374_/D _9901_/CLK _9374_/Q PHY_9/VDD PHY_9/VDD VSUBS VSUBS gf180mcu_fd_sc_mcu7t5v0__dffq_1
X_8325_ _8325_/A1 _8322_/Z _8324_/Z _8325_/Z PHY_9/VDD PHY_9/VDD VSUBS VSUBS gf180mcu_fd_sc_mcu7t5v0__xor3_1
X_5537_ _9446_/Q _5525_/Z _5544_/A2 _9473_/Q _5538_/A2 PHY_9/VDD PHY_9/VDD VSUBS VSUBS
+ gf180mcu_fd_sc_mcu7t5v0__aoi22_1
X_8256_ _8256_/A1 _8256_/A2 _8256_/A3 _8256_/B1 _8256_/B2 _8284_/A1 PHY_9/VDD PHY_9/VDD
+ VSUBS VSUBS gf180mcu_fd_sc_mcu7t5v0__oai32_2
X_7207_ _7208_/A2 _7258_/A1 _7206_/Z _7258_/A2 PHY_9/VDD PHY_9/VDD VSUBS VSUBS gf180mcu_fd_sc_mcu7t5v0__nor3_2
X_5468_ _9446_/Q _5495_/B _5474_/B _5469_/B PHY_9/VDD PHY_9/VDD VSUBS VSUBS gf180mcu_fd_sc_mcu7t5v0__oai21_1
X_5399_ _9221_/A1 _5853_/A1 _5559_/B _5399_/Z PHY_9/VDD PHY_9/VDD VSUBS VSUBS gf180mcu_fd_sc_mcu7t5v0__mux2_4
X_8187_ _9908_/Q _8186_/Z _8209_/B PHY_9/VDD PHY_9/VDD VSUBS VSUBS gf180mcu_fd_sc_mcu7t5v0__and2_1
X_7138_ _7281_/A1 _7250_/A1 _7138_/B1 _7138_/B2 _7138_/C _7139_/B PHY_9/VDD PHY_9/VDD
+ VSUBS VSUBS gf180mcu_fd_sc_mcu7t5v0__oai221_1
X_7069_ _9850_/Q _7069_/A2 _7062_/Z _7070_/A2 PHY_9/VDD PHY_9/VDD VSUBS VSUBS gf180mcu_fd_sc_mcu7t5v0__xnor3_1
X_4770_ _9846_/Q _7036_/A1 PHY_9/VDD PHY_9/VDD VSUBS VSUBS gf180mcu_fd_sc_mcu7t5v0__clkinv_4
X_6440_ _6651_/A1 _6440_/A2 _6440_/B _6440_/C _6441_/B2 PHY_9/VDD PHY_9/VDD VSUBS
+ VSUBS gf180mcu_fd_sc_mcu7t5v0__oai211_1
X_6371_ _6648_/A1 _6649_/B _6474_/A2 PHY_9/VDD PHY_9/VDD VSUBS VSUBS gf180mcu_fd_sc_mcu7t5v0__nor2_2
X_5322_ _9398_/Q _5331_/A2 _5323_/B PHY_9/VDD PHY_9/VDD VSUBS VSUBS gf180mcu_fd_sc_mcu7t5v0__nor2_1
X_8110_ _8309_/A2 _8075_/B _8110_/B _8111_/A2 PHY_9/VDD PHY_9/VDD VSUBS VSUBS gf180mcu_fd_sc_mcu7t5v0__aoi21_1
X_9090_ _9090_/A1 _9270_/B _9090_/B1 _9090_/B2 _9090_/C _9093_/A1 PHY_9/VDD PHY_9/VDD
+ VSUBS VSUBS gf180mcu_fd_sc_mcu7t5v0__aoi221_4
X_5253_ _9461_/Q _5260_/A2 rst_n _5254_/B PHY_9/VDD PHY_9/VDD VSUBS VSUBS gf180mcu_fd_sc_mcu7t5v0__oai21_1
X_8041_ _9090_/C _8309_/A2 _8086_/A1 PHY_9/VDD PHY_9/VDD VSUBS VSUBS gf180mcu_fd_sc_mcu7t5v0__nor2_2
X_5184_ _9650_/Q _9649_/Q _9648_/Q _5185_/A2 PHY_9/VDD PHY_9/VDD VSUBS VSUBS gf180mcu_fd_sc_mcu7t5v0__nand3_1
X_8943_ _8994_/A1 _9897_/Q _8717_/Z _9973_/Q _8944_/B2 PHY_9/VDD PHY_9/VDD VSUBS VSUBS
+ gf180mcu_fd_sc_mcu7t5v0__aoi22_2
X_8874_ _8734_/I _8868_/Z _8888_/C PHY_9/VDD PHY_9/VDD VSUBS VSUBS gf180mcu_fd_sc_mcu7t5v0__nand2_1
X_7825_ _7977_/A1 _7825_/A2 _7832_/B1 PHY_9/VDD PHY_9/VDD VSUBS VSUBS gf180mcu_fd_sc_mcu7t5v0__nand2_1
X_4968_ _9585_/Q _5755_/B2 PHY_9/VDD PHY_9/VDD VSUBS VSUBS gf180mcu_fd_sc_mcu7t5v0__clkinv_1
X_7756_ _9090_/C _7988_/A2 _7776_/B _7814_/A1 PHY_9/VDD PHY_9/VDD VSUBS VSUBS gf180mcu_fd_sc_mcu7t5v0__nor3_4
X_4899_ _9698_/Q _5991_/B2 PHY_9/VDD PHY_9/VDD VSUBS VSUBS gf180mcu_fd_sc_mcu7t5v0__clkinv_1
X_6707_ _9892_/Q _9835_/Q _6709_/A2 PHY_9/VDD PHY_9/VDD VSUBS VSUBS gf180mcu_fd_sc_mcu7t5v0__nor2_1
X_7687_ _9378_/Q _9034_/A2 _7695_/B _7688_/B PHY_9/VDD PHY_9/VDD VSUBS VSUBS gf180mcu_fd_sc_mcu7t5v0__oai21_1
X_6638_ _6638_/A1 _6638_/A2 _6637_/Z _6638_/Z PHY_9/VDD PHY_9/VDD VSUBS VSUBS gf180mcu_fd_sc_mcu7t5v0__xor3_1
X_9426_ _9426_/D _9901_/CLK _9426_/Q PHY_9/VDD PHY_9/VDD VSUBS VSUBS gf180mcu_fd_sc_mcu7t5v0__dffq_1
X_9357_ _9357_/A1 _9356_/C _9357_/B _9357_/C _9974_/D PHY_9/VDD PHY_9/VDD VSUBS VSUBS
+ gf180mcu_fd_sc_mcu7t5v0__aoi211_1
X_6569_ _9876_/Q _6569_/A2 _6570_/A2 PHY_9/VDD PHY_9/VDD VSUBS VSUBS gf180mcu_fd_sc_mcu7t5v0__nand2_1
X_8308_ _9812_/Q _8097_/Z _8312_/A2 PHY_9/VDD PHY_9/VDD VSUBS VSUBS gf180mcu_fd_sc_mcu7t5v0__nand2_1
X_9288_ _9282_/I _9287_/Z _9290_/A2 PHY_9/VDD PHY_9/VDD VSUBS VSUBS gf180mcu_fd_sc_mcu7t5v0__xnor2_1
X_8239_ _8291_/A1 _8234_/Z _8251_/C PHY_9/VDD PHY_9/VDD VSUBS VSUBS gf180mcu_fd_sc_mcu7t5v0__nand2_1
Xrepeater9 _9035_/B _8027_/B PHY_9/VDD PHY_9/VDD VSUBS VSUBS gf180mcu_fd_sc_mcu7t5v0__buf_8
X_5940_ _9681_/Q _5951_/A2 _5961_/B _5941_/B PHY_9/VDD PHY_9/VDD VSUBS VSUBS gf180mcu_fd_sc_mcu7t5v0__oai21_1
X_5871_ _9648_/Q _5871_/A2 _5871_/A3 _5871_/Z PHY_9/VDD PHY_9/VDD VSUBS VSUBS gf180mcu_fd_sc_mcu7t5v0__and3_1
X_7610_ _7601_/Z _7608_/Z _7610_/Z PHY_9/VDD PHY_9/VDD VSUBS VSUBS gf180mcu_fd_sc_mcu7t5v0__xor2_1
X_4822_ _9673_/Q _5941_/A1 PHY_9/VDD PHY_9/VDD VSUBS VSUBS gf180mcu_fd_sc_mcu7t5v0__clkinv_1
X_8590_ _8590_/A1 _8572_/Z _8590_/B _8640_/A1 PHY_9/VDD PHY_9/VDD VSUBS VSUBS gf180mcu_fd_sc_mcu7t5v0__aoi21_1
X_7541_ _7435_/Z _7541_/A2 _7541_/B _7544_/A3 PHY_9/VDD PHY_9/VDD VSUBS VSUBS gf180mcu_fd_sc_mcu7t5v0__aoi21_2
X_4753_ _9872_/Q _8430_/A1 PHY_9/VDD PHY_9/VDD VSUBS VSUBS gf180mcu_fd_sc_mcu7t5v0__clkinv_3
X_7472_ _7472_/A1 _7472_/A2 _7472_/B _7478_/A1 PHY_9/VDD PHY_9/VDD VSUBS VSUBS gf180mcu_fd_sc_mcu7t5v0__oai21_1
X_6423_ _6423_/A1 _6421_/Z _6440_/A2 PHY_9/VDD PHY_9/VDD VSUBS VSUBS gf180mcu_fd_sc_mcu7t5v0__xnor2_1
X_9211_ _9354_/A1 _9211_/A2 _9211_/A3 _9217_/C PHY_9/VDD PHY_9/VDD VSUBS VSUBS gf180mcu_fd_sc_mcu7t5v0__nand3_1
X_4684_ _9362_/Q _5236_/A1 PHY_9/VDD PHY_9/VDD VSUBS VSUBS gf180mcu_fd_sc_mcu7t5v0__clkinv_1
X_6354_ _9836_/Q _6350_/Z _6569_/A2 _9870_/Q _6583_/A3 PHY_9/VDD PHY_9/VDD VSUBS VSUBS
+ gf180mcu_fd_sc_mcu7t5v0__aoi22_4
X_9142_ _9142_/A1 _9142_/A2 _9142_/B _9153_/A2 PHY_9/VDD PHY_9/VDD VSUBS VSUBS gf180mcu_fd_sc_mcu7t5v0__oai21_1
X_6285_ _9425_/Q _6288_/A2 _6287_/A2 _9573_/Q _6286_/A2 PHY_9/VDD PHY_9/VDD VSUBS
+ VSUBS gf180mcu_fd_sc_mcu7t5v0__aoi22_1
X_5305_ _5396_/A1 _5307_/A2 _5305_/B _5973_/C _9391_/D PHY_9/VDD PHY_9/VDD VSUBS VSUBS
+ gf180mcu_fd_sc_mcu7t5v0__aoi211_1
X_9073_ _9327_/A1 _9965_/Q _9905_/Q _9090_/B1 PHY_9/VDD PHY_9/VDD VSUBS VSUBS gf180mcu_fd_sc_mcu7t5v0__nand3_4
X_8024_ _8057_/A1 _9036_/A2 _8024_/B _9901_/D PHY_9/VDD PHY_9/VDD VSUBS VSUBS gf180mcu_fd_sc_mcu7t5v0__aoi21_1
X_5236_ _5236_/A1 _5236_/A2 _5236_/B _9362_/D PHY_9/VDD PHY_9/VDD VSUBS VSUBS gf180mcu_fd_sc_mcu7t5v0__aoi21_1
X_5167_ _9660_/Q _5900_/A1 _5167_/A3 _5166_/Z _5170_/A2 PHY_9/VDD PHY_9/VDD VSUBS
+ VSUBS gf180mcu_fd_sc_mcu7t5v0__nand4_1
X_5098_ _9557_/Q _5715_/B2 PHY_9/VDD PHY_9/VDD VSUBS VSUBS gf180mcu_fd_sc_mcu7t5v0__clkinv_1
X_8926_ _8926_/I _8976_/B PHY_9/VDD PHY_9/VDD VSUBS VSUBS gf180mcu_fd_sc_mcu7t5v0__clkinv_1
X_8857_ _8857_/A1 _8857_/A2 _9811_/Q _8857_/C _8858_/B PHY_9/VDD PHY_9/VDD VSUBS VSUBS
+ gf180mcu_fd_sc_mcu7t5v0__oai211_4
X_8788_ _9227_/A1 _8752_/I _8821_/A1 PHY_9/VDD PHY_9/VDD VSUBS VSUBS gf180mcu_fd_sc_mcu7t5v0__nor2_1
X_7808_ _9808_/Q _7771_/Z _7806_/Z _7808_/A4 _7852_/A2 PHY_9/VDD PHY_9/VDD VSUBS VSUBS
+ gf180mcu_fd_sc_mcu7t5v0__nand4_2
X_7739_ _9889_/Q _7739_/A2 _7739_/B _7739_/C _7805_/A2 PHY_9/VDD PHY_9/VDD VSUBS VSUBS
+ gf180mcu_fd_sc_mcu7t5v0__oai211_4
X_9409_ _9409_/D _9901_/CLK _9409_/Q PHY_9/VDD PHY_9/VDD VSUBS VSUBS gf180mcu_fd_sc_mcu7t5v0__dffq_1
X_6070_ _9794_/Q _6287_/A2 _6287_/B1 _9558_/Q _6072_/A1 PHY_9/VDD PHY_9/VDD VSUBS
+ VSUBS gf180mcu_fd_sc_mcu7t5v0__aoi22_1
X_5021_ _9861_/Q _7333_/B2 PHY_9/VDD PHY_9/VDD VSUBS VSUBS gf180mcu_fd_sc_mcu7t5v0__clkinv_1
X_9760_ _9760_/D _9939_/CLK _9760_/Q PHY_9/VDD PHY_9/VDD VSUBS VSUBS gf180mcu_fd_sc_mcu7t5v0__dffq_1
X_6972_ _9807_/Q _6998_/A2 _6975_/A1 PHY_9/VDD PHY_9/VDD VSUBS VSUBS gf180mcu_fd_sc_mcu7t5v0__nand2_1
X_8711_ _8768_/A1 _9807_/Q _8711_/B _8738_/C PHY_9/VDD PHY_9/VDD VSUBS VSUBS gf180mcu_fd_sc_mcu7t5v0__oai21_1
X_9691_ _9691_/D _9939_/CLK _9691_/Q PHY_9/VDD PHY_9/VDD VSUBS VSUBS gf180mcu_fd_sc_mcu7t5v0__dffq_1
X_5923_ _9666_/Q _5919_/Z _5932_/B _5924_/A2 PHY_9/VDD PHY_9/VDD VSUBS VSUBS gf180mcu_fd_sc_mcu7t5v0__oai21_1
X_8642_ _8597_/Z _8642_/A2 _8642_/B _8659_/A1 PHY_9/VDD PHY_9/VDD VSUBS VSUBS gf180mcu_fd_sc_mcu7t5v0__aoi21_1
X_5854_ _9645_/Q _9523_/Q _5854_/B _5856_/A2 PHY_9/VDD PHY_9/VDD VSUBS VSUBS gf180mcu_fd_sc_mcu7t5v0__aoi21_1
X_4805_ _9803_/Q _6389_/A2 PHY_9/VDD PHY_9/VDD VSUBS VSUBS gf180mcu_fd_sc_mcu7t5v0__clkinv_2
X_8573_ _8590_/A1 _8572_/Z _8573_/Z PHY_9/VDD PHY_9/VDD VSUBS VSUBS gf180mcu_fd_sc_mcu7t5v0__xor2_1
X_5785_ _8344_/A1 _6291_/B2 _5794_/A2 PHY_9/VDD PHY_9/VDD VSUBS VSUBS gf180mcu_fd_sc_mcu7t5v0__nand2_4
X_7524_ _7475_/Z _7478_/Z _7524_/B _7576_/A2 PHY_9/VDD PHY_9/VDD VSUBS VSUBS gf180mcu_fd_sc_mcu7t5v0__oai21_1
X_4736_ _9899_/Q _8058_/A3 PHY_9/VDD PHY_9/VDD VSUBS VSUBS gf180mcu_fd_sc_mcu7t5v0__clkinv_3
X_7455_ _9869_/Q _9868_/Q _7650_/B1 PHY_9/VDD PHY_9/VDD VSUBS VSUBS gf180mcu_fd_sc_mcu7t5v0__nor2_4
X_6406_ _6406_/A1 _6406_/A2 _6414_/A2 _6651_/A1 _6406_/C _6410_/A2 PHY_9/VDD PHY_9/VDD
+ VSUBS VSUBS gf180mcu_fd_sc_mcu7t5v0__oai221_1
X_7386_ _7382_/Z _7385_/Z _7428_/A2 PHY_9/VDD PHY_9/VDD VSUBS VSUBS gf180mcu_fd_sc_mcu7t5v0__xnor2_1
X_9125_ _9347_/I1 _9191_/A1 _9348_/C _9126_/B1 PHY_9/VDD PHY_9/VDD VSUBS VSUBS gf180mcu_fd_sc_mcu7t5v0__aoi21_1
X_6337_ _9091_/B _9034_/A2 _6337_/B _9808_/D PHY_9/VDD PHY_9/VDD VSUBS VSUBS gf180mcu_fd_sc_mcu7t5v0__aoi21_1
X_6268_ _9919_/Q _6287_/A2 _6287_/B1 _9864_/Q _6270_/A1 PHY_9/VDD PHY_9/VDD VSUBS
+ VSUBS gf180mcu_fd_sc_mcu7t5v0__aoi22_1
X_9056_ _9168_/A2 _9314_/A1 _9128_/A2 PHY_9/VDD PHY_9/VDD VSUBS VSUBS gf180mcu_fd_sc_mcu7t5v0__nand2_1
X_6199_ _9758_/Q _6287_/A2 _6287_/B1 _9742_/Q _6201_/A1 PHY_9/VDD PHY_9/VDD VSUBS
+ VSUBS gf180mcu_fd_sc_mcu7t5v0__aoi22_1
X_5219_ _5219_/A1 _5222_/A3 _9732_/D PHY_9/VDD PHY_9/VDD VSUBS VSUBS gf180mcu_fd_sc_mcu7t5v0__nor2_1
X_8007_ _9814_/Q _8013_/A2 _8008_/S PHY_9/VDD PHY_9/VDD VSUBS VSUBS gf180mcu_fd_sc_mcu7t5v0__nand2_1
X_9958_ _9958_/D _9974_/CLK _9958_/Q PHY_9/VDD PHY_9/VDD VSUBS VSUBS gf180mcu_fd_sc_mcu7t5v0__dffq_2
X_8909_ _9812_/Q _9004_/A2 _8909_/B _8955_/A3 PHY_9/VDD PHY_9/VDD VSUBS VSUBS gf180mcu_fd_sc_mcu7t5v0__aoi21_1
X_9889_ _9889_/D _9957_/CLK _9889_/Q PHY_9/VDD PHY_9/VDD VSUBS VSUBS gf180mcu_fd_sc_mcu7t5v0__dffq_4
X_5570_ _9491_/Q _5575_/A3 _5591_/A2 PHY_9/VDD PHY_9/VDD VSUBS VSUBS gf180mcu_fd_sc_mcu7t5v0__nor2_4
X_7240_ _7240_/A1 _7240_/A2 _7319_/A2 PHY_9/VDD PHY_9/VDD VSUBS VSUBS gf180mcu_fd_sc_mcu7t5v0__nand2_2
X_7171_ _7089_/B _7293_/A2 _7172_/B PHY_9/VDD PHY_9/VDD VSUBS VSUBS gf180mcu_fd_sc_mcu7t5v0__nand2_1
X_6122_ _6122_/A1 _6122_/A2 _6286_/B _6146_/C PHY_9/VDD PHY_9/VDD VSUBS VSUBS gf180mcu_fd_sc_mcu7t5v0__aoi21_2
X_6053_ _8691_/A1 _6059_/A2 _6059_/B1 _6053_/B2 _9763_/D PHY_9/VDD PHY_9/VDD VSUBS
+ VSUBS gf180mcu_fd_sc_mcu7t5v0__oai22_1
X_5004_ _9422_/Q _5400_/A1 PHY_9/VDD PHY_9/VDD VSUBS VSUBS gf180mcu_fd_sc_mcu7t5v0__clkinv_1
X_9812_ _9812_/D _9974_/CLK _9812_/Q PHY_9/VDD PHY_9/VDD VSUBS VSUBS gf180mcu_fd_sc_mcu7t5v0__dffq_4
X_9743_ _9743_/D _9939_/CLK _9743_/Q PHY_9/VDD PHY_9/VDD VSUBS VSUBS gf180mcu_fd_sc_mcu7t5v0__dffq_1
X_6955_ _9813_/Q _6696_/B _6956_/A2 _6996_/A1 _6955_/C _6956_/B PHY_9/VDD PHY_9/VDD
+ VSUBS VSUBS gf180mcu_fd_sc_mcu7t5v0__aoi221_1
X_5906_ _9660_/Q _5906_/A2 _9661_/Q _5907_/A3 PHY_9/VDD PHY_9/VDD VSUBS VSUBS gf180mcu_fd_sc_mcu7t5v0__aoi21_1
X_9674_ _9674_/D _9972_/CLK _9674_/Q PHY_9/VDD PHY_9/VDD VSUBS VSUBS gf180mcu_fd_sc_mcu7t5v0__dffq_1
X_6886_ _6911_/A1 _6886_/A2 _6886_/A3 _6886_/Z PHY_9/VDD PHY_9/VDD VSUBS VSUBS gf180mcu_fd_sc_mcu7t5v0__xor3_1
X_8625_ _9812_/Q _8625_/A2 _8625_/B _8665_/A1 PHY_9/VDD PHY_9/VDD VSUBS VSUBS gf180mcu_fd_sc_mcu7t5v0__aoi21_1
X_5837_ _5837_/A1 _5837_/A2 _9640_/D PHY_9/VDD PHY_9/VDD VSUBS VSUBS gf180mcu_fd_sc_mcu7t5v0__nor2_1
X_5768_ _5404_/Z _5769_/A2 _5769_/B1 _5768_/B2 _9596_/D PHY_9/VDD PHY_9/VDD VSUBS
+ VSUBS gf180mcu_fd_sc_mcu7t5v0__oai22_1
X_8556_ _9810_/Q _8653_/A2 _8603_/B2 PHY_9/VDD PHY_9/VDD VSUBS VSUBS gf180mcu_fd_sc_mcu7t5v0__nand2_1
X_7507_ _7561_/A1 _7505_/Z _7562_/A1 PHY_9/VDD PHY_9/VDD VSUBS VSUBS gf180mcu_fd_sc_mcu7t5v0__nor2_1
X_4719_ _9922_/Q _8389_/A1 PHY_9/VDD PHY_9/VDD VSUBS VSUBS gf180mcu_fd_sc_mcu7t5v0__inv_2
X_8487_ _8664_/A1 _8487_/A2 _8492_/A1 PHY_9/VDD PHY_9/VDD VSUBS VSUBS gf180mcu_fd_sc_mcu7t5v0__nand2_1
X_7438_ _9809_/Q _7668_/A2 _7435_/Z _7667_/I0 _7482_/B _7439_/B PHY_9/VDD PHY_9/VDD
+ VSUBS VSUBS gf180mcu_fd_sc_mcu7t5v0__aoi221_1
X_5699_ _9548_/Q _5696_/Z _5702_/A2 PHY_9/VDD PHY_9/VDD VSUBS VSUBS gf180mcu_fd_sc_mcu7t5v0__nand2_1
X_7369_ _7369_/A1 _7674_/C2 _7369_/B _7372_/B2 PHY_9/VDD PHY_9/VDD VSUBS VSUBS gf180mcu_fd_sc_mcu7t5v0__aoi21_1
X_9108_ _9809_/Q _9331_/A2 _9285_/A2 _9808_/Q _9142_/A2 PHY_9/VDD PHY_9/VDD VSUBS
+ VSUBS gf180mcu_fd_sc_mcu7t5v0__aoi22_1
X_9039_ _9964_/Q _9214_/A1 _9348_/C PHY_9/VDD PHY_9/VDD VSUBS VSUBS gf180mcu_fd_sc_mcu7t5v0__nor2_2
X_6740_ _6740_/A1 _6970_/A2 _6740_/B1 _6740_/B2 _6974_/A2 PHY_9/VDD PHY_9/VDD VSUBS
+ VSUBS gf180mcu_fd_sc_mcu7t5v0__aoi22_4
X_6671_ _6698_/A1 _9036_/A2 _6671_/B _9833_/D PHY_9/VDD PHY_9/VDD VSUBS VSUBS gf180mcu_fd_sc_mcu7t5v0__aoi21_1
X_9390_ _9390_/D _9856_/CLK _9390_/Q PHY_9/VDD PHY_9/VDD VSUBS VSUBS gf180mcu_fd_sc_mcu7t5v0__dffq_1
X_8410_ _8380_/Z _8449_/A2 _8420_/A2 PHY_9/VDD PHY_9/VDD VSUBS VSUBS gf180mcu_fd_sc_mcu7t5v0__nand2_1
X_5622_ _5622_/A1 _5622_/A2 _5973_/C _9509_/D PHY_9/VDD PHY_9/VDD VSUBS VSUBS gf180mcu_fd_sc_mcu7t5v0__aoi21_1
X_5553_ _8692_/A1 _5558_/A2 _5558_/B1 _5553_/B2 _9483_/D PHY_9/VDD PHY_9/VDD VSUBS
+ VSUBS gf180mcu_fd_sc_mcu7t5v0__oai22_1
X_8341_ _8341_/A1 _8328_/Z _8336_/Z _8199_/B _8341_/C _8342_/A2 PHY_9/VDD PHY_9/VDD
+ VSUBS VSUBS gf180mcu_fd_sc_mcu7t5v0__oai221_1
X_8272_ _6613_/B _8309_/A2 _8276_/A3 PHY_9/VDD PHY_9/VDD VSUBS VSUBS gf180mcu_fd_sc_mcu7t5v0__nor2_1
X_5484_ _5484_/A1 _5493_/B _5484_/B _9453_/D PHY_9/VDD PHY_9/VDD VSUBS VSUBS gf180mcu_fd_sc_mcu7t5v0__aoi21_1
X_7223_ _7046_/Z _7223_/A2 _7273_/B PHY_9/VDD PHY_9/VDD VSUBS VSUBS gf180mcu_fd_sc_mcu7t5v0__nor2_2
X_7154_ _9811_/Q _7019_/I _7254_/A2 _9810_/Q _7157_/A2 PHY_9/VDD PHY_9/VDD VSUBS VSUBS
+ gf180mcu_fd_sc_mcu7t5v0__aoi22_1
X_6105_ _6105_/A1 _6105_/A2 _6276_/B _6117_/C PHY_9/VDD PHY_9/VDD VSUBS VSUBS gf180mcu_fd_sc_mcu7t5v0__aoi21_1
X_7085_ _7085_/A1 _7085_/A2 _7101_/A2 PHY_9/VDD PHY_9/VDD VSUBS VSUBS gf180mcu_fd_sc_mcu7t5v0__xnor2_1
X_6036_ _5399_/Z _6039_/A2 _6039_/B1 _6036_/B2 _9750_/D PHY_9/VDD PHY_9/VDD VSUBS
+ VSUBS gf180mcu_fd_sc_mcu7t5v0__oai22_1
X_7987_ _7988_/A3 _7987_/A2 _7987_/A3 _7987_/Z PHY_9/VDD PHY_9/VDD VSUBS VSUBS gf180mcu_fd_sc_mcu7t5v0__xor3_1
X_6938_ _6939_/A1 _6937_/Z _6984_/A2 PHY_9/VDD PHY_9/VDD VSUBS VSUBS gf180mcu_fd_sc_mcu7t5v0__nand2_1
X_9726_ _9726_/D _9800_/CLK _9726_/Q PHY_9/VDD PHY_9/VDD VSUBS VSUBS gf180mcu_fd_sc_mcu7t5v0__dffq_1
X_6869_ _9809_/Q _6921_/A2 _6924_/A2 PHY_9/VDD PHY_9/VDD VSUBS VSUBS gf180mcu_fd_sc_mcu7t5v0__nand2_1
X_9657_ _9657_/D _9689_/CLK _9657_/Q PHY_9/VDD PHY_9/VDD VSUBS VSUBS gf180mcu_fd_sc_mcu7t5v0__dffq_2
X_9588_ _9588_/D _9939_/CLK _9588_/Q PHY_9/VDD PHY_9/VDD VSUBS VSUBS gf180mcu_fd_sc_mcu7t5v0__dffq_1
X_8608_ _8608_/A1 _8652_/B2 _8608_/A3 _8611_/A3 PHY_9/VDD PHY_9/VDD VSUBS VSUBS gf180mcu_fd_sc_mcu7t5v0__xnor3_1
X_8539_ _8391_/C _8539_/A2 _8539_/B _9356_/C _8540_/C PHY_9/VDD PHY_9/VDD VSUBS VSUBS
+ gf180mcu_fd_sc_mcu7t5v0__aoi211_1
X_8890_ _8890_/A1 _9356_/C _8890_/B1 _8890_/B2 _9357_/B _9958_/D PHY_9/VDD PHY_9/VDD
+ VSUBS VSUBS gf180mcu_fd_sc_mcu7t5v0__aoi221_1
X_7910_ _9896_/Q _7912_/A2 _7930_/B PHY_9/VDD PHY_9/VDD VSUBS VSUBS gf180mcu_fd_sc_mcu7t5v0__nand2_1
X_7841_ _7838_/Z _7841_/A2 _7842_/I PHY_9/VDD PHY_9/VDD VSUBS VSUBS gf180mcu_fd_sc_mcu7t5v0__nand2_1
X_4984_ _9634_/Q _5820_/B2 PHY_9/VDD PHY_9/VDD VSUBS VSUBS gf180mcu_fd_sc_mcu7t5v0__clkinv_1
X_7772_ _9807_/Q _7771_/Z _7772_/Z PHY_9/VDD PHY_9/VDD VSUBS VSUBS gf180mcu_fd_sc_mcu7t5v0__and2_1
X_6723_ _9808_/Q _6710_/Z _6723_/B _6729_/B PHY_9/VDD PHY_9/VDD VSUBS VSUBS gf180mcu_fd_sc_mcu7t5v0__oai21_1
X_9511_ _9511_/D _9972_/CLK _9511_/Q PHY_9/VDD PHY_9/VDD VSUBS VSUBS gf180mcu_fd_sc_mcu7t5v0__dffq_4
X_6654_ _6561_/B _6643_/Z _6654_/B _6655_/C PHY_9/VDD PHY_9/VDD VSUBS VSUBS gf180mcu_fd_sc_mcu7t5v0__aoi21_1
X_9442_ _9442_/D _9800_/CLK _9442_/Q PHY_9/VDD PHY_9/VDD VSUBS VSUBS gf180mcu_fd_sc_mcu7t5v0__dffq_1
X_5605_ _9775_/Q _9036_/A2 _9035_/B _5606_/B PHY_9/VDD PHY_9/VDD VSUBS VSUBS gf180mcu_fd_sc_mcu7t5v0__oai21_1
X_6585_ _6585_/A1 _6635_/B1 _6585_/Z PHY_9/VDD PHY_9/VDD VSUBS VSUBS gf180mcu_fd_sc_mcu7t5v0__or2_1
X_9373_ _9373_/D _9901_/CLK _9373_/Q PHY_9/VDD PHY_9/VDD VSUBS VSUBS gf180mcu_fd_sc_mcu7t5v0__dffq_1
X_8324_ _8310_/Z _8324_/A2 _8323_/Z _8324_/Z PHY_9/VDD PHY_9/VDD VSUBS VSUBS gf180mcu_fd_sc_mcu7t5v0__xor3_1
X_5536_ _5973_/C _5536_/A2 _9472_/D PHY_9/VDD PHY_9/VDD VSUBS VSUBS gf180mcu_fd_sc_mcu7t5v0__nor2_1
X_5467_ _5484_/A1 _5495_/B _5467_/B _9445_/D PHY_9/VDD PHY_9/VDD VSUBS VSUBS gf180mcu_fd_sc_mcu7t5v0__aoi21_1
X_8255_ _8255_/A1 _8255_/A2 _8255_/B _8306_/A1 PHY_9/VDD PHY_9/VDD VSUBS VSUBS gf180mcu_fd_sc_mcu7t5v0__oai21_1
X_7206_ _7208_/A1 _7297_/A1 _7206_/Z PHY_9/VDD PHY_9/VDD VSUBS VSUBS gf180mcu_fd_sc_mcu7t5v0__and2_1
X_5398_ _5398_/A1 _5407_/A2 _8693_/A1 _5407_/B2 _9421_/D PHY_9/VDD PHY_9/VDD VSUBS
+ VSUBS gf180mcu_fd_sc_mcu7t5v0__oai22_1
X_8186_ _8186_/A1 _8186_/A2 _8186_/Z PHY_9/VDD PHY_9/VDD VSUBS VSUBS gf180mcu_fd_sc_mcu7t5v0__xor2_1
X_7137_ _9810_/Q _7315_/A2 _7138_/C PHY_9/VDD PHY_9/VDD VSUBS VSUBS gf180mcu_fd_sc_mcu7t5v0__nand2_1
X_7068_ _7069_/A2 _7074_/A1 _7068_/A3 _7074_/A2 PHY_9/VDD PHY_9/VDD VSUBS VSUBS gf180mcu_fd_sc_mcu7t5v0__nor3_1
X_6019_ _5371_/Z _6019_/A2 _6290_/B2 PHY_9/VDD PHY_9/VDD VSUBS VSUBS gf180mcu_fd_sc_mcu7t5v0__nor2_4
X_9709_ _9709_/D _9939_/CLK _9709_/Q PHY_9/VDD PHY_9/VDD VSUBS VSUBS gf180mcu_fd_sc_mcu7t5v0__dffq_1
X_6370_ _6408_/A2 _6370_/A2 _6370_/B _6374_/A1 PHY_9/VDD PHY_9/VDD VSUBS VSUBS gf180mcu_fd_sc_mcu7t5v0__oai21_1
X_5321_ _5321_/A1 _5343_/A2 _5331_/A2 PHY_9/VDD PHY_9/VDD VSUBS VSUBS gf180mcu_fd_sc_mcu7t5v0__nor2_4
X_8040_ _8036_/Z _8040_/A2 _8040_/A3 _8040_/B _8309_/A2 PHY_9/VDD PHY_9/VDD VSUBS
+ VSUBS gf180mcu_fd_sc_mcu7t5v0__oai31_4
X_5252_ _5252_/A1 _5260_/A2 _5252_/B _9368_/D PHY_9/VDD PHY_9/VDD VSUBS VSUBS gf180mcu_fd_sc_mcu7t5v0__aoi21_1
X_5183_ _9525_/Q _5831_/A2 _5826_/B PHY_9/VDD PHY_9/VDD VSUBS VSUBS gf180mcu_fd_sc_mcu7t5v0__nand2_1
X_8942_ _8994_/A1 _9931_/Q _8994_/B _8944_/B1 PHY_9/VDD PHY_9/VDD VSUBS VSUBS gf180mcu_fd_sc_mcu7t5v0__oai21_2
X_8873_ _8842_/B _8892_/A2 _8872_/Z _8890_/B1 PHY_9/VDD PHY_9/VDD VSUBS VSUBS gf180mcu_fd_sc_mcu7t5v0__nand3_1
X_7824_ _7863_/A1 _7823_/Z _7824_/Z PHY_9/VDD PHY_9/VDD VSUBS VSUBS gf180mcu_fd_sc_mcu7t5v0__xor2_1
X_4967_ _9593_/Q _5765_/B2 PHY_9/VDD PHY_9/VDD VSUBS VSUBS gf180mcu_fd_sc_mcu7t5v0__clkinv_1
X_7755_ _9091_/B _7988_/A2 _7757_/B PHY_9/VDD PHY_9/VDD VSUBS VSUBS gf180mcu_fd_sc_mcu7t5v0__nor2_1
X_4898_ _9706_/Q _6001_/B2 PHY_9/VDD PHY_9/VDD VSUBS VSUBS gf180mcu_fd_sc_mcu7t5v0__clkinv_1
X_7686_ _5406_/Z _7686_/A2 _7686_/B1 _7686_/B2 _9885_/D PHY_9/VDD PHY_9/VDD VSUBS
+ VSUBS gf180mcu_fd_sc_mcu7t5v0__oai22_1
X_6706_ _9835_/Q _6815_/B _7379_/A3 _6781_/A2 PHY_9/VDD PHY_9/VDD VSUBS VSUBS gf180mcu_fd_sc_mcu7t5v0__nand3_4
X_6637_ _6637_/A1 _6633_/Z _6636_/Z _6637_/Z PHY_9/VDD PHY_9/VDD VSUBS VSUBS gf180mcu_fd_sc_mcu7t5v0__xor3_1
X_9425_ _9425_/D _9901_/CLK _9425_/Q PHY_9/VDD PHY_9/VDD VSUBS VSUBS gf180mcu_fd_sc_mcu7t5v0__dffq_1
X_6568_ _9842_/Q _6350_/Z _6570_/A1 PHY_9/VDD PHY_9/VDD VSUBS VSUBS gf180mcu_fd_sc_mcu7t5v0__nand2_1
X_9356_ _9342_/Z _9356_/A2 _9356_/B1 _9343_/B _9356_/C _9357_/C PHY_9/VDD PHY_9/VDD
+ VSUBS VSUBS gf180mcu_fd_sc_mcu7t5v0__aoi221_1
X_8307_ _8307_/A1 _8281_/Z _8307_/B _8326_/A1 PHY_9/VDD PHY_9/VDD VSUBS VSUBS gf180mcu_fd_sc_mcu7t5v0__oai21_1
X_5519_ _9432_/Q _5522_/A2 _5522_/B _5520_/B2 PHY_9/VDD PHY_9/VDD VSUBS VSUBS gf180mcu_fd_sc_mcu7t5v0__aoi21_1
X_6499_ _6499_/A1 _6499_/A2 _6498_/Z _6545_/A1 PHY_9/VDD PHY_9/VDD VSUBS VSUBS gf180mcu_fd_sc_mcu7t5v0__nand3_1
X_9287_ _9287_/A1 _9323_/B2 _9287_/A3 _9287_/Z PHY_9/VDD PHY_9/VDD VSUBS VSUBS gf180mcu_fd_sc_mcu7t5v0__xor3_1
X_8238_ _8156_/B _8237_/Z _8252_/B PHY_9/VDD PHY_9/VDD VSUBS VSUBS gf180mcu_fd_sc_mcu7t5v0__nand2_1
X_8169_ _9971_/Q _8169_/A2 _8169_/B1 _8169_/B2 _8216_/A2 PHY_9/VDD PHY_9/VDD VSUBS
+ VSUBS gf180mcu_fd_sc_mcu7t5v0__oai22_2
X_5870_ _5870_/I _9647_/D PHY_9/VDD PHY_9/VDD VSUBS VSUBS gf180mcu_fd_sc_mcu7t5v0__clkinv_1
X_4821_ _9674_/Q _5943_/A1 PHY_9/VDD PHY_9/VDD VSUBS VSUBS gf180mcu_fd_sc_mcu7t5v0__clkinv_1
X_7540_ _9811_/Q _7382_/Z _7544_/A2 PHY_9/VDD PHY_9/VDD VSUBS VSUBS gf180mcu_fd_sc_mcu7t5v0__nand2_1
X_4752_ _9873_/Q _8463_/B1 PHY_9/VDD PHY_9/VDD VSUBS VSUBS gf180mcu_fd_sc_mcu7t5v0__clkinv_1
X_7471_ _9873_/Q _7489_/A1 _7468_/Z _7471_/Z PHY_9/VDD PHY_9/VDD VSUBS VSUBS gf180mcu_fd_sc_mcu7t5v0__xor3_1
X_4683_ _9966_/Q _9327_/A1 PHY_9/VDD PHY_9/VDD VSUBS VSUBS gf180mcu_fd_sc_mcu7t5v0__clkinv_3
X_6422_ _6423_/A1 _6421_/Z _6499_/A1 PHY_9/VDD PHY_9/VDD VSUBS VSUBS gf180mcu_fd_sc_mcu7t5v0__nor2_1
X_9210_ _9210_/I _9211_/A3 PHY_9/VDD PHY_9/VDD VSUBS VSUBS gf180mcu_fd_sc_mcu7t5v0__clkinv_1
X_9141_ _9807_/Q _9333_/A2 _9268_/A1 PHY_9/VDD PHY_9/VDD VSUBS VSUBS gf180mcu_fd_sc_mcu7t5v0__nand2_1
X_6353_ _9806_/Q _9805_/Q _6353_/Z PHY_9/VDD PHY_9/VDD VSUBS VSUBS gf180mcu_fd_sc_mcu7t5v0__or2_4
X_6284_ _9793_/Q _6287_/B1 _6288_/B1 _9557_/Q _6286_/A1 PHY_9/VDD PHY_9/VDD VSUBS
+ VSUBS gf180mcu_fd_sc_mcu7t5v0__aoi22_1
X_5304_ _9391_/Q _5307_/A2 _5305_/B PHY_9/VDD PHY_9/VDD VSUBS VSUBS gf180mcu_fd_sc_mcu7t5v0__nor2_1
X_9072_ _9090_/C _9331_/A2 _9072_/Z PHY_9/VDD PHY_9/VDD VSUBS VSUBS gf180mcu_fd_sc_mcu7t5v0__and2_1
X_5235_ _9464_/Q _5236_/A2 _9035_/B _5236_/B PHY_9/VDD PHY_9/VDD VSUBS VSUBS gf180mcu_fd_sc_mcu7t5v0__oai21_1
X_8023_ _9375_/Q _9036_/A2 _8027_/B _8024_/B PHY_9/VDD PHY_9/VDD VSUBS VSUBS gf180mcu_fd_sc_mcu7t5v0__oai21_1
X_5166_ _9656_/Q _9655_/Q _5166_/Z PHY_9/VDD PHY_9/VDD VSUBS VSUBS gf180mcu_fd_sc_mcu7t5v0__and2_1
X_5097_ _9581_/Q _5749_/B2 PHY_9/VDD PHY_9/VDD VSUBS VSUBS gf180mcu_fd_sc_mcu7t5v0__clkinv_1
X_9974_ _9974_/D _9974_/CLK _9974_/Q PHY_9/VDD PHY_9/VDD VSUBS VSUBS gf180mcu_fd_sc_mcu7t5v0__dffq_1
X_8925_ _8813_/Z _8925_/A2 _8850_/Z _8925_/B _8926_/I PHY_9/VDD PHY_9/VDD VSUBS VSUBS
+ gf180mcu_fd_sc_mcu7t5v0__oai31_1
X_8856_ _8856_/A1 _8861_/A2 _8856_/B1 _8856_/B2 _8863_/A1 PHY_9/VDD PHY_9/VDD VSUBS
+ VSUBS gf180mcu_fd_sc_mcu7t5v0__aoi22_1
X_5999_ _8688_/A1 _6283_/A1 _6008_/A2 PHY_9/VDD PHY_9/VDD VSUBS VSUBS gf180mcu_fd_sc_mcu7t5v0__nand2_4
X_8787_ _8857_/A1 _8857_/A2 _9809_/Q _8857_/C _8789_/B PHY_9/VDD PHY_9/VDD VSUBS VSUBS
+ gf180mcu_fd_sc_mcu7t5v0__oai211_2
X_7807_ _6471_/B _7988_/A2 _7807_/B _7808_/A4 PHY_9/VDD PHY_9/VDD VSUBS VSUBS gf180mcu_fd_sc_mcu7t5v0__oai21_1
X_7738_ _7994_/B _9871_/Q _7703_/Z _9905_/Q _7738_/C _7740_/B2 PHY_9/VDD PHY_9/VDD
+ VSUBS VSUBS gf180mcu_fd_sc_mcu7t5v0__aoi221_4
X_7669_ _7669_/A1 _7669_/A2 _7673_/A1 PHY_9/VDD PHY_9/VDD VSUBS VSUBS gf180mcu_fd_sc_mcu7t5v0__nand2_1
X_9408_ _9408_/D _9901_/CLK _9408_/Q PHY_9/VDD PHY_9/VDD VSUBS VSUBS gf180mcu_fd_sc_mcu7t5v0__dffq_1
X_9339_ _9339_/A1 _9339_/A2 _9338_/Z _9340_/A2 PHY_9/VDD PHY_9/VDD VSUBS VSUBS gf180mcu_fd_sc_mcu7t5v0__xnor3_1
X_5020_ _9882_/Q _7683_/B2 PHY_9/VDD PHY_9/VDD VSUBS VSUBS gf180mcu_fd_sc_mcu7t5v0__clkinv_1
Xclkbuf_leaf_2_clk clkbuf_leaf_9_clk/I _9901_/CLK PHY_9/VDD PHY_9/VDD VSUBS VSUBS
+ gf180mcu_fd_sc_mcu7t5v0__clkbuf_16
X_6971_ _6971_/A1 _6971_/A2 _6998_/A2 PHY_9/VDD PHY_9/VDD VSUBS VSUBS gf180mcu_fd_sc_mcu7t5v0__nand2_2
X_8710_ _9951_/Q _8885_/A1 _8982_/C PHY_9/VDD PHY_9/VDD VSUBS VSUBS gf180mcu_fd_sc_mcu7t5v0__nor2_4
X_9690_ _9690_/D _9939_/CLK _9690_/Q PHY_9/VDD PHY_9/VDD VSUBS VSUBS gf180mcu_fd_sc_mcu7t5v0__dffq_1
X_5922_ _9666_/Q _5919_/Z _5922_/Z PHY_9/VDD PHY_9/VDD VSUBS VSUBS gf180mcu_fd_sc_mcu7t5v0__and2_1
X_8641_ _8641_/A1 _8641_/A2 _8641_/B _8661_/A1 PHY_9/VDD PHY_9/VDD VSUBS VSUBS gf180mcu_fd_sc_mcu7t5v0__oai21_1
X_5853_ _5853_/A1 _9523_/Q _5854_/B PHY_9/VDD PHY_9/VDD VSUBS VSUBS gf180mcu_fd_sc_mcu7t5v0__nor2_1
X_4804_ _9804_/Q _6648_/A1 PHY_9/VDD PHY_9/VDD VSUBS VSUBS gf180mcu_fd_sc_mcu7t5v0__clkinv_4
X_5784_ _5371_/Z _5783_/Z _6291_/B2 PHY_9/VDD PHY_9/VDD VSUBS VSUBS gf180mcu_fd_sc_mcu7t5v0__nor2_4
X_8572_ _9930_/Q _8570_/Z _8572_/Z PHY_9/VDD PHY_9/VDD VSUBS VSUBS gf180mcu_fd_sc_mcu7t5v0__xor2_1
X_7523_ _9811_/Q _7521_/Z _7524_/B PHY_9/VDD PHY_9/VDD VSUBS VSUBS gf180mcu_fd_sc_mcu7t5v0__xor2_1
X_4735_ _9374_/Q _5266_/A1 PHY_9/VDD PHY_9/VDD VSUBS VSUBS gf180mcu_fd_sc_mcu7t5v0__clkinv_1
X_7454_ _7604_/B1 _9818_/Q _7553_/B _7457_/A2 PHY_9/VDD PHY_9/VDD VSUBS VSUBS gf180mcu_fd_sc_mcu7t5v0__oai21_2
X_6405_ _6423_/A1 _6405_/A2 _6414_/A2 PHY_9/VDD PHY_9/VDD VSUBS VSUBS gf180mcu_fd_sc_mcu7t5v0__nand2_1
X_7385_ _7647_/A2 _7473_/B _7385_/Z PHY_9/VDD PHY_9/VDD VSUBS VSUBS gf180mcu_fd_sc_mcu7t5v0__and2_1
X_9124_ _9809_/Q _9103_/Z _9191_/A1 PHY_9/VDD PHY_9/VDD VSUBS VSUBS gf180mcu_fd_sc_mcu7t5v0__nand2_1
X_6336_ _9507_/Q _9034_/A2 _8706_/B _6337_/B PHY_9/VDD PHY_9/VDD VSUBS VSUBS gf180mcu_fd_sc_mcu7t5v0__oai21_1
X_9055_ _9964_/Q _9963_/Q _9077_/A2 PHY_9/VDD PHY_9/VDD VSUBS VSUBS gf180mcu_fd_sc_mcu7t5v0__nor2_1
X_6267_ _6267_/A1 _6267_/A2 _6290_/A2 PHY_9/VDD PHY_9/VDD VSUBS VSUBS gf180mcu_fd_sc_mcu7t5v0__nand2_1
X_6198_ _6198_/A1 _6198_/A2 _6203_/B1 PHY_9/VDD PHY_9/VDD VSUBS VSUBS gf180mcu_fd_sc_mcu7t5v0__nand2_1
X_5218_ _5961_/B _9725_/Q _9733_/D PHY_9/VDD PHY_9/VDD VSUBS VSUBS gf180mcu_fd_sc_mcu7t5v0__and2_1
X_8006_ _9814_/Q _8013_/A2 _8016_/B1 PHY_9/VDD PHY_9/VDD VSUBS VSUBS gf180mcu_fd_sc_mcu7t5v0__nor2_1
X_5149_ _5973_/C _9728_/Q _9737_/Q _9733_/Q _5150_/A4 PHY_9/VDD PHY_9/VDD VSUBS VSUBS
+ gf180mcu_fd_sc_mcu7t5v0__nor4_2
X_9957_ _9957_/D _9957_/CLK _9957_/Q PHY_9/VDD PHY_9/VDD VSUBS VSUBS gf180mcu_fd_sc_mcu7t5v0__dffq_1
X_8908_ _9812_/Q _8958_/A2 _8955_/B1 PHY_9/VDD PHY_9/VDD VSUBS VSUBS gf180mcu_fd_sc_mcu7t5v0__nand2_1
X_9888_ _9888_/D _9957_/CLK _9888_/Q PHY_9/VDD PHY_9/VDD VSUBS VSUBS gf180mcu_fd_sc_mcu7t5v0__dffq_2
X_8839_ _9810_/Q _8813_/Z _8843_/B2 PHY_9/VDD PHY_9/VDD VSUBS VSUBS gf180mcu_fd_sc_mcu7t5v0__nor2_1
X_7170_ _7322_/A1 _7165_/Z _7185_/C PHY_9/VDD PHY_9/VDD VSUBS VSUBS gf180mcu_fd_sc_mcu7t5v0__nand2_1
X_6121_ _9420_/Q _6288_/A2 _6287_/A2 _9568_/Q _6122_/A2 PHY_9/VDD PHY_9/VDD VSUBS
+ VSUBS gf180mcu_fd_sc_mcu7t5v0__aoi22_1
X_6052_ _5388_/Z _6059_/A2 _6059_/B1 _6052_/B2 _9762_/D PHY_9/VDD PHY_9/VDD VSUBS
+ VSUBS gf180mcu_fd_sc_mcu7t5v0__oai22_1
X_5003_ _9570_/Q _5734_/B2 PHY_9/VDD PHY_9/VDD VSUBS VSUBS gf180mcu_fd_sc_mcu7t5v0__clkinv_1
X_9811_ _9811_/D _9974_/CLK _9811_/Q PHY_9/VDD PHY_9/VDD VSUBS VSUBS gf180mcu_fd_sc_mcu7t5v0__dffq_4
X_9742_ _9742_/D _9939_/CLK _9742_/Q PHY_9/VDD PHY_9/VDD VSUBS VSUBS gf180mcu_fd_sc_mcu7t5v0__dffq_1
X_6954_ _9813_/Q _6991_/A2 _6956_/A2 PHY_9/VDD PHY_9/VDD VSUBS VSUBS gf180mcu_fd_sc_mcu7t5v0__nand2_1
X_5905_ _9660_/Q _9661_/Q _5906_/A2 _5905_/Z PHY_9/VDD PHY_9/VDD VSUBS VSUBS gf180mcu_fd_sc_mcu7t5v0__and3_1
X_9673_ _9673_/D _9689_/CLK _9673_/Q PHY_9/VDD PHY_9/VDD VSUBS VSUBS gf180mcu_fd_sc_mcu7t5v0__dffq_1
X_6885_ _6886_/A2 _6886_/A3 _6935_/A2 PHY_9/VDD PHY_9/VDD VSUBS VSUBS gf180mcu_fd_sc_mcu7t5v0__nor2_1
X_8624_ _8664_/A1 _8624_/A2 _8636_/A2 PHY_9/VDD PHY_9/VDD VSUBS VSUBS gf180mcu_fd_sc_mcu7t5v0__nand2_1
X_5836_ _9460_/Q _5867_/A2 _5836_/B _5837_/A2 PHY_9/VDD PHY_9/VDD VSUBS VSUBS gf180mcu_fd_sc_mcu7t5v0__aoi21_1
X_5767_ _8695_/A1 _5769_/A2 _5769_/B1 _5767_/B2 _9595_/D PHY_9/VDD PHY_9/VDD VSUBS
+ VSUBS gf180mcu_fd_sc_mcu7t5v0__oai22_1
X_8555_ _8509_/Z _8510_/Z _8563_/A2 PHY_9/VDD PHY_9/VDD VSUBS VSUBS gf180mcu_fd_sc_mcu7t5v0__nand2_1
X_7506_ _7561_/A1 _7505_/Z _7506_/Z PHY_9/VDD PHY_9/VDD VSUBS VSUBS gf180mcu_fd_sc_mcu7t5v0__and2_1
X_5698_ _5696_/Z _5698_/A2 _9547_/D PHY_9/VDD PHY_9/VDD VSUBS VSUBS gf180mcu_fd_sc_mcu7t5v0__nor2_1
X_8486_ _8380_/Z _8525_/B _8485_/Z _8486_/Z PHY_9/VDD PHY_9/VDD VSUBS VSUBS gf180mcu_fd_sc_mcu7t5v0__and3_1
X_4718_ _9371_/Q _5258_/A1 PHY_9/VDD PHY_9/VDD VSUBS VSUBS gf180mcu_fd_sc_mcu7t5v0__clkinv_1
X_7437_ _7667_/I1 _7505_/A1 _7668_/B _7439_/A2 PHY_9/VDD PHY_9/VDD VSUBS VSUBS gf180mcu_fd_sc_mcu7t5v0__aoi21_1
X_7368_ _7369_/B _7368_/A2 _7668_/A2 _9807_/Q _7373_/A1 PHY_9/VDD PHY_9/VDD VSUBS
+ VSUBS gf180mcu_fd_sc_mcu7t5v0__aoi22_1
X_7299_ _9843_/Q _7299_/A2 _7299_/B1 _9911_/Q _7300_/A2 PHY_9/VDD PHY_9/VDD VSUBS
+ VSUBS gf180mcu_fd_sc_mcu7t5v0__aoi22_1
X_9107_ _9809_/Q _9285_/A2 _9107_/A3 _9142_/B PHY_9/VDD PHY_9/VDD VSUBS VSUBS gf180mcu_fd_sc_mcu7t5v0__nand3_1
X_6319_ _8693_/A1 _6323_/A2 _6323_/B1 _6319_/B2 _9797_/D PHY_9/VDD PHY_9/VDD VSUBS
+ VSUBS gf180mcu_fd_sc_mcu7t5v0__oai22_1
X_9038_ _9963_/Q _9962_/Q _9214_/A1 PHY_9/VDD PHY_9/VDD VSUBS VSUBS gf180mcu_fd_sc_mcu7t5v0__nand2_1
X_6670_ _9395_/Q _9036_/A2 _8027_/B _6671_/B PHY_9/VDD PHY_9/VDD VSUBS VSUBS gf180mcu_fd_sc_mcu7t5v0__oai21_1
X_5621_ _9509_/Q _5633_/A2 _5622_/A2 PHY_9/VDD PHY_9/VDD VSUBS VSUBS gf180mcu_fd_sc_mcu7t5v0__nand2_1
X_5552_ _8691_/A1 _5558_/A2 _5558_/B1 _5552_/B2 _9482_/D PHY_9/VDD PHY_9/VDD VSUBS
+ VSUBS gf180mcu_fd_sc_mcu7t5v0__oai22_1
X_8340_ _8300_/C _8340_/A2 _8340_/A3 _8340_/B1 _9814_/Q _8341_/C PHY_9/VDD PHY_9/VDD
+ VSUBS VSUBS gf180mcu_fd_sc_mcu7t5v0__oai32_1
X_8271_ _9811_/Q _8097_/Z _8313_/A1 PHY_9/VDD PHY_9/VDD VSUBS VSUBS gf180mcu_fd_sc_mcu7t5v0__nand2_1
X_5483_ _9453_/Q _5493_/B _5770_/B _5484_/B PHY_9/VDD PHY_9/VDD VSUBS VSUBS gf180mcu_fd_sc_mcu7t5v0__oai21_1
X_7222_ _7322_/A1 _7218_/Z _7233_/A2 PHY_9/VDD PHY_9/VDD VSUBS VSUBS gf180mcu_fd_sc_mcu7t5v0__nand2_1
X_7153_ _9811_/Q _7019_/I _7158_/A3 PHY_9/VDD PHY_9/VDD VSUBS VSUBS gf180mcu_fd_sc_mcu7t5v0__nand2_1
X_6104_ _9583_/Q _6288_/A2 _6287_/A2 _9591_/Q _6105_/A2 PHY_9/VDD PHY_9/VDD VSUBS
+ VSUBS gf180mcu_fd_sc_mcu7t5v0__aoi22_1
X_7084_ _7084_/A1 _7084_/A2 _7085_/A2 _7122_/A1 PHY_9/VDD PHY_9/VDD VSUBS VSUBS gf180mcu_fd_sc_mcu7t5v0__nor3_2
X_6035_ _8693_/A1 _6039_/A2 _6039_/B1 _6035_/B2 _9749_/D PHY_9/VDD PHY_9/VDD VSUBS
+ VSUBS gf180mcu_fd_sc_mcu7t5v0__oai22_1
X_7986_ _7989_/A2 _7986_/A2 _7986_/A3 _7987_/A3 PHY_9/VDD PHY_9/VDD VSUBS VSUBS gf180mcu_fd_sc_mcu7t5v0__xnor3_1
X_9725_ _9725_/D _9800_/CLK _9725_/Q PHY_9/VDD PHY_9/VDD VSUBS VSUBS gf180mcu_fd_sc_mcu7t5v0__dffq_2
X_6937_ _6964_/A1 _6936_/Z _6937_/Z PHY_9/VDD PHY_9/VDD VSUBS VSUBS gf180mcu_fd_sc_mcu7t5v0__xor2_1
X_6868_ _9809_/Q _6966_/A2 _6871_/A2 PHY_9/VDD PHY_9/VDD VSUBS VSUBS gf180mcu_fd_sc_mcu7t5v0__nand2_1
X_9656_ _9656_/D _9972_/CLK _9656_/Q PHY_9/VDD PHY_9/VDD VSUBS VSUBS gf180mcu_fd_sc_mcu7t5v0__dffq_1
X_9587_ _9587_/D _9948_/CLK _9587_/Q PHY_9/VDD PHY_9/VDD VSUBS VSUBS gf180mcu_fd_sc_mcu7t5v0__dffq_1
X_5819_ _8692_/A1 _5824_/A2 _5824_/B1 _5819_/B2 _9633_/D PHY_9/VDD PHY_9/VDD VSUBS
+ VSUBS gf180mcu_fd_sc_mcu7t5v0__oai22_1
X_8607_ _8608_/A1 _8608_/A3 _8607_/Z PHY_9/VDD PHY_9/VDD VSUBS VSUBS gf180mcu_fd_sc_mcu7t5v0__and2_1
X_6799_ _6471_/B _6797_/Z _6799_/Z PHY_9/VDD PHY_9/VDD VSUBS VSUBS gf180mcu_fd_sc_mcu7t5v0__xor2_1
X_8538_ _8538_/A1 _8538_/A2 _8538_/B1 _8538_/B2 _8538_/C _8539_/A2 PHY_9/VDD PHY_9/VDD
+ VSUBS VSUBS gf180mcu_fd_sc_mcu7t5v0__oai221_1
X_8469_ _6471_/B _9227_/A1 _8369_/Z _8401_/Z _8504_/B PHY_9/VDD PHY_9/VDD VSUBS VSUBS
+ gf180mcu_fd_sc_mcu7t5v0__nor4_2
X_7840_ _7840_/I _7841_/A2 PHY_9/VDD PHY_9/VDD VSUBS VSUBS gf180mcu_fd_sc_mcu7t5v0__clkinv_1
X_4983_ _9610_/Q _5790_/B2 PHY_9/VDD PHY_9/VDD VSUBS VSUBS gf180mcu_fd_sc_mcu7t5v0__clkinv_1
X_7771_ _9956_/Q _9872_/Q _9838_/Q _9906_/Q _9890_/Q _9889_/Q _7771_/Z PHY_9/VDD PHY_9/VDD
+ VSUBS VSUBS gf180mcu_fd_sc_mcu7t5v0__mux4_4
X_6722_ _6997_/B2 _6746_/A1 _6722_/B _6723_/B PHY_9/VDD PHY_9/VDD VSUBS VSUBS gf180mcu_fd_sc_mcu7t5v0__oai21_1
X_9510_ _9510_/D _9974_/CLK _9510_/Q PHY_9/VDD PHY_9/VDD VSUBS VSUBS gf180mcu_fd_sc_mcu7t5v0__dffq_2
X_6653_ _6561_/B _6653_/A2 _9317_/C _6654_/B PHY_9/VDD PHY_9/VDD VSUBS VSUBS gf180mcu_fd_sc_mcu7t5v0__oai21_1
X_9441_ _9441_/D _9972_/CLK _9441_/Q PHY_9/VDD PHY_9/VDD VSUBS VSUBS gf180mcu_fd_sc_mcu7t5v0__dffq_1
X_5604_ _5604_/A1 _9034_/A2 _5604_/B _9502_/D PHY_9/VDD PHY_9/VDD VSUBS VSUBS gf180mcu_fd_sc_mcu7t5v0__aoi21_1
X_6584_ _9813_/Q _6624_/A2 _6584_/B1 _9812_/Q _6635_/B1 PHY_9/VDD PHY_9/VDD VSUBS
+ VSUBS gf180mcu_fd_sc_mcu7t5v0__aoi22_1
X_9372_ _9372_/D _9974_/CLK _9372_/Q PHY_9/VDD PHY_9/VDD VSUBS VSUBS gf180mcu_fd_sc_mcu7t5v0__dffq_1
X_8323_ _8323_/A1 _8323_/A2 _8323_/Z PHY_9/VDD PHY_9/VDD VSUBS VSUBS gf180mcu_fd_sc_mcu7t5v0__xor2_1
X_5535_ _9445_/Q _5525_/Z _5544_/A2 _9472_/Q _5536_/A2 PHY_9/VDD PHY_9/VDD VSUBS VSUBS
+ gf180mcu_fd_sc_mcu7t5v0__aoi22_1
X_5466_ _9445_/Q _5495_/B _5474_/B _5467_/B PHY_9/VDD PHY_9/VDD VSUBS VSUBS gf180mcu_fd_sc_mcu7t5v0__oai21_1
X_8254_ _9910_/Q _9356_/C _8305_/A1 PHY_9/VDD PHY_9/VDD VSUBS VSUBS gf180mcu_fd_sc_mcu7t5v0__nand2_1
X_7205_ _7208_/A1 _7297_/A1 _7258_/A1 PHY_9/VDD PHY_9/VDD VSUBS VSUBS gf180mcu_fd_sc_mcu7t5v0__nor2_2
X_8185_ _8186_/A1 _8186_/A2 _8234_/A1 PHY_9/VDD PHY_9/VDD VSUBS VSUBS gf180mcu_fd_sc_mcu7t5v0__nor2_1
X_5397_ _9970_/Q _5201_/Z _5397_/B _8693_/A1 PHY_9/VDD PHY_9/VDD VSUBS VSUBS gf180mcu_fd_sc_mcu7t5v0__aoi21_4
X_7136_ _7314_/I1 _7250_/A1 _7315_/B _7138_/B1 PHY_9/VDD PHY_9/VDD VSUBS VSUBS gf180mcu_fd_sc_mcu7t5v0__aoi21_1
X_7067_ _9850_/Q _7062_/Z _7068_/A3 PHY_9/VDD PHY_9/VDD VSUBS VSUBS gf180mcu_fd_sc_mcu7t5v0__nor2_1
X_6018_ _5406_/Z _6018_/A2 _6018_/B1 _6018_/B2 _9721_/D PHY_9/VDD PHY_9/VDD VSUBS
+ VSUBS gf180mcu_fd_sc_mcu7t5v0__oai22_1
X_7969_ _7970_/A1 _7970_/A2 _7969_/B _8010_/B PHY_9/VDD PHY_9/VDD VSUBS VSUBS gf180mcu_fd_sc_mcu7t5v0__aoi21_1
X_9708_ _9708_/D _9939_/CLK _9708_/Q PHY_9/VDD PHY_9/VDD VSUBS VSUBS gf180mcu_fd_sc_mcu7t5v0__dffq_1
X_9639_ _9639_/D _9800_/CLK _9639_/Q PHY_9/VDD PHY_9/VDD VSUBS VSUBS gf180mcu_fd_sc_mcu7t5v0__dffq_1
X_5320_ _9472_/Q _5369_/A1 _5343_/A2 PHY_9/VDD PHY_9/VDD VSUBS VSUBS gf180mcu_fd_sc_mcu7t5v0__nand2_2
X_5251_ _9460_/Q _5260_/A2 rst_n _5252_/B PHY_9/VDD PHY_9/VDD VSUBS VSUBS gf180mcu_fd_sc_mcu7t5v0__oai21_1
X_5182_ _5182_/A1 _5182_/A2 _5182_/A3 _5182_/A4 _5831_/A2 PHY_9/VDD PHY_9/VDD VSUBS
+ VSUBS gf180mcu_fd_sc_mcu7t5v0__nand4_4
X_8941_ _8941_/A1 _8941_/A2 _8941_/B _8968_/A1 PHY_9/VDD PHY_9/VDD VSUBS VSUBS gf180mcu_fd_sc_mcu7t5v0__oai21_1
X_8872_ _8872_/A1 _8870_/Z _8872_/Z PHY_9/VDD PHY_9/VDD VSUBS VSUBS gf180mcu_fd_sc_mcu7t5v0__or2_1
X_7823_ _9810_/Q _7821_/Z _7823_/Z PHY_9/VDD PHY_9/VDD VSUBS VSUBS gf180mcu_fd_sc_mcu7t5v0__xor2_1
X_7754_ _8008_/I1 _7776_/B _8009_/C _7761_/B2 PHY_9/VDD PHY_9/VDD VSUBS VSUBS gf180mcu_fd_sc_mcu7t5v0__aoi21_1
X_4966_ _9936_/Q _8683_/B2 PHY_9/VDD PHY_9/VDD VSUBS VSUBS gf180mcu_fd_sc_mcu7t5v0__clkinv_1
X_6705_ _7705_/A2 _9356_/C _6705_/B1 _6705_/B2 _9357_/B _9836_/D PHY_9/VDD PHY_9/VDD
+ VSUBS VSUBS gf180mcu_fd_sc_mcu7t5v0__aoi221_1
X_7685_ _5404_/Z _7686_/A2 _7686_/B1 _7685_/B2 _9884_/D PHY_9/VDD PHY_9/VDD VSUBS
+ VSUBS gf180mcu_fd_sc_mcu7t5v0__oai22_1
X_4897_ _9558_/Q _5720_/B2 PHY_9/VDD PHY_9/VDD VSUBS VSUBS gf180mcu_fd_sc_mcu7t5v0__clkinv_1
X_6636_ _6636_/A1 _6636_/A2 _6636_/Z PHY_9/VDD PHY_9/VDD VSUBS VSUBS gf180mcu_fd_sc_mcu7t5v0__xor2_1
X_9424_ _9424_/D _9830_/CLK _9424_/Q PHY_9/VDD PHY_9/VDD VSUBS VSUBS gf180mcu_fd_sc_mcu7t5v0__dffq_1
X_6567_ _6567_/A1 _6540_/Z _6567_/B _6596_/A1 PHY_9/VDD PHY_9/VDD VSUBS VSUBS gf180mcu_fd_sc_mcu7t5v0__aoi21_1
X_9355_ _9355_/A1 _9355_/A2 _9355_/B _9355_/C _9356_/B1 PHY_9/VDD PHY_9/VDD VSUBS
+ VSUBS gf180mcu_fd_sc_mcu7t5v0__oai211_1
X_5518_ _9440_/Q _5498_/Z _5520_/B1 PHY_9/VDD PHY_9/VDD VSUBS VSUBS gf180mcu_fd_sc_mcu7t5v0__nand2_1
X_8306_ _8306_/A1 _8289_/Z _8306_/B _8331_/A1 PHY_9/VDD PHY_9/VDD VSUBS VSUBS gf180mcu_fd_sc_mcu7t5v0__aoi21_1
X_6498_ _6498_/A1 _6496_/Z _6498_/Z PHY_9/VDD PHY_9/VDD VSUBS VSUBS gf180mcu_fd_sc_mcu7t5v0__xor2_1
X_9286_ _9287_/A1 _9287_/A3 _9286_/Z PHY_9/VDD PHY_9/VDD VSUBS VSUBS gf180mcu_fd_sc_mcu7t5v0__and2_1
X_5449_ _9437_/Q _5458_/A2 _5474_/B _5450_/B PHY_9/VDD PHY_9/VDD VSUBS VSUBS gf180mcu_fd_sc_mcu7t5v0__oai21_1
X_8237_ _9909_/Q _8255_/A1 _8234_/Z _8237_/Z PHY_9/VDD PHY_9/VDD VSUBS VSUBS gf180mcu_fd_sc_mcu7t5v0__xor3_1
X_8168_ _9221_/A1 _8319_/A2 _8168_/B _8266_/A2 PHY_9/VDD PHY_9/VDD VSUBS VSUBS gf180mcu_fd_sc_mcu7t5v0__aoi21_4
X_7119_ _7119_/A1 _7082_/Z _7118_/B _7144_/A2 PHY_9/VDD PHY_9/VDD VSUBS VSUBS gf180mcu_fd_sc_mcu7t5v0__nor3_1
X_8099_ _9227_/A1 _8309_/A2 _8175_/A1 PHY_9/VDD PHY_9/VDD VSUBS VSUBS gf180mcu_fd_sc_mcu7t5v0__nor2_1
X_4820_ _9675_/Q _5945_/A1 PHY_9/VDD PHY_9/VDD VSUBS VSUBS gf180mcu_fd_sc_mcu7t5v0__clkinv_1
X_4751_ _9874_/Q _8498_/B1 PHY_9/VDD PHY_9/VDD VSUBS VSUBS gf180mcu_fd_sc_mcu7t5v0__inv_2
X_7470_ _9873_/Q _7468_/Z _7489_/B PHY_9/VDD PHY_9/VDD VSUBS VSUBS gf180mcu_fd_sc_mcu7t5v0__and2_1
X_4682_ _9967_/Q _9071_/A1 PHY_9/VDD PHY_9/VDD VSUBS VSUBS gf180mcu_fd_sc_mcu7t5v0__inv_1
X_6421_ _6421_/A1 _6448_/B2 _6421_/A3 _6421_/Z PHY_9/VDD PHY_9/VDD VSUBS VSUBS gf180mcu_fd_sc_mcu7t5v0__xor3_1
X_9140_ _9090_/C _9227_/A2 _9177_/A1 PHY_9/VDD PHY_9/VDD VSUBS VSUBS gf180mcu_fd_sc_mcu7t5v0__nor2_1
X_6352_ _9806_/Q _9805_/Q _6569_/A2 PHY_9/VDD PHY_9/VDD VSUBS VSUBS gf180mcu_fd_sc_mcu7t5v0__nor2_4
X_6283_ _6283_/A1 _6283_/A2 _6283_/B1 _6283_/B2 _6292_/A1 PHY_9/VDD PHY_9/VDD VSUBS
+ VSUBS gf180mcu_fd_sc_mcu7t5v0__aoi22_1
X_5303_ _5393_/A1 _5307_/A2 _5303_/B _5973_/C _9390_/D PHY_9/VDD PHY_9/VDD VSUBS VSUBS
+ gf180mcu_fd_sc_mcu7t5v0__aoi211_1
X_9071_ _9071_/A1 _9356_/C _9071_/B1 _9071_/B2 _9357_/B _9967_/D PHY_9/VDD PHY_9/VDD
+ VSUBS VSUBS gf180mcu_fd_sc_mcu7t5v0__aoi221_1
X_5234_ _5234_/A1 _5236_/A2 _5234_/B _9361_/D PHY_9/VDD PHY_9/VDD VSUBS VSUBS gf180mcu_fd_sc_mcu7t5v0__aoi21_1
X_8022_ _8043_/A2 _9036_/A2 _8022_/B _9900_/D PHY_9/VDD PHY_9/VDD VSUBS VSUBS gf180mcu_fd_sc_mcu7t5v0__aoi21_1
X_5165_ _5973_/C _5165_/A2 _9480_/D PHY_9/VDD PHY_9/VDD VSUBS VSUBS gf180mcu_fd_sc_mcu7t5v0__nor2_1
X_5096_ _9589_/Q _5759_/B2 PHY_9/VDD PHY_9/VDD VSUBS VSUBS gf180mcu_fd_sc_mcu7t5v0__clkinv_1
X_9973_ _9973_/D _9974_/CLK _9973_/Q PHY_9/VDD PHY_9/VDD VSUBS VSUBS gf180mcu_fd_sc_mcu7t5v0__dffq_2
X_8924_ _8734_/I _8924_/A2 _8937_/A2 PHY_9/VDD PHY_9/VDD VSUBS VSUBS gf180mcu_fd_sc_mcu7t5v0__nand2_1
X_8855_ _8941_/A1 _8855_/A2 _8893_/A1 PHY_9/VDD PHY_9/VDD VSUBS VSUBS gf180mcu_fd_sc_mcu7t5v0__nand2_1
X_7806_ _6471_/B _7988_/A2 _7807_/B _7806_/Z PHY_9/VDD PHY_9/VDD VSUBS VSUBS gf180mcu_fd_sc_mcu7t5v0__or3_1
X_5998_ _5406_/Z _5998_/A2 _5998_/B1 _5998_/B2 _9705_/D PHY_9/VDD PHY_9/VDD VSUBS
+ VSUBS gf180mcu_fd_sc_mcu7t5v0__oai22_1
X_8786_ _9227_/A1 _8832_/A1 _8856_/A1 PHY_9/VDD PHY_9/VDD VSUBS VSUBS gf180mcu_fd_sc_mcu7t5v0__nor2_1
X_4949_ _9516_/Q _5641_/B2 PHY_9/VDD PHY_9/VDD VSUBS VSUBS gf180mcu_fd_sc_mcu7t5v0__clkinv_1
X_7737_ _9905_/Q _9890_/Q _9889_/Q _7739_/C PHY_9/VDD PHY_9/VDD VSUBS VSUBS gf180mcu_fd_sc_mcu7t5v0__nand3_2
X_7668_ _9814_/Q _7668_/A2 _7668_/B _7668_/C _7674_/B2 PHY_9/VDD PHY_9/VDD VSUBS VSUBS
+ gf180mcu_fd_sc_mcu7t5v0__aoi211_2
X_6619_ _9357_/B _6619_/A2 _9821_/D PHY_9/VDD PHY_9/VDD VSUBS VSUBS gf180mcu_fd_sc_mcu7t5v0__nor2_1
X_9407_ _9407_/D _9901_/CLK _9407_/Q PHY_9/VDD PHY_9/VDD VSUBS VSUBS gf180mcu_fd_sc_mcu7t5v0__dffq_1
X_7599_ _9810_/Q _7599_/A2 _7658_/A1 PHY_9/VDD PHY_9/VDD VSUBS VSUBS gf180mcu_fd_sc_mcu7t5v0__nand2_1
X_9338_ _9338_/A1 _9338_/A2 _9337_/Z _9338_/Z PHY_9/VDD PHY_9/VDD VSUBS VSUBS gf180mcu_fd_sc_mcu7t5v0__xor3_1
X_9269_ _9327_/B _9960_/Q _9910_/Q _9326_/B1 _9271_/B1 PHY_9/VDD PHY_9/VDD VSUBS VSUBS
+ gf180mcu_fd_sc_mcu7t5v0__aoi22_2
X_6970_ _9822_/Q _6970_/A2 _6970_/B1 _9898_/Q _6971_/A2 PHY_9/VDD PHY_9/VDD VSUBS
+ VSUBS gf180mcu_fd_sc_mcu7t5v0__aoi22_1
X_5921_ _5919_/Z _5921_/A2 _9665_/D PHY_9/VDD PHY_9/VDD VSUBS VSUBS gf180mcu_fd_sc_mcu7t5v0__nor2_1
X_5852_ _5852_/A1 _5852_/A2 _9643_/D PHY_9/VDD PHY_9/VDD VSUBS VSUBS gf180mcu_fd_sc_mcu7t5v0__nor2_1
X_8640_ _8640_/A1 _8640_/A2 _8640_/B _8662_/A2 PHY_9/VDD PHY_9/VDD VSUBS VSUBS gf180mcu_fd_sc_mcu7t5v0__oai21_1
X_5783_ _5783_/A1 _5367_/Z _5783_/Z PHY_9/VDD PHY_9/VDD VSUBS VSUBS gf180mcu_fd_sc_mcu7t5v0__or2_2
X_4803_ _9805_/Q _6331_/A1 PHY_9/VDD PHY_9/VDD VSUBS VSUBS gf180mcu_fd_sc_mcu7t5v0__clkinv_1
X_8571_ _9930_/Q _8570_/Z _8590_/B PHY_9/VDD PHY_9/VDD VSUBS VSUBS gf180mcu_fd_sc_mcu7t5v0__and2_1
X_7522_ _9811_/Q _7521_/Z _7576_/A1 PHY_9/VDD PHY_9/VDD VSUBS VSUBS gf180mcu_fd_sc_mcu7t5v0__nand2_1
X_4734_ _9900_/Q _8043_/A2 PHY_9/VDD PHY_9/VDD VSUBS VSUBS gf180mcu_fd_sc_mcu7t5v0__inv_1
X_7453_ _9868_/Q _7453_/A2 _9869_/Q _7458_/A2 PHY_9/VDD PHY_9/VDD VSUBS VSUBS gf180mcu_fd_sc_mcu7t5v0__aoi21_1
X_6404_ _9090_/C _6583_/A4 _6404_/B _6405_/A2 PHY_9/VDD PHY_9/VDD VSUBS VSUBS gf180mcu_fd_sc_mcu7t5v0__oai21_1
X_7384_ _9865_/Q _7384_/A2 _7473_/B PHY_9/VDD PHY_9/VDD VSUBS VSUBS gf180mcu_fd_sc_mcu7t5v0__nand2_2
X_9123_ _9809_/Q _9103_/Z _9126_/B2 PHY_9/VDD PHY_9/VDD VSUBS VSUBS gf180mcu_fd_sc_mcu7t5v0__nor2_1
X_6335_ _9090_/C _9034_/A2 _6335_/B _9807_/D PHY_9/VDD PHY_9/VDD VSUBS VSUBS gf180mcu_fd_sc_mcu7t5v0__aoi21_1
X_9054_ _9065_/A1 _9066_/A2 _9314_/A1 PHY_9/VDD PHY_9/VDD VSUBS VSUBS gf180mcu_fd_sc_mcu7t5v0__nand2_2
X_6266_ _9785_/Q _6288_/A2 _6288_/B1 _9830_/Q _6267_/A2 PHY_9/VDD PHY_9/VDD VSUBS
+ VSUBS gf180mcu_fd_sc_mcu7t5v0__aoi22_1
X_8005_ _8005_/A1 _8003_/Z _8005_/B _8018_/B1 PHY_9/VDD PHY_9/VDD VSUBS VSUBS gf180mcu_fd_sc_mcu7t5v0__oai21_1
X_6197_ _9882_/Q _6288_/A2 _6288_/B1 _9945_/Q _6198_/A2 PHY_9/VDD PHY_9/VDD VSUBS
+ VSUBS gf180mcu_fd_sc_mcu7t5v0__aoi22_1
X_5217_ _5480_/A1 _5217_/A2 _9726_/D PHY_9/VDD PHY_9/VDD VSUBS VSUBS gf180mcu_fd_sc_mcu7t5v0__nor2_1
X_5148_ _5459_/A1 _9458_/Q _5770_/B _9734_/Q _5150_/A3 PHY_9/VDD PHY_9/VDD VSUBS VSUBS
+ gf180mcu_fd_sc_mcu7t5v0__oai211_1
X_5079_ _9613_/Q _5793_/B2 PHY_9/VDD PHY_9/VDD VSUBS VSUBS gf180mcu_fd_sc_mcu7t5v0__clkinv_1
X_9956_ _9956_/D _9957_/CLK _9956_/Q PHY_9/VDD PHY_9/VDD VSUBS VSUBS gf180mcu_fd_sc_mcu7t5v0__dffq_2
X_8907_ _6558_/B _8752_/I _8959_/B PHY_9/VDD PHY_9/VDD VSUBS VSUBS gf180mcu_fd_sc_mcu7t5v0__nor2_1
X_9887_ _9887_/D _9957_/CLK _9887_/Q PHY_9/VDD PHY_9/VDD VSUBS VSUBS gf180mcu_fd_sc_mcu7t5v0__dffq_2
X_8838_ _9024_/B2 _8875_/B _8844_/B2 PHY_9/VDD PHY_9/VDD VSUBS VSUBS gf180mcu_fd_sc_mcu7t5v0__nor2_1
X_8769_ _8734_/I _8767_/Z _8769_/B _8769_/C _8770_/B PHY_9/VDD PHY_9/VDD VSUBS VSUBS
+ gf180mcu_fd_sc_mcu7t5v0__aoi211_1
X_6120_ _9788_/Q _6287_/B1 _6288_/B1 _9552_/Q _6122_/A1 PHY_9/VDD PHY_9/VDD VSUBS
+ VSUBS gf180mcu_fd_sc_mcu7t5v0__aoi22_1
X_6051_ _8689_/A1 _6059_/A2 _6059_/B1 PHY_9/VDD PHY_9/VDD VSUBS VSUBS gf180mcu_fd_sc_mcu7t5v0__nand2_2
X_5002_ _9554_/Q _5712_/B2 PHY_9/VDD PHY_9/VDD VSUBS VSUBS gf180mcu_fd_sc_mcu7t5v0__clkinv_1
X_9810_ _9810_/D _9974_/CLK _9810_/Q PHY_9/VDD PHY_9/VDD VSUBS VSUBS gf180mcu_fd_sc_mcu7t5v0__dffq_4
X_9741_ _9741_/D _9939_/CLK _9741_/Q PHY_9/VDD PHY_9/VDD VSUBS VSUBS gf180mcu_fd_sc_mcu7t5v0__dffq_1
X_6953_ _6995_/C _6952_/Z _6958_/A3 PHY_9/VDD PHY_9/VDD VSUBS VSUBS gf180mcu_fd_sc_mcu7t5v0__nand2_1
X_6884_ _6886_/A2 _6886_/A3 _6884_/Z PHY_9/VDD PHY_9/VDD VSUBS VSUBS gf180mcu_fd_sc_mcu7t5v0__and2_1
X_5904_ _5967_/B _5904_/A2 _5903_/Z _9660_/D PHY_9/VDD PHY_9/VDD VSUBS VSUBS gf180mcu_fd_sc_mcu7t5v0__and3_1
X_9672_ _9672_/D _9689_/CLK _9672_/Q PHY_9/VDD PHY_9/VDD VSUBS VSUBS gf180mcu_fd_sc_mcu7t5v0__dffq_1
X_5835_ _5832_/Z _5835_/A2 _5836_/B PHY_9/VDD PHY_9/VDD VSUBS VSUBS gf180mcu_fd_sc_mcu7t5v0__nand2_1
X_8623_ _9931_/Q _8640_/A1 _8624_/A2 _8623_/Z PHY_9/VDD PHY_9/VDD VSUBS VSUBS gf180mcu_fd_sc_mcu7t5v0__xor3_1
X_5766_ _5399_/Z _5769_/A2 _5769_/B1 _5766_/B2 _9594_/D PHY_9/VDD PHY_9/VDD VSUBS
+ VSUBS gf180mcu_fd_sc_mcu7t5v0__oai22_1
X_8554_ _8554_/A1 _8552_/Z _8598_/A1 PHY_9/VDD PHY_9/VDD VSUBS VSUBS gf180mcu_fd_sc_mcu7t5v0__xnor2_1
X_7505_ _7505_/A1 _7548_/A1 _7505_/A3 _7505_/Z PHY_9/VDD PHY_9/VDD VSUBS VSUBS gf180mcu_fd_sc_mcu7t5v0__xor3_1
X_5697_ _9547_/Q _5693_/Z _5700_/B _5698_/A2 PHY_9/VDD PHY_9/VDD VSUBS VSUBS gf180mcu_fd_sc_mcu7t5v0__oai21_1
X_8485_ _8485_/A1 _8485_/A2 _8484_/B _8485_/Z PHY_9/VDD PHY_9/VDD VSUBS VSUBS gf180mcu_fd_sc_mcu7t5v0__or3_1
X_4717_ _9923_/Q _8647_/A3 PHY_9/VDD PHY_9/VDD VSUBS VSUBS gf180mcu_fd_sc_mcu7t5v0__clkinv_4
X_7436_ _9809_/Q _7657_/A2 _7505_/A1 PHY_9/VDD PHY_9/VDD VSUBS VSUBS gf180mcu_fd_sc_mcu7t5v0__nand2_1
X_7367_ _9867_/Q _7367_/A2 _7668_/B PHY_9/VDD PHY_9/VDD VSUBS VSUBS gf180mcu_fd_sc_mcu7t5v0__nor2_4
X_9106_ _9809_/Q _9285_/A2 _9150_/A1 PHY_9/VDD PHY_9/VDD VSUBS VSUBS gf180mcu_fd_sc_mcu7t5v0__nand2_1
X_7298_ _9848_/Q _9847_/Q _9513_/Q _7300_/A1 PHY_9/VDD PHY_9/VDD VSUBS VSUBS gf180mcu_fd_sc_mcu7t5v0__nand3_1
X_6318_ _8692_/A1 _6323_/A2 _6323_/B1 _6318_/B2 _9796_/D PHY_9/VDD PHY_9/VDD VSUBS
+ VSUBS gf180mcu_fd_sc_mcu7t5v0__oai22_1
X_6249_ _9884_/Q _6288_/A2 _6288_/B1 _9947_/Q _6250_/A2 PHY_9/VDD PHY_9/VDD VSUBS
+ VSUBS gf180mcu_fd_sc_mcu7t5v0__aoi22_1
X_9037_ _9059_/A2 _9058_/A1 _9313_/A2 PHY_9/VDD PHY_9/VDD VSUBS VSUBS gf180mcu_fd_sc_mcu7t5v0__nor2_4
X_9939_ _9939_/D _9939_/CLK _9939_/Q PHY_9/VDD PHY_9/VDD VSUBS VSUBS gf180mcu_fd_sc_mcu7t5v0__dffq_1
X_5620_ _9773_/Q _5561_/I _5622_/A1 PHY_9/VDD PHY_9/VDD VSUBS VSUBS gf180mcu_fd_sc_mcu7t5v0__nand2_1
X_5551_ _5388_/Z _5558_/A2 _5558_/B1 _5551_/B2 _9481_/D PHY_9/VDD PHY_9/VDD VSUBS
+ VSUBS gf180mcu_fd_sc_mcu7t5v0__oai22_1
X_8270_ _8270_/A1 _8270_/A2 _8270_/B _8278_/A1 PHY_9/VDD PHY_9/VDD VSUBS VSUBS gf180mcu_fd_sc_mcu7t5v0__oai21_1
X_7221_ _9854_/Q _7236_/A1 _7218_/Z _7221_/Z PHY_9/VDD PHY_9/VDD VSUBS VSUBS gf180mcu_fd_sc_mcu7t5v0__xor3_1
X_5482_ _5482_/A1 _5493_/B _5482_/B _9452_/D PHY_9/VDD PHY_9/VDD VSUBS VSUBS gf180mcu_fd_sc_mcu7t5v0__aoi21_1
X_7152_ _7152_/A1 _7158_/A2 _7152_/B1 _7152_/B2 _7160_/A1 PHY_9/VDD PHY_9/VDD VSUBS
+ VSUBS gf180mcu_fd_sc_mcu7t5v0__oai22_1
X_7083_ _7078_/Z _7081_/Z _7085_/A2 PHY_9/VDD PHY_9/VDD VSUBS VSUBS gf180mcu_fd_sc_mcu7t5v0__xnor2_1
X_6103_ _9575_/Q _6287_/B1 _6288_/B1 _9934_/Q _6105_/A1 PHY_9/VDD PHY_9/VDD VSUBS
+ VSUBS gf180mcu_fd_sc_mcu7t5v0__aoi22_1
X_6034_ _8692_/A1 _6039_/A2 _6039_/B1 _6034_/B2 _9748_/D PHY_9/VDD PHY_9/VDD VSUBS
+ VSUBS gf180mcu_fd_sc_mcu7t5v0__oai22_1
X_7985_ _9811_/Q _7800_/Z _7986_/A3 PHY_9/VDD PHY_9/VDD VSUBS VSUBS gf180mcu_fd_sc_mcu7t5v0__nand2_1
X_6936_ _6936_/A1 _6935_/B _6936_/Z PHY_9/VDD PHY_9/VDD VSUBS VSUBS gf180mcu_fd_sc_mcu7t5v0__xor2_1
X_9724_ _9724_/D _9800_/CLK _9724_/Q PHY_9/VDD PHY_9/VDD VSUBS VSUBS gf180mcu_fd_sc_mcu7t5v0__dffq_1
X_6867_ _6920_/A1 _6920_/A2 _9090_/C _6916_/A1 PHY_9/VDD PHY_9/VDD VSUBS VSUBS gf180mcu_fd_sc_mcu7t5v0__aoi21_2
X_9655_ _9655_/D _9972_/CLK _9655_/Q PHY_9/VDD PHY_9/VDD VSUBS VSUBS gf180mcu_fd_sc_mcu7t5v0__dffq_1
X_9586_ _9586_/D _9939_/CLK _9586_/Q PHY_9/VDD PHY_9/VDD VSUBS VSUBS gf180mcu_fd_sc_mcu7t5v0__dffq_1
X_6798_ _9810_/Q _6797_/Z _6843_/B PHY_9/VDD PHY_9/VDD VSUBS VSUBS gf180mcu_fd_sc_mcu7t5v0__nand2_1
X_5818_ _8691_/A1 _5824_/A2 _5824_/B1 _5818_/B2 _9632_/D PHY_9/VDD PHY_9/VDD VSUBS
+ VSUBS gf180mcu_fd_sc_mcu7t5v0__oai22_1
X_8606_ _9813_/Q _8606_/A2 _8655_/A1 PHY_9/VDD PHY_9/VDD VSUBS VSUBS gf180mcu_fd_sc_mcu7t5v0__nand2_1
X_5749_ _5406_/Z _5749_/A2 _5749_/B1 _5749_/B2 _9581_/D PHY_9/VDD PHY_9/VDD VSUBS
+ VSUBS gf180mcu_fd_sc_mcu7t5v0__oai22_1
X_8537_ _9811_/Q _8537_/A2 _8537_/B1 _8673_/I1 _8674_/B _8538_/B2 PHY_9/VDD PHY_9/VDD
+ VSUBS VSUBS gf180mcu_fd_sc_mcu7t5v0__aoi221_1
X_8468_ _9810_/Q _8606_/A2 _8511_/A2 PHY_9/VDD PHY_9/VDD VSUBS VSUBS gf180mcu_fd_sc_mcu7t5v0__nand2_1
X_7419_ _7413_/I _7420_/A2 _7419_/B _7421_/A1 PHY_9/VDD PHY_9/VDD VSUBS VSUBS gf180mcu_fd_sc_mcu7t5v0__oai21_1
X_8399_ _8647_/A2 _9499_/Q _9923_/Q _8401_/A3 PHY_9/VDD PHY_9/VDD VSUBS VSUBS gf180mcu_fd_sc_mcu7t5v0__aoi21_2
X_4982_ _9618_/Q _5800_/B2 PHY_9/VDD PHY_9/VDD VSUBS VSUBS gf180mcu_fd_sc_mcu7t5v0__clkinv_1
X_7770_ _7770_/A1 _7764_/Z _7770_/B _7782_/A1 PHY_9/VDD PHY_9/VDD VSUBS VSUBS gf180mcu_fd_sc_mcu7t5v0__aoi21_1
X_6721_ _6996_/A1 _6746_/A1 _6955_/C _6722_/B PHY_9/VDD PHY_9/VDD VSUBS VSUBS gf180mcu_fd_sc_mcu7t5v0__aoi21_1
X_6652_ _6611_/C _6647_/Z _6652_/B _6652_/C _6653_/A2 PHY_9/VDD PHY_9/VDD VSUBS VSUBS
+ gf180mcu_fd_sc_mcu7t5v0__aoi211_1
X_9440_ _9440_/D _9972_/CLK _9440_/Q PHY_9/VDD PHY_9/VDD VSUBS VSUBS gf180mcu_fd_sc_mcu7t5v0__dffq_1
X_9371_ _9371_/D _9957_/CLK _9371_/Q PHY_9/VDD PHY_9/VDD VSUBS VSUBS gf180mcu_fd_sc_mcu7t5v0__dffq_1
X_5603_ _9774_/Q _9034_/A2 _8706_/B _5604_/B PHY_9/VDD PHY_9/VDD VSUBS VSUBS gf180mcu_fd_sc_mcu7t5v0__oai21_1
X_6583_ _6613_/B _6558_/B _6583_/A3 _6583_/A4 _6585_/A1 PHY_9/VDD PHY_9/VDD VSUBS
+ VSUBS gf180mcu_fd_sc_mcu7t5v0__nor4_1
X_8322_ _8322_/A1 _8322_/A2 _8322_/Z PHY_9/VDD PHY_9/VDD VSUBS VSUBS gf180mcu_fd_sc_mcu7t5v0__xor2_1
X_5534_ _5973_/C _5534_/A2 _9471_/D PHY_9/VDD PHY_9/VDD VSUBS VSUBS gf180mcu_fd_sc_mcu7t5v0__nor2_1
X_5465_ _5482_/A1 _5495_/B _5465_/B _9444_/D PHY_9/VDD PHY_9/VDD VSUBS VSUBS gf180mcu_fd_sc_mcu7t5v0__aoi21_1
X_8253_ _8253_/A1 _8253_/A2 _9357_/B _9909_/D PHY_9/VDD PHY_9/VDD VSUBS VSUBS gf180mcu_fd_sc_mcu7t5v0__aoi21_1
X_7204_ _9812_/Q _7254_/A2 _7256_/A1 PHY_9/VDD PHY_9/VDD VSUBS VSUBS gf180mcu_fd_sc_mcu7t5v0__nand2_1
X_8184_ _8285_/A1 _8285_/A2 _8186_/A2 PHY_9/VDD PHY_9/VDD VSUBS VSUBS gf180mcu_fd_sc_mcu7t5v0__xnor2_1
X_7135_ _9810_/Q _7293_/A2 _7250_/A1 PHY_9/VDD PHY_9/VDD VSUBS VSUBS gf180mcu_fd_sc_mcu7t5v0__nand2_2
X_5396_ _5396_/A1 _5201_/Z _5397_/B PHY_9/VDD PHY_9/VDD VSUBS VSUBS gf180mcu_fd_sc_mcu7t5v0__nor2_1
X_7066_ _7066_/I _7074_/A1 PHY_9/VDD PHY_9/VDD VSUBS VSUBS gf180mcu_fd_sc_mcu7t5v0__clkinv_1
X_6017_ _5404_/Z _6018_/A2 _6018_/B1 _6017_/B2 _9720_/D PHY_9/VDD PHY_9/VDD VSUBS
+ VSUBS gf180mcu_fd_sc_mcu7t5v0__oai22_1
X_7968_ _6613_/B _7967_/Z _7969_/B PHY_9/VDD PHY_9/VDD VSUBS VSUBS gf180mcu_fd_sc_mcu7t5v0__xor2_1
X_9707_ _9707_/D _9939_/CLK _9707_/Q PHY_9/VDD PHY_9/VDD VSUBS VSUBS gf180mcu_fd_sc_mcu7t5v0__dffq_1
X_6919_ _6872_/Z _6919_/A2 _6919_/B _6936_/A1 PHY_9/VDD PHY_9/VDD VSUBS VSUBS gf180mcu_fd_sc_mcu7t5v0__aoi21_1
X_7899_ _7897_/B _7899_/A2 _7899_/A3 _7900_/B PHY_9/VDD PHY_9/VDD VSUBS VSUBS gf180mcu_fd_sc_mcu7t5v0__xnor3_1
X_9638_ _9638_/D _9948_/CLK _9638_/Q PHY_9/VDD PHY_9/VDD VSUBS VSUBS gf180mcu_fd_sc_mcu7t5v0__dffq_1
X_9569_ _9569_/D _9901_/CLK _9569_/Q PHY_9/VDD PHY_9/VDD VSUBS VSUBS gf180mcu_fd_sc_mcu7t5v0__dffq_1
X_5250_ _5262_/A1 _5132_/Z _5224_/Z _5260_/A2 PHY_9/VDD PHY_9/VDD VSUBS VSUBS gf180mcu_fd_sc_mcu7t5v0__nand3_4
X_5181_ _9543_/Q _9542_/Q _9545_/Q _9544_/Q _5182_/A4 PHY_9/VDD PHY_9/VDD VSUBS VSUBS
+ gf180mcu_fd_sc_mcu7t5v0__nor4_4
X_8940_ _8940_/A1 _8921_/Z _8940_/B _8990_/A1 PHY_9/VDD PHY_9/VDD VSUBS VSUBS gf180mcu_fd_sc_mcu7t5v0__aoi21_1
X_8871_ _8872_/A1 _8870_/Z _8892_/A2 PHY_9/VDD PHY_9/VDD VSUBS VSUBS gf180mcu_fd_sc_mcu7t5v0__nand2_1
X_7822_ _9810_/Q _7821_/Z _7863_/B PHY_9/VDD PHY_9/VDD VSUBS VSUBS gf180mcu_fd_sc_mcu7t5v0__and2_1
X_4965_ _9601_/Q _5777_/B2 PHY_9/VDD PHY_9/VDD VSUBS VSUBS gf180mcu_fd_sc_mcu7t5v0__clkinv_1
X_7753_ _7805_/A1 _7805_/A2 _9808_/Q _7805_/C _7776_/B PHY_9/VDD PHY_9/VDD VSUBS VSUBS
+ gf180mcu_fd_sc_mcu7t5v0__oai211_4
X_6704_ _9356_/C _6704_/A2 _6705_/B2 PHY_9/VDD PHY_9/VDD VSUBS VSUBS gf180mcu_fd_sc_mcu7t5v0__nor2_1
X_7684_ _8695_/A1 _7686_/A2 _7686_/B1 _7684_/B2 _9883_/D PHY_9/VDD PHY_9/VDD VSUBS
+ VSUBS gf180mcu_fd_sc_mcu7t5v0__oai22_1
X_9423_ _9423_/D _9830_/CLK _9423_/Q PHY_9/VDD PHY_9/VDD VSUBS VSUBS gf180mcu_fd_sc_mcu7t5v0__dffq_1
X_4896_ _9778_/Q _6296_/B2 PHY_9/VDD PHY_9/VDD VSUBS VSUBS gf180mcu_fd_sc_mcu7t5v0__clkinv_1
X_6635_ _6635_/A1 _6635_/A2 _6635_/B1 _6635_/B2 _6636_/A2 PHY_9/VDD PHY_9/VDD VSUBS
+ VSUBS gf180mcu_fd_sc_mcu7t5v0__oai22_1
X_6566_ _6566_/A1 _6566_/A2 _6566_/Z PHY_9/VDD PHY_9/VDD VSUBS VSUBS gf180mcu_fd_sc_mcu7t5v0__and2_1
X_9354_ _9354_/A1 _9353_/Z _9355_/B PHY_9/VDD PHY_9/VDD VSUBS VSUBS gf180mcu_fd_sc_mcu7t5v0__nand2_1
X_9285_ _9813_/Q _9285_/A2 _9332_/A1 PHY_9/VDD PHY_9/VDD VSUBS VSUBS gf180mcu_fd_sc_mcu7t5v0__nand2_1
X_5517_ _5517_/A1 _5522_/B _5517_/B1 _5517_/B2 _5973_/C _9465_/D PHY_9/VDD PHY_9/VDD
+ VSUBS VSUBS gf180mcu_fd_sc_mcu7t5v0__aoi221_1
X_8305_ _8305_/A1 _8305_/A2 _9357_/B _9910_/D PHY_9/VDD PHY_9/VDD VSUBS VSUBS gf180mcu_fd_sc_mcu7t5v0__aoi21_1
X_6497_ _6498_/A1 _6496_/Z _6543_/A2 PHY_9/VDD PHY_9/VDD VSUBS VSUBS gf180mcu_fd_sc_mcu7t5v0__nand2_1
X_8236_ _9909_/Q _8234_/Z _8255_/B PHY_9/VDD PHY_9/VDD VSUBS VSUBS gf180mcu_fd_sc_mcu7t5v0__nand2_1
X_5448_ _5482_/A1 _5458_/A2 _5448_/B _9436_/D PHY_9/VDD PHY_9/VDD VSUBS VSUBS gf180mcu_fd_sc_mcu7t5v0__aoi21_1
X_8167_ _8169_/B1 _8169_/B2 _8168_/B PHY_9/VDD PHY_9/VDD VSUBS VSUBS gf180mcu_fd_sc_mcu7t5v0__nor2_1
X_5379_ _6089_/B _5379_/A2 _5705_/A1 PHY_9/VDD PHY_9/VDD VSUBS VSUBS gf180mcu_fd_sc_mcu7t5v0__nand2_4
X_7118_ _7119_/A1 _7082_/Z _7118_/B _7144_/B PHY_9/VDD PHY_9/VDD VSUBS VSUBS gf180mcu_fd_sc_mcu7t5v0__oai21_1
X_8098_ _9807_/Q _8097_/Z _8098_/Z PHY_9/VDD PHY_9/VDD VSUBS VSUBS gf180mcu_fd_sc_mcu7t5v0__and2_1
X_7049_ _7254_/A2 _7051_/A3 _7049_/Z PHY_9/VDD PHY_9/VDD VSUBS VSUBS gf180mcu_fd_sc_mcu7t5v0__xor2_1
X_4750_ _9877_/Q _7676_/A1 PHY_9/VDD PHY_9/VDD VSUBS VSUBS gf180mcu_fd_sc_mcu7t5v0__clkinv_2
X_4681_ _9971_/Q _9221_/A1 PHY_9/VDD PHY_9/VDD VSUBS VSUBS gf180mcu_fd_sc_mcu7t5v0__clkinv_3
X_6420_ _9809_/Q _6624_/A2 _6584_/B1 _9808_/Q _6448_/B1 PHY_9/VDD PHY_9/VDD VSUBS
+ VSUBS gf180mcu_fd_sc_mcu7t5v0__aoi22_1
X_6351_ _9836_/Q _9806_/Q _9805_/Q _6355_/B PHY_9/VDD PHY_9/VDD VSUBS VSUBS gf180mcu_fd_sc_mcu7t5v0__nand3_2
X_5302_ _9390_/Q _5307_/A2 _5303_/B PHY_9/VDD PHY_9/VDD VSUBS VSUBS gf180mcu_fd_sc_mcu7t5v0__nor2_1
X_6282_ _6282_/A1 _6282_/A2 _6283_/B1 PHY_9/VDD PHY_9/VDD VSUBS VSUBS gf180mcu_fd_sc_mcu7t5v0__nand2_1
X_9070_ _9098_/A1 _9070_/A2 _9356_/C _9071_/B2 PHY_9/VDD PHY_9/VDD VSUBS VSUBS gf180mcu_fd_sc_mcu7t5v0__aoi21_1
X_8021_ _9374_/Q _9036_/A2 _8027_/B _8022_/B PHY_9/VDD PHY_9/VDD VSUBS VSUBS gf180mcu_fd_sc_mcu7t5v0__oai21_1
X_5233_ _9463_/Q _5236_/A2 _9035_/B _5234_/B PHY_9/VDD PHY_9/VDD VSUBS VSUBS gf180mcu_fd_sc_mcu7t5v0__oai21_1
X_5164_ _9480_/Q _5164_/A2 _5163_/Z _9478_/Q _5165_/A2 PHY_9/VDD PHY_9/VDD VSUBS VSUBS
+ gf180mcu_fd_sc_mcu7t5v0__aoi22_1
X_5095_ _9597_/Q _5769_/B2 PHY_9/VDD PHY_9/VDD VSUBS VSUBS gf180mcu_fd_sc_mcu7t5v0__clkinv_1
X_9972_ _9972_/D _9972_/CLK _9972_/Q PHY_9/VDD PHY_9/VDD VSUBS VSUBS gf180mcu_fd_sc_mcu7t5v0__dffq_4
X_8923_ _9959_/Q _8940_/A1 _8924_/A2 _8923_/Z PHY_9/VDD PHY_9/VDD VSUBS VSUBS gf180mcu_fd_sc_mcu7t5v0__xor3_1
X_8854_ _8854_/I _8855_/A2 PHY_9/VDD PHY_9/VDD VSUBS VSUBS gf180mcu_fd_sc_mcu7t5v0__clkinv_1
X_7805_ _7805_/A1 _7805_/A2 _9810_/Q _7805_/C _7845_/B PHY_9/VDD PHY_9/VDD VSUBS VSUBS
+ gf180mcu_fd_sc_mcu7t5v0__oai211_2
X_5997_ _5404_/Z _5998_/A2 _5998_/B1 _5997_/B2 _9704_/D PHY_9/VDD PHY_9/VDD VSUBS
+ VSUBS gf180mcu_fd_sc_mcu7t5v0__oai22_1
X_8785_ _9090_/C _8784_/I _8816_/B2 PHY_9/VDD PHY_9/VDD VSUBS VSUBS gf180mcu_fd_sc_mcu7t5v0__nor2_1
X_7736_ _7994_/A1 _9889_/Q _9837_/Q _7740_/B1 PHY_9/VDD PHY_9/VDD VSUBS VSUBS gf180mcu_fd_sc_mcu7t5v0__nand3_2
X_4948_ _9528_/Q _5651_/B2 PHY_9/VDD PHY_9/VDD VSUBS VSUBS gf180mcu_fd_sc_mcu7t5v0__clkinv_1
X_4879_ _9754_/Q _6042_/B2 PHY_9/VDD PHY_9/VDD VSUBS VSUBS gf180mcu_fd_sc_mcu7t5v0__clkinv_1
X_7667_ _7667_/I0 _7667_/I1 _7667_/S _7668_/C PHY_9/VDD PHY_9/VDD VSUBS VSUBS gf180mcu_fd_sc_mcu7t5v0__mux2_1
X_6618_ _9821_/Q _9356_/C _6618_/B1 _6618_/B2 _6619_/A2 PHY_9/VDD PHY_9/VDD VSUBS
+ VSUBS gf180mcu_fd_sc_mcu7t5v0__aoi22_1
X_9406_ _9406_/D _9901_/CLK _9406_/Q PHY_9/VDD PHY_9/VDD VSUBS VSUBS gf180mcu_fd_sc_mcu7t5v0__dffq_1
X_7598_ _9811_/Q _7657_/A2 _7646_/B2 PHY_9/VDD PHY_9/VDD VSUBS VSUBS gf180mcu_fd_sc_mcu7t5v0__nand2_1
X_6549_ _6501_/Z _6503_/Z _6549_/B _6566_/A2 PHY_9/VDD PHY_9/VDD VSUBS VSUBS gf180mcu_fd_sc_mcu7t5v0__oai21_1
X_9337_ _9337_/A1 _9337_/A2 _9336_/Z _9337_/Z PHY_9/VDD PHY_9/VDD VSUBS VSUBS gf180mcu_fd_sc_mcu7t5v0__xor3_1
X_9268_ _9268_/A1 _9273_/A1 _9243_/Z _9268_/B _9296_/A1 PHY_9/VDD PHY_9/VDD VSUBS
+ VSUBS gf180mcu_fd_sc_mcu7t5v0__oai31_1
X_8219_ _8219_/A1 _8214_/Z _8314_/A1 _8219_/Z PHY_9/VDD PHY_9/VDD VSUBS VSUBS gf180mcu_fd_sc_mcu7t5v0__xor3_1
X_9199_ _9154_/Z _9297_/B2 _9221_/A2 PHY_9/VDD PHY_9/VDD VSUBS VSUBS gf180mcu_fd_sc_mcu7t5v0__xnor2_1
X_5920_ _9665_/Q _5916_/Z _5932_/B _5921_/A2 PHY_9/VDD PHY_9/VDD VSUBS VSUBS gf180mcu_fd_sc_mcu7t5v0__oai21_1
X_5851_ _9463_/Q _5867_/A2 _5851_/B _5852_/A2 PHY_9/VDD PHY_9/VDD VSUBS VSUBS gf180mcu_fd_sc_mcu7t5v0__aoi21_1
X_5782_ _5406_/Z _5782_/A2 _5782_/B1 _5782_/B2 _9606_/D PHY_9/VDD PHY_9/VDD VSUBS
+ VSUBS gf180mcu_fd_sc_mcu7t5v0__oai22_1
X_4802_ _9806_/Q _6333_/A1 PHY_9/VDD PHY_9/VDD VSUBS VSUBS gf180mcu_fd_sc_mcu7t5v0__clkinv_1
X_8570_ _8570_/A1 _8568_/Z _8570_/Z PHY_9/VDD PHY_9/VDD VSUBS VSUBS gf180mcu_fd_sc_mcu7t5v0__xor2_1
X_7521_ _7572_/A1 _7521_/A2 _7521_/Z PHY_9/VDD PHY_9/VDD VSUBS VSUBS gf180mcu_fd_sc_mcu7t5v0__xor2_1
X_4733_ _9375_/Q _5268_/A1 PHY_9/VDD PHY_9/VDD VSUBS VSUBS gf180mcu_fd_sc_mcu7t5v0__clkinv_1
X_7452_ _9894_/Q _7450_/Z _7457_/A1 PHY_9/VDD PHY_9/VDD VSUBS VSUBS gf180mcu_fd_sc_mcu7t5v0__nand2_1
X_6403_ _9808_/Q _6408_/A2 _6584_/B1 _6423_/A1 PHY_9/VDD PHY_9/VDD VSUBS VSUBS gf180mcu_fd_sc_mcu7t5v0__nand3_2
X_7383_ _9865_/Q _7384_/A2 _7572_/B PHY_9/VDD PHY_9/VDD VSUBS VSUBS gf180mcu_fd_sc_mcu7t5v0__and2_1
X_9122_ _9122_/A1 _9121_/B _9122_/Z PHY_9/VDD PHY_9/VDD VSUBS VSUBS gf180mcu_fd_sc_mcu7t5v0__xor2_1
X_6334_ _9506_/Q _9034_/A2 _8706_/B _6335_/B PHY_9/VDD PHY_9/VDD VSUBS VSUBS gf180mcu_fd_sc_mcu7t5v0__oai21_1
X_9053_ _9964_/Q _9065_/A2 _9347_/I0 PHY_9/VDD PHY_9/VDD VSUBS VSUBS gf180mcu_fd_sc_mcu7t5v0__nor2_1
X_6265_ _9801_/Q _6287_/A2 _6287_/B1 _9565_/Q _6267_/A1 PHY_9/VDD PHY_9/VDD VSUBS
+ VSUBS gf180mcu_fd_sc_mcu7t5v0__aoi22_1
X_5216_ _5770_/B _9726_/Q _9734_/D PHY_9/VDD PHY_9/VDD VSUBS VSUBS gf180mcu_fd_sc_mcu7t5v0__and2_1
X_8004_ _8005_/A1 _8003_/Z _8004_/B _8005_/B PHY_9/VDD PHY_9/VDD VSUBS VSUBS gf180mcu_fd_sc_mcu7t5v0__aoi21_1
X_6196_ _9916_/Q _6287_/A2 _6287_/B1 _9861_/Q _6198_/A1 PHY_9/VDD PHY_9/VDD VSUBS
+ VSUBS gf180mcu_fd_sc_mcu7t5v0__aoi22_1
X_5147_ _5770_/B _9724_/Q _5219_/A1 _5222_/A2 _5150_/A2 PHY_9/VDD PHY_9/VDD VSUBS
+ VSUBS gf180mcu_fd_sc_mcu7t5v0__nand4_1
X_5078_ _9621_/Q _5803_/B2 PHY_9/VDD PHY_9/VDD VSUBS VSUBS gf180mcu_fd_sc_mcu7t5v0__clkinv_1
X_9955_ _9955_/D _9974_/CLK _9955_/Q PHY_9/VDD PHY_9/VDD VSUBS VSUBS gf180mcu_fd_sc_mcu7t5v0__dffq_2
X_8906_ _9812_/Q _9004_/A2 _8999_/B2 PHY_9/VDD PHY_9/VDD VSUBS VSUBS gf180mcu_fd_sc_mcu7t5v0__nand2_1
X_9886_ _9886_/D _9974_/CLK _9886_/Q PHY_9/VDD PHY_9/VDD VSUBS VSUBS gf180mcu_fd_sc_mcu7t5v0__dffq_2
X_8837_ _8837_/A1 _8837_/A2 _8837_/B _8875_/B PHY_9/VDD PHY_9/VDD VSUBS VSUBS gf180mcu_fd_sc_mcu7t5v0__aoi21_1
X_8768_ _8768_/A1 _9091_/B _8885_/A1 _8983_/A1 _8790_/A1 _8769_/B PHY_9/VDD PHY_9/VDD
+ VSUBS VSUBS gf180mcu_fd_sc_mcu7t5v0__oai32_1
X_7719_ _9886_/Q _7719_/A2 _8016_/A1 PHY_9/VDD PHY_9/VDD VSUBS VSUBS gf180mcu_fd_sc_mcu7t5v0__nand2_1
X_8699_ _8740_/A3 _9036_/A2 _8699_/B _9949_/D PHY_9/VDD PHY_9/VDD VSUBS VSUBS gf180mcu_fd_sc_mcu7t5v0__aoi21_1
X_6050_ _8688_/A1 _6290_/B2 _6059_/A2 PHY_9/VDD PHY_9/VDD VSUBS VSUBS gf180mcu_fd_sc_mcu7t5v0__nand2_4
X_5001_ _9578_/Q _5746_/B2 PHY_9/VDD PHY_9/VDD VSUBS VSUBS gf180mcu_fd_sc_mcu7t5v0__clkinv_1
X_9740_ _9740_/D _9939_/CLK _9740_/Q PHY_9/VDD PHY_9/VDD VSUBS VSUBS gf180mcu_fd_sc_mcu7t5v0__dffq_1
X_6952_ _6988_/A1 _6951_/Z _6952_/Z PHY_9/VDD PHY_9/VDD VSUBS VSUBS gf180mcu_fd_sc_mcu7t5v0__xor2_1
X_6883_ _6883_/A1 _6883_/A2 _6886_/A3 PHY_9/VDD PHY_9/VDD VSUBS VSUBS gf180mcu_fd_sc_mcu7t5v0__xnor2_1
X_5903_ _9660_/Q _5906_/A2 _5903_/Z PHY_9/VDD PHY_9/VDD VSUBS VSUBS gf180mcu_fd_sc_mcu7t5v0__xor2_1
X_9671_ _9671_/D _9689_/CLK _9671_/Q PHY_9/VDD PHY_9/VDD VSUBS VSUBS gf180mcu_fd_sc_mcu7t5v0__dffq_1
X_5834_ _9640_/Q _5832_/Z _5961_/B _5837_/A1 PHY_9/VDD PHY_9/VDD VSUBS VSUBS gf180mcu_fd_sc_mcu7t5v0__oai21_1
X_8622_ _9931_/Q _8624_/A2 _8640_/A2 PHY_9/VDD PHY_9/VDD VSUBS VSUBS gf180mcu_fd_sc_mcu7t5v0__nor2_1
X_5765_ _8693_/A1 _5769_/A2 _5769_/B1 _5765_/B2 _9593_/D PHY_9/VDD PHY_9/VDD VSUBS
+ VSUBS gf180mcu_fd_sc_mcu7t5v0__oai22_1
X_8553_ _9807_/Q _8644_/A2 _8552_/Z _8595_/A2 PHY_9/VDD PHY_9/VDD VSUBS VSUBS gf180mcu_fd_sc_mcu7t5v0__nand3_1
X_7504_ _9091_/B _9090_/C _7504_/A3 _7572_/A1 _7541_/B PHY_9/VDD PHY_9/VDD VSUBS VSUBS
+ gf180mcu_fd_sc_mcu7t5v0__nor4_2
X_5696_ _9547_/Q _5693_/Z _5696_/Z PHY_9/VDD PHY_9/VDD VSUBS VSUBS gf180mcu_fd_sc_mcu7t5v0__and2_1
X_8484_ _8485_/A1 _8485_/A2 _8484_/B _8525_/B PHY_9/VDD PHY_9/VDD VSUBS VSUBS gf180mcu_fd_sc_mcu7t5v0__oai21_1
X_4716_ _9372_/Q _5260_/A1 PHY_9/VDD PHY_9/VDD VSUBS VSUBS gf180mcu_fd_sc_mcu7t5v0__clkinv_1
X_7435_ _9809_/Q _7657_/A2 _7435_/Z PHY_9/VDD PHY_9/VDD VSUBS VSUBS gf180mcu_fd_sc_mcu7t5v0__and2_1
X_7366_ _7370_/A1 _7367_/A2 _7668_/A2 PHY_9/VDD PHY_9/VDD VSUBS VSUBS gf180mcu_fd_sc_mcu7t5v0__nor2_4
X_9105_ _9809_/Q _9331_/A2 _9109_/A3 PHY_9/VDD PHY_9/VDD VSUBS VSUBS gf180mcu_fd_sc_mcu7t5v0__nand2_1
X_6317_ _8691_/A1 _6323_/A2 _6323_/B1 _6317_/B2 _9795_/D PHY_9/VDD PHY_9/VDD VSUBS
+ VSUBS gf180mcu_fd_sc_mcu7t5v0__oai22_1
X_7297_ _7297_/A1 _7297_/A2 _7255_/Z _7297_/B2 _7305_/A1 PHY_9/VDD PHY_9/VDD VSUBS
+ VSUBS gf180mcu_fd_sc_mcu7t5v0__oai22_1
X_6248_ _9918_/Q _6287_/A2 _6287_/B1 _9863_/Q _6250_/A1 PHY_9/VDD PHY_9/VDD VSUBS
+ VSUBS gf180mcu_fd_sc_mcu7t5v0__aoi22_1
X_9036_ _9327_/A1 _9036_/A2 _9036_/B _9966_/D PHY_9/VDD PHY_9/VDD VSUBS VSUBS gf180mcu_fd_sc_mcu7t5v0__aoi21_1
X_6179_ _9782_/Q _6288_/A2 _6288_/B1 _9827_/Q _6180_/A2 PHY_9/VDD PHY_9/VDD VSUBS
+ VSUBS gf180mcu_fd_sc_mcu7t5v0__aoi22_1
X_9938_ _9938_/D _9940_/CLK _9938_/Q PHY_9/VDD PHY_9/VDD VSUBS VSUBS gf180mcu_fd_sc_mcu7t5v0__dffq_1
X_9869_ _9869_/D _9907_/CLK _9869_/Q PHY_9/VDD PHY_9/VDD VSUBS VSUBS gf180mcu_fd_sc_mcu7t5v0__dffq_4
X_5550_ _9031_/B _5558_/A2 _5558_/B1 PHY_9/VDD PHY_9/VDD VSUBS VSUBS gf180mcu_fd_sc_mcu7t5v0__nand2_2
X_5481_ _9452_/Q _5493_/B _5770_/B _5482_/B PHY_9/VDD PHY_9/VDD VSUBS VSUBS gf180mcu_fd_sc_mcu7t5v0__oai21_1
X_7220_ _9854_/Q _7218_/Z _7236_/B PHY_9/VDD PHY_9/VDD VSUBS VSUBS gf180mcu_fd_sc_mcu7t5v0__and2_1
X_7151_ _7237_/A1 _7151_/A2 _7151_/Z PHY_9/VDD PHY_9/VDD VSUBS VSUBS gf180mcu_fd_sc_mcu7t5v0__or2_1
X_7082_ _7078_/Z _7081_/Z _7082_/Z PHY_9/VDD PHY_9/VDD VSUBS VSUBS gf180mcu_fd_sc_mcu7t5v0__and2_1
X_6102_ _6102_/A1 _6102_/A2 _6116_/A2 PHY_9/VDD PHY_9/VDD VSUBS VSUBS gf180mcu_fd_sc_mcu7t5v0__nand2_1
X_6033_ _8691_/A1 _6039_/A2 _6039_/B1 _6033_/B2 _9747_/D PHY_9/VDD PHY_9/VDD VSUBS
+ VSUBS gf180mcu_fd_sc_mcu7t5v0__oai22_1
X_7984_ _9349_/A1 _7988_/A2 _7987_/A2 PHY_9/VDD PHY_9/VDD VSUBS VSUBS gf180mcu_fd_sc_mcu7t5v0__nor2_1
X_6935_ _6919_/B _6935_/A2 _6935_/B _6964_/B PHY_9/VDD PHY_9/VDD VSUBS VSUBS gf180mcu_fd_sc_mcu7t5v0__oai21_1
X_9723_ _9723_/D _9800_/CLK _9723_/Q PHY_9/VDD PHY_9/VDD VSUBS VSUBS gf180mcu_fd_sc_mcu7t5v0__dffq_1
X_6866_ _6920_/A1 _6920_/A2 _6977_/A2 PHY_9/VDD PHY_9/VDD VSUBS VSUBS gf180mcu_fd_sc_mcu7t5v0__nand2_2
X_9654_ _9654_/D _9689_/CLK _9654_/Q PHY_9/VDD PHY_9/VDD VSUBS VSUBS gf180mcu_fd_sc_mcu7t5v0__dffq_1
X_9585_ _9585_/D _9939_/CLK _9585_/Q PHY_9/VDD PHY_9/VDD VSUBS VSUBS gf180mcu_fd_sc_mcu7t5v0__dffq_1
X_6797_ _6966_/A2 _6845_/A1 _6797_/Z PHY_9/VDD PHY_9/VDD VSUBS VSUBS gf180mcu_fd_sc_mcu7t5v0__xor2_1
X_5817_ _5388_/Z _5824_/A2 _5824_/B1 _5817_/B2 _9631_/D PHY_9/VDD PHY_9/VDD VSUBS
+ VSUBS gf180mcu_fd_sc_mcu7t5v0__oai22_1
X_8605_ _9813_/Q _8654_/A2 _8608_/A3 PHY_9/VDD PHY_9/VDD VSUBS VSUBS gf180mcu_fd_sc_mcu7t5v0__nand2_1
X_5748_ _5404_/Z _5749_/A2 _5749_/B1 _5748_/B2 _9580_/D PHY_9/VDD PHY_9/VDD VSUBS
+ VSUBS gf180mcu_fd_sc_mcu7t5v0__oai22_1
X_8536_ _9811_/Q _8600_/A2 _8537_/B1 PHY_9/VDD PHY_9/VDD VSUBS VSUBS gf180mcu_fd_sc_mcu7t5v0__nand2_1
X_5679_ _9541_/Q _5676_/Z _5680_/A3 PHY_9/VDD PHY_9/VDD VSUBS VSUBS gf180mcu_fd_sc_mcu7t5v0__nor2_1
X_8467_ _6471_/B _8369_/Z _8471_/A3 PHY_9/VDD PHY_9/VDD VSUBS VSUBS gf180mcu_fd_sc_mcu7t5v0__nor2_1
X_7418_ _9807_/Q _7657_/A2 _7419_/B PHY_9/VDD PHY_9/VDD VSUBS VSUBS gf180mcu_fd_sc_mcu7t5v0__nand2_1
X_8398_ _9955_/Q _8647_/A2 _8401_/A2 PHY_9/VDD PHY_9/VDD VSUBS VSUBS gf180mcu_fd_sc_mcu7t5v0__nor2_2
X_7349_ _9891_/Q _7553_/B _7446_/A3 PHY_9/VDD PHY_9/VDD VSUBS VSUBS gf180mcu_fd_sc_mcu7t5v0__nor2_2
X_9019_ _9019_/A1 _9016_/Z _9019_/A3 _9019_/Z PHY_9/VDD PHY_9/VDD VSUBS VSUBS gf180mcu_fd_sc_mcu7t5v0__xor3_1
X_4981_ _9517_/Q _5642_/B2 PHY_9/VDD PHY_9/VDD VSUBS VSUBS gf180mcu_fd_sc_mcu7t5v0__clkinv_1
X_6720_ _9808_/Q _6781_/A2 _6781_/A3 _6746_/A1 PHY_9/VDD PHY_9/VDD VSUBS VSUBS gf180mcu_fd_sc_mcu7t5v0__nand3_2
X_6651_ _6651_/A1 _6651_/A2 _6645_/Z _6614_/B _6651_/C _6652_/C PHY_9/VDD PHY_9/VDD
+ VSUBS VSUBS gf180mcu_fd_sc_mcu7t5v0__oai221_1
X_6582_ _9813_/Q _6584_/B1 _6635_/A2 PHY_9/VDD PHY_9/VDD VSUBS VSUBS gf180mcu_fd_sc_mcu7t5v0__nand2_1
X_9370_ _9370_/D _9957_/CLK _9370_/Q PHY_9/VDD PHY_9/VDD VSUBS VSUBS gf180mcu_fd_sc_mcu7t5v0__dffq_1
X_5602_ _9138_/A1 _9036_/A2 _5602_/B _9501_/D PHY_9/VDD PHY_9/VDD VSUBS VSUBS gf180mcu_fd_sc_mcu7t5v0__aoi21_1
X_8321_ _9808_/Q _8333_/A2 _8322_/A2 PHY_9/VDD PHY_9/VDD VSUBS VSUBS gf180mcu_fd_sc_mcu7t5v0__nand2_1
X_5533_ _9444_/Q _5525_/Z _5544_/A2 _9471_/Q _5534_/A2 PHY_9/VDD PHY_9/VDD VSUBS VSUBS
+ gf180mcu_fd_sc_mcu7t5v0__aoi22_1
X_5464_ _9444_/Q _5495_/B _5474_/B _5465_/B PHY_9/VDD PHY_9/VDD VSUBS VSUBS gf180mcu_fd_sc_mcu7t5v0__oai21_1
X_8252_ _8156_/B _8252_/A2 _8252_/B _9317_/C _8253_/A2 PHY_9/VDD PHY_9/VDD VSUBS VSUBS
+ gf180mcu_fd_sc_mcu7t5v0__oai211_1
X_7203_ _9812_/Q _7019_/I _7297_/A1 PHY_9/VDD PHY_9/VDD VSUBS VSUBS gf180mcu_fd_sc_mcu7t5v0__nand2_2
X_5395_ _5395_/A1 _5407_/A2 _8692_/A1 _5407_/B2 _9420_/D PHY_9/VDD PHY_9/VDD VSUBS
+ VSUBS gf180mcu_fd_sc_mcu7t5v0__oai22_1
X_8183_ _8285_/A1 _8285_/A2 _8232_/A2 PHY_9/VDD PHY_9/VDD VSUBS VSUBS gf180mcu_fd_sc_mcu7t5v0__nor2_1
X_7134_ _9810_/Q _7293_/A2 _7138_/B2 PHY_9/VDD PHY_9/VDD VSUBS VSUBS gf180mcu_fd_sc_mcu7t5v0__nor2_1
X_7065_ _9850_/Q _7062_/Z _7066_/I PHY_9/VDD PHY_9/VDD VSUBS VSUBS gf180mcu_fd_sc_mcu7t5v0__nand2_1
X_6016_ _8695_/A1 _6018_/A2 _6018_/B1 _6016_/B2 _9719_/D PHY_9/VDD PHY_9/VDD VSUBS
+ VSUBS gf180mcu_fd_sc_mcu7t5v0__oai22_1
X_7967_ _8011_/A2 _8012_/A1 _7967_/Z PHY_9/VDD PHY_9/VDD VSUBS VSUBS gf180mcu_fd_sc_mcu7t5v0__xor2_1
X_6918_ _6918_/A1 _6918_/A2 _6964_/A1 PHY_9/VDD PHY_9/VDD VSUBS VSUBS gf180mcu_fd_sc_mcu7t5v0__xnor2_1
X_9706_ _9706_/D _9939_/CLK _9706_/Q PHY_9/VDD PHY_9/VDD VSUBS VSUBS gf180mcu_fd_sc_mcu7t5v0__dffq_1
X_7898_ _9810_/Q _7771_/Z _7953_/A1 _7898_/A4 _7953_/A2 PHY_9/VDD PHY_9/VDD VSUBS
+ VSUBS gf180mcu_fd_sc_mcu7t5v0__nand4_2
X_6849_ _9811_/Q _6850_/A2 _6900_/A1 PHY_9/VDD PHY_9/VDD VSUBS VSUBS gf180mcu_fd_sc_mcu7t5v0__nand2_1
X_9637_ _9637_/D _9948_/CLK _9637_/Q PHY_9/VDD PHY_9/VDD VSUBS VSUBS gf180mcu_fd_sc_mcu7t5v0__dffq_1
X_9568_ _9568_/D _9901_/CLK _9568_/Q PHY_9/VDD PHY_9/VDD VSUBS VSUBS gf180mcu_fd_sc_mcu7t5v0__dffq_1
X_8519_ _8519_/A1 _8519_/A2 _8519_/Z PHY_9/VDD PHY_9/VDD VSUBS VSUBS gf180mcu_fd_sc_mcu7t5v0__xor2_1
X_9499_ _9499_/D _9974_/CLK _9499_/Q PHY_9/VDD PHY_9/VDD VSUBS VSUBS gf180mcu_fd_sc_mcu7t5v0__dffq_2
X_5180_ _9547_/Q _9546_/Q _9549_/Q _9548_/Q _5182_/A3 PHY_9/VDD PHY_9/VDD VSUBS VSUBS
+ gf180mcu_fd_sc_mcu7t5v0__nor4_4
X_8870_ _9958_/Q _8868_/Z _8870_/Z PHY_9/VDD PHY_9/VDD VSUBS VSUBS gf180mcu_fd_sc_mcu7t5v0__xor2_1
X_7821_ _7800_/Z _7821_/A2 _7821_/Z PHY_9/VDD PHY_9/VDD VSUBS VSUBS gf180mcu_fd_sc_mcu7t5v0__xor2_1
X_4964_ _9692_/Q _5983_/B2 PHY_9/VDD PHY_9/VDD VSUBS VSUBS gf180mcu_fd_sc_mcu7t5v0__clkinv_1
X_7752_ _9808_/Q _7948_/A2 _7761_/B1 PHY_9/VDD PHY_9/VDD VSUBS VSUBS gf180mcu_fd_sc_mcu7t5v0__nor2_1
X_6703_ _6737_/A1 _6703_/A2 _6704_/A2 PHY_9/VDD PHY_9/VDD VSUBS VSUBS gf180mcu_fd_sc_mcu7t5v0__nor2_1
X_7683_ _5399_/Z _7686_/A2 _7686_/B1 _7683_/B2 _9882_/D PHY_9/VDD PHY_9/VDD VSUBS
+ VSUBS gf180mcu_fd_sc_mcu7t5v0__oai22_1
X_9422_ _9422_/D _9901_/CLK _9422_/Q PHY_9/VDD PHY_9/VDD VSUBS VSUBS gf180mcu_fd_sc_mcu7t5v0__dffq_1
X_4895_ _9794_/Q _6316_/B2 PHY_9/VDD PHY_9/VDD VSUBS VSUBS gf180mcu_fd_sc_mcu7t5v0__clkinv_1
X_6634_ _9809_/Q _6634_/A2 _6636_/A1 PHY_9/VDD PHY_9/VDD VSUBS VSUBS gf180mcu_fd_sc_mcu7t5v0__nand2_1
X_6565_ _9357_/B _6565_/A2 _9820_/D PHY_9/VDD PHY_9/VDD VSUBS VSUBS gf180mcu_fd_sc_mcu7t5v0__nor2_1
X_9353_ _9349_/Z _9353_/A2 _9353_/A3 _9353_/Z PHY_9/VDD PHY_9/VDD VSUBS VSUBS gf180mcu_fd_sc_mcu7t5v0__xor3_1
X_6496_ _6521_/A1 _6496_/A2 _6494_/B _6496_/Z PHY_9/VDD PHY_9/VDD VSUBS VSUBS gf180mcu_fd_sc_mcu7t5v0__xor3_1
X_9284_ _9813_/Q _9331_/A2 _9287_/A3 PHY_9/VDD PHY_9/VDD VSUBS VSUBS gf180mcu_fd_sc_mcu7t5v0__nand2_1
X_5516_ _9431_/Q _5522_/A2 _5522_/B _5517_/B2 PHY_9/VDD PHY_9/VDD VSUBS VSUBS gf180mcu_fd_sc_mcu7t5v0__aoi21_1
X_8304_ _8330_/B _8290_/Z _8304_/B _9317_/C _8305_/A2 PHY_9/VDD PHY_9/VDD VSUBS VSUBS
+ gf180mcu_fd_sc_mcu7t5v0__oai211_1
X_5447_ _9436_/Q _5458_/A2 _5474_/B _5448_/B PHY_9/VDD PHY_9/VDD VSUBS VSUBS gf180mcu_fd_sc_mcu7t5v0__oai21_1
X_8235_ _9909_/Q _8234_/Z _8255_/A2 PHY_9/VDD PHY_9/VDD VSUBS VSUBS gf180mcu_fd_sc_mcu7t5v0__nor2_1
X_5378_ _5569_/A1 _5378_/A2 _5379_/A2 PHY_9/VDD PHY_9/VDD VSUBS VSUBS gf180mcu_fd_sc_mcu7t5v0__nand2_1
X_8166_ _9903_/Q _8166_/A2 _9902_/Q _8169_/B2 PHY_9/VDD PHY_9/VDD VSUBS VSUBS gf180mcu_fd_sc_mcu7t5v0__aoi21_1
X_7117_ _7152_/B2 _7117_/A2 _7118_/B PHY_9/VDD PHY_9/VDD VSUBS VSUBS gf180mcu_fd_sc_mcu7t5v0__xnor2_1
X_8097_ _9969_/Q _9893_/Q _9851_/Q _9508_/Q _9903_/Q _9902_/Q _8097_/Z PHY_9/VDD PHY_9/VDD
+ VSUBS VSUBS gf180mcu_fd_sc_mcu7t5v0__mux4_4
X_7048_ _7048_/A1 _7048_/A2 _7089_/B _7051_/A3 PHY_9/VDD PHY_9/VDD VSUBS VSUBS gf180mcu_fd_sc_mcu7t5v0__nand3_1
X_8999_ _6512_/B _8784_/I _8999_/A3 _9007_/A1 _8999_/B2 _9000_/A2 PHY_9/VDD PHY_9/VDD
+ VSUBS VSUBS gf180mcu_fd_sc_mcu7t5v0__oai32_1
X_4680_ _9973_/Q _9301_/A1 PHY_9/VDD PHY_9/VDD VSUBS VSUBS gf180mcu_fd_sc_mcu7t5v0__inv_2
X_6350_ _9806_/Q _9805_/Q _6350_/Z PHY_9/VDD PHY_9/VDD VSUBS VSUBS gf180mcu_fd_sc_mcu7t5v0__and2_2
X_5301_ _5390_/A1 _5307_/A2 _5301_/B _5973_/C _9389_/D PHY_9/VDD PHY_9/VDD VSUBS VSUBS
+ gf180mcu_fd_sc_mcu7t5v0__aoi211_1
X_6281_ _9533_/Q _6288_/A2 _6288_/B1 _9721_/Q _6282_/A2 PHY_9/VDD PHY_9/VDD VSUBS
+ VSUBS gf180mcu_fd_sc_mcu7t5v0__aoi22_1
Xclkbuf_leaf_5_clk clkbuf_leaf_8_clk/I _9939_/CLK PHY_9/VDD PHY_9/VDD VSUBS VSUBS
+ gf180mcu_fd_sc_mcu7t5v0__clkbuf_16
X_5232_ _5232_/A1 _5236_/A2 _5232_/B _9360_/D PHY_9/VDD PHY_9/VDD VSUBS VSUBS gf180mcu_fd_sc_mcu7t5v0__aoi21_1
X_8020_ _8058_/A3 _9036_/A2 _8020_/B _9899_/D PHY_9/VDD PHY_9/VDD VSUBS VSUBS gf180mcu_fd_sc_mcu7t5v0__aoi21_1
X_5163_ _5158_/I _5162_/Z _5163_/Z PHY_9/VDD PHY_9/VDD VSUBS VSUBS gf180mcu_fd_sc_mcu7t5v0__and2_1
X_5094_ _9940_/Q _8687_/B2 PHY_9/VDD PHY_9/VDD VSUBS VSUBS gf180mcu_fd_sc_mcu7t5v0__clkinv_1
X_9971_ _9971_/D _9974_/CLK _9971_/Q PHY_9/VDD PHY_9/VDD VSUBS VSUBS gf180mcu_fd_sc_mcu7t5v0__dffq_2
X_8922_ _9959_/Q _8924_/A2 _8940_/B PHY_9/VDD PHY_9/VDD VSUBS VSUBS gf180mcu_fd_sc_mcu7t5v0__and2_1
X_8853_ _9808_/Q _8813_/Z _8850_/Z _9807_/Q _8854_/I PHY_9/VDD PHY_9/VDD VSUBS VSUBS
+ gf180mcu_fd_sc_mcu7t5v0__aoi22_1
X_7804_ _6471_/B _7988_/A2 _7809_/A3 PHY_9/VDD PHY_9/VDD VSUBS VSUBS gf180mcu_fd_sc_mcu7t5v0__nor2_1
X_5996_ _8695_/A1 _5998_/A2 _5998_/B1 _5996_/B2 _9703_/D PHY_9/VDD PHY_9/VDD VSUBS
+ VSUBS gf180mcu_fd_sc_mcu7t5v0__oai22_1
X_8784_ _8784_/I _9003_/A2 PHY_9/VDD PHY_9/VDD VSUBS VSUBS gf180mcu_fd_sc_mcu7t5v0__inv_1
X_4947_ _9483_/Q _5553_/B2 PHY_9/VDD PHY_9/VDD VSUBS VSUBS gf180mcu_fd_sc_mcu7t5v0__clkinv_1
X_7735_ _9890_/Q _7994_/B _7735_/A3 _7805_/A1 PHY_9/VDD PHY_9/VDD VSUBS VSUBS gf180mcu_fd_sc_mcu7t5v0__nor3_4
X_4878_ _9762_/Q _6052_/B2 PHY_9/VDD PHY_9/VDD VSUBS VSUBS gf180mcu_fd_sc_mcu7t5v0__clkinv_1
X_7666_ _9814_/Q _7672_/A2 _7667_/S PHY_9/VDD PHY_9/VDD VSUBS VSUBS gf180mcu_fd_sc_mcu7t5v0__nand2_1
X_6617_ _6561_/B _6602_/Z _9356_/C _6618_/B2 PHY_9/VDD PHY_9/VDD VSUBS VSUBS gf180mcu_fd_sc_mcu7t5v0__aoi21_1
X_9405_ _9405_/D _9901_/CLK _9405_/Q PHY_9/VDD PHY_9/VDD VSUBS VSUBS gf180mcu_fd_sc_mcu7t5v0__dffq_1
X_9336_ _9330_/Z _9334_/Z _9336_/A3 _9336_/Z PHY_9/VDD PHY_9/VDD VSUBS VSUBS gf180mcu_fd_sc_mcu7t5v0__xor3_1
X_7597_ _7597_/A1 _7595_/Z _7614_/A1 PHY_9/VDD PHY_9/VDD VSUBS VSUBS gf180mcu_fd_sc_mcu7t5v0__xnor2_1
X_6548_ _9820_/Q _6548_/A2 _6549_/B PHY_9/VDD PHY_9/VDD VSUBS VSUBS gf180mcu_fd_sc_mcu7t5v0__xor2_1
X_6479_ _9357_/B _6479_/A2 _9818_/D PHY_9/VDD PHY_9/VDD VSUBS VSUBS gf180mcu_fd_sc_mcu7t5v0__nor2_1
X_9267_ _9972_/Q _9267_/A2 _9267_/B _9319_/A1 PHY_9/VDD PHY_9/VDD VSUBS VSUBS gf180mcu_fd_sc_mcu7t5v0__aoi21_1
X_8218_ _8219_/A1 _8314_/A1 _8261_/A2 PHY_9/VDD PHY_9/VDD VSUBS VSUBS gf180mcu_fd_sc_mcu7t5v0__nand2_1
X_9198_ _9154_/Z _9297_/B2 _9246_/A1 PHY_9/VDD PHY_9/VDD VSUBS VSUBS gf180mcu_fd_sc_mcu7t5v0__nor2_1
X_8149_ _9810_/Q _8147_/Z _8149_/Z PHY_9/VDD PHY_9/VDD VSUBS VSUBS gf180mcu_fd_sc_mcu7t5v0__xor2_1
X_5850_ _5832_/Z _5850_/A2 _5851_/B PHY_9/VDD PHY_9/VDD VSUBS VSUBS gf180mcu_fd_sc_mcu7t5v0__nand2_1
X_5781_ _5404_/Z _5782_/A2 _5782_/B1 _5781_/B2 _9605_/D PHY_9/VDD PHY_9/VDD VSUBS
+ VSUBS gf180mcu_fd_sc_mcu7t5v0__oai22_1
X_4801_ _9807_/Q _9090_/C PHY_9/VDD PHY_9/VDD VSUBS VSUBS gf180mcu_fd_sc_mcu7t5v0__clkinv_20
X_7520_ _7572_/B _7572_/A2 _7521_/A2 PHY_9/VDD PHY_9/VDD VSUBS VSUBS gf180mcu_fd_sc_mcu7t5v0__nor2_1
X_4732_ _9901_/Q _8057_/A1 PHY_9/VDD PHY_9/VDD VSUBS VSUBS gf180mcu_fd_sc_mcu7t5v0__clkinv_3
X_7451_ _9894_/Q _7450_/Z _7451_/Z PHY_9/VDD PHY_9/VDD VSUBS VSUBS gf180mcu_fd_sc_mcu7t5v0__and2_1
X_6402_ _9808_/Q _6624_/A2 _6404_/B PHY_9/VDD PHY_9/VDD VSUBS VSUBS gf180mcu_fd_sc_mcu7t5v0__nand2_1
X_7382_ _7411_/A2 _7411_/A3 _7382_/Z PHY_9/VDD PHY_9/VDD VSUBS VSUBS gf180mcu_fd_sc_mcu7t5v0__and2_4
X_6333_ _6333_/A1 _9036_/A2 _6333_/B _9806_/D PHY_9/VDD PHY_9/VDD VSUBS VSUBS gf180mcu_fd_sc_mcu7t5v0__aoi21_1
X_9121_ _9121_/A1 _9083_/Z _9121_/B _9165_/A2 PHY_9/VDD PHY_9/VDD VSUBS VSUBS gf180mcu_fd_sc_mcu7t5v0__aoi21_1
X_6264_ _6089_/B _6264_/A2 _9776_/D PHY_9/VDD PHY_9/VDD VSUBS VSUBS gf180mcu_fd_sc_mcu7t5v0__and2_1
X_9052_ _9963_/Q _9058_/A1 _9065_/A2 PHY_9/VDD PHY_9/VDD VSUBS VSUBS gf180mcu_fd_sc_mcu7t5v0__nand2_1
X_5215_ _5770_/B _9727_/Q _9735_/D PHY_9/VDD PHY_9/VDD VSUBS VSUBS gf180mcu_fd_sc_mcu7t5v0__and2_1
X_8003_ _9898_/Q _8016_/A2 _8003_/Z PHY_9/VDD PHY_9/VDD VSUBS VSUBS gf180mcu_fd_sc_mcu7t5v0__xor2_1
X_6195_ _6195_/A1 _6195_/A2 _6276_/B _6204_/C PHY_9/VDD PHY_9/VDD VSUBS VSUBS gf180mcu_fd_sc_mcu7t5v0__aoi21_1
X_5146_ _5770_/B _9724_/Q _5222_/A3 PHY_9/VDD PHY_9/VDD VSUBS VSUBS gf180mcu_fd_sc_mcu7t5v0__nand2_1
X_9954_ _9954_/D _9974_/CLK _9954_/Q PHY_9/VDD PHY_9/VDD VSUBS VSUBS gf180mcu_fd_sc_mcu7t5v0__dffq_2
X_5077_ _9520_/Q _5645_/B2 PHY_9/VDD PHY_9/VDD VSUBS VSUBS gf180mcu_fd_sc_mcu7t5v0__clkinv_1
X_8905_ _6471_/B _8784_/I _8910_/A2 PHY_9/VDD PHY_9/VDD VSUBS VSUBS gf180mcu_fd_sc_mcu7t5v0__nor2_1
X_9885_ _9885_/D _9948_/CLK _9885_/Q PHY_9/VDD PHY_9/VDD VSUBS VSUBS gf180mcu_fd_sc_mcu7t5v0__dffq_1
X_8836_ _8837_/A1 _8837_/A2 _8837_/B _8844_/B1 PHY_9/VDD PHY_9/VDD VSUBS VSUBS gf180mcu_fd_sc_mcu7t5v0__nand3_1
X_5979_ _7677_/A1 _6283_/A1 _5988_/A2 PHY_9/VDD PHY_9/VDD VSUBS VSUBS gf180mcu_fd_sc_mcu7t5v0__nand2_4
X_8767_ _8767_/A1 _8816_/A1 _8767_/Z PHY_9/VDD PHY_9/VDD VSUBS VSUBS gf180mcu_fd_sc_mcu7t5v0__xor2_1
X_7718_ _7725_/A3 _7791_/A2 _7977_/A1 PHY_9/VDD PHY_9/VDD VSUBS VSUBS gf180mcu_fd_sc_mcu7t5v0__nor2_2
X_8698_ _9363_/Q _9036_/A2 rst_n _8699_/B PHY_9/VDD PHY_9/VDD VSUBS VSUBS gf180mcu_fd_sc_mcu7t5v0__oai21_1
X_7649_ _7649_/A1 _7649_/A2 _7649_/A3 _7660_/A2 PHY_9/VDD PHY_9/VDD VSUBS VSUBS gf180mcu_fd_sc_mcu7t5v0__xnor3_1
X_9319_ _9319_/A1 _9301_/Z _9319_/B _9343_/A1 PHY_9/VDD PHY_9/VDD VSUBS VSUBS gf180mcu_fd_sc_mcu7t5v0__oai21_1
X_5000_ _9586_/Q _5756_/B2 PHY_9/VDD PHY_9/VDD VSUBS VSUBS gf180mcu_fd_sc_mcu7t5v0__clkinv_1
X_6951_ _6613_/B _6949_/Z _6951_/Z PHY_9/VDD PHY_9/VDD VSUBS VSUBS gf180mcu_fd_sc_mcu7t5v0__xor2_1
X_6882_ _6883_/A1 _6883_/A2 _6919_/A2 PHY_9/VDD PHY_9/VDD VSUBS VSUBS gf180mcu_fd_sc_mcu7t5v0__nand2_1
X_9670_ _9670_/D _9972_/CLK _9670_/Q PHY_9/VDD PHY_9/VDD VSUBS VSUBS gf180mcu_fd_sc_mcu7t5v0__dffq_1
X_5902_ _5907_/A1 _5901_/Z _9659_/D PHY_9/VDD PHY_9/VDD VSUBS VSUBS gf180mcu_fd_sc_mcu7t5v0__nor2_1
X_5833_ _9641_/Q _9523_/Q _5835_/A2 PHY_9/VDD PHY_9/VDD VSUBS VSUBS gf180mcu_fd_sc_mcu7t5v0__nand2_1
X_8621_ _9931_/Q _8624_/A2 _8640_/B PHY_9/VDD PHY_9/VDD VSUBS VSUBS gf180mcu_fd_sc_mcu7t5v0__nand2_1
X_8552_ _8552_/A1 _8657_/A1 _8552_/Z PHY_9/VDD PHY_9/VDD VSUBS VSUBS gf180mcu_fd_sc_mcu7t5v0__xor2_1
X_5764_ _8692_/A1 _5769_/A2 _5769_/B1 _5764_/B2 _9592_/D PHY_9/VDD PHY_9/VDD VSUBS
+ VSUBS gf180mcu_fd_sc_mcu7t5v0__oai22_1
X_7503_ _9808_/Q _7599_/A2 _7551_/A1 PHY_9/VDD PHY_9/VDD VSUBS VSUBS gf180mcu_fd_sc_mcu7t5v0__nand2_1
X_5695_ _5693_/Z _5695_/A2 _9546_/D PHY_9/VDD PHY_9/VDD VSUBS VSUBS gf180mcu_fd_sc_mcu7t5v0__nor2_1
X_8483_ _6471_/B _8645_/A2 _8526_/B _8484_/B PHY_9/VDD PHY_9/VDD VSUBS VSUBS gf180mcu_fd_sc_mcu7t5v0__xor3_1
X_4715_ _9924_/Q _8647_/A2 PHY_9/VDD PHY_9/VDD VSUBS VSUBS gf180mcu_fd_sc_mcu7t5v0__clkinv_8
X_7434_ _9809_/Q _7657_/A2 _7439_/A1 PHY_9/VDD PHY_9/VDD VSUBS VSUBS gf180mcu_fd_sc_mcu7t5v0__nor2_1
X_7365_ _7636_/A1 _7674_/A1 _7368_/A2 PHY_9/VDD PHY_9/VDD VSUBS VSUBS gf180mcu_fd_sc_mcu7t5v0__nand2_1
X_9104_ _9807_/Q _9103_/Z _9142_/A1 PHY_9/VDD PHY_9/VDD VSUBS VSUBS gf180mcu_fd_sc_mcu7t5v0__nand2_1
X_6316_ _5388_/Z _6323_/A2 _6323_/B1 _6316_/B2 _9794_/D PHY_9/VDD PHY_9/VDD VSUBS
+ VSUBS gf180mcu_fd_sc_mcu7t5v0__oai22_1
X_7296_ _7296_/A1 _7296_/A2 _7296_/B _7307_/A1 PHY_9/VDD PHY_9/VDD VSUBS VSUBS gf180mcu_fd_sc_mcu7t5v0__oai21_1
X_6247_ _6247_/A1 _6247_/A2 _6276_/B _6262_/C PHY_9/VDD PHY_9/VDD VSUBS VSUBS gf180mcu_fd_sc_mcu7t5v0__aoi21_1
X_9035_ _9362_/Q _9036_/A2 _9035_/B _9036_/B PHY_9/VDD PHY_9/VDD VSUBS VSUBS gf180mcu_fd_sc_mcu7t5v0__oai21_1
X_6178_ _9798_/Q _6287_/A2 _6287_/B1 _9562_/Q _6180_/A1 PHY_9/VDD PHY_9/VDD VSUBS
+ VSUBS gf180mcu_fd_sc_mcu7t5v0__aoi22_1
X_5129_ _5137_/A2 _5224_/A3 _5262_/A1 _5130_/I PHY_9/VDD PHY_9/VDD VSUBS VSUBS gf180mcu_fd_sc_mcu7t5v0__and3_4
X_9937_ _9937_/D _9940_/CLK _9937_/Q PHY_9/VDD PHY_9/VDD VSUBS VSUBS gf180mcu_fd_sc_mcu7t5v0__dffq_1
X_9868_ _9868_/D _9907_/CLK _9868_/Q PHY_9/VDD PHY_9/VDD VSUBS VSUBS gf180mcu_fd_sc_mcu7t5v0__dffq_4
X_8819_ _6471_/B _8752_/I _8861_/A2 PHY_9/VDD PHY_9/VDD VSUBS VSUBS gf180mcu_fd_sc_mcu7t5v0__nor2_1
X_9799_ _9799_/D _9800_/CLK _9799_/Q PHY_9/VDD PHY_9/VDD VSUBS VSUBS gf180mcu_fd_sc_mcu7t5v0__dffq_1
X_5480_ _5480_/A1 _5493_/B _5480_/B _9451_/D PHY_9/VDD PHY_9/VDD VSUBS VSUBS gf180mcu_fd_sc_mcu7t5v0__aoi21_1
X_7150_ _9808_/Q _7293_/A2 _7247_/A2 _9807_/Q _7151_/A2 PHY_9/VDD PHY_9/VDD VSUBS
+ VSUBS gf180mcu_fd_sc_mcu7t5v0__aoi22_1
X_7081_ _7084_/A2 _7152_/A1 _7081_/Z PHY_9/VDD PHY_9/VDD VSUBS VSUBS gf180mcu_fd_sc_mcu7t5v0__xor2_1
X_6101_ _9879_/Q _6288_/A2 _6288_/B1 _9942_/Q _6102_/A2 PHY_9/VDD PHY_9/VDD VSUBS
+ VSUBS gf180mcu_fd_sc_mcu7t5v0__aoi22_1
X_6032_ _5388_/Z _6039_/A2 _6039_/B1 _6032_/B2 _9746_/D PHY_9/VDD PHY_9/VDD VSUBS
+ VSUBS gf180mcu_fd_sc_mcu7t5v0__oai22_1
X_7983_ _9812_/Q _7771_/Z _7986_/A2 PHY_9/VDD PHY_9/VDD VSUBS VSUBS gf180mcu_fd_sc_mcu7t5v0__nand2_1
X_6934_ _6981_/A1 _6934_/A2 _6931_/Z _6935_/B PHY_9/VDD PHY_9/VDD VSUBS VSUBS gf180mcu_fd_sc_mcu7t5v0__xor3_1
X_9722_ _9722_/D _9800_/CLK _9722_/Q PHY_9/VDD PHY_9/VDD VSUBS VSUBS gf180mcu_fd_sc_mcu7t5v0__dffq_1
X_9653_ _9653_/D _9689_/CLK _9653_/Q PHY_9/VDD PHY_9/VDD VSUBS VSUBS gf180mcu_fd_sc_mcu7t5v0__dffq_1
X_6865_ _9854_/Q _6771_/Z _6970_/B1 _9896_/Q _6920_/A2 PHY_9/VDD PHY_9/VDD VSUBS VSUBS
+ gf180mcu_fd_sc_mcu7t5v0__aoi22_4
X_8604_ _9811_/Q _8653_/A2 _8652_/B2 PHY_9/VDD PHY_9/VDD VSUBS VSUBS gf180mcu_fd_sc_mcu7t5v0__nand2_1
X_9584_ _9584_/D _9939_/CLK _9584_/Q PHY_9/VDD PHY_9/VDD VSUBS VSUBS gf180mcu_fd_sc_mcu7t5v0__dffq_1
X_6796_ _6680_/Z _6710_/Z _6974_/A2 _6948_/B _6845_/A1 PHY_9/VDD PHY_9/VDD VSUBS VSUBS
+ gf180mcu_fd_sc_mcu7t5v0__oai31_1
X_5816_ _8689_/A1 _5824_/A2 _5824_/B1 PHY_9/VDD PHY_9/VDD VSUBS VSUBS gf180mcu_fd_sc_mcu7t5v0__nand2_2
X_5747_ _8695_/A1 _5749_/A2 _5749_/B1 _5747_/B2 _9579_/D PHY_9/VDD PHY_9/VDD VSUBS
+ VSUBS gf180mcu_fd_sc_mcu7t5v0__oai22_1
X_8535_ _8535_/A1 _8535_/A2 _8537_/A2 PHY_9/VDD PHY_9/VDD VSUBS VSUBS gf180mcu_fd_sc_mcu7t5v0__nand2_1
X_8466_ _9808_/Q _8653_/A2 _8466_/Z PHY_9/VDD PHY_9/VDD VSUBS VSUBS gf180mcu_fd_sc_mcu7t5v0__and2_1
X_5678_ _9541_/Q _5676_/Z _5678_/Z PHY_9/VDD PHY_9/VDD VSUBS VSUBS gf180mcu_fd_sc_mcu7t5v0__and2_1
X_7417_ _8781_/A3 _9869_/Q _7604_/B1 _7417_/B2 _7417_/C _7657_/A2 PHY_9/VDD PHY_9/VDD
+ VSUBS VSUBS gf180mcu_fd_sc_mcu7t5v0__aoi221_4
X_8397_ _9924_/Q _8647_/A3 _9871_/Q _8401_/A1 PHY_9/VDD PHY_9/VDD VSUBS VSUBS gf180mcu_fd_sc_mcu7t5v0__nor3_2
X_7348_ _9869_/Q _7604_/B1 _9815_/Q _7446_/A2 PHY_9/VDD PHY_9/VDD VSUBS VSUBS gf180mcu_fd_sc_mcu7t5v0__nor3_4
X_7279_ _9813_/Q _7319_/A2 _7281_/A2 PHY_9/VDD PHY_9/VDD VSUBS VSUBS gf180mcu_fd_sc_mcu7t5v0__nand2_1
X_9018_ _9018_/A1 _9018_/A2 _9019_/A3 PHY_9/VDD PHY_9/VDD VSUBS VSUBS gf180mcu_fd_sc_mcu7t5v0__nand2_1
X_4980_ _9529_/Q _5652_/B2 PHY_9/VDD PHY_9/VDD VSUBS VSUBS gf180mcu_fd_sc_mcu7t5v0__clkinv_1
X_6650_ _9814_/Q _6650_/A2 _6650_/A3 _6651_/C PHY_9/VDD PHY_9/VDD VSUBS VSUBS gf180mcu_fd_sc_mcu7t5v0__nand3_1
X_6581_ _9811_/Q _6627_/A2 _6635_/B2 PHY_9/VDD PHY_9/VDD VSUBS VSUBS gf180mcu_fd_sc_mcu7t5v0__nand2_1
X_5601_ _9773_/Q _9036_/A2 _8706_/B _5602_/B PHY_9/VDD PHY_9/VDD VSUBS VSUBS gf180mcu_fd_sc_mcu7t5v0__oai21_1
X_8320_ _9807_/Q _8340_/B1 _8322_/A1 PHY_9/VDD PHY_9/VDD VSUBS VSUBS gf180mcu_fd_sc_mcu7t5v0__nand2_1
X_5532_ _5973_/C _5532_/A2 _9470_/D PHY_9/VDD PHY_9/VDD VSUBS VSUBS gf180mcu_fd_sc_mcu7t5v0__nor2_1
X_5463_ _5480_/A1 _5495_/B _5463_/B _9443_/D PHY_9/VDD PHY_9/VDD VSUBS VSUBS gf180mcu_fd_sc_mcu7t5v0__aoi21_1
X_8251_ _8199_/B _8246_/Z _8251_/B _8251_/C _8252_/A2 PHY_9/VDD PHY_9/VDD VSUBS VSUBS
+ gf180mcu_fd_sc_mcu7t5v0__oai211_1
X_7202_ _9810_/Q _7290_/A2 _7208_/A2 PHY_9/VDD PHY_9/VDD VSUBS VSUBS gf180mcu_fd_sc_mcu7t5v0__nand2_1
X_8182_ _8174_/Z _8181_/Z _8285_/A2 PHY_9/VDD PHY_9/VDD VSUBS VSUBS gf180mcu_fd_sc_mcu7t5v0__xnor2_1
X_5394_ _9969_/Q _5201_/Z _5394_/B _8692_/A1 PHY_9/VDD PHY_9/VDD VSUBS VSUBS gf180mcu_fd_sc_mcu7t5v0__aoi21_4
X_7133_ _7278_/C _7178_/A2 _7140_/A2 PHY_9/VDD PHY_9/VDD VSUBS VSUBS gf180mcu_fd_sc_mcu7t5v0__nand2_1
X_7064_ _7064_/A1 _7064_/A2 _7064_/A3 _7070_/B PHY_9/VDD PHY_9/VDD VSUBS VSUBS gf180mcu_fd_sc_mcu7t5v0__nand3_1
X_6015_ _5399_/Z _6018_/A2 _6018_/B1 _6015_/B2 _9718_/D PHY_9/VDD PHY_9/VDD VSUBS
+ VSUBS gf180mcu_fd_sc_mcu7t5v0__oai22_1
X_9705_ _9705_/D _9940_/CLK _9705_/Q PHY_9/VDD PHY_9/VDD VSUBS VSUBS gf180mcu_fd_sc_mcu7t5v0__dffq_1
X_7966_ _7836_/Z _7914_/B _7992_/A2 _7966_/B _8012_/A1 PHY_9/VDD PHY_9/VDD VSUBS VSUBS
+ gf180mcu_fd_sc_mcu7t5v0__oai31_1
X_6917_ _6918_/A1 _6918_/A2 _6984_/A1 PHY_9/VDD PHY_9/VDD VSUBS VSUBS gf180mcu_fd_sc_mcu7t5v0__nor2_1
X_7897_ _6558_/B _7988_/A2 _7897_/B _7898_/A4 PHY_9/VDD PHY_9/VDD VSUBS VSUBS gf180mcu_fd_sc_mcu7t5v0__oai21_1
X_6848_ _6846_/Z _6848_/A2 _6850_/A2 PHY_9/VDD PHY_9/VDD VSUBS VSUBS gf180mcu_fd_sc_mcu7t5v0__nand2_1
X_9636_ _9636_/D _9948_/CLK _9636_/Q PHY_9/VDD PHY_9/VDD VSUBS VSUBS gf180mcu_fd_sc_mcu7t5v0__dffq_1
X_9567_ _9567_/D _9901_/CLK _9567_/Q PHY_9/VDD PHY_9/VDD VSUBS VSUBS gf180mcu_fd_sc_mcu7t5v0__dffq_1
X_6779_ _9808_/Q _6974_/A2 _6779_/Z PHY_9/VDD PHY_9/VDD VSUBS VSUBS gf180mcu_fd_sc_mcu7t5v0__and2_1
X_8518_ _8519_/A1 _8519_/A2 _8570_/A1 PHY_9/VDD PHY_9/VDD VSUBS VSUBS gf180mcu_fd_sc_mcu7t5v0__nor2_1
X_9498_ _9498_/D _9974_/CLK _9498_/Q PHY_9/VDD PHY_9/VDD VSUBS VSUBS gf180mcu_fd_sc_mcu7t5v0__dffq_2
X_8449_ _8449_/A1 _8449_/A2 _8448_/B _8449_/Z PHY_9/VDD PHY_9/VDD VSUBS VSUBS gf180mcu_fd_sc_mcu7t5v0__and3_1
X_7820_ _7771_/Z _7864_/A2 _7966_/B _7821_/A2 PHY_9/VDD PHY_9/VDD VSUBS VSUBS gf180mcu_fd_sc_mcu7t5v0__oai21_1
X_4963_ _9700_/Q _5993_/B2 PHY_9/VDD PHY_9/VDD VSUBS VSUBS gf180mcu_fd_sc_mcu7t5v0__clkinv_1
X_7751_ _7870_/B _7751_/A2 _7761_/A2 PHY_9/VDD PHY_9/VDD VSUBS VSUBS gf180mcu_fd_sc_mcu7t5v0__nand2_1
X_7682_ _8693_/A1 _7686_/A2 _7686_/B1 _7682_/B2 _9881_/D PHY_9/VDD PHY_9/VDD VSUBS
+ VSUBS gf180mcu_fd_sc_mcu7t5v0__oai22_1
X_6702_ _9836_/Q _6724_/A2 _6808_/C _6703_/A2 PHY_9/VDD PHY_9/VDD VSUBS VSUBS gf180mcu_fd_sc_mcu7t5v0__oai21_1
X_6633_ _6633_/A1 _6633_/A2 _6632_/Z _6633_/Z PHY_9/VDD PHY_9/VDD VSUBS VSUBS gf180mcu_fd_sc_mcu7t5v0__xor3_1
X_9421_ _9421_/D _9830_/CLK _9421_/Q PHY_9/VDD PHY_9/VDD VSUBS VSUBS gf180mcu_fd_sc_mcu7t5v0__dffq_1
X_4894_ _9823_/Q _6658_/B2 PHY_9/VDD PHY_9/VDD VSUBS VSUBS gf180mcu_fd_sc_mcu7t5v0__clkinv_1
X_6564_ _9820_/Q _9356_/C _6564_/B1 _6564_/B2 _6565_/A2 PHY_9/VDD PHY_9/VDD VSUBS
+ VSUBS gf180mcu_fd_sc_mcu7t5v0__aoi22_1
X_9352_ _9352_/A1 _9352_/A2 _9353_/A3 PHY_9/VDD PHY_9/VDD VSUBS VSUBS gf180mcu_fd_sc_mcu7t5v0__nand2_1
X_6495_ _6495_/A1 _6495_/A2 _6494_/B _6521_/A2 PHY_9/VDD PHY_9/VDD VSUBS VSUBS gf180mcu_fd_sc_mcu7t5v0__nor3_1
X_9283_ _9811_/Q _9103_/Z _9323_/B2 PHY_9/VDD PHY_9/VDD VSUBS VSUBS gf180mcu_fd_sc_mcu7t5v0__nand2_1
X_5515_ _9439_/Q _5498_/Z _5517_/B1 PHY_9/VDD PHY_9/VDD VSUBS VSUBS gf180mcu_fd_sc_mcu7t5v0__nand2_1
X_8303_ _8330_/B _8303_/A2 _8303_/A3 _8303_/A4 _8304_/B PHY_9/VDD PHY_9/VDD VSUBS
+ VSUBS gf180mcu_fd_sc_mcu7t5v0__nand4_1
X_8234_ _8234_/A1 _8234_/A2 _8234_/Z PHY_9/VDD PHY_9/VDD VSUBS VSUBS gf180mcu_fd_sc_mcu7t5v0__xor2_1
X_5446_ _5480_/A1 _5458_/A2 _5446_/B _9435_/D PHY_9/VDD PHY_9/VDD VSUBS VSUBS gf180mcu_fd_sc_mcu7t5v0__aoi21_1
X_5377_ _9468_/Q _5439_/A2 _5559_/B _5378_/A2 PHY_9/VDD PHY_9/VDD VSUBS VSUBS gf180mcu_fd_sc_mcu7t5v0__nand3_1
X_8165_ _9903_/Q _8318_/B _8165_/A3 _8165_/B _8169_/B1 PHY_9/VDD PHY_9/VDD VSUBS VSUBS
+ gf180mcu_fd_sc_mcu7t5v0__oai31_1
X_7116_ _7114_/Z _7152_/B1 _7117_/A2 PHY_9/VDD PHY_9/VDD VSUBS VSUBS gf180mcu_fd_sc_mcu7t5v0__nor2_1
X_8096_ _8060_/Z _8091_/Z _8096_/B _8107_/A1 PHY_9/VDD PHY_9/VDD VSUBS VSUBS gf180mcu_fd_sc_mcu7t5v0__aoi21_1
X_7047_ _9844_/Q _7047_/A2 _7089_/B PHY_9/VDD PHY_9/VDD VSUBS VSUBS gf180mcu_fd_sc_mcu7t5v0__nand2_2
X_8998_ _9809_/Q _8998_/A2 _9000_/A1 PHY_9/VDD PHY_9/VDD VSUBS VSUBS gf180mcu_fd_sc_mcu7t5v0__nand2_1
X_7949_ _6613_/B _7988_/A2 _7746_/B _6558_/B _7950_/B PHY_9/VDD PHY_9/VDD VSUBS VSUBS
+ gf180mcu_fd_sc_mcu7t5v0__oai22_1
X_9619_ _9619_/D _9830_/CLK _9619_/Q PHY_9/VDD PHY_9/VDD VSUBS VSUBS gf180mcu_fd_sc_mcu7t5v0__dffq_1
X_5300_ _9389_/Q _5307_/A2 _5301_/B PHY_9/VDD PHY_9/VDD VSUBS VSUBS gf180mcu_fd_sc_mcu7t5v0__nor2_1
X_6280_ _9488_/Q _6287_/A2 _6287_/B1 _9521_/Q _6282_/A1 PHY_9/VDD PHY_9/VDD VSUBS
+ VSUBS gf180mcu_fd_sc_mcu7t5v0__aoi22_1
X_5231_ _9462_/Q _5236_/A2 _9031_/B _5232_/B PHY_9/VDD PHY_9/VDD VSUBS VSUBS gf180mcu_fd_sc_mcu7t5v0__oai21_1
X_5162_ _9689_/Q _9688_/Q _9687_/Q _5162_/Z PHY_9/VDD PHY_9/VDD VSUBS VSUBS gf180mcu_fd_sc_mcu7t5v0__and3_1
X_5093_ _9605_/Q _5781_/B2 PHY_9/VDD PHY_9/VDD VSUBS VSUBS gf180mcu_fd_sc_mcu7t5v0__clkinv_1
X_9970_ _9970_/D _9972_/CLK _9970_/Q PHY_9/VDD PHY_9/VDD VSUBS VSUBS gf180mcu_fd_sc_mcu7t5v0__dffq_2
X_8921_ _9959_/Q _8924_/A2 _8921_/Z PHY_9/VDD PHY_9/VDD VSUBS VSUBS gf180mcu_fd_sc_mcu7t5v0__or2_1
X_8852_ _9808_/Q _8852_/A2 _8850_/Z _8941_/A1 PHY_9/VDD PHY_9/VDD VSUBS VSUBS gf180mcu_fd_sc_mcu7t5v0__nand3_2
X_8783_ _9500_/Q _8720_/B _8783_/B1 _8783_/B2 _8784_/I PHY_9/VDD PHY_9/VDD VSUBS VSUBS
+ gf180mcu_fd_sc_mcu7t5v0__oai22_4
X_7803_ _9808_/Q _7771_/Z _7809_/A2 PHY_9/VDD PHY_9/VDD VSUBS VSUBS gf180mcu_fd_sc_mcu7t5v0__nand2_1
X_5995_ _5399_/Z _5998_/A2 _5998_/B1 _5995_/B2 _9702_/D PHY_9/VDD PHY_9/VDD VSUBS
+ VSUBS gf180mcu_fd_sc_mcu7t5v0__oai22_1
X_7734_ _8777_/A1 _7738_/C _7805_/C PHY_9/VDD PHY_9/VDD VSUBS VSUBS gf180mcu_fd_sc_mcu7t5v0__nand2_4
X_4946_ _9716_/Q _6013_/B2 PHY_9/VDD PHY_9/VDD VSUBS VSUBS gf180mcu_fd_sc_mcu7t5v0__clkinv_1
X_4877_ _9786_/Q _6306_/B2 PHY_9/VDD PHY_9/VDD VSUBS VSUBS gf180mcu_fd_sc_mcu7t5v0__clkinv_1
X_7665_ _9814_/Q _7672_/A2 _7674_/B1 PHY_9/VDD PHY_9/VDD VSUBS VSUBS gf180mcu_fd_sc_mcu7t5v0__nor2_1
X_6616_ _6406_/C _6616_/A2 _6616_/A3 _6616_/A4 _6618_/B1 PHY_9/VDD PHY_9/VDD VSUBS
+ VSUBS gf180mcu_fd_sc_mcu7t5v0__nand4_1
X_9404_ _9404_/D _9901_/CLK _9404_/Q PHY_9/VDD PHY_9/VDD VSUBS VSUBS gf180mcu_fd_sc_mcu7t5v0__dffq_1
X_7596_ _9813_/Q _7647_/A2 _7595_/Z _7645_/B PHY_9/VDD PHY_9/VDD VSUBS VSUBS gf180mcu_fd_sc_mcu7t5v0__nand3_1
X_6547_ _9820_/Q _6548_/A2 _6566_/A1 PHY_9/VDD PHY_9/VDD VSUBS VSUBS gf180mcu_fd_sc_mcu7t5v0__nand2_1
X_9335_ _9335_/A1 _9335_/A2 _9335_/B1 _9335_/B2 _9336_/A3 PHY_9/VDD PHY_9/VDD VSUBS
+ VSUBS gf180mcu_fd_sc_mcu7t5v0__oai22_1
X_6478_ _9818_/Q _9356_/C _6478_/B _6479_/A2 PHY_9/VDD PHY_9/VDD VSUBS VSUBS gf180mcu_fd_sc_mcu7t5v0__aoi21_1
X_9266_ _9973_/Q _9356_/C _9318_/A1 PHY_9/VDD PHY_9/VDD VSUBS VSUBS gf180mcu_fd_sc_mcu7t5v0__nand2_1
X_8217_ _8219_/A1 _8314_/A1 _8261_/B PHY_9/VDD PHY_9/VDD VSUBS VSUBS gf180mcu_fd_sc_mcu7t5v0__nor2_1
X_9197_ _9297_/A1 _9297_/A2 _9297_/B2 PHY_9/VDD PHY_9/VDD VSUBS VSUBS gf180mcu_fd_sc_mcu7t5v0__xnor2_2
X_5429_ _9775_/Q _5439_/A2 _5429_/B1 _5130_/I _5488_/A1 PHY_9/VDD PHY_9/VDD VSUBS
+ VSUBS gf180mcu_fd_sc_mcu7t5v0__aoi22_4
X_8148_ _9810_/Q _8147_/Z _8191_/A1 PHY_9/VDD PHY_9/VDD VSUBS VSUBS gf180mcu_fd_sc_mcu7t5v0__nand2_1
X_8079_ _8108_/A1 _8077_/Z _8079_/B _8093_/A1 PHY_9/VDD PHY_9/VDD VSUBS VSUBS gf180mcu_fd_sc_mcu7t5v0__aoi21_1
X_4800_ _9808_/Q _9091_/B PHY_9/VDD PHY_9/VDD VSUBS VSUBS gf180mcu_fd_sc_mcu7t5v0__clkinv_12
X_5780_ _8695_/A1 _5782_/A2 _5782_/B1 _5780_/B2 _9604_/D PHY_9/VDD PHY_9/VDD VSUBS
+ VSUBS gf180mcu_fd_sc_mcu7t5v0__oai22_1
X_4731_ _9376_/Q _5270_/A1 PHY_9/VDD PHY_9/VDD VSUBS VSUBS gf180mcu_fd_sc_mcu7t5v0__clkinv_1
X_7450_ _9869_/Q _9868_/Q _7450_/Z PHY_9/VDD PHY_9/VDD VSUBS VSUBS gf180mcu_fd_sc_mcu7t5v0__and2_1
X_6401_ _9808_/Q _6474_/A2 _6401_/B1 _6401_/B2 _6401_/C _6406_/A2 PHY_9/VDD PHY_9/VDD
+ VSUBS VSUBS gf180mcu_fd_sc_mcu7t5v0__aoi221_1
X_9120_ _9227_/A1 _9103_/Z _9120_/A3 _9121_/B PHY_9/VDD PHY_9/VDD VSUBS VSUBS gf180mcu_fd_sc_mcu7t5v0__xor3_1
X_7381_ _8750_/A2 _7604_/B1 _7381_/B1 _9869_/Q _7411_/A3 PHY_9/VDD PHY_9/VDD VSUBS
+ VSUBS gf180mcu_fd_sc_mcu7t5v0__oai22_2
X_6332_ _9402_/Q _9036_/A2 _7695_/B _6333_/B PHY_9/VDD PHY_9/VDD VSUBS VSUBS gf180mcu_fd_sc_mcu7t5v0__oai21_1
X_6263_ _6263_/A1 _6263_/A2 _6263_/A3 _6264_/A2 PHY_9/VDD PHY_9/VDD VSUBS VSUBS gf180mcu_fd_sc_mcu7t5v0__nand3_1
X_9051_ _9059_/A2 _9962_/Q _9066_/A2 PHY_9/VDD PHY_9/VDD VSUBS VSUBS gf180mcu_fd_sc_mcu7t5v0__nor2_2
X_5214_ _9450_/Q _5222_/A2 _5222_/A3 _9736_/D PHY_9/VDD PHY_9/VDD VSUBS VSUBS gf180mcu_fd_sc_mcu7t5v0__nor3_1
X_8002_ _8002_/A1 _8001_/Z _8016_/A2 PHY_9/VDD PHY_9/VDD VSUBS VSUBS gf180mcu_fd_sc_mcu7t5v0__xnor2_1
X_6194_ _9586_/Q _6288_/A2 _6287_/A2 _9594_/Q _6195_/A2 PHY_9/VDD PHY_9/VDD VSUBS
+ VSUBS gf180mcu_fd_sc_mcu7t5v0__aoi22_1
X_5145_ _9451_/Q _5145_/A2 _5145_/A3 _5222_/A2 PHY_9/VDD PHY_9/VDD VSUBS VSUBS gf180mcu_fd_sc_mcu7t5v0__nand3_1
X_5076_ _9532_/Q _5655_/B2 PHY_9/VDD PHY_9/VDD VSUBS VSUBS gf180mcu_fd_sc_mcu7t5v0__clkinv_1
X_9953_ _9953_/D _9974_/CLK _9953_/Q PHY_9/VDD PHY_9/VDD VSUBS VSUBS gf180mcu_fd_sc_mcu7t5v0__dffq_4
X_8904_ _8904_/A1 _8904_/A2 _8904_/B _8912_/A1 PHY_9/VDD PHY_9/VDD VSUBS VSUBS gf180mcu_fd_sc_mcu7t5v0__aoi21_1
X_9884_ _9884_/D _9948_/CLK _9884_/Q PHY_9/VDD PHY_9/VDD VSUBS VSUBS gf180mcu_fd_sc_mcu7t5v0__dffq_1
X_8835_ _6471_/B _8813_/Z _8835_/A3 _8837_/B PHY_9/VDD PHY_9/VDD VSUBS VSUBS gf180mcu_fd_sc_mcu7t5v0__xor3_1
X_5978_ _5978_/A1 _5978_/A2 _9689_/D PHY_9/VDD PHY_9/VDD VSUBS VSUBS gf180mcu_fd_sc_mcu7t5v0__nor2_1
X_8766_ _8736_/B _8790_/A1 _8827_/A1 PHY_9/VDD PHY_9/VDD VSUBS VSUBS gf180mcu_fd_sc_mcu7t5v0__nor2_2
X_8697_ _5406_/Z _8697_/A2 _8697_/B1 _8697_/B2 _9948_/D PHY_9/VDD PHY_9/VDD VSUBS
+ VSUBS gf180mcu_fd_sc_mcu7t5v0__oai22_1
X_7717_ _7973_/A2 _7719_/A2 _8008_/I0 _7870_/B PHY_9/VDD PHY_9/VDD VSUBS VSUBS gf180mcu_fd_sc_mcu7t5v0__nor3_4
X_4929_ _9559_/Q _5721_/B2 PHY_9/VDD PHY_9/VDD VSUBS VSUBS gf180mcu_fd_sc_mcu7t5v0__clkinv_1
X_7648_ _9813_/Q _7382_/Z _7649_/A3 PHY_9/VDD PHY_9/VDD VSUBS VSUBS gf180mcu_fd_sc_mcu7t5v0__nand2_1
X_7579_ _9812_/Q _7668_/A2 _7580_/A2 _7667_/I1 _7668_/B _7580_/B PHY_9/VDD PHY_9/VDD
+ VSUBS VSUBS gf180mcu_fd_sc_mcu7t5v0__aoi221_1
X_9318_ _9318_/A1 _9318_/A2 _9357_/B _9973_/D PHY_9/VDD PHY_9/VDD VSUBS VSUBS gf180mcu_fd_sc_mcu7t5v0__aoi21_1
X_9249_ _9249_/A1 _9247_/Z _9249_/Z PHY_9/VDD PHY_9/VDD VSUBS VSUBS gf180mcu_fd_sc_mcu7t5v0__xor2_1
X_6950_ _9813_/Q _6949_/Z _6988_/B PHY_9/VDD PHY_9/VDD VSUBS VSUBS gf180mcu_fd_sc_mcu7t5v0__nand2_1
X_5901_ _9659_/Q _5901_/A2 _5901_/Z PHY_9/VDD PHY_9/VDD VSUBS VSUBS gf180mcu_fd_sc_mcu7t5v0__xor2_1
X_6881_ _6883_/A1 _6883_/A2 _6919_/B PHY_9/VDD PHY_9/VDD VSUBS VSUBS gf180mcu_fd_sc_mcu7t5v0__nor2_1
X_8620_ _8620_/A1 _8641_/A1 _8617_/Z _8624_/A2 PHY_9/VDD PHY_9/VDD VSUBS VSUBS gf180mcu_fd_sc_mcu7t5v0__xnor3_1
X_5832_ _5209_/B _5871_/A3 _5832_/Z PHY_9/VDD PHY_9/VDD VSUBS VSUBS gf180mcu_fd_sc_mcu7t5v0__and2_4
X_5763_ _8691_/A1 _5769_/A2 _5769_/B1 _5763_/B2 _9591_/D PHY_9/VDD PHY_9/VDD VSUBS
+ VSUBS gf180mcu_fd_sc_mcu7t5v0__oai22_1
X_8551_ _9808_/Q _8645_/A2 _8550_/Z _8595_/A1 PHY_9/VDD PHY_9/VDD VSUBS VSUBS gf180mcu_fd_sc_mcu7t5v0__nand3_1
X_7502_ _9091_/B _7504_/A3 _7572_/A1 _9090_/C _7541_/A2 PHY_9/VDD PHY_9/VDD VSUBS
+ VSUBS gf180mcu_fd_sc_mcu7t5v0__oai22_1
X_4714_ _9925_/Q _8715_/A3 PHY_9/VDD PHY_9/VDD VSUBS VSUBS gf180mcu_fd_sc_mcu7t5v0__inv_1
X_5694_ _9546_/Q _5690_/Z _5700_/B _5695_/A2 PHY_9/VDD PHY_9/VDD VSUBS VSUBS gf180mcu_fd_sc_mcu7t5v0__oai21_1
X_8482_ _8645_/A2 _8526_/B _8482_/Z PHY_9/VDD PHY_9/VDD VSUBS VSUBS gf180mcu_fd_sc_mcu7t5v0__xor2_1
X_7433_ _9809_/Q _7472_/A1 _7430_/Z _7433_/Z PHY_9/VDD PHY_9/VDD VSUBS VSUBS gf180mcu_fd_sc_mcu7t5v0__xor3_1
X_7364_ _9867_/Q _7364_/A2 _9865_/Q _7674_/A1 PHY_9/VDD PHY_9/VDD VSUBS VSUBS gf180mcu_fd_sc_mcu7t5v0__nand3_2
X_9103_ _9500_/Q _9906_/Q _9956_/Q _9508_/Q _9965_/Q _9966_/Q _9103_/Z PHY_9/VDD PHY_9/VDD
+ VSUBS VSUBS gf180mcu_fd_sc_mcu7t5v0__mux4_4
X_6315_ _5474_/B _6323_/A2 _6323_/B1 PHY_9/VDD PHY_9/VDD VSUBS VSUBS gf180mcu_fd_sc_mcu7t5v0__nand2_2
X_7295_ _7295_/A1 _7292_/Z _7294_/Z _7295_/Z PHY_9/VDD PHY_9/VDD VSUBS VSUBS gf180mcu_fd_sc_mcu7t5v0__xor3_1
X_9034_ _9327_/B _9034_/A2 _9034_/B _9965_/D PHY_9/VDD PHY_9/VDD VSUBS VSUBS gf180mcu_fd_sc_mcu7t5v0__aoi21_1
X_6246_ _9588_/Q _6288_/A2 _6287_/A2 _9596_/Q _6247_/A2 PHY_9/VDD PHY_9/VDD VSUBS
+ VSUBS gf180mcu_fd_sc_mcu7t5v0__aoi22_1
X_6177_ _9031_/B _6177_/A2 _9773_/D PHY_9/VDD PHY_9/VDD VSUBS VSUBS gf180mcu_fd_sc_mcu7t5v0__and2_1
X_5128_ _9472_/Q _9471_/Q _5262_/A1 PHY_9/VDD PHY_9/VDD VSUBS VSUBS gf180mcu_fd_sc_mcu7t5v0__nor2_4
X_5059_ _9703_/Q _5996_/B2 PHY_9/VDD PHY_9/VDD VSUBS VSUBS gf180mcu_fd_sc_mcu7t5v0__clkinv_1
X_9936_ _9936_/D _9940_/CLK _9936_/Q PHY_9/VDD PHY_9/VDD VSUBS VSUBS gf180mcu_fd_sc_mcu7t5v0__dffq_1
X_9867_ _9867_/D _9907_/CLK _9867_/Q PHY_9/VDD PHY_9/VDD VSUBS VSUBS gf180mcu_fd_sc_mcu7t5v0__dffq_4
X_8818_ _8857_/A1 _8857_/A2 _9810_/Q _8857_/C _8820_/B PHY_9/VDD PHY_9/VDD VSUBS VSUBS
+ gf180mcu_fd_sc_mcu7t5v0__oai211_2
X_9798_ _9798_/D _9801_/CLK _9798_/Q PHY_9/VDD PHY_9/VDD VSUBS VSUBS gf180mcu_fd_sc_mcu7t5v0__dffq_1
X_8749_ _8994_/B _9926_/Q _8749_/Z PHY_9/VDD PHY_9/VDD VSUBS VSUBS gf180mcu_fd_sc_mcu7t5v0__and2_1
X_6100_ _9913_/Q _6287_/A2 _6287_/B1 _9858_/Q _6102_/A1 PHY_9/VDD PHY_9/VDD VSUBS
+ VSUBS gf180mcu_fd_sc_mcu7t5v0__aoi22_1
X_7080_ _7084_/A2 _7152_/A1 _7119_/A1 PHY_9/VDD PHY_9/VDD VSUBS VSUBS gf180mcu_fd_sc_mcu7t5v0__nor2_1
X_6031_ _8689_/A1 _6039_/A2 _6039_/B1 PHY_9/VDD PHY_9/VDD VSUBS VSUBS gf180mcu_fd_sc_mcu7t5v0__nand2_2
X_7982_ _7939_/Z _7956_/Z _7982_/B _8000_/A1 PHY_9/VDD PHY_9/VDD VSUBS VSUBS gf180mcu_fd_sc_mcu7t5v0__oai21_1
X_6933_ _6934_/A2 _6931_/Z _6981_/A2 PHY_9/VDD PHY_9/VDD VSUBS VSUBS gf180mcu_fd_sc_mcu7t5v0__nand2_1
X_9721_ _9721_/D _9830_/CLK _9721_/Q PHY_9/VDD PHY_9/VDD VSUBS VSUBS gf180mcu_fd_sc_mcu7t5v0__dffq_1
X_6864_ _9820_/Q _6970_/A2 _6920_/A1 PHY_9/VDD PHY_9/VDD VSUBS VSUBS gf180mcu_fd_sc_mcu7t5v0__nand2_2
X_9652_ _9652_/D _9689_/CLK _9652_/Q PHY_9/VDD PHY_9/VDD VSUBS VSUBS gf180mcu_fd_sc_mcu7t5v0__dffq_1
X_5815_ _7677_/A1 _6291_/B2 _5824_/A2 PHY_9/VDD PHY_9/VDD VSUBS VSUBS gf180mcu_fd_sc_mcu7t5v0__nand2_4
X_8603_ _8603_/A1 _8608_/A1 _8559_/Z _8603_/B2 _8611_/A2 PHY_9/VDD PHY_9/VDD VSUBS
+ VSUBS gf180mcu_fd_sc_mcu7t5v0__oai22_2
X_9583_ _9583_/D _9939_/CLK _9583_/Q PHY_9/VDD PHY_9/VDD VSUBS VSUBS gf180mcu_fd_sc_mcu7t5v0__dffq_1
X_6795_ _6795_/A1 _6795_/A2 _6795_/Z PHY_9/VDD PHY_9/VDD VSUBS VSUBS gf180mcu_fd_sc_mcu7t5v0__and2_1
X_5746_ _5399_/Z _5749_/A2 _5749_/B1 _5746_/B2 _9578_/D PHY_9/VDD PHY_9/VDD VSUBS
+ VSUBS gf180mcu_fd_sc_mcu7t5v0__oai22_1
X_8534_ _8673_/I0 _8600_/A2 _8535_/A2 PHY_9/VDD PHY_9/VDD VSUBS VSUBS gf180mcu_fd_sc_mcu7t5v0__nand2_1
X_5677_ _5659_/I _5677_/A2 _5676_/Z _9540_/D PHY_9/VDD PHY_9/VDD VSUBS VSUBS gf180mcu_fd_sc_mcu7t5v0__nor3_1
X_8465_ _8473_/A1 _8437_/Z _8474_/A2 PHY_9/VDD PHY_9/VDD VSUBS VSUBS gf180mcu_fd_sc_mcu7t5v0__nand2_1
X_7416_ _9927_/Q _7553_/B _7417_/B2 PHY_9/VDD PHY_9/VDD VSUBS VSUBS gf180mcu_fd_sc_mcu7t5v0__nand2_1
X_8396_ _8715_/A3 _9356_/C _8396_/B1 _8396_/B2 _9357_/B _9925_/D PHY_9/VDD PHY_9/VDD
+ VSUBS VSUBS gf180mcu_fd_sc_mcu7t5v0__aoi221_1
X_7347_ _7553_/B _9868_/Q _7651_/A2 PHY_9/VDD PHY_9/VDD VSUBS VSUBS gf180mcu_fd_sc_mcu7t5v0__nand2_1
X_7278_ _7278_/A1 _7276_/Z _7278_/B _7278_/C _7283_/A3 PHY_9/VDD PHY_9/VDD VSUBS VSUBS
+ gf180mcu_fd_sc_mcu7t5v0__oai211_1
X_6229_ _9636_/Q _6288_/A2 _6288_/B1 _9620_/Q _6230_/A2 PHY_9/VDD PHY_9/VDD VSUBS
+ VSUBS gf180mcu_fd_sc_mcu7t5v0__aoi22_1
X_9017_ _8925_/B _9017_/A2 _9018_/A2 PHY_9/VDD PHY_9/VDD VSUBS VSUBS gf180mcu_fd_sc_mcu7t5v0__nand2_1
X_9919_ _9919_/D _9948_/CLK _9919_/Q PHY_9/VDD PHY_9/VDD VSUBS VSUBS gf180mcu_fd_sc_mcu7t5v0__dffq_1
X_6580_ _6580_/A1 _6580_/A2 _6534_/Z _6580_/B2 _6588_/A1 PHY_9/VDD PHY_9/VDD VSUBS
+ VSUBS gf180mcu_fd_sc_mcu7t5v0__oai22_1
X_5600_ _5600_/A1 _9034_/A2 _5600_/B _9500_/D PHY_9/VDD PHY_9/VDD VSUBS VSUBS gf180mcu_fd_sc_mcu7t5v0__aoi21_1
X_5531_ _9443_/Q _5525_/Z _5544_/A2 _9470_/Q _5531_/C _5532_/A2 PHY_9/VDD PHY_9/VDD
+ VSUBS VSUBS gf180mcu_fd_sc_mcu7t5v0__aoi221_1
X_8250_ _9812_/Q _8316_/A2 _8250_/B _8251_/B PHY_9/VDD PHY_9/VDD VSUBS VSUBS gf180mcu_fd_sc_mcu7t5v0__oai21_1
X_7201_ _7156_/Z _7210_/A2 _7211_/A2 PHY_9/VDD PHY_9/VDD VSUBS VSUBS gf180mcu_fd_sc_mcu7t5v0__nor2_1
X_5462_ _9443_/Q _5495_/B _5474_/B _5463_/B PHY_9/VDD PHY_9/VDD VSUBS VSUBS gf180mcu_fd_sc_mcu7t5v0__oai21_1
X_8181_ _8181_/A1 _8181_/A2 _8181_/Z PHY_9/VDD PHY_9/VDD VSUBS VSUBS gf180mcu_fd_sc_mcu7t5v0__xor2_1
X_5393_ _5393_/A1 _5201_/Z _5394_/B PHY_9/VDD PHY_9/VDD VSUBS VSUBS gf180mcu_fd_sc_mcu7t5v0__nor2_1
X_7132_ _7132_/A1 _7132_/A2 _7131_/B _7140_/A1 PHY_9/VDD PHY_9/VDD VSUBS VSUBS gf180mcu_fd_sc_mcu7t5v0__nor3_1
X_7063_ _9808_/Q _7315_/A2 _7062_/Z _7322_/A1 _7139_/C _7064_/A3 PHY_9/VDD PHY_9/VDD
+ VSUBS VSUBS gf180mcu_fd_sc_mcu7t5v0__aoi221_1
X_6014_ _8693_/A1 _6018_/A2 _6018_/B1 _6014_/B2 _9717_/D PHY_9/VDD PHY_9/VDD VSUBS
+ VSUBS gf180mcu_fd_sc_mcu7t5v0__oai22_1
X_9704_ _9704_/D _9940_/CLK _9704_/Q PHY_9/VDD PHY_9/VDD VSUBS VSUBS gf180mcu_fd_sc_mcu7t5v0__dffq_1
X_7965_ _7965_/A1 _7981_/A1 _7962_/Z _7965_/Z PHY_9/VDD PHY_9/VDD VSUBS VSUBS gf180mcu_fd_sc_mcu7t5v0__xor3_1
X_6916_ _6916_/A1 _6871_/Z _6916_/B _6918_/A2 PHY_9/VDD PHY_9/VDD VSUBS VSUBS gf180mcu_fd_sc_mcu7t5v0__aoi21_1
X_7896_ _9811_/Q _7948_/A2 _7899_/A3 _7953_/A1 PHY_9/VDD PHY_9/VDD VSUBS VSUBS gf180mcu_fd_sc_mcu7t5v0__nand3_2
X_6847_ _6921_/A2 _6847_/A2 _6848_/A2 PHY_9/VDD PHY_9/VDD VSUBS VSUBS gf180mcu_fd_sc_mcu7t5v0__nand2_1
X_9635_ _9635_/D _9830_/CLK _9635_/Q PHY_9/VDD PHY_9/VDD VSUBS VSUBS gf180mcu_fd_sc_mcu7t5v0__dffq_1
X_6778_ _6741_/Z _6778_/A2 _6778_/B _6787_/A1 PHY_9/VDD PHY_9/VDD VSUBS VSUBS gf180mcu_fd_sc_mcu7t5v0__aoi21_2
X_9566_ _9566_/D _9901_/CLK _9566_/Q PHY_9/VDD PHY_9/VDD VSUBS VSUBS gf180mcu_fd_sc_mcu7t5v0__dffq_1
X_5729_ _7007_/B _5737_/A2 _5737_/B1 PHY_9/VDD PHY_9/VDD VSUBS VSUBS gf180mcu_fd_sc_mcu7t5v0__nand2_2
X_8517_ _8515_/Z _8517_/A2 _8519_/A2 PHY_9/VDD PHY_9/VDD VSUBS VSUBS gf180mcu_fd_sc_mcu7t5v0__nand2_1
X_9497_ _9497_/D _9901_/CLK _9497_/Q PHY_9/VDD PHY_9/VDD VSUBS VSUBS gf180mcu_fd_sc_mcu7t5v0__dffq_1
X_8448_ _8449_/A1 _8449_/A2 _8448_/B _8485_/A2 PHY_9/VDD PHY_9/VDD VSUBS VSUBS gf180mcu_fd_sc_mcu7t5v0__aoi21_1
X_8379_ _9921_/Q _9920_/Q _8535_/A1 PHY_9/VDD PHY_9/VDD VSUBS VSUBS gf180mcu_fd_sc_mcu7t5v0__nand2_2
X_4962_ _9708_/Q _6003_/B2 PHY_9/VDD PHY_9/VDD VSUBS VSUBS gf180mcu_fd_sc_mcu7t5v0__clkinv_1
X_7750_ _7783_/A1 _7748_/Z _7761_/A1 PHY_9/VDD PHY_9/VDD VSUBS VSUBS gf180mcu_fd_sc_mcu7t5v0__nor2_1
X_4893_ _9857_/Q _7329_/B2 PHY_9/VDD PHY_9/VDD VSUBS VSUBS gf180mcu_fd_sc_mcu7t5v0__clkinv_1
X_7681_ _8692_/A1 _7686_/A2 _7686_/B1 _7681_/B2 _9880_/D PHY_9/VDD PHY_9/VDD VSUBS
+ VSUBS gf180mcu_fd_sc_mcu7t5v0__oai22_1
X_6701_ _7705_/A2 _9090_/C _6752_/B2 _6737_/A1 PHY_9/VDD PHY_9/VDD VSUBS VSUBS gf180mcu_fd_sc_mcu7t5v0__nor3_2
X_6632_ _6635_/A2 _6632_/A2 _6631_/Z _6632_/Z PHY_9/VDD PHY_9/VDD VSUBS VSUBS gf180mcu_fd_sc_mcu7t5v0__xor3_1
X_9420_ _9420_/D _9830_/CLK _9420_/Q PHY_9/VDD PHY_9/VDD VSUBS VSUBS gf180mcu_fd_sc_mcu7t5v0__dffq_1
X_6563_ _6561_/B _6550_/Z _9356_/C _6564_/B2 PHY_9/VDD PHY_9/VDD VSUBS VSUBS gf180mcu_fd_sc_mcu7t5v0__aoi21_1
X_9351_ _9251_/B _9351_/A2 _9352_/A2 PHY_9/VDD PHY_9/VDD VSUBS VSUBS gf180mcu_fd_sc_mcu7t5v0__nand2_1
X_6494_ _6495_/A1 _6495_/A2 _6494_/B _6521_/B PHY_9/VDD PHY_9/VDD VSUBS VSUBS gf180mcu_fd_sc_mcu7t5v0__oai21_1
X_9282_ _9282_/I _9321_/A1 PHY_9/VDD PHY_9/VDD VSUBS VSUBS gf180mcu_fd_sc_mcu7t5v0__clkinv_1
X_5514_ _5973_/C _5514_/A2 _9464_/D PHY_9/VDD PHY_9/VDD VSUBS VSUBS gf180mcu_fd_sc_mcu7t5v0__nor2_1
X_8302_ _9813_/Q _8333_/A2 _8302_/B _8303_/A4 PHY_9/VDD PHY_9/VDD VSUBS VSUBS gf180mcu_fd_sc_mcu7t5v0__oai21_1
X_8233_ _8234_/A1 _8234_/A2 _8285_/B PHY_9/VDD PHY_9/VDD VSUBS VSUBS gf180mcu_fd_sc_mcu7t5v0__nand2_1
X_5445_ _9435_/Q _5458_/A2 _5474_/B _5446_/B PHY_9/VDD PHY_9/VDD VSUBS VSUBS gf180mcu_fd_sc_mcu7t5v0__oai21_1
X_8164_ _9903_/Q _9902_/Q _9510_/Q _8165_/B PHY_9/VDD PHY_9/VDD VSUBS VSUBS gf180mcu_fd_sc_mcu7t5v0__nand3_1
X_7115_ _9810_/Q _7019_/I _7254_/A2 _9809_/Q _7152_/B1 PHY_9/VDD PHY_9/VDD VSUBS VSUBS
+ gf180mcu_fd_sc_mcu7t5v0__aoi22_1
X_5376_ _9491_/Q _5560_/A2 _9489_/Q _5569_/A1 PHY_9/VDD PHY_9/VDD VSUBS VSUBS gf180mcu_fd_sc_mcu7t5v0__nand3_1
X_8095_ _9317_/C _8095_/A2 _8095_/B _9905_/D PHY_9/VDD PHY_9/VDD VSUBS VSUBS gf180mcu_fd_sc_mcu7t5v0__aoi21_1
X_7046_ _9844_/Q _7047_/A2 _7046_/Z PHY_9/VDD PHY_9/VDD VSUBS VSUBS gf180mcu_fd_sc_mcu7t5v0__and2_1
X_8997_ _9808_/Q _9017_/A2 _9008_/A2 PHY_9/VDD PHY_9/VDD VSUBS VSUBS gf180mcu_fd_sc_mcu7t5v0__nand2_1
X_7948_ _9813_/Q _7948_/A2 _7988_/A3 PHY_9/VDD PHY_9/VDD VSUBS VSUBS gf180mcu_fd_sc_mcu7t5v0__nand2_1
X_9618_ _9618_/D _9830_/CLK _9618_/Q PHY_9/VDD PHY_9/VDD VSUBS VSUBS gf180mcu_fd_sc_mcu7t5v0__dffq_1
X_7879_ _7831_/C _7862_/Z _7879_/B _7880_/C PHY_9/VDD PHY_9/VDD VSUBS VSUBS gf180mcu_fd_sc_mcu7t5v0__aoi21_1
X_9549_ _9549_/D _9689_/CLK _9549_/Q PHY_9/VDD PHY_9/VDD VSUBS VSUBS gf180mcu_fd_sc_mcu7t5v0__dffq_1
X_5230_ _5230_/A1 _5236_/A2 _5230_/B _9359_/D PHY_9/VDD PHY_9/VDD VSUBS VSUBS gf180mcu_fd_sc_mcu7t5v0__aoi21_1
X_5161_ _5967_/B _5951_/A2 _5161_/A3 _9477_/D PHY_9/VDD PHY_9/VDD VSUBS VSUBS gf180mcu_fd_sc_mcu7t5v0__nand3_1
X_5092_ _9696_/Q _5987_/B2 PHY_9/VDD PHY_9/VDD VSUBS VSUBS gf180mcu_fd_sc_mcu7t5v0__clkinv_1
X_8920_ _8920_/A1 _8918_/Z _8924_/A2 PHY_9/VDD PHY_9/VDD VSUBS VSUBS gf180mcu_fd_sc_mcu7t5v0__xnor2_1
X_8851_ _9808_/Q _8850_/Z _8903_/A1 PHY_9/VDD PHY_9/VDD VSUBS VSUBS gf180mcu_fd_sc_mcu7t5v0__nand2_1
X_5994_ _8693_/A1 _5998_/A2 _5998_/B1 _5994_/B2 _9701_/D PHY_9/VDD PHY_9/VDD VSUBS
+ VSUBS gf180mcu_fd_sc_mcu7t5v0__oai22_1
X_8782_ _9953_/Q _8782_/A2 _9952_/Q _8783_/B2 PHY_9/VDD PHY_9/VDD VSUBS VSUBS gf180mcu_fd_sc_mcu7t5v0__aoi21_2
X_7802_ _7757_/B _7809_/A1 _7802_/B1 _7772_/Z _7811_/A1 PHY_9/VDD PHY_9/VDD VSUBS
+ VSUBS gf180mcu_fd_sc_mcu7t5v0__aoi22_1
X_4945_ _9740_/Q _6024_/B2 PHY_9/VDD PHY_9/VDD VSUBS VSUBS gf180mcu_fd_sc_mcu7t5v0__clkinv_1
X_7733_ _7733_/I _7783_/A1 PHY_9/VDD PHY_9/VDD VSUBS VSUBS gf180mcu_fd_sc_mcu7t5v0__clkinv_1
X_4876_ _9418_/Q _5389_/A1 PHY_9/VDD PHY_9/VDD VSUBS VSUBS gf180mcu_fd_sc_mcu7t5v0__clkinv_1
X_7664_ _7482_/B _7663_/Z _7676_/B1 PHY_9/VDD PHY_9/VDD VSUBS VSUBS gf180mcu_fd_sc_mcu7t5v0__nand2_1
X_6615_ _6401_/C _6615_/A2 _6615_/A3 _6646_/A1 _9813_/Q _6616_/A4 PHY_9/VDD PHY_9/VDD
+ VSUBS VSUBS gf180mcu_fd_sc_mcu7t5v0__oai32_1
X_9403_ _9403_/D _9901_/CLK _9403_/Q PHY_9/VDD PHY_9/VDD VSUBS VSUBS gf180mcu_fd_sc_mcu7t5v0__dffq_1
X_7595_ _7645_/A1 _7645_/A2 _7595_/Z PHY_9/VDD PHY_9/VDD VSUBS VSUBS gf180mcu_fd_sc_mcu7t5v0__xor2_1
X_6546_ _6546_/I _6548_/A2 PHY_9/VDD PHY_9/VDD VSUBS VSUBS gf180mcu_fd_sc_mcu7t5v0__clkinv_1
X_9334_ _9335_/A2 _9332_/Z _9334_/A3 _9334_/Z PHY_9/VDD PHY_9/VDD VSUBS VSUBS gf180mcu_fd_sc_mcu7t5v0__xor3_1
X_6477_ _6561_/B _6463_/Z _6477_/B _9356_/C _6478_/B PHY_9/VDD PHY_9/VDD VSUBS VSUBS
+ gf180mcu_fd_sc_mcu7t5v0__aoi211_1
X_9265_ _9265_/A1 _9265_/A2 _9357_/B _9972_/D PHY_9/VDD PHY_9/VDD VSUBS VSUBS gf180mcu_fd_sc_mcu7t5v0__aoi21_1
X_8216_ _9227_/A1 _8216_/A2 _8267_/B PHY_9/VDD PHY_9/VDD VSUBS VSUBS gf180mcu_fd_sc_mcu7t5v0__nor2_1
X_9196_ _9297_/A1 _9297_/A2 _9245_/A2 PHY_9/VDD PHY_9/VDD VSUBS VSUBS gf180mcu_fd_sc_mcu7t5v0__nor2_1
X_5428_ _5428_/I _5429_/B1 PHY_9/VDD PHY_9/VDD VSUBS VSUBS gf180mcu_fd_sc_mcu7t5v0__clkinv_1
X_5359_ _9462_/Q _5364_/A2 _7007_/B _5360_/B PHY_9/VDD PHY_9/VDD VSUBS VSUBS gf180mcu_fd_sc_mcu7t5v0__oai21_1
X_8147_ _8311_/A2 _8147_/A2 _8147_/Z PHY_9/VDD PHY_9/VDD VSUBS VSUBS gf180mcu_fd_sc_mcu7t5v0__xor2_1
X_8078_ _8108_/A1 _8077_/Z _8151_/B _8079_/B PHY_9/VDD PHY_9/VDD VSUBS VSUBS gf180mcu_fd_sc_mcu7t5v0__oai21_1
X_7029_ _7039_/A2 _7314_/I1 _7278_/C _7035_/A1 PHY_9/VDD PHY_9/VDD VSUBS VSUBS gf180mcu_fd_sc_mcu7t5v0__nor3_1
X_4730_ _9902_/Q _8318_/B PHY_9/VDD PHY_9/VDD VSUBS VSUBS gf180mcu_fd_sc_mcu7t5v0__inv_4
X_6400_ _9808_/Q _6400_/A2 _6584_/B1 _6401_/B2 PHY_9/VDD PHY_9/VDD VSUBS VSUBS gf180mcu_fd_sc_mcu7t5v0__nand3_1
X_7380_ _9926_/Q _9868_/Q _7381_/B1 PHY_9/VDD PHY_9/VDD VSUBS VSUBS gf180mcu_fd_sc_mcu7t5v0__nor2_1
X_6331_ _6331_/A1 _9036_/A2 _6331_/B _9805_/D PHY_9/VDD PHY_9/VDD VSUBS VSUBS gf180mcu_fd_sc_mcu7t5v0__aoi21_1
X_6262_ _6283_/A1 _6262_/A2 _6262_/B1 _6290_/B2 _6262_/C _6263_/A3 PHY_9/VDD PHY_9/VDD
+ VSUBS VSUBS gf180mcu_fd_sc_mcu7t5v0__aoi221_2
X_9050_ _9962_/Q _9168_/A2 _9347_/I1 PHY_9/VDD PHY_9/VDD VSUBS VSUBS gf180mcu_fd_sc_mcu7t5v0__nor2_2
X_6193_ _9578_/Q _6287_/B1 _6288_/B1 _9937_/Q _6195_/A1 PHY_9/VDD PHY_9/VDD VSUBS
+ VSUBS gf180mcu_fd_sc_mcu7t5v0__aoi22_1
X_5213_ _5961_/B _9729_/Q _9737_/D PHY_9/VDD PHY_9/VDD VSUBS VSUBS gf180mcu_fd_sc_mcu7t5v0__and2_1
X_8001_ _8001_/A1 _8001_/A2 _8000_/Z _8001_/Z PHY_9/VDD PHY_9/VDD VSUBS VSUBS gf180mcu_fd_sc_mcu7t5v0__xor3_1
X_5144_ _5144_/A1 _9450_/Q _5145_/A2 _5145_/A3 _5219_/A1 PHY_9/VDD PHY_9/VDD VSUBS
+ VSUBS gf180mcu_fd_sc_mcu7t5v0__nand4_1
X_9952_ _9952_/D _9974_/CLK _9952_/Q PHY_9/VDD PHY_9/VDD VSUBS VSUBS gf180mcu_fd_sc_mcu7t5v0__dffq_4
X_5075_ _9487_/Q _5557_/B2 PHY_9/VDD PHY_9/VDD VSUBS VSUBS gf180mcu_fd_sc_mcu7t5v0__clkinv_1
X_9883_ _9883_/D _9948_/CLK _9883_/Q PHY_9/VDD PHY_9/VDD VSUBS VSUBS gf180mcu_fd_sc_mcu7t5v0__dffq_1
X_8903_ _8903_/A1 _8898_/I _8903_/A3 _8903_/Z PHY_9/VDD PHY_9/VDD VSUBS VSUBS gf180mcu_fd_sc_mcu7t5v0__xor3_1
X_8834_ _8813_/Z _8835_/A3 _8834_/Z PHY_9/VDD PHY_9/VDD VSUBS VSUBS gf180mcu_fd_sc_mcu7t5v0__xor2_1
X_8765_ _9091_/B _8832_/A1 _8816_/A1 PHY_9/VDD PHY_9/VDD VSUBS VSUBS gf180mcu_fd_sc_mcu7t5v0__nor2_1
X_5977_ _9688_/Q _5973_/B _9689_/Q _5978_/A2 PHY_9/VDD PHY_9/VDD VSUBS VSUBS gf180mcu_fd_sc_mcu7t5v0__aoi21_1
X_8696_ _5404_/Z _8697_/A2 _8697_/B1 _8696_/B2 _9947_/D PHY_9/VDD PHY_9/VDD VSUBS
+ VSUBS gf180mcu_fd_sc_mcu7t5v0__oai22_1
X_4928_ _9779_/Q _6297_/B2 PHY_9/VDD PHY_9/VDD VSUBS VSUBS gf180mcu_fd_sc_mcu7t5v0__clkinv_1
X_7716_ _9888_/Q _9887_/Q _7743_/A2 PHY_9/VDD PHY_9/VDD VSUBS VSUBS gf180mcu_fd_sc_mcu7t5v0__nor2_1
X_7647_ _9814_/Q _7647_/A2 _7649_/A2 PHY_9/VDD PHY_9/VDD VSUBS VSUBS gf180mcu_fd_sc_mcu7t5v0__nand2_1
X_4859_ _9405_/Q _5338_/A1 PHY_9/VDD PHY_9/VDD VSUBS VSUBS gf180mcu_fd_sc_mcu7t5v0__clkinv_1
X_7578_ _9812_/Q _7655_/A2 _7580_/A2 PHY_9/VDD PHY_9/VDD VSUBS VSUBS gf180mcu_fd_sc_mcu7t5v0__nand2_1
X_6529_ _6529_/A1 _6572_/B2 _6622_/A1 _6529_/Z PHY_9/VDD PHY_9/VDD VSUBS VSUBS gf180mcu_fd_sc_mcu7t5v0__xor3_1
X_9317_ _9343_/B _9302_/Z _9317_/B _9317_/C _9318_/A2 PHY_9/VDD PHY_9/VDD VSUBS VSUBS
+ gf180mcu_fd_sc_mcu7t5v0__oai211_1
X_9248_ _9249_/A1 _9247_/Z _9267_/B PHY_9/VDD PHY_9/VDD VSUBS VSUBS gf180mcu_fd_sc_mcu7t5v0__and2_1
X_9179_ _9807_/Q _9178_/Z _9183_/A1 PHY_9/VDD PHY_9/VDD VSUBS VSUBS gf180mcu_fd_sc_mcu7t5v0__nand2_1
X_5900_ _5900_/A1 _5901_/A2 _5906_/A2 PHY_9/VDD PHY_9/VDD VSUBS VSUBS gf180mcu_fd_sc_mcu7t5v0__nor2_1
X_6880_ _6880_/A1 _6875_/Z _6978_/A1 _6883_/A2 PHY_9/VDD PHY_9/VDD VSUBS VSUBS gf180mcu_fd_sc_mcu7t5v0__xnor3_1
X_5831_ _5867_/A2 _5831_/A2 _5875_/B _5871_/A3 PHY_9/VDD PHY_9/VDD VSUBS VSUBS gf180mcu_fd_sc_mcu7t5v0__oai21_1
X_5762_ _5388_/Z _5769_/A2 _5769_/B1 _5762_/B2 _9590_/D PHY_9/VDD PHY_9/VDD VSUBS
+ VSUBS gf180mcu_fd_sc_mcu7t5v0__oai22_1
X_8550_ _9809_/Q _8600_/A2 _8550_/Z PHY_9/VDD PHY_9/VDD VSUBS VSUBS gf180mcu_fd_sc_mcu7t5v0__and2_1
X_7501_ _9807_/Q _7599_/A2 _7505_/A3 PHY_9/VDD PHY_9/VDD VSUBS VSUBS gf180mcu_fd_sc_mcu7t5v0__nand2_1
X_4713_ _9927_/Q _8782_/A2 PHY_9/VDD PHY_9/VDD VSUBS VSUBS gf180mcu_fd_sc_mcu7t5v0__inv_1
X_5693_ _9546_/Q _5690_/Z _5693_/Z PHY_9/VDD PHY_9/VDD VSUBS VSUBS gf180mcu_fd_sc_mcu7t5v0__and2_1
X_8481_ _8402_/Z _8481_/A2 _8526_/B PHY_9/VDD PHY_9/VDD VSUBS VSUBS gf180mcu_fd_sc_mcu7t5v0__nor2_2
X_7432_ _9809_/Q _7430_/Z _7472_/A2 PHY_9/VDD PHY_9/VDD VSUBS VSUBS gf180mcu_fd_sc_mcu7t5v0__nor2_1
X_7363_ _7371_/A3 _7363_/A2 _7625_/A1 PHY_9/VDD PHY_9/VDD VSUBS VSUBS gf180mcu_fd_sc_mcu7t5v0__nor2_2
X_7294_ _7294_/A1 _7294_/A2 _7294_/Z PHY_9/VDD PHY_9/VDD VSUBS VSUBS gf180mcu_fd_sc_mcu7t5v0__xor2_1
X_9102_ _9968_/Q _9093_/Z _9102_/B _9133_/A1 PHY_9/VDD PHY_9/VDD VSUBS VSUBS gf180mcu_fd_sc_mcu7t5v0__aoi21_1
X_6314_ _8344_/A1 _6656_/A2 _6323_/A2 PHY_9/VDD PHY_9/VDD VSUBS VSUBS gf180mcu_fd_sc_mcu7t5v0__nand2_4
X_6245_ _9580_/Q _6287_/B1 _6288_/B1 _9939_/Q _6247_/A1 PHY_9/VDD PHY_9/VDD VSUBS
+ VSUBS gf180mcu_fd_sc_mcu7t5v0__aoi22_1
X_9033_ _9361_/Q _9036_/A2 _9035_/B _9034_/B PHY_9/VDD PHY_9/VDD VSUBS VSUBS gf180mcu_fd_sc_mcu7t5v0__oai21_1
X_6176_ _6176_/A1 _6176_/A2 _6176_/A3 _6177_/A2 PHY_9/VDD PHY_9/VDD VSUBS VSUBS gf180mcu_fd_sc_mcu7t5v0__nand3_1
X_5127_ _5544_/A1 _9475_/Q _9474_/Q _5224_/A3 PHY_9/VDD PHY_9/VDD VSUBS VSUBS gf180mcu_fd_sc_mcu7t5v0__nor3_2
X_5058_ _9711_/Q _6006_/B2 PHY_9/VDD PHY_9/VDD VSUBS VSUBS gf180mcu_fd_sc_mcu7t5v0__clkinv_1
X_9935_ _9935_/D _9940_/CLK _9935_/Q PHY_9/VDD PHY_9/VDD VSUBS VSUBS gf180mcu_fd_sc_mcu7t5v0__dffq_1
X_9866_ _9866_/D _9907_/CLK _9866_/Q PHY_9/VDD PHY_9/VDD VSUBS VSUBS gf180mcu_fd_sc_mcu7t5v0__dffq_4
X_8817_ _9091_/B _8784_/I _8856_/B2 PHY_9/VDD PHY_9/VDD VSUBS VSUBS gf180mcu_fd_sc_mcu7t5v0__nor2_1
X_9797_ _9797_/D _9801_/CLK _9797_/Q PHY_9/VDD PHY_9/VDD VSUBS VSUBS gf180mcu_fd_sc_mcu7t5v0__dffq_1
X_8748_ _9968_/Q _8717_/Z _8748_/Z PHY_9/VDD PHY_9/VDD VSUBS VSUBS gf180mcu_fd_sc_mcu7t5v0__and2_1
X_8679_ _7007_/B _8687_/A2 _8687_/B1 PHY_9/VDD PHY_9/VDD VSUBS VSUBS gf180mcu_fd_sc_mcu7t5v0__nand2_2
X_6030_ _7677_/A1 _6290_/B2 _6039_/A2 PHY_9/VDD PHY_9/VDD VSUBS VSUBS gf180mcu_fd_sc_mcu7t5v0__nand2_4
X_7981_ _7981_/A1 _7964_/Z _7981_/B _8005_/A1 PHY_9/VDD PHY_9/VDD VSUBS VSUBS gf180mcu_fd_sc_mcu7t5v0__aoi21_1
X_6932_ _6934_/A2 _6931_/Z _6981_/B PHY_9/VDD PHY_9/VDD VSUBS VSUBS gf180mcu_fd_sc_mcu7t5v0__nor2_1
X_9720_ _9720_/D _9830_/CLK _9720_/Q PHY_9/VDD PHY_9/VDD VSUBS VSUBS gf180mcu_fd_sc_mcu7t5v0__dffq_1
X_6863_ _6863_/A1 _6863_/A2 _6863_/B _6911_/A1 PHY_9/VDD PHY_9/VDD VSUBS VSUBS gf180mcu_fd_sc_mcu7t5v0__aoi21_1
X_9651_ _9651_/D _9689_/CLK uart_tx PHY_9/VDD PHY_9/VDD VSUBS VSUBS gf180mcu_fd_sc_mcu7t5v0__dffq_2
X_5814_ _5406_/Z _5814_/A2 _5814_/B1 _5814_/B2 _9630_/D PHY_9/VDD PHY_9/VDD VSUBS
+ VSUBS gf180mcu_fd_sc_mcu7t5v0__oai22_1
X_8602_ _8488_/Z _8550_/Z _8657_/B2 _8602_/Z PHY_9/VDD PHY_9/VDD VSUBS VSUBS gf180mcu_fd_sc_mcu7t5v0__xor3_1
X_9582_ _9582_/D _9940_/CLK _9582_/Q PHY_9/VDD PHY_9/VDD VSUBS VSUBS gf180mcu_fd_sc_mcu7t5v0__dffq_1
X_6794_ _6812_/A1 _6793_/Z _6794_/Z PHY_9/VDD PHY_9/VDD VSUBS VSUBS gf180mcu_fd_sc_mcu7t5v0__xor2_1
X_5745_ _8693_/A1 _5749_/A2 _5749_/B1 _5745_/B2 _9577_/D PHY_9/VDD PHY_9/VDD VSUBS
+ VSUBS gf180mcu_fd_sc_mcu7t5v0__oai22_1
X_8533_ _9811_/Q _8600_/A2 _8538_/B1 PHY_9/VDD PHY_9/VDD VSUBS VSUBS gf180mcu_fd_sc_mcu7t5v0__nor2_1
X_5676_ _9540_/Q _5673_/Z _5676_/Z PHY_9/VDD PHY_9/VDD VSUBS VSUBS gf180mcu_fd_sc_mcu7t5v0__and2_1
X_8464_ _9807_/Q _8645_/A2 _8464_/Z PHY_9/VDD PHY_9/VDD VSUBS VSUBS gf180mcu_fd_sc_mcu7t5v0__and2_1
X_7415_ _9869_/Q _7604_/B1 _9817_/Q _7417_/C PHY_9/VDD PHY_9/VDD VSUBS VSUBS gf180mcu_fd_sc_mcu7t5v0__nor3_2
X_8395_ _8423_/A1 _8395_/A2 _9356_/C _8396_/B2 PHY_9/VDD PHY_9/VDD VSUBS VSUBS gf180mcu_fd_sc_mcu7t5v0__aoi21_1
X_7346_ _7553_/B _9034_/A2 _7346_/B _9869_/D PHY_9/VDD PHY_9/VDD VSUBS VSUBS gf180mcu_fd_sc_mcu7t5v0__aoi21_1
X_7277_ _7278_/A1 _7276_/Z _7278_/B PHY_9/VDD PHY_9/VDD VSUBS VSUBS gf180mcu_fd_sc_mcu7t5v0__nand2_1
X_6228_ _9612_/Q _6287_/A2 _6287_/B1 _9628_/Q _6230_/A1 PHY_9/VDD PHY_9/VDD VSUBS
+ VSUBS gf180mcu_fd_sc_mcu7t5v0__aoi22_1
X_9016_ _9349_/A1 _9023_/B1 _9016_/Z PHY_9/VDD PHY_9/VDD VSUBS VSUBS gf180mcu_fd_sc_mcu7t5v0__xor2_1
X_6159_ _9693_/Q _6288_/A2 _6288_/B1 _9709_/Q _6160_/A2 PHY_9/VDD PHY_9/VDD VSUBS
+ VSUBS gf180mcu_fd_sc_mcu7t5v0__aoi22_1
X_9918_ _9918_/D _9948_/CLK _9918_/Q PHY_9/VDD PHY_9/VDD VSUBS VSUBS gf180mcu_fd_sc_mcu7t5v0__dffq_1
X_9849_ _9849_/D _9940_/CLK _9849_/Q PHY_9/VDD PHY_9/VDD VSUBS VSUBS gf180mcu_fd_sc_mcu7t5v0__dffq_1
X_5530_ _5530_/A1 _5544_/A2 _5530_/B1 _5527_/Z _5973_/C _9469_/D PHY_9/VDD PHY_9/VDD
+ VSUBS VSUBS gf180mcu_fd_sc_mcu7t5v0__aoi221_1
X_5461_ _5478_/A1 _5495_/B _5461_/B _9442_/D PHY_9/VDD PHY_9/VDD VSUBS VSUBS gf180mcu_fd_sc_mcu7t5v0__aoi21_1
X_7200_ _7200_/A1 _7242_/A1 _7200_/A3 _7245_/A1 PHY_9/VDD PHY_9/VDD VSUBS VSUBS gf180mcu_fd_sc_mcu7t5v0__xnor3_1
X_8180_ _8181_/A1 _8181_/A2 _8210_/B PHY_9/VDD PHY_9/VDD VSUBS VSUBS gf180mcu_fd_sc_mcu7t5v0__nor2_1
X_5392_ _5392_/A1 _5407_/A2 _8691_/A1 _5407_/B2 _9419_/D PHY_9/VDD PHY_9/VDD VSUBS
+ VSUBS gf180mcu_fd_sc_mcu7t5v0__oai22_1
X_7131_ _7132_/A1 _7132_/A2 _7131_/B _7178_/A2 PHY_9/VDD PHY_9/VDD VSUBS VSUBS gf180mcu_fd_sc_mcu7t5v0__oai21_2
X_7062_ _7062_/A1 _7062_/A2 _7062_/Z PHY_9/VDD PHY_9/VDD VSUBS VSUBS gf180mcu_fd_sc_mcu7t5v0__xor2_1
X_6013_ _8692_/A1 _6018_/A2 _6018_/B1 _6013_/B2 _9716_/D PHY_9/VDD PHY_9/VDD VSUBS
+ VSUBS gf180mcu_fd_sc_mcu7t5v0__oai22_1
X_7964_ _9897_/Q _7962_/Z _7964_/Z PHY_9/VDD PHY_9/VDD VSUBS VSUBS gf180mcu_fd_sc_mcu7t5v0__or2_1
X_6915_ _9807_/Q _6991_/A2 _6918_/A1 PHY_9/VDD PHY_9/VDD VSUBS VSUBS gf180mcu_fd_sc_mcu7t5v0__nand2_1
X_9703_ _9703_/D _9940_/CLK _9703_/Q PHY_9/VDD PHY_9/VDD VSUBS VSUBS gf180mcu_fd_sc_mcu7t5v0__dffq_1
X_7895_ _6558_/B _7988_/A2 _7899_/A3 PHY_9/VDD PHY_9/VDD VSUBS VSUBS gf180mcu_fd_sc_mcu7t5v0__nor2_1
X_6846_ _6921_/A2 _6847_/A2 _6846_/Z PHY_9/VDD PHY_9/VDD VSUBS VSUBS gf180mcu_fd_sc_mcu7t5v0__or2_1
X_9634_ _9634_/D _9830_/CLK _9634_/Q PHY_9/VDD PHY_9/VDD VSUBS VSUBS gf180mcu_fd_sc_mcu7t5v0__dffq_1
X_6777_ _6777_/I _6820_/A2 PHY_9/VDD PHY_9/VDD VSUBS VSUBS gf180mcu_fd_sc_mcu7t5v0__clkinv_1
X_9565_ _9565_/D _9800_/CLK _9565_/Q PHY_9/VDD PHY_9/VDD VSUBS VSUBS gf180mcu_fd_sc_mcu7t5v0__dffq_1
X_5728_ _5372_/Z _8344_/A1 _5737_/A2 PHY_9/VDD PHY_9/VDD VSUBS VSUBS gf180mcu_fd_sc_mcu7t5v0__nand2_4
X_8516_ _8516_/A1 _8516_/A2 _8517_/A2 PHY_9/VDD PHY_9/VDD VSUBS VSUBS gf180mcu_fd_sc_mcu7t5v0__nand2_1
X_9496_ _9496_/D _9901_/CLK _9496_/Q PHY_9/VDD PHY_9/VDD VSUBS VSUBS gf180mcu_fd_sc_mcu7t5v0__dffq_1
X_5659_ _5659_/I _5700_/B PHY_9/VDD PHY_9/VDD VSUBS VSUBS gf180mcu_fd_sc_mcu7t5v0__clkinv_2
X_8447_ _9227_/A1 _8653_/A2 _8447_/A3 _8448_/B PHY_9/VDD PHY_9/VDD VSUBS VSUBS gf180mcu_fd_sc_mcu7t5v0__xor3_1
X_8378_ _9922_/Q _9921_/Q _8403_/A2 PHY_9/VDD PHY_9/VDD VSUBS VSUBS gf180mcu_fd_sc_mcu7t5v0__nor2_1
X_7329_ _5388_/Z _7336_/A2 _7336_/B1 _7329_/B2 _9857_/D PHY_9/VDD PHY_9/VDD VSUBS
+ VSUBS gf180mcu_fd_sc_mcu7t5v0__oai22_1
X_4961_ _9560_/Q _5722_/B2 PHY_9/VDD PHY_9/VDD VSUBS VSUBS gf180mcu_fd_sc_mcu7t5v0__clkinv_1
X_4892_ _9878_/Q _7679_/B2 PHY_9/VDD PHY_9/VDD VSUBS VSUBS gf180mcu_fd_sc_mcu7t5v0__clkinv_1
X_6700_ _9807_/Q _6680_/Z _6700_/B _6700_/C _6705_/B1 PHY_9/VDD PHY_9/VDD VSUBS VSUBS
+ gf180mcu_fd_sc_mcu7t5v0__oai211_1
X_7680_ _8691_/A1 _7686_/A2 _7686_/B1 _7680_/B2 _9879_/D PHY_9/VDD PHY_9/VDD VSUBS
+ VSUBS gf180mcu_fd_sc_mcu7t5v0__oai22_1
X_6631_ _6631_/A1 _6631_/A2 _6631_/A3 _6631_/Z PHY_9/VDD PHY_9/VDD VSUBS VSUBS gf180mcu_fd_sc_mcu7t5v0__xor3_1
X_9350_ _9350_/A1 _9350_/A2 _9353_/A2 PHY_9/VDD PHY_9/VDD VSUBS VSUBS gf180mcu_fd_sc_mcu7t5v0__nand2_1
X_6562_ _6651_/A1 _6546_/I _6562_/B _6562_/C _6564_/B1 PHY_9/VDD PHY_9/VDD VSUBS VSUBS
+ gf180mcu_fd_sc_mcu7t5v0__oai211_1
X_8301_ _8301_/A1 _8301_/A2 _8301_/B _8302_/B PHY_9/VDD PHY_9/VDD VSUBS VSUBS gf180mcu_fd_sc_mcu7t5v0__oai21_1
X_6493_ _6435_/Z _6493_/A2 _6580_/A1 _6494_/B PHY_9/VDD PHY_9/VDD VSUBS VSUBS gf180mcu_fd_sc_mcu7t5v0__xor3_1
X_9281_ _9281_/A1 _9287_/A1 _9281_/B1 _9281_/B2 _9282_/I PHY_9/VDD PHY_9/VDD VSUBS
+ VSUBS gf180mcu_fd_sc_mcu7t5v0__oai22_1
X_5513_ _9438_/Q _5498_/Z _5522_/B _9464_/Q _5513_/C _5514_/A2 PHY_9/VDD PHY_9/VDD
+ VSUBS VSUBS gf180mcu_fd_sc_mcu7t5v0__aoi221_1
Xclkbuf_leaf_8_clk clkbuf_leaf_8_clk/I _9907_/CLK PHY_9/VDD PHY_9/VDD VSUBS VSUBS
+ gf180mcu_fd_sc_mcu7t5v0__clkbuf_16
X_8232_ _8232_/A1 _8232_/A2 _8256_/A3 _8234_/A2 PHY_9/VDD PHY_9/VDD VSUBS VSUBS gf180mcu_fd_sc_mcu7t5v0__xnor3_1
X_5444_ _5478_/A1 _5458_/A2 _5444_/B _9434_/D PHY_9/VDD PHY_9/VDD VSUBS VSUBS gf180mcu_fd_sc_mcu7t5v0__aoi21_1
X_8163_ _8163_/A1 _8163_/A2 _8163_/B _8285_/A1 PHY_9/VDD PHY_9/VDD VSUBS VSUBS gf180mcu_fd_sc_mcu7t5v0__aoi21_2
X_7114_ _9810_/Q _9809_/Q _7019_/I _7254_/A2 _7114_/Z PHY_9/VDD PHY_9/VDD VSUBS VSUBS
+ gf180mcu_fd_sc_mcu7t5v0__and4_1
X_5375_ _5560_/A2 _9489_/Q _5575_/A3 PHY_9/VDD PHY_9/VDD VSUBS VSUBS gf180mcu_fd_sc_mcu7t5v0__nand2_2
X_8094_ _9905_/Q _9317_/C _9100_/B _8095_/B PHY_9/VDD PHY_9/VDD VSUBS VSUBS gf180mcu_fd_sc_mcu7t5v0__oai21_1
X_7045_ _7735_/A3 _7299_/A2 _7045_/B1 _7045_/B2 _7045_/C _7254_/A2 PHY_9/VDD PHY_9/VDD
+ VSUBS VSUBS gf180mcu_fd_sc_mcu7t5v0__aoi221_4
X_8996_ _9807_/Q _9023_/B1 _9008_/A1 PHY_9/VDD PHY_9/VDD VSUBS VSUBS gf180mcu_fd_sc_mcu7t5v0__nand2_1
X_7947_ _9811_/Q _7771_/Z _7988_/B2 PHY_9/VDD PHY_9/VDD VSUBS VSUBS gf180mcu_fd_sc_mcu7t5v0__nand2_1
X_7878_ _7831_/C _7878_/A2 _9317_/C _7879_/B PHY_9/VDD PHY_9/VDD VSUBS VSUBS gf180mcu_fd_sc_mcu7t5v0__oai21_1
X_6829_ _6831_/A2 _6828_/Z _6863_/B PHY_9/VDD PHY_9/VDD VSUBS VSUBS gf180mcu_fd_sc_mcu7t5v0__nor2_1
X_9617_ _9617_/D _9948_/CLK _9617_/Q PHY_9/VDD PHY_9/VDD VSUBS VSUBS gf180mcu_fd_sc_mcu7t5v0__dffq_1
X_9548_ _9548_/D _9800_/CLK _9548_/Q PHY_9/VDD PHY_9/VDD VSUBS VSUBS gf180mcu_fd_sc_mcu7t5v0__dffq_1
X_9479_ _9479_/D _9689_/CLK _9479_/Q PHY_9/VDD PHY_9/VDD VSUBS VSUBS gf180mcu_fd_sc_mcu7t5v0__dffq_1
X_5160_ _9652_/Q _9477_/Q _5161_/A3 PHY_9/VDD PHY_9/VDD VSUBS VSUBS gf180mcu_fd_sc_mcu7t5v0__nand2_1
X_5091_ _9704_/Q _5997_/B2 PHY_9/VDD PHY_9/VDD VSUBS VSUBS gf180mcu_fd_sc_mcu7t5v0__clkinv_1
X_8850_ _9502_/Q _9895_/Q _9929_/Q _9971_/Q _9952_/Q _9953_/Q _8850_/Z PHY_9/VDD PHY_9/VDD
+ VSUBS VSUBS gf180mcu_fd_sc_mcu7t5v0__mux4_4
X_5993_ _8692_/A1 _5998_/A2 _5998_/B1 _5993_/B2 _9700_/D PHY_9/VDD PHY_9/VDD VSUBS
+ VSUBS gf180mcu_fd_sc_mcu7t5v0__oai22_1
X_8781_ _9953_/Q _8994_/B _8781_/A3 _8781_/B _8783_/B1 PHY_9/VDD PHY_9/VDD VSUBS VSUBS
+ gf180mcu_fd_sc_mcu7t5v0__oai31_2
X_7801_ _9807_/Q _7800_/Z _7838_/A1 PHY_9/VDD PHY_9/VDD VSUBS VSUBS gf180mcu_fd_sc_mcu7t5v0__nand2_1
X_4944_ _9748_/Q _6034_/B2 PHY_9/VDD PHY_9/VDD VSUBS VSUBS gf180mcu_fd_sc_mcu7t5v0__clkinv_1
X_7732_ _9807_/Q _7988_/A2 _7733_/I PHY_9/VDD PHY_9/VDD VSUBS VSUBS gf180mcu_fd_sc_mcu7t5v0__nor2_1
X_9402_ _9402_/D _9856_/CLK _9402_/Q PHY_9/VDD PHY_9/VDD VSUBS VSUBS gf180mcu_fd_sc_mcu7t5v0__dffq_1
X_4875_ _9566_/Q _5730_/B2 PHY_9/VDD PHY_9/VDD VSUBS VSUBS gf180mcu_fd_sc_mcu7t5v0__clkinv_1
X_7663_ _7676_/A1 _7663_/A2 _7662_/Z _7663_/Z PHY_9/VDD PHY_9/VDD VSUBS VSUBS gf180mcu_fd_sc_mcu7t5v0__xor3_1
X_6614_ _9813_/Q _6646_/A1 _6614_/B _6615_/A3 PHY_9/VDD PHY_9/VDD VSUBS VSUBS gf180mcu_fd_sc_mcu7t5v0__aoi21_1
X_7594_ _7594_/A1 _7594_/A2 _7645_/A2 PHY_9/VDD PHY_9/VDD VSUBS VSUBS gf180mcu_fd_sc_mcu7t5v0__nor2_1
X_6545_ _6545_/A1 _6543_/Z _6546_/I PHY_9/VDD PHY_9/VDD VSUBS VSUBS gf180mcu_fd_sc_mcu7t5v0__xnor2_1
X_9333_ _9811_/Q _9333_/A2 _9334_/A3 PHY_9/VDD PHY_9/VDD VSUBS VSUBS gf180mcu_fd_sc_mcu7t5v0__nand2_1
X_9264_ _9343_/B _9249_/Z _9264_/B _9317_/C _9265_/A2 PHY_9/VDD PHY_9/VDD VSUBS VSUBS
+ gf180mcu_fd_sc_mcu7t5v0__oai211_1
X_6476_ _6603_/A1 _6460_/Z _6469_/Z _6476_/B2 _6476_/C _6477_/B PHY_9/VDD PHY_9/VDD
+ VSUBS VSUBS gf180mcu_fd_sc_mcu7t5v0__aoi221_1
X_8215_ _9809_/Q _8311_/A2 _8314_/A1 PHY_9/VDD PHY_9/VDD VSUBS VSUBS gf180mcu_fd_sc_mcu7t5v0__nand2_1
X_9195_ _9183_/Z _9222_/A2 _9297_/A2 PHY_9/VDD PHY_9/VDD VSUBS VSUBS gf180mcu_fd_sc_mcu7t5v0__xnor2_1
X_5427_ _9645_/Q _5437_/A2 _5883_/A3 _9676_/Q _5428_/I PHY_9/VDD PHY_9/VDD VSUBS VSUBS
+ gf180mcu_fd_sc_mcu7t5v0__aoi22_1
X_5358_ _5358_/A1 _5364_/A2 _5358_/B _9414_/D PHY_9/VDD PHY_9/VDD VSUBS VSUBS gf180mcu_fd_sc_mcu7t5v0__aoi21_1
X_8146_ _8097_/Z _8192_/A2 _8293_/B _8147_/A2 PHY_9/VDD PHY_9/VDD VSUBS VSUBS gf180mcu_fd_sc_mcu7t5v0__oai21_1
X_8077_ _9808_/Q _8075_/B _8077_/A3 _8077_/Z PHY_9/VDD PHY_9/VDD VSUBS VSUBS gf180mcu_fd_sc_mcu7t5v0__xor3_1
X_7028_ _9846_/Q _7047_/A2 _7028_/S _7278_/C PHY_9/VDD PHY_9/VDD VSUBS VSUBS gf180mcu_fd_sc_mcu7t5v0__mux2_2
X_5289_ _9461_/Q _5296_/A2 _7695_/B _5290_/B PHY_9/VDD PHY_9/VDD VSUBS VSUBS gf180mcu_fd_sc_mcu7t5v0__oai21_1
X_8979_ _8980_/A1 _8978_/Z _9015_/B PHY_9/VDD PHY_9/VDD VSUBS VSUBS gf180mcu_fd_sc_mcu7t5v0__and2_1
X_6330_ _9401_/Q _9036_/A2 _7695_/B _6331_/B PHY_9/VDD PHY_9/VDD VSUBS VSUBS gf180mcu_fd_sc_mcu7t5v0__oai21_1
X_6261_ _8688_/A2 _6261_/A2 _6261_/B1 _6656_/A2 _6283_/B2 _6261_/C2 _6263_/A2 PHY_9/VDD
+ PHY_9/VDD VSUBS VSUBS gf180mcu_fd_sc_mcu7t5v0__aoi222_2
X_5212_ _5770_/B _9735_/Q _5478_/A1 _9725_/D PHY_9/VDD PHY_9/VDD VSUBS VSUBS gf180mcu_fd_sc_mcu7t5v0__and3_1
X_8000_ _8000_/A1 _7999_/Z _8000_/Z PHY_9/VDD PHY_9/VDD VSUBS VSUBS gf180mcu_fd_sc_mcu7t5v0__xor2_1
X_6192_ _6192_/A1 _6192_/A2 _6203_/A2 PHY_9/VDD PHY_9/VDD VSUBS VSUBS gf180mcu_fd_sc_mcu7t5v0__nand2_1
X_5143_ _9453_/Q _9452_/Q _5145_/A3 PHY_9/VDD PHY_9/VDD VSUBS VSUBS gf180mcu_fd_sc_mcu7t5v0__nor2_1
X_5074_ _9720_/Q _6017_/B2 PHY_9/VDD PHY_9/VDD VSUBS VSUBS gf180mcu_fd_sc_mcu7t5v0__clkinv_1
X_9951_ _9951_/D _9974_/CLK _9951_/Q PHY_9/VDD PHY_9/VDD VSUBS VSUBS gf180mcu_fd_sc_mcu7t5v0__dffq_4
X_9882_ _9882_/D _9948_/CLK _9882_/Q PHY_9/VDD PHY_9/VDD VSUBS VSUBS gf180mcu_fd_sc_mcu7t5v0__dffq_1
X_8902_ _8903_/A1 _8903_/A3 _8946_/A2 PHY_9/VDD PHY_9/VDD VSUBS VSUBS gf180mcu_fd_sc_mcu7t5v0__nand2_1
X_8833_ _8925_/B _8925_/A2 _8835_/A3 PHY_9/VDD PHY_9/VDD VSUBS VSUBS gf180mcu_fd_sc_mcu7t5v0__nand2_1
X_8764_ _9090_/C _8752_/I _8767_/A1 PHY_9/VDD PHY_9/VDD VSUBS VSUBS gf180mcu_fd_sc_mcu7t5v0__nor2_1
X_5976_ _5978_/A1 _5975_/Z _9688_/D PHY_9/VDD PHY_9/VDD VSUBS VSUBS gf180mcu_fd_sc_mcu7t5v0__nor2_1
X_8695_ _8695_/A1 _8697_/A2 _8697_/B1 _8695_/B2 _9946_/D PHY_9/VDD PHY_9/VDD VSUBS
+ VSUBS gf180mcu_fd_sc_mcu7t5v0__oai22_1
X_7715_ _7724_/A1 _9887_/Q _7725_/A3 _7974_/A1 PHY_9/VDD PHY_9/VDD VSUBS VSUBS gf180mcu_fd_sc_mcu7t5v0__nand3_4
X_4927_ _9795_/Q _6317_/B2 PHY_9/VDD PHY_9/VDD VSUBS VSUBS gf180mcu_fd_sc_mcu7t5v0__clkinv_1
X_4858_ _9406_/Q _5340_/A1 PHY_9/VDD PHY_9/VDD VSUBS VSUBS gf180mcu_fd_sc_mcu7t5v0__clkinv_1
X_7646_ _7646_/A1 _7658_/A1 _7600_/Z _7646_/B2 _7649_/A1 PHY_9/VDD PHY_9/VDD VSUBS
+ VSUBS gf180mcu_fd_sc_mcu7t5v0__oai22_1
X_4789_ _9819_/Q _7497_/A2 PHY_9/VDD PHY_9/VDD VSUBS VSUBS gf180mcu_fd_sc_mcu7t5v0__inv_1
X_7577_ _7577_/A1 _7576_/B _7577_/Z PHY_9/VDD PHY_9/VDD VSUBS VSUBS gf180mcu_fd_sc_mcu7t5v0__xor2_1
X_9316_ _9343_/B _9316_/A2 _9316_/A3 _9316_/A4 _9317_/B PHY_9/VDD PHY_9/VDD VSUBS
+ VSUBS gf180mcu_fd_sc_mcu7t5v0__nand4_1
X_6528_ _6529_/A1 _6622_/A1 _6528_/Z PHY_9/VDD PHY_9/VDD VSUBS VSUBS gf180mcu_fd_sc_mcu7t5v0__and2_1
X_6459_ _6499_/A1 _6499_/A2 _6500_/A1 PHY_9/VDD PHY_9/VDD VSUBS VSUBS gf180mcu_fd_sc_mcu7t5v0__nand2_1
X_9247_ _9972_/Q _9267_/A2 _9247_/Z PHY_9/VDD PHY_9/VDD VSUBS VSUBS gf180mcu_fd_sc_mcu7t5v0__xor2_1
X_9178_ _9502_/Q _9908_/Q _9958_/Q _9510_/Q _9965_/Q _9966_/Q _9178_/Z PHY_9/VDD PHY_9/VDD
+ VSUBS VSUBS gf180mcu_fd_sc_mcu7t5v0__mux4_4
X_8129_ _8129_/I _8163_/A1 PHY_9/VDD PHY_9/VDD VSUBS VSUBS gf180mcu_fd_sc_mcu7t5v0__clkinv_1
X_5830_ _5867_/A2 _9522_/Q _5875_/B PHY_9/VDD PHY_9/VDD VSUBS VSUBS gf180mcu_fd_sc_mcu7t5v0__nand2_1
X_5761_ _6089_/B _5769_/A2 _5769_/B1 PHY_9/VDD PHY_9/VDD VSUBS VSUBS gf180mcu_fd_sc_mcu7t5v0__nand2_2
X_8480_ _8654_/A2 _8606_/A2 _8653_/A2 _8481_/A2 PHY_9/VDD PHY_9/VDD VSUBS VSUBS gf180mcu_fd_sc_mcu7t5v0__nor3_1
X_4712_ _9928_/Q _7457_/B2 PHY_9/VDD PHY_9/VDD VSUBS VSUBS gf180mcu_fd_sc_mcu7t5v0__clkinv_1
X_7500_ _9929_/Q _7500_/A2 _7495_/Z _7500_/B2 _7572_/A1 PHY_9/VDD PHY_9/VDD VSUBS
+ VSUBS gf180mcu_fd_sc_mcu7t5v0__oai22_4
X_7431_ _9809_/Q _7430_/Z _7472_/B PHY_9/VDD PHY_9/VDD VSUBS VSUBS gf180mcu_fd_sc_mcu7t5v0__nand2_1
X_5692_ _5690_/Z _5692_/A2 _9545_/D PHY_9/VDD PHY_9/VDD VSUBS VSUBS gf180mcu_fd_sc_mcu7t5v0__nor2_1
X_7362_ _7363_/A2 _7636_/A1 _7367_/A2 _7674_/C2 PHY_9/VDD PHY_9/VDD VSUBS VSUBS gf180mcu_fd_sc_mcu7t5v0__nand3_4
X_7293_ _9811_/Q _7293_/A2 _7294_/A2 PHY_9/VDD PHY_9/VDD VSUBS VSUBS gf180mcu_fd_sc_mcu7t5v0__nand2_1
X_6313_ _5406_/Z _6313_/A2 _6313_/B1 _6313_/B2 _9793_/D PHY_9/VDD PHY_9/VDD VSUBS
+ VSUBS gf180mcu_fd_sc_mcu7t5v0__oai22_1
X_9101_ _9317_/C _9101_/A2 _9101_/B _9968_/D PHY_9/VDD PHY_9/VDD VSUBS VSUBS gf180mcu_fd_sc_mcu7t5v0__aoi21_1
X_6244_ _6244_/A1 _6244_/A2 _6260_/B1 PHY_9/VDD PHY_9/VDD VSUBS VSUBS gf180mcu_fd_sc_mcu7t5v0__nand2_1
X_9032_ _9065_/A1 _9036_/A2 _9032_/B _9964_/D PHY_9/VDD PHY_9/VDD VSUBS VSUBS gf180mcu_fd_sc_mcu7t5v0__aoi21_1
X_6175_ _6283_/A1 _6175_/A2 _6175_/B1 _6290_/B2 _6175_/C _6176_/A3 PHY_9/VDD PHY_9/VDD
+ VSUBS VSUBS gf180mcu_fd_sc_mcu7t5v0__aoi221_2
X_5126_ _5544_/A1 _9475_/Q _5137_/A3 PHY_9/VDD PHY_9/VDD VSUBS VSUBS gf180mcu_fd_sc_mcu7t5v0__nor2_1
X_9934_ _9934_/D _9939_/CLK _9934_/Q PHY_9/VDD PHY_9/VDD VSUBS VSUBS gf180mcu_fd_sc_mcu7t5v0__dffq_1
X_5057_ _9563_/Q _5725_/B2 PHY_9/VDD PHY_9/VDD VSUBS VSUBS gf180mcu_fd_sc_mcu7t5v0__clkinv_1
X_9865_ _9865_/D _9907_/CLK _9865_/Q PHY_9/VDD PHY_9/VDD VSUBS VSUBS gf180mcu_fd_sc_mcu7t5v0__dffq_2
X_8816_ _8816_/A1 _8821_/A1 _8816_/B1 _8816_/B2 _8824_/A1 PHY_9/VDD PHY_9/VDD VSUBS
+ VSUBS gf180mcu_fd_sc_mcu7t5v0__aoi22_2
X_9796_ _9796_/D _9801_/CLK _9796_/Q PHY_9/VDD PHY_9/VDD VSUBS VSUBS gf180mcu_fd_sc_mcu7t5v0__dffq_1
X_5959_ _9683_/Q _5973_/A2 _5961_/B _5960_/B PHY_9/VDD PHY_9/VDD VSUBS VSUBS gf180mcu_fd_sc_mcu7t5v0__oai21_1
X_8747_ _9090_/C _9004_/A2 _8760_/A1 PHY_9/VDD PHY_9/VDD VSUBS VSUBS gf180mcu_fd_sc_mcu7t5v0__nand2_1
X_8678_ _8688_/A1 _8678_/A2 _8687_/A2 PHY_9/VDD PHY_9/VDD VSUBS VSUBS gf180mcu_fd_sc_mcu7t5v0__nand2_4
X_7629_ _9813_/Q _7627_/Z _7630_/B PHY_9/VDD PHY_9/VDD VSUBS VSUBS gf180mcu_fd_sc_mcu7t5v0__xor2_1
X_7980_ _9357_/B _7980_/A2 _9897_/D PHY_9/VDD PHY_9/VDD VSUBS VSUBS gf180mcu_fd_sc_mcu7t5v0__nor2_1
X_6931_ _6931_/A1 _6978_/B2 _6931_/A3 _6931_/Z PHY_9/VDD PHY_9/VDD VSUBS VSUBS gf180mcu_fd_sc_mcu7t5v0__xor3_1
X_6862_ _6862_/A1 _6862_/A2 _6862_/B _6910_/A1 PHY_9/VDD PHY_9/VDD VSUBS VSUBS gf180mcu_fd_sc_mcu7t5v0__oai21_1
X_9650_ _9650_/D _9689_/CLK _9650_/Q PHY_9/VDD PHY_9/VDD VSUBS VSUBS gf180mcu_fd_sc_mcu7t5v0__dffq_1
X_9581_ _9581_/D _9940_/CLK _9581_/Q PHY_9/VDD PHY_9/VDD VSUBS VSUBS gf180mcu_fd_sc_mcu7t5v0__dffq_1
X_5813_ _5404_/Z _5814_/A2 _5814_/B1 _5813_/B2 _9629_/D PHY_9/VDD PHY_9/VDD VSUBS
+ VSUBS gf180mcu_fd_sc_mcu7t5v0__oai22_1
X_8601_ _8488_/Z _8550_/Z _8657_/B1 PHY_9/VDD PHY_9/VDD VSUBS VSUBS gf180mcu_fd_sc_mcu7t5v0__nor2_1
X_6793_ _9839_/Q _6791_/Z _6793_/Z PHY_9/VDD PHY_9/VDD VSUBS VSUBS gf180mcu_fd_sc_mcu7t5v0__xor2_1
X_8532_ _8380_/Z _8580_/A2 _8538_/A2 PHY_9/VDD PHY_9/VDD VSUBS VSUBS gf180mcu_fd_sc_mcu7t5v0__nand2_1
X_5744_ _8692_/A1 _5749_/A2 _5749_/B1 _5744_/B2 _9576_/D PHY_9/VDD PHY_9/VDD VSUBS
+ VSUBS gf180mcu_fd_sc_mcu7t5v0__oai22_1
X_5675_ _9540_/Q _5673_/Z _5677_/A2 PHY_9/VDD PHY_9/VDD VSUBS VSUBS gf180mcu_fd_sc_mcu7t5v0__nor2_1
X_8463_ _9136_/A2 _9924_/Q _8463_/B1 _8646_/A2 _8463_/C _8645_/A2 PHY_9/VDD PHY_9/VDD
+ VSUBS VSUBS gf180mcu_fd_sc_mcu7t5v0__aoi221_4
X_7414_ _9809_/Q _7647_/A2 _7382_/Z _9808_/Q _7420_/A2 PHY_9/VDD PHY_9/VDD VSUBS VSUBS
+ gf180mcu_fd_sc_mcu7t5v0__aoi22_1
X_8394_ _8391_/C _8394_/A2 _8395_/A2 PHY_9/VDD PHY_9/VDD VSUBS VSUBS gf180mcu_fd_sc_mcu7t5v0__nor2_1
X_7345_ _9387_/Q _9034_/A2 _7695_/B _7346_/B PHY_9/VDD PHY_9/VDD VSUBS VSUBS gf180mcu_fd_sc_mcu7t5v0__oai21_1
X_7276_ _9813_/Q _7274_/Z _7276_/Z PHY_9/VDD PHY_9/VDD VSUBS VSUBS gf180mcu_fd_sc_mcu7t5v0__xor2_1
X_6227_ _6227_/A1 _6227_/A2 _6232_/C2 PHY_9/VDD PHY_9/VDD VSUBS VSUBS gf180mcu_fd_sc_mcu7t5v0__nand2_1
X_9015_ _9813_/Q _8977_/Z _9015_/B _9019_/A1 PHY_9/VDD PHY_9/VDD VSUBS VSUBS gf180mcu_fd_sc_mcu7t5v0__aoi21_1
X_6158_ _9701_/Q _6287_/A2 _6287_/B1 _9602_/Q _6160_/A1 PHY_9/VDD PHY_9/VDD VSUBS
+ VSUBS gf180mcu_fd_sc_mcu7t5v0__aoi22_1
X_5109_ _9521_/Q _5646_/B2 PHY_9/VDD PHY_9/VDD VSUBS VSUBS gf180mcu_fd_sc_mcu7t5v0__clkinv_1
X_6089_ _6089_/A1 _6089_/A2 _6089_/B _6090_/I PHY_9/VDD PHY_9/VDD VSUBS VSUBS gf180mcu_fd_sc_mcu7t5v0__oai21_1
X_9917_ _9917_/D _9948_/CLK _9917_/Q PHY_9/VDD PHY_9/VDD VSUBS VSUBS gf180mcu_fd_sc_mcu7t5v0__dffq_1
X_9848_ _9848_/D _9901_/CLK _9848_/Q PHY_9/VDD PHY_9/VDD VSUBS VSUBS gf180mcu_fd_sc_mcu7t5v0__dffq_4
X_9779_ _9779_/D _9830_/CLK _9779_/Q PHY_9/VDD PHY_9/VDD VSUBS VSUBS gf180mcu_fd_sc_mcu7t5v0__dffq_1
X_5460_ _9442_/Q _5495_/B _5474_/B _5461_/B PHY_9/VDD PHY_9/VDD VSUBS VSUBS gf180mcu_fd_sc_mcu7t5v0__oai21_1
X_5391_ _9968_/Q _5201_/Z _5391_/B _8691_/A1 PHY_9/VDD PHY_9/VDD VSUBS VSUBS gf180mcu_fd_sc_mcu7t5v0__aoi21_4
X_7130_ _6471_/B _7293_/A2 _7130_/A3 _7131_/B PHY_9/VDD PHY_9/VDD VSUBS VSUBS gf180mcu_fd_sc_mcu7t5v0__xor3_1
X_7061_ _7084_/A1 _7084_/A2 _7085_/A1 PHY_9/VDD PHY_9/VDD VSUBS VSUBS gf180mcu_fd_sc_mcu7t5v0__nor2_1
X_6012_ _8691_/A1 _6018_/A2 _6018_/B1 _6012_/B2 _9715_/D PHY_9/VDD PHY_9/VDD VSUBS
+ VSUBS gf180mcu_fd_sc_mcu7t5v0__oai22_1
.ends
