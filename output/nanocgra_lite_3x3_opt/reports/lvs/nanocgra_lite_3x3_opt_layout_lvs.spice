* NGSPICE file created from NanoCGRA_Lite.ext - technology: gf180mcuD

.subckt gf180mcu_fd_sc_mcu7t5v0__clkinv_1 VDD VSS I ZN VNW VPW
M0 ZN I VSS VPW nfet_05v0 ad=0.2112p pd=1.84u as=0.2112p ps=1.84u w=0.48u l=0.6u
M1 ZN I VDD VNW pfet_05v0 ad=0.5368p pd=3.32u as=0.5368p ps=3.32u w=1.22u l=0.5u
.ends

.subckt gf180mcu_fd_sc_mcu7t5v0__nand2_4 VDD VSS ZN A1 A2 VNW VPW
M0 ZN A1 VDD VNW pfet_05v0 ad=0.2938p pd=1.65u as=0.2938p ps=1.65u w=1.13u l=0.5u
M1 VSS A2 a_661_68# VPW nfet_05v0 ad=0.22755p pd=1.375u as=98.399994f ps=1.06u w=0.82u l=0.6u
M2 VDD A2 ZN VNW pfet_05v0 ad=0.2938p pd=1.65u as=0.2938p ps=1.65u w=1.13u l=0.5u
M3 ZN A1 a_260_68# VPW nfet_05v0 ad=0.23165p pd=1.385u as=98.399994f ps=1.06u w=0.82u l=0.6u
M4 a_1468_68# A1 ZN VPW nfet_05v0 ad=0.1312p pd=1.14u as=0.2132p ps=1.34u w=0.82u l=0.6u
M5 ZN A2 VDD VNW pfet_05v0 ad=0.2938p pd=1.65u as=0.2938p ps=1.65u w=1.13u l=0.5u
M6 VDD A1 ZN VNW pfet_05v0 ad=0.2938p pd=1.65u as=0.2938p ps=1.65u w=1.13u l=0.5u
M7 ZN A1 a_1060_68# VPW nfet_05v0 ad=0.2132p pd=1.34u as=0.1312p ps=1.14u w=0.82u l=0.6u
M8 ZN A1 VDD VNW pfet_05v0 ad=0.2938p pd=1.65u as=0.2938p ps=1.65u w=1.13u l=0.5u
M9 a_661_68# A1 ZN VPW nfet_05v0 ad=98.399994f pd=1.06u as=0.23165p ps=1.385u w=0.82u l=0.6u
M10 a_1060_68# A2 VSS VPW nfet_05v0 ad=0.1312p pd=1.14u as=0.22755p ps=1.375u w=0.82u l=0.6u
M11 VDD A2 ZN VNW pfet_05v0 ad=0.4972p pd=3.14u as=0.2938p ps=1.65u w=1.13u l=0.5u
M12 a_260_68# A2 VSS VPW nfet_05v0 ad=98.399994f pd=1.06u as=0.3608p ps=2.52u w=0.82u l=0.6u
M13 VSS A2 a_1468_68# VPW nfet_05v0 ad=0.3608p pd=2.52u as=0.1312p ps=1.14u w=0.82u l=0.6u
M14 ZN A2 VDD VNW pfet_05v0 ad=0.2938p pd=1.65u as=0.4972p ps=3.14u w=1.13u l=0.5u
M15 VDD A1 ZN VNW pfet_05v0 ad=0.2938p pd=1.65u as=0.2938p ps=1.65u w=1.13u l=0.5u
.ends

.subckt gf180mcu_fd_sc_mcu7t5v0__clkinv_3 VDD ZN I VSS VNW VPW
M0 ZN I VDD VNW pfet_05v0 ad=0.5368p pd=3.32u as=0.3782p ps=1.84u w=1.22u l=0.5u
M1 ZN I VSS VPW nfet_05v0 ad=0.1248p pd=1u as=0.2112p ps=1.84u w=0.48u l=0.6u
M2 VDD I ZN VNW pfet_05v0 ad=0.3782p pd=1.84u as=0.3782p ps=1.84u w=1.22u l=0.5u
M3 ZN I VSS VPW nfet_05v0 ad=0.2112p pd=1.84u as=0.1248p ps=1u w=0.48u l=0.6u
M4 ZN I VDD VNW pfet_05v0 ad=0.3782p pd=1.84u as=0.5368p ps=3.32u w=1.22u l=0.5u
M5 VSS I ZN VPW nfet_05v0 ad=0.1248p pd=1u as=0.1248p ps=1u w=0.48u l=0.6u
.ends

.subckt gf180mcu_fd_sc_mcu7t5v0__dffq_4 D Q VDD VSS CLK VNW VPW
M0 VSS CLK a_36_151# VPW nfet_05v0 ad=0.1053p pd=0.925u as=0.1782p ps=1.69u w=0.405u l=0.6u
M1 VDD a_2011_527# a_2304_115# VNW pfet_05v0 ad=0.38575p pd=1.92u as=0.2457p ps=1.465u w=0.945u l=0.5u
M2 a_1004_159# D a_836_159# VPW nfet_05v0 ad=0.207p pd=1.51u as=43.199997f ps=0.6u w=0.36u l=0.6u
M3 VSS a_2304_115# Q VPW nfet_05v0 ad=0.3586p pd=2.51u as=0.2119p ps=1.335u w=0.815u l=0.6u
M4 a_2304_115# a_2011_527# VSS VPW nfet_05v0 ad=0.2119p pd=1.335u as=0.2333p ps=1.555u w=0.815u l=0.6u
M5 a_1004_159# D a_880_527# VNW pfet_05v0 ad=0.1872p pd=1.4u as=53.999996f ps=0.66u w=0.36u l=0.5u
M6 a_2011_527# a_36_151# a_1376_115# VNW pfet_05v0 ad=0.1665p pd=1.285u as=0.1791p ps=1.355u w=0.36u l=0.5u
M7 a_2296_527# a_448_472# a_2011_527# VNW pfet_05v0 ad=50.399998f pd=0.64u as=0.1665p ps=1.285u w=0.36u l=0.5u
M8 Q a_2304_115# VDD VNW pfet_05v0 ad=0.4392p pd=1.94u as=0.38575p ps=1.92u w=1.22u l=0.5u
M9 VSS a_2304_115# Q VPW nfet_05v0 ad=0.2119p pd=1.335u as=0.2119p ps=1.335u w=0.815u l=0.6u
M10 a_1376_115# a_1004_159# VDD VNW pfet_05v0 ad=0.1791p pd=1.355u as=0.1044p ps=0.94u w=0.36u l=0.5u
M11 VDD CLK a_36_151# VNW pfet_05v0 ad=0.2249p pd=1.385u as=0.3806p ps=2.61u w=0.865u l=0.5u
M12 VDD a_2304_115# Q VNW pfet_05v0 ad=0.3172p pd=1.74u as=0.4392p ps=1.94u w=1.22u l=0.5u
M13 VSS a_1376_115# a_1328_159# VPW nfet_05v0 ad=0.2637p pd=1.825u as=43.199997f ps=0.6u w=0.36u l=0.6u
M14 a_2011_527# a_448_472# a_1376_115# VPW nfet_05v0 ad=93.59999f pd=0.88u as=93.59999f ps=0.88u w=0.36u l=0.6u
M15 Q a_2304_115# VDD VNW pfet_05v0 ad=0.4392p pd=1.94u as=0.3172p ps=1.74u w=1.22u l=0.5u
M16 a_448_472# a_36_151# VDD VNW pfet_05v0 ad=0.3806p pd=2.61u as=0.2249p ps=1.385u w=0.865u l=0.5u
M17 Q a_2304_115# VSS VPW nfet_05v0 ad=0.2119p pd=1.335u as=0.2119p ps=1.335u w=0.815u l=0.6u
M18 a_1376_115# a_1004_159# VSS VPW nfet_05v0 ad=93.59999f pd=0.88u as=0.2637p ps=1.825u w=0.36u l=0.6u
M19 VSS a_2304_115# a_2256_159# VPW nfet_05v0 ad=0.2333p pd=1.555u as=43.199997f ps=0.6u w=0.36u l=0.6u
M20 Q a_2304_115# VSS VPW nfet_05v0 ad=0.2119p pd=1.335u as=0.2608p ps=1.455u w=0.815u l=0.6u
M21 a_836_159# a_36_151# VSS VPW nfet_05v0 ad=43.199997f pd=0.6u as=0.1584p ps=1.6u w=0.36u l=0.6u
M22 a_448_472# a_36_151# VSS VPW nfet_05v0 ad=0.1782p pd=1.69u as=0.1053p ps=0.925u w=0.405u l=0.6u
M23 a_2256_159# a_36_151# a_2011_527# VPW nfet_05v0 ad=43.199997f pd=0.6u as=93.59999f ps=0.88u w=0.36u l=0.6u
M24 a_880_527# a_448_472# VDD VNW pfet_05v0 ad=53.999996f pd=0.66u as=0.4554p ps=3.25u w=0.36u l=0.5u
M25 a_1348_527# a_36_151# a_1004_159# VNW pfet_05v0 ad=43.199997f pd=0.6u as=0.1872p ps=1.4u w=0.36u l=0.5u
M26 VDD a_2304_115# Q VNW pfet_05v0 ad=0.5368p pd=3.32u as=0.4392p ps=1.94u w=1.22u l=0.5u
M27 a_1328_159# a_448_472# a_1004_159# VPW nfet_05v0 ad=43.199997f pd=0.6u as=0.207p ps=1.51u w=0.36u l=0.6u
M28 VDD a_1376_115# a_1348_527# VNW pfet_05v0 ad=0.1044p pd=0.94u as=43.199997f ps=0.6u w=0.36u l=0.5u
M29 VSS a_2011_527# a_2304_115# VPW nfet_05v0 ad=0.2608p pd=1.455u as=0.2119p ps=1.335u w=0.815u l=0.6u
M30 VDD a_2304_115# a_2296_527# VNW pfet_05v0 ad=0.2619p pd=1.685u as=50.399998f ps=0.64u w=0.36u l=0.5u
M31 a_2304_115# a_2011_527# VDD VNW pfet_05v0 ad=0.2457p pd=1.465u as=0.2619p ps=1.685u w=0.945u l=0.5u
.ends

.subckt gf180mcu_fd_sc_mcu7t5v0__nand2_1 VDD VSS ZN A1 A2 VNW VPW
M0 ZN A2 VDD VNW pfet_05v0 ad=0.2938p pd=1.65u as=0.4972p ps=3.14u w=1.13u l=0.5u
M1 ZN A1 a_245_68# VPW nfet_05v0 ad=0.3608p pd=2.52u as=0.1312p ps=1.14u w=0.82u l=0.6u
M2 VDD A1 ZN VNW pfet_05v0 ad=0.4972p pd=3.14u as=0.2938p ps=1.65u w=1.13u l=0.5u
M3 a_245_68# A2 VSS VPW nfet_05v0 ad=0.1312p pd=1.14u as=0.3608p ps=2.52u w=0.82u l=0.6u
.ends

.subckt gf180mcu_fd_sc_mcu7t5v0__aoi221_1 B2 C VDD VSS ZN A1 A2 B1 VNW VPW
M0 a_672_472# C a_56_472# VNW pfet_05v0 ad=0.3402p pd=1.775u as=0.37665p ps=1.835u w=1.215u l=0.5u
M1 VDD B2 a_56_472# VNW pfet_05v0 ad=0.3159p pd=1.735u as=0.5346p ps=3.31u w=1.215u l=0.5u
M2 ZN A1 a_940_90# VPW nfet_05v0 ad=0.3124p pd=2.3u as=85.2f ps=0.95u w=0.71u l=0.6u
M3 a_56_472# B1 VDD VNW pfet_05v0 ad=0.37665p pd=1.835u as=0.3159p ps=1.735u w=1.215u l=0.5u
M4 a_672_472# A1 ZN VNW pfet_05v0 ad=0.5346p pd=3.31u as=0.37665p ps=1.835u w=1.215u l=0.5u
M5 ZN A2 a_672_472# VNW pfet_05v0 ad=0.37665p pd=1.835u as=0.3402p ps=1.775u w=1.215u l=0.5u
M6 a_244_90# B2 VSS VPW nfet_05v0 ad=85.2f pd=0.95u as=0.3124p ps=2.3u w=0.71u l=0.6u
M7 ZN B1 a_244_90# VPW nfet_05v0 ad=0.21175p pd=1.41u as=85.2f ps=0.95u w=0.71u l=0.6u
M8 a_940_90# A2 VSS VPW nfet_05v0 ad=85.2f pd=0.95u as=0.22595p ps=1.45u w=0.71u l=0.6u
M9 VSS C ZN VPW nfet_05v0 ad=0.22595p pd=1.45u as=0.21175p ps=1.41u w=0.465u l=0.6u
.ends

.subckt gf180mcu_fd_sc_mcu7t5v0__clkinv_4 VDD VSS ZN I VNW VPW
M0 ZN I VDD VNW pfet_05v0 ad=0.4392p pd=1.94u as=0.3172p ps=1.74u w=1.22u l=0.5u
M1 VSS I ZN VPW nfet_05v0 ad=0.2112p pd=1.84u as=0.1248p ps=1u w=0.48u l=0.6u
M2 ZN I VSS VPW nfet_05v0 ad=0.1248p pd=1u as=0.2112p ps=1.84u w=0.48u l=0.6u
M3 VDD I ZN VNW pfet_05v0 ad=0.5368p pd=3.32u as=0.4392p ps=1.94u w=1.22u l=0.5u
M4 ZN I VSS VPW nfet_05v0 ad=0.1248p pd=1u as=0.1248p ps=1u w=0.48u l=0.6u
M5 ZN I VDD VNW pfet_05v0 ad=0.4392p pd=1.94u as=0.5368p ps=3.32u w=1.22u l=0.5u
M6 VDD I ZN VNW pfet_05v0 ad=0.3172p pd=1.74u as=0.4392p ps=1.94u w=1.22u l=0.5u
M7 VSS I ZN VPW nfet_05v0 ad=0.1248p pd=1u as=0.1248p ps=1u w=0.48u l=0.6u
.ends

.subckt gf180mcu_fd_sc_mcu7t5v0__dffq_1 VDD Q CLK VSS D VNW VPW
M0 VSS CLK a_36_151# VPW nfet_05v0 ad=0.1053p pd=0.925u as=0.1782p ps=1.69u w=0.405u l=0.6u
M1 Q a_2304_115# VSS VPW nfet_05v0 ad=0.3608p pd=2.52u as=0.3608p ps=2.52u w=0.82u l=0.6u
M2 a_2304_115# a_2011_527# VSS VPW nfet_05v0 ad=0.176p pd=1.68u as=0.142p ps=1.14u w=0.4u l=0.6u
M3 a_1004_159# D a_836_159# VPW nfet_05v0 ad=0.207p pd=1.51u as=43.199997f ps=0.6u w=0.36u l=0.6u
M4 a_1004_159# D a_880_527# VNW pfet_05v0 ad=0.1872p pd=1.4u as=53.999996f ps=0.66u w=0.36u l=0.5u
M5 a_2011_527# a_36_151# a_1376_115# VNW pfet_05v0 ad=0.1665p pd=1.285u as=0.1791p ps=1.355u w=0.36u l=0.5u
M6 a_2296_527# a_448_472# a_2011_527# VNW pfet_05v0 ad=50.399998f pd=0.64u as=0.1665p ps=1.285u w=0.36u l=0.5u
M7 a_1376_115# a_1004_159# VDD VNW pfet_05v0 ad=0.1791p pd=1.355u as=0.1044p ps=0.94u w=0.36u l=0.5u
M8 VDD CLK a_36_151# VNW pfet_05v0 ad=0.2249p pd=1.385u as=0.3806p ps=2.61u w=0.865u l=0.5u
M9 VSS a_1376_115# a_1328_159# VPW nfet_05v0 ad=0.2637p pd=1.825u as=43.199997f ps=0.6u w=0.36u l=0.6u
M10 a_2011_527# a_448_472# a_1376_115# VPW nfet_05v0 ad=93.59999f pd=0.88u as=93.59999f ps=0.88u w=0.36u l=0.6u
M11 a_448_472# a_36_151# VDD VNW pfet_05v0 ad=0.3806p pd=2.61u as=0.2249p ps=1.385u w=0.865u l=0.5u
M12 Q a_2304_115# VDD VNW pfet_05v0 ad=0.5368p pd=3.32u as=0.5368p ps=3.32u w=1.22u l=0.5u
M13 a_1376_115# a_1004_159# VSS VPW nfet_05v0 ad=93.59999f pd=0.88u as=0.2637p ps=1.825u w=0.36u l=0.6u
M14 VSS a_2304_115# a_2256_159# VPW nfet_05v0 ad=0.142p pd=1.14u as=43.199997f ps=0.6u w=0.36u l=0.6u
M15 a_836_159# a_36_151# VSS VPW nfet_05v0 ad=43.199997f pd=0.6u as=0.1584p ps=1.6u w=0.36u l=0.6u
M16 a_448_472# a_36_151# VSS VPW nfet_05v0 ad=0.1782p pd=1.69u as=0.1053p ps=0.925u w=0.405u l=0.6u
M17 a_2256_159# a_36_151# a_2011_527# VPW nfet_05v0 ad=43.199997f pd=0.6u as=93.59999f ps=0.88u w=0.36u l=0.6u
M18 a_880_527# a_448_472# VDD VNW pfet_05v0 ad=53.999996f pd=0.66u as=0.4554p ps=3.25u w=0.36u l=0.5u
M19 a_1348_527# a_36_151# a_1004_159# VNW pfet_05v0 ad=43.199997f pd=0.6u as=0.1872p ps=1.4u w=0.36u l=0.5u
M20 a_1328_159# a_448_472# a_1004_159# VPW nfet_05v0 ad=43.199997f pd=0.6u as=0.207p ps=1.51u w=0.36u l=0.6u
M21 VDD a_1376_115# a_1348_527# VNW pfet_05v0 ad=0.1044p pd=0.94u as=43.199997f ps=0.6u w=0.36u l=0.5u
M22 VDD a_2304_115# a_2296_527# VNW pfet_05v0 ad=0.23p pd=1.54u as=50.399998f ps=0.64u w=0.36u l=0.5u
M23 a_2304_115# a_2011_527# VDD VNW pfet_05v0 ad=0.352p pd=2.48u as=0.23p ps=1.54u w=0.8u l=0.5u
.ends

.subckt gf180mcu_fd_sc_mcu7t5v0__nand3_2 A3 VDD VSS ZN A1 A2 VNW VPW
M0 ZN A1 VDD VNW pfet_05v0 ad=0.2561p pd=1.505u as=0.2561p ps=1.505u w=0.985u l=0.5u
M1 VDD A1 ZN VNW pfet_05v0 ad=0.2561p pd=1.505u as=0.2561p ps=1.505u w=0.985u l=0.5u
M2 a_1044_68# A2 a_860_68# VPW nfet_05v0 ad=0.1722p pd=1.24u as=0.1312p ps=1.14u w=0.82u l=0.6u
M3 a_860_68# A1 ZN VPW nfet_05v0 ad=0.1312p pd=1.14u as=0.2132p ps=1.34u w=0.82u l=0.6u
M4 ZN A2 VDD VNW pfet_05v0 ad=0.2561p pd=1.505u as=0.2561p ps=1.505u w=0.985u l=0.5u
M5 VDD A3 ZN VNW pfet_05v0 ad=0.4334p pd=2.85u as=0.2561p ps=1.505u w=0.985u l=0.5u
M6 VSS A3 a_1044_68# VPW nfet_05v0 ad=0.3608p pd=2.52u as=0.1722p ps=1.24u w=0.82u l=0.6u
M7 a_276_68# A3 VSS VPW nfet_05v0 ad=0.1148p pd=1.1u as=0.3608p ps=2.52u w=0.82u l=0.6u
M8 ZN A3 VDD VNW pfet_05v0 ad=0.2561p pd=1.505u as=0.4334p ps=2.85u w=0.985u l=0.5u
M9 VDD A2 ZN VNW pfet_05v0 ad=0.2561p pd=1.505u as=0.2561p ps=1.505u w=0.985u l=0.5u
M10 a_452_68# A2 a_276_68# VPW nfet_05v0 ad=0.1312p pd=1.14u as=0.1148p ps=1.1u w=0.82u l=0.6u
M11 ZN A1 a_452_68# VPW nfet_05v0 ad=0.2132p pd=1.34u as=0.1312p ps=1.14u w=0.82u l=0.6u
.ends

.subckt gf180mcu_fd_sc_mcu7t5v0__xor2_1 VDD VSS Z A1 A2 VNW VPW
M0 a_728_472# a_56_604# VDD VNW pfet_05v0 ad=0.3172p pd=1.74u as=0.4005p ps=2.12u w=1.22u l=0.5u
M1 Z A1 a_728_472# VNW pfet_05v0 ad=0.3172p pd=1.74u as=0.3172p ps=1.74u w=1.22u l=0.5u
M2 VSS A1 a_56_604# VPW nfet_05v0 ad=0.218p pd=1.52u as=93.59999f ps=0.88u w=0.36u l=0.6u
M3 a_728_472# A2 Z VNW pfet_05v0 ad=0.5368p pd=3.32u as=0.3172p ps=1.74u w=1.22u l=0.5u
M4 Z a_56_604# VSS VPW nfet_05v0 ad=0.2132p pd=1.34u as=0.218p ps=1.52u w=0.82u l=0.6u
M5 VSS A2 a_952_68# VPW nfet_05v0 ad=0.3608p pd=2.52u as=0.1312p ps=1.14u w=0.82u l=0.6u
M6 a_244_604# A2 a_56_604# VNW pfet_05v0 ad=0.1456p pd=1.08u as=0.2464p ps=2u w=0.56u l=0.5u
M7 a_56_604# A2 VSS VPW nfet_05v0 ad=93.59999f pd=0.88u as=0.1584p ps=1.6u w=0.36u l=0.6u
M8 a_952_68# A1 Z VPW nfet_05v0 ad=0.1312p pd=1.14u as=0.2132p ps=1.34u w=0.82u l=0.6u
M9 VDD A1 a_244_604# VNW pfet_05v0 ad=0.4005p pd=2.12u as=0.1456p ps=1.08u w=0.56u l=0.5u
.ends

.subckt gf180mcu_fd_sc_mcu7t5v0__nor3_1 A3 VDD VSS ZN A1 A2 VNW VPW
M0 ZN A1 a_448_472# VNW pfet_05v0 ad=0.5368p pd=3.32u as=0.3782p ps=1.84u w=1.22u l=0.5u
M1 ZN A1 VSS VPW nfet_05v0 ad=0.2046p pd=1.81u as=0.1209p ps=0.985u w=0.465u l=0.6u
M2 a_244_472# A3 VDD VNW pfet_05v0 ad=0.3172p pd=1.74u as=0.5368p ps=3.32u w=1.22u l=0.5u
M3 a_448_472# A2 a_244_472# VNW pfet_05v0 ad=0.3782p pd=1.84u as=0.3172p ps=1.74u w=1.22u l=0.5u
M4 VSS A2 ZN VPW nfet_05v0 ad=0.1209p pd=0.985u as=0.1209p ps=0.985u w=0.465u l=0.6u
M5 ZN A3 VSS VPW nfet_05v0 ad=0.1209p pd=0.985u as=0.2046p ps=1.81u w=0.465u l=0.6u
.ends

.subckt gf180mcu_fd_sc_mcu7t5v0__nand3_1 A3 VDD VSS ZN A1 A2 VNW VPW
M0 ZN A1 a_455_68# VPW nfet_05v0 ad=0.3608p pd=2.52u as=0.1722p ps=1.24u w=0.82u l=0.6u
M1 ZN A3 VDD VNW pfet_05v0 ad=0.2561p pd=1.505u as=0.4334p ps=2.85u w=0.985u l=0.5u
M2 VDD A2 ZN VNW pfet_05v0 ad=0.2561p pd=1.505u as=0.2561p ps=1.505u w=0.985u l=0.5u
M3 ZN A1 VDD VNW pfet_05v0 ad=0.4334p pd=2.85u as=0.2561p ps=1.505u w=0.985u l=0.5u
M4 a_271_68# A3 VSS VPW nfet_05v0 ad=0.1312p pd=1.14u as=0.3608p ps=2.52u w=0.82u l=0.6u
M5 a_455_68# A2 a_271_68# VPW nfet_05v0 ad=0.1722p pd=1.24u as=0.1312p ps=1.14u w=0.82u l=0.6u
.ends

.subckt gf180mcu_fd_sc_mcu7t5v0__inv_3 VSS ZN I VDD VNW VPW
M0 ZN I VDD VNW pfet_05v0 ad=0.5368p pd=3.32u as=0.3172p ps=1.74u w=1.22u l=0.5u
M1 ZN I VSS VPW nfet_05v0 ad=0.3608p pd=2.52u as=0.2132p ps=1.34u w=0.82u l=0.6u
M2 ZN I VSS VPW nfet_05v0 ad=0.2132p pd=1.34u as=0.3608p ps=2.52u w=0.82u l=0.6u
M3 ZN I VDD VNW pfet_05v0 ad=0.4392p pd=1.94u as=0.5368p ps=3.32u w=1.22u l=0.5u
M4 VSS I ZN VPW nfet_05v0 ad=0.2132p pd=1.34u as=0.2132p ps=1.34u w=0.82u l=0.6u
M5 VDD I ZN VNW pfet_05v0 ad=0.3172p pd=1.74u as=0.4392p ps=1.94u w=1.22u l=0.5u
.ends

.subckt gf180mcu_fd_sc_mcu7t5v0__oai32_1 A3 B1 B2 VDD VSS ZN A1 A2 VNW VPW
M0 ZN A1 a_468_472# VNW pfet_05v0 ad=0.4392p pd=1.94u as=0.3172p ps=1.74u w=1.22u l=0.5u
M1 a_244_68# A1 VSS VPW nfet_05v0 ad=0.2132p pd=1.34u as=0.2132p ps=1.34u w=0.82u l=0.6u
M2 a_244_68# A3 VSS VPW nfet_05v0 ad=0.2132p pd=1.34u as=0.3608p ps=2.52u w=0.82u l=0.6u
M3 a_916_472# B1 ZN VNW pfet_05v0 ad=0.3172p pd=1.74u as=0.4392p ps=1.94u w=1.22u l=0.5u
M4 VDD B2 a_916_472# VNW pfet_05v0 ad=0.5368p pd=3.32u as=0.3172p ps=1.74u w=1.22u l=0.5u
M5 ZN B1 a_244_68# VPW nfet_05v0 ad=0.2132p pd=1.34u as=0.2132p ps=1.34u w=0.82u l=0.6u
M6 a_224_472# A3 VDD VNW pfet_05v0 ad=0.4392p pd=1.94u as=0.5368p ps=3.32u w=1.22u l=0.5u
M7 VSS A2 a_244_68# VPW nfet_05v0 ad=0.2132p pd=1.34u as=0.2132p ps=1.34u w=0.82u l=0.6u
M8 a_244_68# B2 ZN VPW nfet_05v0 ad=0.3608p pd=2.52u as=0.2132p ps=1.34u w=0.82u l=0.6u
M9 a_468_472# A2 a_224_472# VNW pfet_05v0 ad=0.3172p pd=1.74u as=0.4392p ps=1.94u w=1.22u l=0.5u
.ends

.subckt gf180mcu_fd_sc_mcu7t5v0__xnor3_1 A3 VDD VSS ZN A1 A2 VNW VPW
M0 a_952_93# A1 a_728_93# VPW nfet_05v0 ad=57.599995f pd=0.68u as=93.59999f ps=0.88u w=0.36u l=0.6u
M1 a_244_567# A2 a_56_567# VNW pfet_05v0 ad=0.1026p pd=0.93u as=0.1584p ps=1.6u w=0.36u l=0.5u
M2 a_728_93# A1 a_718_527# VNW pfet_05v0 ad=0.1456p pd=1.08u as=0.1596p ps=1.13u w=0.56u l=0.5u
M3 ZN A3 a_1948_68# VPW nfet_05v0 ad=0.4161p pd=1.905u as=0.2132p ps=1.34u w=0.82u l=0.6u
M4 ZN a_1296_93# VDD VNW pfet_05v0 ad=0.33945p pd=1.715u as=0.352075p ps=1.895u w=1.095u l=0.5u
M5 VDD a_728_93# a_2172_497# VNW pfet_05v0 ad=0.4818p pd=3.07u as=0.5256p ps=2.055u w=1.095u l=0.5u
M6 a_718_527# a_56_567# VDD VNW pfet_05v0 ad=0.1596p pd=1.13u as=0.184p ps=1.36u w=0.56u l=0.5u
M7 a_718_527# A2 a_728_93# VNW pfet_05v0 ad=0.2464p pd=2u as=0.1456p ps=1.08u w=0.56u l=0.5u
M8 VSS A1 a_56_567# VPW nfet_05v0 ad=0.126p pd=1.06u as=93.59999f ps=0.88u w=0.36u l=0.6u
M9 VSS A3 a_1504_93# VPW nfet_05v0 ad=0.218p pd=1.52u as=57.599995f ps=0.68u w=0.36u l=0.6u
M10 a_1948_68# a_728_93# ZN VPW nfet_05v0 ad=0.3608p pd=2.52u as=0.4161p ps=1.905u w=0.82u l=0.6u
M11 a_2172_497# A3 ZN VNW pfet_05v0 ad=0.5256p pd=2.055u as=0.33945p ps=1.715u w=1.095u l=0.5u
M12 a_1504_93# a_728_93# a_1296_93# VPW nfet_05v0 ad=57.599995f pd=0.68u as=0.1584p ps=1.6u w=0.36u l=0.6u
M13 a_56_567# A2 VSS VPW nfet_05v0 ad=93.59999f pd=0.88u as=0.1584p ps=1.6u w=0.36u l=0.6u
M14 a_1948_68# a_1296_93# VSS VPW nfet_05v0 ad=0.2132p pd=1.34u as=0.218p ps=1.52u w=0.82u l=0.6u
M15 a_1296_93# a_728_93# VDD VNW pfet_05v0 ad=0.1456p pd=1.08u as=0.2464p ps=2u w=0.56u l=0.5u
M16 a_728_93# a_56_567# VSS VPW nfet_05v0 ad=93.59999f pd=0.88u as=0.126p ps=1.06u w=0.36u l=0.6u
M17 VDD A3 a_1296_93# VNW pfet_05v0 ad=0.352075p pd=1.895u as=0.1456p ps=1.08u w=0.56u l=0.5u
M18 VDD A1 a_244_567# VNW pfet_05v0 ad=0.184p pd=1.36u as=0.1026p ps=0.93u w=0.36u l=0.5u
M19 VSS A2 a_952_93# VPW nfet_05v0 ad=0.1584p pd=1.6u as=57.599995f ps=0.68u w=0.36u l=0.6u
.ends

.subckt gf180mcu_fd_sc_mcu7t5v0__nor3_4 A3 VDD VSS ZN A1 A2 VNW VPW
M0 a_672_472# A3 VDD VNW pfet_05v0 ad=0.3782p pd=1.84u as=0.3782p ps=1.84u w=1.22u l=0.5u
M1 ZN A1 a_36_472# VNW pfet_05v0 ad=0.3782p pd=1.84u as=0.3782p ps=1.84u w=1.22u l=0.5u
M2 ZN A1 VSS VPW nfet_05v0 ad=0.1209p pd=0.985u as=0.1209p ps=0.985u w=0.465u l=0.6u
M3 VDD A3 a_1120_472# VNW pfet_05v0 ad=0.3782p pd=1.84u as=0.3782p ps=1.84u w=1.22u l=0.5u
M4 ZN A1 a_1792_472# VNW pfet_05v0 ad=0.3782p pd=1.84u as=0.3782p ps=1.84u w=1.22u l=0.5u
M5 VSS A2 ZN VPW nfet_05v0 ad=0.1209p pd=0.985u as=0.1209p ps=0.985u w=0.465u l=0.6u
M6 VSS A3 ZN VPW nfet_05v0 ad=0.1209p pd=0.985u as=0.1209p ps=0.985u w=0.465u l=0.6u
M7 a_1792_472# A2 a_1568_472# VNW pfet_05v0 ad=0.3782p pd=1.84u as=0.3782p ps=1.84u w=1.22u l=0.5u
M8 VSS A1 ZN VPW nfet_05v0 ad=0.1209p pd=0.985u as=0.1209p ps=0.985u w=0.465u l=0.6u
M9 VDD A3 a_224_472# VNW pfet_05v0 ad=0.3782p pd=1.84u as=0.3782p ps=1.84u w=1.22u l=0.5u
M10 VSS A2 ZN VPW nfet_05v0 ad=0.1209p pd=0.985u as=0.1209p ps=0.985u w=0.465u l=0.6u
M11 a_36_472# A1 ZN VNW pfet_05v0 ad=0.3782p pd=1.84u as=0.3782p ps=1.84u w=1.22u l=0.5u
M12 VSS A3 ZN VPW nfet_05v0 ad=0.1209p pd=0.985u as=0.1209p ps=0.985u w=0.465u l=0.6u
M13 a_1120_472# A2 a_36_472# VNW pfet_05v0 ad=0.3782p pd=1.84u as=0.3782p ps=1.84u w=1.22u l=0.5u
M14 ZN A2 VSS VPW nfet_05v0 ad=0.1209p pd=0.985u as=0.1209p ps=0.985u w=0.465u l=0.6u
M15 a_36_472# A2 a_672_472# VNW pfet_05v0 ad=0.3782p pd=1.84u as=0.3782p ps=1.84u w=1.22u l=0.5u
M16 a_36_472# A1 ZN VNW pfet_05v0 ad=0.5368p pd=3.32u as=0.3782p ps=1.84u w=1.22u l=0.5u
M17 a_1568_472# A3 VDD VNW pfet_05v0 ad=0.3782p pd=1.84u as=0.3782p ps=1.84u w=1.22u l=0.5u
M18 ZN A3 VSS VPW nfet_05v0 ad=0.1209p pd=0.985u as=0.1209p ps=0.985u w=0.465u l=0.6u
M19 VSS A1 ZN VPW nfet_05v0 ad=0.2046p pd=1.81u as=0.1209p ps=0.985u w=0.465u l=0.6u
M20 ZN A2 VSS VPW nfet_05v0 ad=0.1209p pd=0.985u as=0.2046p ps=1.81u w=0.465u l=0.6u
M21 a_224_472# A2 a_36_472# VNW pfet_05v0 ad=0.3782p pd=1.84u as=0.5368p ps=3.32u w=1.22u l=0.5u
M22 ZN A1 VSS VPW nfet_05v0 ad=0.1209p pd=0.985u as=0.1209p ps=0.985u w=0.465u l=0.6u
M23 ZN A3 VSS VPW nfet_05v0 ad=0.1209p pd=0.985u as=0.1209p ps=0.985u w=0.465u l=0.6u
.ends

.subckt gf180mcu_fd_sc_mcu7t5v0__oai21_4 B VDD VSS A1 ZN A2 VNW VPW
M0 ZN A1 a_36_68# VPW nfet_05v0 ad=0.2132p pd=1.34u as=0.2132p ps=1.34u w=0.82u l=0.6u
M1 a_716_497# A1 ZN VNW pfet_05v0 ad=0.3942p pd=1.815u as=0.2847p ps=1.615u w=1.095u l=0.5u
M2 VDD B ZN VNW pfet_05v0 ad=0.4202p pd=2.79u as=0.2483p ps=1.475u w=0.955u l=0.5u
M3 VSS B a_36_68# VPW nfet_05v0 ad=0.2132p pd=1.34u as=0.2132p ps=1.34u w=0.82u l=0.6u
M4 VDD A2 a_716_497# VNW pfet_05v0 ad=0.2847p pd=1.615u as=0.3942p ps=1.815u w=1.095u l=0.5u
M5 VSS B a_36_68# VPW nfet_05v0 ad=0.2132p pd=1.34u as=0.30715p ps=1.685u w=0.82u l=0.6u
M6 ZN A2 a_36_68# VPW nfet_05v0 ad=0.30965p pd=1.685u as=0.3608p ps=2.52u w=0.82u l=0.6u
M7 a_36_68# A2 ZN VPW nfet_05v0 ad=0.2132p pd=1.34u as=0.2132p ps=1.34u w=0.82u l=0.6u
M8 a_1164_497# A2 VDD VNW pfet_05v0 ad=0.3942p pd=1.815u as=0.2847p ps=1.615u w=1.095u l=0.5u
M9 VDD A2 a_1612_497# VNW pfet_05v0 ad=0.5246p pd=2.135u as=0.33945p ps=1.715u w=1.095u l=0.5u
M10 a_36_68# A1 ZN VPW nfet_05v0 ad=0.2132p pd=1.34u as=0.30965p ps=1.685u w=0.82u l=0.6u
M11 a_36_68# A2 ZN VPW nfet_05v0 ad=0.30715p pd=1.685u as=0.2132p ps=1.34u w=0.82u l=0.6u
M12 a_36_68# A1 ZN VPW nfet_05v0 ad=0.2132p pd=1.34u as=0.2132p ps=1.34u w=0.82u l=0.6u
M13 ZN A1 a_1164_497# VNW pfet_05v0 ad=0.2847p pd=1.615u as=0.3942p ps=1.815u w=1.095u l=0.5u
M14 a_1612_497# A1 ZN VNW pfet_05v0 ad=0.33945p pd=1.715u as=0.2847p ps=1.615u w=1.095u l=0.5u
M15 ZN B VDD VNW pfet_05v0 ad=0.2483p pd=1.475u as=0.5246p ps=2.135u w=0.955u l=0.5u
M16 a_36_68# B VSS VPW nfet_05v0 ad=0.3608p pd=2.52u as=0.2132p ps=1.34u w=0.82u l=0.6u
M17 ZN A1 a_36_68# VPW nfet_05v0 ad=0.2132p pd=1.34u as=0.2132p ps=1.34u w=0.82u l=0.6u
M18 a_36_68# B VSS VPW nfet_05v0 ad=0.2132p pd=1.34u as=0.2132p ps=1.34u w=0.82u l=0.6u
M19 VDD B ZN VNW pfet_05v0 ad=0.2483p pd=1.475u as=0.2483p ps=1.475u w=0.955u l=0.5u
M20 ZN A2 a_36_68# VPW nfet_05v0 ad=0.2132p pd=1.34u as=0.2132p ps=1.34u w=0.82u l=0.6u
M21 a_224_497# A2 VDD VNW pfet_05v0 ad=0.51465p pd=2.035u as=0.4818p ps=3.07u w=1.095u l=0.5u
M22 ZN B VDD VNW pfet_05v0 ad=0.2483p pd=1.475u as=0.2483p ps=1.475u w=0.955u l=0.5u
M23 ZN A1 a_224_497# VNW pfet_05v0 ad=0.2847p pd=1.615u as=0.51465p ps=2.035u w=1.095u l=0.5u
.ends

.subckt gf180mcu_fd_sc_mcu7t5v0__oai31_1 VDD ZN B A1 A2 VSS A3 VNW VPW
M0 a_468_497# A1 ZN VNW pfet_05v0 ad=0.58035p pd=2.155u as=0.4012p ps=1.85u w=1.095u l=0.5u
M1 a_244_69# A2 ZN VPW nfet_05v0 ad=0.2119p pd=1.335u as=0.4137p ps=1.9u w=0.815u l=0.6u
M2 a_780_497# A2 a_468_497# VNW pfet_05v0 ad=0.2847p pd=1.615u as=0.58035p ps=2.155u w=1.095u l=0.5u
M3 ZN A1 a_244_69# VPW nfet_05v0 ad=0.4137p pd=1.9u as=0.2119p ps=1.335u w=0.815u l=0.6u
M4 VDD A3 a_780_497# VNW pfet_05v0 ad=0.5913p pd=3.27u as=0.2847p ps=1.615u w=1.095u l=0.5u
M5 a_244_69# B VSS VPW nfet_05v0 ad=0.2119p pd=1.335u as=0.3586p ps=2.51u w=0.815u l=0.6u
M6 ZN B VDD VNW pfet_05v0 ad=0.4012p pd=1.85u as=0.4972p ps=3.14u w=1.13u l=0.5u
M7 ZN A3 a_244_69# VPW nfet_05v0 ad=0.3586p pd=2.51u as=0.2119p ps=1.335u w=0.815u l=0.6u
.ends

.subckt gf180mcu_fd_sc_mcu7t5v0__aoi222_2 B2 B1 A2 A1 ZN VSS VDD C2 C1 VNW VPW
M0 VSS C2 a_251_68# VPW nfet_05v0 ad=0.316p pd=1.59u as=96f ps=1.04u w=0.8u l=0.6u
M1 ZN C1 a_697_68# VPW nfet_05v0 ad=0.384p pd=1.76u as=0.124p ps=1.11u w=0.8u l=0.6u
M2 a_231_472# C1 VDD VNW pfet_05v0 ad=0.3172p pd=1.74u as=0.5368p ps=3.32u w=1.22u l=0.5u
M3 a_1003_472# B2 a_231_472# VNW pfet_05v0 ad=0.3172p pd=1.74u as=0.3172p ps=1.74u w=1.22u l=0.5u
M4 ZN A2 a_1003_472# VNW pfet_05v0 ad=0.3172p pd=1.74u as=0.3172p ps=1.74u w=1.22u l=0.5u
M5 ZN A1 a_1003_472# VNW pfet_05v0 ad=0.3172p pd=1.74u as=0.32635p ps=1.755u w=1.22u l=0.5u
M6 VSS B2 a_1191_68# VPW nfet_05v0 ad=0.208p pd=1.32u as=0.168p ps=1.22u w=0.8u l=0.6u
M7 a_231_472# B2 a_1003_472# VNW pfet_05v0 ad=0.3172p pd=1.74u as=0.3172p ps=1.74u w=1.22u l=0.5u
M8 a_1003_472# A1 ZN VNW pfet_05v0 ad=0.5368p pd=3.32u as=0.3172p ps=1.74u w=1.22u l=0.5u
M9 VDD C2 a_231_472# VNW pfet_05v0 ad=0.3172p pd=1.74u as=0.3172p ps=1.74u w=1.22u l=0.5u
M10 a_231_472# C2 VDD VNW pfet_05v0 ad=0.3172p pd=1.74u as=0.3172p ps=1.74u w=1.22u l=0.5u
M11 ZN B1 a_1619_68# VPW nfet_05v0 ad=0.214p pd=1.335u as=0.128p ps=1.12u w=0.8u l=0.6u
M12 VDD C1 a_231_472# VNW pfet_05v0 ad=0.5368p pd=3.32u as=0.3172p ps=1.74u w=1.22u l=0.5u
M13 a_2438_68# A2 VSS VPW nfet_05v0 ad=0.128p pd=1.12u as=0.208p ps=1.32u w=0.8u l=0.6u
M14 a_2030_68# A1 ZN VPW nfet_05v0 ad=0.128p pd=1.12u as=0.214p ps=1.335u w=0.8u l=0.6u
M15 a_251_68# C1 ZN VPW nfet_05v0 ad=96f pd=1.04u as=0.352p ps=2.48u w=0.8u l=0.6u
M16 a_1003_472# B1 a_231_472# VNW pfet_05v0 ad=0.32635p pd=1.755u as=0.3172p ps=1.74u w=1.22u l=0.5u
M17 VSS A2 a_2030_68# VPW nfet_05v0 ad=0.208p pd=1.32u as=0.128p ps=1.12u w=0.8u l=0.6u
M18 a_1191_68# B1 ZN VPW nfet_05v0 ad=0.168p pd=1.22u as=0.384p ps=1.76u w=0.8u l=0.6u
M19 a_1619_68# B2 VSS VPW nfet_05v0 ad=0.128p pd=1.12u as=0.208p ps=1.32u w=0.8u l=0.6u
M20 ZN A1 a_2438_68# VPW nfet_05v0 ad=0.352p pd=2.48u as=0.128p ps=1.12u w=0.8u l=0.6u
M21 a_231_472# B1 a_1003_472# VNW pfet_05v0 ad=0.3172p pd=1.74u as=0.5368p ps=3.32u w=1.22u l=0.5u
M22 a_697_68# C2 VSS VPW nfet_05v0 ad=0.124p pd=1.11u as=0.316p ps=1.59u w=0.8u l=0.6u
M23 a_1003_472# A2 ZN VNW pfet_05v0 ad=0.3172p pd=1.74u as=0.3172p ps=1.74u w=1.22u l=0.5u
.ends

.subckt gf180mcu_fd_sc_mcu7t5v0__nor3_2 A3 VDD VSS ZN A1 A2 VNW VPW
M0 VDD A3 a_1130_472# VNW pfet_05v0 ad=0.5368p pd=3.32u as=0.3477p ps=1.79u w=1.22u l=0.5u
M1 a_1130_472# A2 a_906_472# VNW pfet_05v0 ad=0.3477p pd=1.79u as=0.3782p ps=1.84u w=1.22u l=0.5u
M2 ZN A3 VSS VPW nfet_05v0 ad=0.2046p pd=1.81u as=0.1209p ps=0.985u w=0.465u l=0.6u
M3 a_244_472# A3 VDD VNW pfet_05v0 ad=0.3782p pd=1.84u as=0.5368p ps=3.32u w=1.22u l=0.5u
M4 ZN A1 VSS VPW nfet_05v0 ad=0.1209p pd=0.985u as=0.1209p ps=0.985u w=0.465u l=0.6u
M5 ZN A2 VSS VPW nfet_05v0 ad=0.1209p pd=0.985u as=0.1209p ps=0.985u w=0.465u l=0.6u
M6 VSS A2 ZN VPW nfet_05v0 ad=0.1209p pd=0.985u as=0.1209p ps=0.985u w=0.465u l=0.6u
M7 a_906_472# A1 ZN VNW pfet_05v0 ad=0.3782p pd=1.84u as=0.3782p ps=1.84u w=1.22u l=0.5u
M8 ZN A1 a_468_472# VNW pfet_05v0 ad=0.3782p pd=1.84u as=0.3477p ps=1.79u w=1.22u l=0.5u
M9 VSS A1 ZN VPW nfet_05v0 ad=0.1209p pd=0.985u as=0.1209p ps=0.985u w=0.465u l=0.6u
M10 VSS A3 ZN VPW nfet_05v0 ad=0.1209p pd=0.985u as=0.2046p ps=1.81u w=0.465u l=0.6u
M11 a_468_472# A2 a_244_472# VNW pfet_05v0 ad=0.3477p pd=1.79u as=0.3782p ps=1.84u w=1.22u l=0.5u
.ends

.subckt gf180mcu_fd_sc_mcu7t5v0__aoi21_4 A2 B VDD VSS ZN A1 VNW VPW
M0 VDD B a_76_476# VNW pfet_05v0 ad=0.312p pd=1.72u as=0.312p ps=1.72u w=1.2u l=0.5u
M1 a_680_68# A1 ZN VPW nfet_05v0 ad=98.399994f pd=1.06u as=0.2132p ps=1.34u w=0.82u l=0.6u
M2 VDD B a_76_476# VNW pfet_05v0 ad=0.312p pd=1.72u as=0.48p ps=2u w=1.2u l=0.5u
M3 a_76_476# B VDD VNW pfet_05v0 ad=0.528p pd=3.28u as=0.312p ps=1.72u w=1.2u l=0.5u
M4 ZN B VSS VPW nfet_05v0 ad=0.1326p pd=1.03u as=0.1326p ps=1.03u w=0.51u l=0.6u
M5 ZN A2 a_76_476# VNW pfet_05v0 ad=0.312p pd=1.72u as=0.528p ps=3.28u w=1.2u l=0.5u
M6 a_76_476# A1 ZN VNW pfet_05v0 ad=0.312p pd=1.72u as=0.312p ps=1.72u w=1.2u l=0.5u
M7 a_1464_68# A1 ZN VPW nfet_05v0 ad=98.399994f pd=1.06u as=0.2132p ps=1.34u w=0.82u l=0.6u
M8 ZN A1 a_76_476# VNW pfet_05v0 ad=0.312p pd=1.72u as=0.312p ps=1.72u w=1.2u l=0.5u
M9 VSS A2 a_1464_68# VPW nfet_05v0 ad=0.2405p pd=1.52u as=98.399994f ps=1.06u w=0.82u l=0.6u
M10 a_76_476# A2 ZN VNW pfet_05v0 ad=0.312p pd=1.72u as=0.312p ps=1.72u w=1.2u l=0.5u
M11 VSS A2 a_680_68# VPW nfet_05v0 ad=0.2132p pd=1.34u as=98.399994f ps=1.06u w=0.82u l=0.6u
M12 ZN A2 a_76_476# VNW pfet_05v0 ad=0.312p pd=1.72u as=0.312p ps=1.72u w=1.2u l=0.5u
M13 VSS B ZN VPW nfet_05v0 ad=0.1326p pd=1.03u as=0.1326p ps=1.03u w=0.51u l=0.6u
M14 ZN A1 a_1072_68# VPW nfet_05v0 ad=0.2132p pd=1.34u as=98.399994f ps=1.06u w=0.82u l=0.6u
M15 a_288_68# A2 VSS VPW nfet_05v0 ad=98.399994f pd=1.06u as=0.3608p ps=2.52u w=0.82u l=0.6u
M16 a_1072_68# A2 VSS VPW nfet_05v0 ad=98.399994f pd=1.06u as=0.2132p ps=1.34u w=0.82u l=0.6u
M17 VSS B ZN VPW nfet_05v0 ad=0.2244p pd=1.9u as=0.1326p ps=1.03u w=0.51u l=0.6u
M18 a_76_476# A1 ZN VNW pfet_05v0 ad=0.312p pd=1.72u as=0.312p ps=1.72u w=1.2u l=0.5u
M19 ZN A1 a_288_68# VPW nfet_05v0 ad=0.2132p pd=1.34u as=98.399994f ps=1.06u w=0.82u l=0.6u
M20 ZN A1 a_76_476# VNW pfet_05v0 ad=0.312p pd=1.72u as=0.312p ps=1.72u w=1.2u l=0.5u
M21 a_76_476# A2 ZN VNW pfet_05v0 ad=0.48p pd=2u as=0.312p ps=1.72u w=1.2u l=0.5u
M22 a_76_476# B VDD VNW pfet_05v0 ad=0.312p pd=1.72u as=0.312p ps=1.72u w=1.2u l=0.5u
M23 ZN B VSS VPW nfet_05v0 ad=0.1326p pd=1.03u as=0.2405p ps=1.52u w=0.51u l=0.6u
.ends

.subckt gf180mcu_fd_sc_mcu7t5v0__and2_1 VDD VSS Z A1 A2 VNW VPW
M0 VDD A2 a_36_159# VNW pfet_05v0 ad=0.40575p pd=2.055u as=0.156p ps=1.12u w=0.6u l=0.5u
M1 Z a_36_159# VDD VNW pfet_05v0 ad=0.5346p pd=3.31u as=0.40575p ps=2.055u w=1.215u l=0.5u
M2 Z a_36_159# VSS VPW nfet_05v0 ad=0.3586p pd=2.51u as=0.23405p ps=1.555u w=0.815u l=0.6u
M3 VSS A2 a_244_159# VPW nfet_05v0 ad=0.23405p pd=1.555u as=58.399994f ps=0.685u w=0.365u l=0.6u
M4 a_244_159# A1 a_36_159# VPW nfet_05v0 ad=58.399994f pd=0.685u as=0.1606p ps=1.61u w=0.365u l=0.6u
M5 a_36_159# A1 VDD VNW pfet_05v0 ad=0.156p pd=1.12u as=0.264p ps=2.08u w=0.6u l=0.5u
.ends

.subckt gf180mcu_fd_sc_mcu7t5v0__aoi211_1 B C VDD VSS ZN A1 A2 VNW VPW
M0 ZN A2 a_37_472# VNW pfet_05v0 ad=0.3159p pd=1.735u as=0.5346p ps=3.31u w=1.215u l=0.5u
M1 VSS B ZN VPW nfet_05v0 ad=0.1209p pd=0.985u as=0.21175p ps=1.41u w=0.465u l=0.6u
M2 a_37_472# A1 ZN VNW pfet_05v0 ad=0.37665p pd=1.835u as=0.3159p ps=1.735u w=1.215u l=0.5u
M3 VDD C a_653_472# VNW pfet_05v0 ad=0.5346p pd=3.31u as=0.37665p ps=1.835u w=1.215u l=0.5u
M4 a_245_90# A2 VSS VPW nfet_05v0 ad=85.2f pd=0.95u as=0.3124p ps=2.3u w=0.71u l=0.6u
M5 ZN A1 a_245_90# VPW nfet_05v0 ad=0.21175p pd=1.41u as=85.2f ps=0.95u w=0.71u l=0.6u
M6 a_653_472# B a_37_472# VNW pfet_05v0 ad=0.37665p pd=1.835u as=0.37665p ps=1.835u w=1.215u l=0.5u
M7 ZN C VSS VPW nfet_05v0 ad=0.2046p pd=1.81u as=0.1209p ps=0.985u w=0.465u l=0.6u
.ends

.subckt gf180mcu_fd_sc_mcu7t5v0__aoi21_1 B VDD VSS ZN A1 A2 VNW VPW
M0 a_244_68# A2 VSS VPW nfet_05v0 ad=0.1312p pd=1.14u as=0.3608p ps=2.52u w=0.82u l=0.6u
M1 ZN A1 a_244_68# VPW nfet_05v0 ad=0.2569p pd=1.56u as=0.1312p ps=1.14u w=0.82u l=0.6u
M2 VDD B a_36_472# VNW pfet_05v0 ad=0.5346p pd=3.31u as=0.44955p ps=1.955u w=1.215u l=0.5u
M3 ZN A2 a_36_472# VNW pfet_05v0 ad=0.3159p pd=1.735u as=0.5346p ps=3.31u w=1.215u l=0.5u
M4 a_36_472# A1 ZN VNW pfet_05v0 ad=0.44955p pd=1.955u as=0.3159p ps=1.735u w=1.215u l=0.5u
M5 VSS B ZN VPW nfet_05v0 ad=0.2244p pd=1.9u as=0.2569p ps=1.56u w=0.51u l=0.6u
.ends

.subckt gf180mcu_fd_sc_mcu7t5v0__oai33_2 A3 B1 B2 B3 VDD VSS ZN A1 A2 VNW VPW
M0 a_468_497# B2 a_244_497# VNW pfet_05v0 ad=0.33945p pd=1.715u as=0.33945p ps=1.715u w=1.095u l=0.5u
M1 a_2508_497# A2 a_2284_497# VNW pfet_05v0 ad=0.4599p pd=1.935u as=0.33945p ps=1.715u w=1.095u l=0.5u
M2 VSS B1 a_36_68# VPW nfet_05v0 ad=0.2132p pd=1.34u as=0.2132p ps=1.34u w=0.82u l=0.6u
M3 VSS B3 a_36_68# VPW nfet_05v0 ad=0.2132p pd=1.34u as=0.3608p ps=2.52u w=0.82u l=0.6u
M4 VDD B3 a_1120_497# VNW pfet_05v0 ad=0.3942p pd=1.815u as=0.33945p ps=1.715u w=1.095u l=0.5u
M5 a_2284_497# A1 ZN VNW pfet_05v0 ad=0.33945p pd=1.715u as=0.2847p ps=1.615u w=1.095u l=0.5u
M6 a_1588_497# A3 VDD VNW pfet_05v0 ad=0.4599p pd=1.935u as=0.3942p ps=1.815u w=1.095u l=0.5u
M7 ZN A3 a_36_68# VPW nfet_05v0 ad=0.30965p pd=1.685u as=0.2132p ps=1.34u w=0.82u l=0.6u
M8 ZN A2 a_36_68# VPW nfet_05v0 ad=0.30965p pd=1.685u as=0.2132p ps=1.34u w=0.82u l=0.6u
M9 VDD A3 a_2508_497# VNW pfet_05v0 ad=0.4818p pd=3.07u as=0.4599p ps=1.935u w=1.095u l=0.5u
M10 ZN A1 a_1856_497# VNW pfet_05v0 ad=0.2847p pd=1.615u as=0.33945p ps=1.715u w=1.095u l=0.5u
M11 a_244_497# B3 VDD VNW pfet_05v0 ad=0.33945p pd=1.715u as=0.4818p ps=3.07u w=1.095u l=0.5u
M12 a_36_68# A2 ZN VPW nfet_05v0 ad=0.2132p pd=1.34u as=0.30965p ps=1.685u w=0.82u l=0.6u
M13 ZN B1 a_468_497# VNW pfet_05v0 ad=0.2847p pd=1.615u as=0.33945p ps=1.715u w=1.095u l=0.5u
M14 a_1120_497# B2 a_896_497# VNW pfet_05v0 ad=0.33945p pd=1.715u as=0.33945p ps=1.715u w=1.095u l=0.5u
M15 a_36_68# B3 VSS VPW nfet_05v0 ad=0.2132p pd=1.34u as=0.2132p ps=1.34u w=0.82u l=0.6u
M16 a_36_68# A1 ZN VPW nfet_05v0 ad=0.2132p pd=1.34u as=0.2132p ps=1.34u w=0.82u l=0.6u
M17 a_896_497# B1 ZN VNW pfet_05v0 ad=0.33945p pd=1.715u as=0.2847p ps=1.615u w=1.095u l=0.5u
M18 ZN A1 a_36_68# VPW nfet_05v0 ad=0.2132p pd=1.34u as=0.2132p ps=1.34u w=0.82u l=0.6u
M19 a_36_68# A3 ZN VPW nfet_05v0 ad=0.3608p pd=2.52u as=0.30965p ps=1.685u w=0.82u l=0.6u
M20 a_36_68# B1 VSS VPW nfet_05v0 ad=0.2132p pd=1.34u as=0.2132p ps=1.34u w=0.82u l=0.6u
M21 a_1856_497# A2 a_1588_497# VNW pfet_05v0 ad=0.33945p pd=1.715u as=0.4599p ps=1.935u w=1.095u l=0.5u
M22 a_36_68# B2 VSS VPW nfet_05v0 ad=0.2132p pd=1.34u as=0.2132p ps=1.34u w=0.82u l=0.6u
M23 VSS B2 a_36_68# VPW nfet_05v0 ad=0.2132p pd=1.34u as=0.2132p ps=1.34u w=0.82u l=0.6u
.ends

.subckt gf180mcu_fd_sc_mcu7t5v0__oai21_1 VDD B A2 ZN A1 VSS VNW VPW
M0 VSS B a_36_68# VPW nfet_05v0 ad=0.3608p pd=2.52u as=0.2132p ps=1.34u w=0.82u l=0.6u
M1 ZN A2 a_36_68# VPW nfet_05v0 ad=0.2132p pd=1.34u as=0.3608p ps=2.52u w=0.82u l=0.6u
M2 VDD B ZN VNW pfet_05v0 ad=0.4972p pd=3.14u as=0.4248p ps=1.94u w=1.13u l=0.5u
M3 a_244_472# A2 VDD VNW pfet_05v0 ad=0.3172p pd=1.74u as=0.5978p ps=3.42u w=1.22u l=0.5u
M4 ZN A1 a_244_472# VNW pfet_05v0 ad=0.4248p pd=1.94u as=0.3172p ps=1.74u w=1.22u l=0.5u
M5 a_36_68# A1 ZN VPW nfet_05v0 ad=0.2132p pd=1.34u as=0.2132p ps=1.34u w=0.82u l=0.6u
.ends

.subckt gf180mcu_fd_sc_mcu7t5v0__nor2_1 VDD VSS ZN A1 A2 VNW VPW
M0 ZN A1 a_224_472# VNW pfet_05v0 ad=0.5368p pd=3.32u as=0.4087p ps=1.89u w=1.22u l=0.5u
M1 VSS A1 ZN VPW nfet_05v0 ad=0.2486p pd=2.01u as=0.1469p ps=1.085u w=0.565u l=0.6u
M2 a_224_472# A2 VDD VNW pfet_05v0 ad=0.4087p pd=1.89u as=0.5368p ps=3.32u w=1.22u l=0.5u
M3 ZN A2 VSS VPW nfet_05v0 ad=0.1469p pd=1.085u as=0.2486p ps=2.01u w=0.565u l=0.6u
.ends

.subckt gf180mcu_fd_sc_mcu7t5v0__aoi21_2 B VDD VSS ZN A1 A2 VNW VPW
M0 VSS A2 a_1133_69# VPW nfet_05v0 ad=0.341p pd=2.43u as=92.99999f ps=1.015u w=0.775u l=0.6u
M1 VDD B a_49_472# VNW pfet_05v0 ad=0.37665p pd=1.835u as=0.5346p ps=3.31u w=1.215u l=0.5u
M2 ZN A1 a_49_472# VNW pfet_05v0 ad=0.3159p pd=1.735u as=0.32805p ps=1.755u w=1.215u l=0.5u
M3 a_741_69# A2 VSS VPW nfet_05v0 ad=92.99999f pd=1.015u as=0.23975p ps=1.475u w=0.775u l=0.6u
M4 a_49_472# A1 ZN VNW pfet_05v0 ad=0.32805p pd=1.755u as=0.37665p ps=1.835u w=1.215u l=0.5u
M5 ZN B VSS VPW nfet_05v0 ad=0.1469p pd=1.085u as=0.2486p ps=2.01u w=0.565u l=0.6u
M6 a_49_472# A2 ZN VNW pfet_05v0 ad=0.5346p pd=3.31u as=0.3159p ps=1.735u w=1.215u l=0.5u
M7 a_49_472# B VDD VNW pfet_05v0 ad=0.3159p pd=1.735u as=0.37665p ps=1.835u w=1.215u l=0.5u
M8 ZN A2 a_49_472# VNW pfet_05v0 ad=0.37665p pd=1.835u as=0.3159p ps=1.735u w=1.215u l=0.5u
M9 VSS B ZN VPW nfet_05v0 ad=0.23975p pd=1.475u as=0.1469p ps=1.085u w=0.565u l=0.6u
M10 ZN A1 a_741_69# VPW nfet_05v0 ad=0.2015p pd=1.295u as=92.99999f ps=1.015u w=0.775u l=0.6u
M11 a_1133_69# A1 ZN VPW nfet_05v0 ad=92.99999f pd=1.015u as=0.2015p ps=1.295u w=0.775u l=0.6u
.ends

.subckt gf180mcu_fd_sc_mcu7t5v0__xor2_2 VDD VSS Z A1 A2 VNW VPW
M0 VSS a_730_497# Z VPW nfet_05v0 ad=0.3608p pd=2.52u as=0.2132p ps=1.34u w=0.82u l=0.6u
M1 a_954_497# A1 a_730_497# VNW pfet_05v0 ad=0.5256p pd=2.055u as=0.33945p ps=1.715u w=1.095u l=0.5u
M2 a_286_93# A2 a_78_93# VPW nfet_05v0 ad=57.599995f pd=0.68u as=0.1584p ps=1.6u w=0.36u l=0.6u
M3 Z a_730_497# VSS VPW nfet_05v0 ad=0.2132p pd=1.34u as=0.3608p ps=2.52u w=0.82u l=0.6u
M4 a_730_497# a_78_93# VDD VNW pfet_05v0 ad=0.33945p pd=1.715u as=0.344375p ps=1.895u w=1.095u l=0.5u
M5 Z a_730_497# VDD VNW pfet_05v0 ad=0.3172p pd=1.74u as=0.5368p ps=3.32u w=1.22u l=0.5u
M6 a_78_93# A2 VDD VNW pfet_05v0 ad=0.1456p pd=1.08u as=0.2464p ps=2u w=0.56u l=0.5u
M7 a_730_497# A1 a_730_68# VPW nfet_05v0 ad=0.4161p pd=1.905u as=0.2132p ps=1.34u w=0.82u l=0.6u
M8 VDD A1 a_78_93# VNW pfet_05v0 ad=0.344375p pd=1.895u as=0.1456p ps=1.08u w=0.56u l=0.5u
M9 VDD a_730_497# Z VNW pfet_05v0 ad=0.5368p pd=3.32u as=0.3172p ps=1.74u w=1.22u l=0.5u
M10 VSS A1 a_286_93# VPW nfet_05v0 ad=0.218p pd=1.52u as=57.599995f ps=0.68u w=0.36u l=0.6u
M11 a_730_68# A2 a_730_497# VPW nfet_05v0 ad=0.3608p pd=2.52u as=0.4161p ps=1.905u w=0.82u l=0.6u
M12 a_730_68# a_78_93# VSS VPW nfet_05v0 ad=0.2132p pd=1.34u as=0.218p ps=1.52u w=0.82u l=0.6u
M13 VDD A2 a_954_497# VNW pfet_05v0 ad=0.4818p pd=3.07u as=0.5256p ps=2.055u w=1.095u l=0.5u
.ends

.subckt gf180mcu_fd_sc_mcu7t5v0__oai211_2 A2 ZN A1 B C VDD VSS VNW VPW
M0 a_1229_68# B a_36_68# VPW nfet_05v0 ad=0.1722p pd=1.24u as=0.21525p ps=1.345u w=0.82u l=0.6u
M1 VDD B ZN VNW pfet_05v0 ad=0.4334p pd=2.85u as=0.2561p ps=1.505u w=0.985u l=0.5u
M2 ZN A1 a_36_68# VPW nfet_05v0 ad=0.30965p pd=1.685u as=0.2132p ps=1.34u w=0.82u l=0.6u
M3 a_716_497# A1 ZN VNW pfet_05v0 ad=0.4599p pd=1.935u as=0.2847p ps=1.615u w=1.095u l=0.5u
M4 a_36_68# B a_1657_68# VPW nfet_05v0 ad=0.3608p pd=2.52u as=0.1312p ps=1.14u w=0.82u l=0.6u
M5 ZN A2 a_36_68# VPW nfet_05v0 ad=0.31215p pd=1.685u as=0.3608p ps=2.52u w=0.82u l=0.6u
M6 VDD A2 a_716_497# VNW pfet_05v0 ad=0.37905p pd=1.82u as=0.4599p ps=1.935u w=1.095u l=0.5u
M7 a_36_68# A1 ZN VPW nfet_05v0 ad=0.2132p pd=1.34u as=0.31215p ps=1.685u w=0.82u l=0.6u
M8 a_244_497# A2 VDD VNW pfet_05v0 ad=0.4599p pd=1.935u as=0.4818p ps=3.07u w=1.095u l=0.5u
M9 a_36_68# A2 ZN VPW nfet_05v0 ad=0.21525p pd=1.345u as=0.30965p ps=1.685u w=0.82u l=0.6u
M10 a_1657_68# C VSS VPW nfet_05v0 ad=0.1312p pd=1.14u as=0.2132p ps=1.34u w=0.82u l=0.6u
M11 ZN B VDD VNW pfet_05v0 ad=0.2561p pd=1.505u as=0.37905p ps=1.82u w=0.985u l=0.5u
M12 VDD C ZN VNW pfet_05v0 ad=0.2561p pd=1.505u as=0.2561p ps=1.505u w=0.985u l=0.5u
M13 VSS C a_1229_68# VPW nfet_05v0 ad=0.2132p pd=1.34u as=0.1722p ps=1.24u w=0.82u l=0.6u
M14 ZN A1 a_244_497# VNW pfet_05v0 ad=0.2847p pd=1.615u as=0.4599p ps=1.935u w=1.095u l=0.5u
M15 ZN C VDD VNW pfet_05v0 ad=0.2561p pd=1.505u as=0.2561p ps=1.505u w=0.985u l=0.5u
.ends

.subckt gf180mcu_fd_sc_mcu7t5v0__mux4_4 I0 VSS VDD I2 I1 S0 I3 S1 Z VNW VPW
M0 a_2595_156# S0 a_3216_156# VPW nfet_05v0 ad=94.899994f pd=0.885u as=94.899994f ps=0.885u w=0.365u l=0.6u
M1 Z a_1108_112# VSS VPW nfet_05v0 ad=98.799995f pd=0.9u as=98.799995f ps=0.9u w=0.38u l=0.6u
M2 a_728_472# a_348_112# a_468_156# VNW pfet_05v0 ad=0.3042p pd=1.56u as=0.2028p ps=1.3u w=0.78u l=0.5u
M3 VSS I3 a_728_472# VPW nfet_05v0 ad=98.799995f pd=0.9u as=98.799995f ps=0.9u w=0.38u l=0.6u
M4 Z a_1108_112# VDD VNW pfet_05v0 ad=0.2028p pd=1.3u as=0.3198p ps=1.6u w=0.78u l=0.5u
M5 a_348_112# S0 VDD VNW pfet_05v0 ad=0.2618p pd=2.07u as=0.18445p ps=1.215u w=0.595u l=0.5u
M6 Z a_1108_112# VSS VPW nfet_05v0 ad=98.799995f pd=0.9u as=98.799995f ps=0.9u w=0.38u l=0.6u
M7 a_3216_156# I1 VSS VPW nfet_05v0 ad=94.899994f pd=0.885u as=94.899994f ps=0.885u w=0.365u l=0.6u
M8 VDD I3 a_728_472# VNW pfet_05v0 ad=0.3198p pd=1.6u as=0.3042p ps=1.56u w=0.78u l=0.5u
M9 VDD a_1108_112# Z VNW pfet_05v0 ad=0.2028p pd=1.3u as=0.2028p ps=1.3u w=0.78u l=0.5u
M10 VSS I0 a_3624_509# VPW nfet_05v0 ad=94.899994f pd=0.885u as=94.899994f ps=0.885u w=0.365u l=0.6u
M11 a_3216_156# I1 VDD VNW pfet_05v0 ad=0.1547p pd=1.115u as=0.18445p ps=1.215u w=0.595u l=0.5u
M12 Z a_1108_112# VDD VNW pfet_05v0 ad=0.2028p pd=1.3u as=0.2028p ps=1.3u w=0.78u l=0.5u
M13 a_468_156# a_348_112# a_224_472# VPW nfet_05v0 ad=0.1824p pd=1.34u as=98.799995f ps=0.9u w=0.38u l=0.6u
M14 a_2595_156# a_348_112# a_3216_156# VNW pfet_05v0 ad=0.1547p pd=1.115u as=0.1547p ps=1.115u w=0.595u l=0.5u
M15 VDD a_1108_112# Z VNW pfet_05v0 ad=0.4524p pd=2.72u as=0.2028p ps=1.3u w=0.78u l=0.5u
M16 a_3624_509# S0 a_2595_156# VNW pfet_05v0 ad=0.2142p pd=1.315u as=0.1547p ps=1.115u w=0.595u l=0.5u
M17 a_728_472# S0 a_468_156# VPW nfet_05v0 ad=98.799995f pd=0.9u as=0.1824p ps=1.34u w=0.38u l=0.6u
M18 a_2595_156# S1 a_1108_112# VNW pfet_05v0 ad=0.2618p pd=2.07u as=0.2618p ps=1.475u w=0.595u l=0.5u
M19 VDD I0 a_3624_509# VNW pfet_05v0 ad=0.18445p pd=1.215u as=0.2142p ps=1.315u w=0.595u l=0.5u
M20 a_2595_156# a_2220_369# a_1108_112# VPW nfet_05v0 ad=0.162425p pd=1.62u as=0.112225p ps=0.98u w=0.365u l=0.6u
M21 VSS a_1108_112# Z VPW nfet_05v0 ad=98.799995f pd=0.9u as=98.799995f ps=0.9u w=0.38u l=0.6u
M22 a_3624_509# a_348_112# a_2595_156# VPW nfet_05v0 ad=94.899994f pd=0.885u as=94.899994f ps=0.885u w=0.365u l=0.6u
M23 VDD S1 a_2220_369# VNW pfet_05v0 ad=0.18445p pd=1.215u as=0.2618p ps=2.07u w=0.595u l=0.5u
M24 a_1108_112# S1 a_468_156# VPW nfet_05v0 ad=0.112225p pd=0.98u as=0.27375p ps=2.23u w=0.365u l=0.6u
M25 a_224_472# I2 VSS VPW nfet_05v0 ad=98.799995f pd=0.9u as=0.1672p ps=1.64u w=0.38u l=0.6u
M26 VSS a_1108_112# Z VPW nfet_05v0 ad=0.1672p pd=1.64u as=98.799995f ps=0.9u w=0.38u l=0.6u
M27 a_348_112# S0 VSS VPW nfet_05v0 ad=0.1606p pd=1.61u as=94.899994f ps=0.885u w=0.365u l=0.6u
M28 VSS S1 a_2220_369# VPW nfet_05v0 ad=94.899994f pd=0.885u as=0.1606p ps=1.61u w=0.365u l=0.6u
M29 a_224_472# I2 VDD VNW pfet_05v0 ad=0.39p pd=1.78u as=0.3432p ps=2.44u w=0.78u l=0.5u
M30 a_1108_112# a_2220_369# a_468_156# VNW pfet_05v0 ad=0.2618p pd=1.475u as=0.401625p ps=2.54u w=0.595u l=0.5u
M31 a_468_156# S0 a_224_472# VNW pfet_05v0 ad=0.2028p pd=1.3u as=0.39p ps=1.78u w=0.78u l=0.5u
.ends

.subckt gf180mcu_fd_sc_mcu7t5v0__oai21_2 A2 ZN A1 VSS B VDD VNW VPW
M0 ZN A1 a_692_497# VNW pfet_05v0 ad=0.2847p pd=1.615u as=0.4599p ps=1.935u w=1.095u l=0.5u
M1 ZN A2 a_36_68# VPW nfet_05v0 ad=0.30965p pd=1.685u as=0.2132p ps=1.34u w=0.82u l=0.6u
M2 VSS B a_36_68# VPW nfet_05v0 ad=0.2132p pd=1.34u as=0.3608p ps=2.52u w=0.82u l=0.6u
M3 a_36_68# A2 ZN VPW nfet_05v0 ad=0.3608p pd=2.52u as=0.31215p ps=1.685u w=0.82u l=0.6u
M4 a_36_68# A1 ZN VPW nfet_05v0 ad=0.2132p pd=1.34u as=0.30965p ps=1.685u w=0.82u l=0.6u
M5 a_1164_497# A1 ZN VNW pfet_05v0 ad=0.4599p pd=1.935u as=0.2847p ps=1.615u w=1.095u l=0.5u
M6 ZN B VDD VNW pfet_05v0 ad=0.2483p pd=1.475u as=0.4202p ps=2.79u w=0.955u l=0.5u
M7 a_692_497# A2 VDD VNW pfet_05v0 ad=0.4599p pd=1.935u as=0.3718p ps=1.815u w=1.095u l=0.5u
M8 VDD B ZN VNW pfet_05v0 ad=0.3718p pd=1.815u as=0.2483p ps=1.475u w=0.955u l=0.5u
M9 VDD A2 a_1164_497# VNW pfet_05v0 ad=0.4818p pd=3.07u as=0.4599p ps=1.935u w=1.095u l=0.5u
M10 a_36_68# B VSS VPW nfet_05v0 ad=0.2132p pd=1.34u as=0.2132p ps=1.34u w=0.82u l=0.6u
M11 ZN A1 a_36_68# VPW nfet_05v0 ad=0.31215p pd=1.685u as=0.2132p ps=1.34u w=0.82u l=0.6u
.ends

.subckt gf180mcu_fd_sc_mcu7t5v0__or3_1 A3 VDD VSS Z A1 A2 VNW VPW
M0 a_224_604# A1 a_36_88# VNW pfet_05v0 ad=0.1736p pd=1.18u as=0.2464p ps=2u w=0.56u l=0.5u
M1 a_36_88# A2 VSS VPW nfet_05v0 ad=0.14p pd=1.1u as=0.104p ps=0.92u w=0.4u l=0.6u
M2 Z a_36_88# VDD VNW pfet_05v0 ad=0.5368p pd=3.32u as=0.389p ps=2.02u w=1.22u l=0.5u
M3 VSS A1 a_36_88# VPW nfet_05v0 ad=0.104p pd=0.92u as=0.176p ps=1.68u w=0.4u l=0.6u
M4 a_448_604# A2 a_224_604# VNW pfet_05v0 ad=0.224p pd=1.36u as=0.1736p ps=1.18u w=0.56u l=0.5u
M5 VSS A3 a_36_88# VPW nfet_05v0 ad=0.224p pd=1.52u as=0.14p ps=1.1u w=0.4u l=0.6u
M6 VDD A3 a_448_604# VNW pfet_05v0 ad=0.389p pd=2.02u as=0.224p ps=1.36u w=0.56u l=0.5u
M7 Z a_36_88# VSS VPW nfet_05v0 ad=0.3608p pd=2.52u as=0.224p ps=1.52u w=0.82u l=0.6u
.ends

.subckt gf180mcu_fd_sc_mcu7t5v0__tiel ZN VDD VSS VNW VPW
M0 ZN a_124_24# VSS VPW nfet_05v0 ad=0.3608p pd=2.52u as=0.3608p ps=2.52u w=0.82u l=0.6u
M1 a_124_24# a_124_24# VDD VNW pfet_05v0 ad=0.5368p pd=3.32u as=0.5368p ps=3.32u w=1.22u l=0.5u
.ends

.subckt gf180mcu_fd_sc_mcu7t5v0__xor3_1 A3 VDD VSS Z A1 A2 VNW VPW
M0 a_952_93# A1 a_728_93# VPW nfet_05v0 ad=57.599995f pd=0.68u as=93.59999f ps=0.88u w=0.36u l=0.6u
M1 a_728_93# A1 a_718_524# VNW pfet_05v0 ad=0.1469p pd=1.085u as=0.161025p ps=1.135u w=0.565u l=0.5u
M2 a_1524_472# a_728_93# a_1336_472# VNW pfet_05v0 ad=90.4f pd=0.885u as=0.2486p ps=2.01u w=0.565u l=0.5u
M3 a_244_524# A2 a_56_524# VNW pfet_05v0 ad=93.59999f pd=0.88u as=0.1584p ps=1.6u w=0.36u l=0.5u
M4 a_718_524# a_56_524# VDD VNW pfet_05v0 ad=0.161025p pd=1.135u as=0.194p ps=1.415u w=0.565u l=0.5u
M5 a_718_524# A2 a_728_93# VNW pfet_05v0 ad=0.2486p pd=2.01u as=0.1469p ps=1.085u w=0.565u l=0.5u
M6 VSS A1 a_56_524# VPW nfet_05v0 ad=0.126p pd=1.06u as=93.59999f ps=0.88u w=0.36u l=0.6u
M7 a_1336_472# a_728_93# VSS VPW nfet_05v0 ad=93.59999f pd=0.88u as=0.1584p ps=1.6u w=0.36u l=0.6u
M8 VDD A1 a_244_524# VNW pfet_05v0 ad=0.194p pd=1.415u as=93.59999f ps=0.88u w=0.36u l=0.5u
M9 a_56_524# A2 VSS VPW nfet_05v0 ad=93.59999f pd=0.88u as=0.1584p ps=1.6u w=0.36u l=0.6u
M10 VSS A3 a_1336_472# VPW nfet_05v0 ad=0.218p pd=1.52u as=93.59999f ps=0.88u w=0.36u l=0.6u
M11 a_2215_68# A3 Z VPW nfet_05v0 ad=0.1312p pd=1.14u as=0.2132p ps=1.34u w=0.82u l=0.6u
M12 VSS a_728_93# a_2215_68# VPW nfet_05v0 ad=0.3608p pd=2.52u as=0.1312p ps=1.14u w=0.82u l=0.6u
M13 Z a_1336_472# VSS VPW nfet_05v0 ad=0.2132p pd=1.34u as=0.218p ps=1.52u w=0.82u l=0.6u
M14 Z A3 a_1936_472# VNW pfet_05v0 ad=0.3172p pd=1.74u as=0.3172p ps=1.74u w=1.22u l=0.5u
M15 a_728_93# a_56_524# VSS VPW nfet_05v0 ad=93.59999f pd=0.88u as=0.126p ps=1.06u w=0.36u l=0.6u
M16 a_1936_472# a_728_93# Z VNW pfet_05v0 ad=0.5368p pd=3.32u as=0.3172p ps=1.74u w=1.22u l=0.5u
M17 VSS A2 a_952_93# VPW nfet_05v0 ad=0.1584p pd=1.6u as=57.599995f ps=0.68u w=0.36u l=0.6u
M18 VDD A3 a_1524_472# VNW pfet_05v0 ad=0.35315p pd=1.96u as=90.4f ps=0.885u w=0.565u l=0.5u
M19 a_1936_472# a_1336_472# VDD VNW pfet_05v0 ad=0.3172p pd=1.74u as=0.35315p ps=1.96u w=1.22u l=0.5u
.ends

.subckt gf180mcu_fd_sc_mcu7t5v0__nand3_4 A3 VDD VSS ZN A1 A2 VNW VPW
M0 VDD A1 ZN VNW pfet_05v0 ad=0.4334p pd=2.85u as=0.52205p ps=2.045u w=0.985u l=0.5u
M1 a_36_68# A1 ZN VPW nfet_05v0 ad=0.2132p pd=1.34u as=0.4161p ps=1.905u w=0.82u l=0.6u
M2 ZN A2 VDD VNW pfet_05v0 ad=0.2561p pd=1.505u as=0.30535p ps=1.605u w=0.985u l=0.5u
M3 a_36_68# A2 a_672_68# VPW nfet_05v0 ad=0.2132p pd=1.34u as=0.1722p ps=1.24u w=0.82u l=0.6u
M4 a_1732_68# A2 a_1528_68# VPW nfet_05v0 ad=0.1722p pd=1.24u as=0.1722p ps=1.24u w=0.82u l=0.6u
M5 ZN A3 VDD VNW pfet_05v0 ad=0.2561p pd=1.505u as=0.30535p ps=1.605u w=0.985u l=0.5u
M6 a_244_68# A2 a_36_68# VPW nfet_05v0 ad=0.1722p pd=1.24u as=0.3608p ps=2.52u w=0.82u l=0.6u
M7 a_1528_68# A3 VSS VPW nfet_05v0 ad=0.1722p pd=1.24u as=0.2132p ps=1.34u w=0.82u l=0.6u
M8 VDD A2 ZN VNW pfet_05v0 ad=0.2561p pd=1.505u as=0.2561p ps=1.505u w=0.985u l=0.5u
M9 ZN A1 a_36_68# VPW nfet_05v0 ad=0.4161p pd=1.905u as=0.2132p ps=1.34u w=0.82u l=0.6u
M10 VDD A3 ZN VNW pfet_05v0 ad=0.30535p pd=1.605u as=0.2561p ps=1.505u w=0.985u l=0.5u
M11 VDD A1 ZN VNW pfet_05v0 ad=0.30535p pd=1.605u as=0.52205p ps=2.045u w=0.985u l=0.5u
M12 a_1100_68# A2 a_36_68# VPW nfet_05v0 ad=0.1722p pd=1.24u as=0.2132p ps=1.34u w=0.82u l=0.6u
M13 ZN A1 VDD VNW pfet_05v0 ad=0.52205p pd=2.045u as=0.2561p ps=1.505u w=0.985u l=0.5u
M14 ZN A3 VDD VNW pfet_05v0 ad=0.2561p pd=1.505u as=0.30535p ps=1.605u w=0.985u l=0.5u
M15 ZN A1 a_1732_68# VPW nfet_05v0 ad=0.4161p pd=1.905u as=0.1722p ps=1.24u w=0.82u l=0.6u
M16 VSS A3 a_244_68# VPW nfet_05v0 ad=0.2132p pd=1.34u as=0.1722p ps=1.24u w=0.82u l=0.6u
M17 VDD A2 ZN VNW pfet_05v0 ad=0.30535p pd=1.605u as=0.2561p ps=1.505u w=0.985u l=0.5u
M18 VSS A3 a_1100_68# VPW nfet_05v0 ad=0.2132p pd=1.34u as=0.1722p ps=1.24u w=0.82u l=0.6u
M19 a_36_68# A1 ZN VPW nfet_05v0 ad=0.3608p pd=2.52u as=0.4161p ps=1.905u w=0.82u l=0.6u
M20 ZN A2 VDD VNW pfet_05v0 ad=0.2561p pd=1.505u as=0.4334p ps=2.85u w=0.985u l=0.5u
M21 a_672_68# A3 VSS VPW nfet_05v0 ad=0.1722p pd=1.24u as=0.2132p ps=1.34u w=0.82u l=0.6u
M22 VDD A3 ZN VNW pfet_05v0 ad=0.30535p pd=1.605u as=0.2561p ps=1.505u w=0.985u l=0.5u
M23 ZN A1 VDD VNW pfet_05v0 ad=0.52205p pd=2.045u as=0.30535p ps=1.605u w=0.985u l=0.5u
.ends

.subckt gf180mcu_fd_sc_mcu7t5v0__oai22_1 A2 B1 B2 VDD VSS ZN A1 VNW VPW
M0 ZN A1 a_36_68# VPW nfet_05v0 ad=0.2132p pd=1.34u as=0.2132p ps=1.34u w=0.82u l=0.6u
M1 VSS B2 a_36_68# VPW nfet_05v0 ad=0.2132p pd=1.34u as=0.3608p ps=2.52u w=0.82u l=0.6u
M2 a_244_472# B2 VDD VNW pfet_05v0 ad=0.3782p pd=1.84u as=0.6588p ps=3.52u w=1.22u l=0.5u
M3 a_692_472# A1 ZN VNW pfet_05v0 ad=0.3172p pd=1.74u as=0.3782p ps=1.84u w=1.22u l=0.5u
M4 VDD A2 a_692_472# VNW pfet_05v0 ad=0.5368p pd=3.32u as=0.3172p ps=1.74u w=1.22u l=0.5u
M5 a_36_68# A2 ZN VPW nfet_05v0 ad=0.3608p pd=2.52u as=0.2132p ps=1.34u w=0.82u l=0.6u
M6 a_36_68# B1 VSS VPW nfet_05v0 ad=0.2132p pd=1.34u as=0.2132p ps=1.34u w=0.82u l=0.6u
M7 ZN B1 a_244_472# VNW pfet_05v0 ad=0.3782p pd=1.84u as=0.3782p ps=1.84u w=1.22u l=0.5u
.ends

.subckt gf180mcu_fd_sc_mcu7t5v0__aoi22_1 B1 B2 VDD VSS ZN A1 A2 VNW VPW
M0 ZN B1 a_257_69# VPW nfet_05v0 ad=0.2119p pd=1.335u as=0.1304p ps=1.135u w=0.815u l=0.6u
M1 VDD B2 a_49_472# VNW pfet_05v0 ad=0.3159p pd=1.735u as=0.5346p ps=3.31u w=1.215u l=0.5u
M2 a_49_472# B1 VDD VNW pfet_05v0 ad=0.3159p pd=1.735u as=0.3159p ps=1.735u w=1.215u l=0.5u
M3 ZN A1 a_49_472# VNW pfet_05v0 ad=0.3159p pd=1.735u as=0.3159p ps=1.735u w=1.215u l=0.5u
M4 a_49_472# A2 ZN VNW pfet_05v0 ad=0.5346p pd=3.31u as=0.3159p ps=1.735u w=1.215u l=0.5u
M5 a_257_69# B2 VSS VPW nfet_05v0 ad=0.1304p pd=1.135u as=0.3586p ps=2.51u w=0.815u l=0.6u
M6 a_665_69# A1 ZN VPW nfet_05v0 ad=0.1304p pd=1.135u as=0.2119p ps=1.335u w=0.815u l=0.6u
M7 VSS A2 a_665_69# VPW nfet_05v0 ad=0.3586p pd=2.51u as=0.1304p ps=1.135u w=0.815u l=0.6u
.ends

.subckt gf180mcu_fd_sc_mcu7t5v0__tieh Z VDD VSS VNW VPW
M0 Z a_125_24# VDD VNW pfet_05v0 ad=0.5368p pd=3.32u as=0.5368p ps=3.32u w=1.22u l=0.5u
M1 a_125_24# a_125_24# VSS VPW nfet_05v0 ad=0.3608p pd=2.52u as=0.3608p ps=2.52u w=0.82u l=0.6u
.ends

.subckt gf180mcu_fd_sc_mcu7t5v0__dffq_2 D VDD VSS CLK Q VNW VPW
M0 VSS a_2304_115# Q VPW nfet_05v0 ad=0.3608p pd=2.52u as=0.2132p ps=1.34u w=0.82u l=0.6u
M1 VSS CLK a_36_151# VPW nfet_05v0 ad=0.1053p pd=0.925u as=0.1782p ps=1.69u w=0.405u l=0.6u
M2 Q a_2304_115# VSS VPW nfet_05v0 ad=0.2132p pd=1.34u as=0.3608p ps=2.52u w=0.82u l=0.6u
M3 a_2304_115# a_2011_527# VSS VPW nfet_05v0 ad=0.176p pd=1.68u as=0.142p ps=1.14u w=0.4u l=0.6u
M4 a_1004_159# D a_836_159# VPW nfet_05v0 ad=0.207p pd=1.51u as=43.199997f ps=0.6u w=0.36u l=0.6u
M5 a_1004_159# D a_880_527# VNW pfet_05v0 ad=0.1872p pd=1.4u as=53.999996f ps=0.66u w=0.36u l=0.5u
M6 a_2011_527# a_36_151# a_1376_115# VNW pfet_05v0 ad=0.1665p pd=1.285u as=0.1791p ps=1.355u w=0.36u l=0.5u
M7 a_2296_527# a_448_472# a_2011_527# VNW pfet_05v0 ad=50.399998f pd=0.64u as=0.1665p ps=1.285u w=0.36u l=0.5u
M8 a_1376_115# a_1004_159# VDD VNW pfet_05v0 ad=0.1791p pd=1.355u as=0.1044p ps=0.94u w=0.36u l=0.5u
M9 VDD CLK a_36_151# VNW pfet_05v0 ad=0.2249p pd=1.385u as=0.3806p ps=2.61u w=0.865u l=0.5u
M10 VDD a_2304_115# Q VNW pfet_05v0 ad=0.854p pd=3.84u as=0.3172p ps=1.74u w=1.22u l=0.5u
M11 VSS a_1376_115# a_1328_159# VPW nfet_05v0 ad=0.2637p pd=1.825u as=43.199997f ps=0.6u w=0.36u l=0.6u
M12 a_2011_527# a_448_472# a_1376_115# VPW nfet_05v0 ad=93.59999f pd=0.88u as=93.59999f ps=0.88u w=0.36u l=0.6u
M13 a_448_472# a_36_151# VDD VNW pfet_05v0 ad=0.3806p pd=2.61u as=0.2249p ps=1.385u w=0.865u l=0.5u
M14 Q a_2304_115# VDD VNW pfet_05v0 ad=0.3172p pd=1.74u as=0.5368p ps=3.32u w=1.22u l=0.5u
M15 a_1376_115# a_1004_159# VSS VPW nfet_05v0 ad=93.59999f pd=0.88u as=0.2637p ps=1.825u w=0.36u l=0.6u
M16 VSS a_2304_115# a_2256_159# VPW nfet_05v0 ad=0.142p pd=1.14u as=43.199997f ps=0.6u w=0.36u l=0.6u
M17 a_836_159# a_36_151# VSS VPW nfet_05v0 ad=43.199997f pd=0.6u as=0.1584p ps=1.6u w=0.36u l=0.6u
M18 a_448_472# a_36_151# VSS VPW nfet_05v0 ad=0.1782p pd=1.69u as=0.1053p ps=0.925u w=0.405u l=0.6u
M19 a_2256_159# a_36_151# a_2011_527# VPW nfet_05v0 ad=43.199997f pd=0.6u as=93.59999f ps=0.88u w=0.36u l=0.6u
M20 a_880_527# a_448_472# VDD VNW pfet_05v0 ad=53.999996f pd=0.66u as=0.4554p ps=3.25u w=0.36u l=0.5u
M21 a_1348_527# a_36_151# a_1004_159# VNW pfet_05v0 ad=43.199997f pd=0.6u as=0.1872p ps=1.4u w=0.36u l=0.5u
M22 a_1328_159# a_448_472# a_1004_159# VPW nfet_05v0 ad=43.199997f pd=0.6u as=0.207p ps=1.51u w=0.36u l=0.6u
M23 VDD a_1376_115# a_1348_527# VNW pfet_05v0 ad=0.1044p pd=0.94u as=43.199997f ps=0.6u w=0.36u l=0.5u
M24 VDD a_2304_115# a_2296_527# VNW pfet_05v0 ad=0.23p pd=1.54u as=50.399998f ps=0.64u w=0.36u l=0.5u
M25 a_2304_115# a_2011_527# VDD VNW pfet_05v0 ad=0.352p pd=2.48u as=0.23p ps=1.54u w=0.8u l=0.5u
.ends

.subckt gf180mcu_fd_sc_mcu7t5v0__inv_20 VSS ZN I VDD VNW VPW
M0 ZN I VDD VNW pfet_05v0 ad=0.3782p pd=1.84u as=0.3782p ps=1.84u w=1.22u l=0.5u
M1 VDD I ZN VNW pfet_05v0 ad=0.3782p pd=1.84u as=0.3782p ps=1.84u w=1.22u l=0.5u
M2 ZN I VDD VNW pfet_05v0 ad=0.3782p pd=1.84u as=0.3782p ps=1.84u w=1.22u l=0.5u
M3 ZN I VSS VPW nfet_05v0 ad=0.2132p pd=1.34u as=0.2132p ps=1.34u w=0.82u l=0.6u
M4 ZN I VSS VPW nfet_05v0 ad=0.2132p pd=1.34u as=0.2132p ps=1.34u w=0.82u l=0.6u
M5 VSS I ZN VPW nfet_05v0 ad=0.2132p pd=1.34u as=0.2132p ps=1.34u w=0.82u l=0.6u
M6 VSS I ZN VPW nfet_05v0 ad=0.2132p pd=1.34u as=0.2132p ps=1.34u w=0.82u l=0.6u
M7 VDD I ZN VNW pfet_05v0 ad=0.3782p pd=1.84u as=0.3782p ps=1.84u w=1.22u l=0.5u
M8 ZN I VDD VNW pfet_05v0 ad=0.3782p pd=1.84u as=0.3782p ps=1.84u w=1.22u l=0.5u
M9 ZN I VSS VPW nfet_05v0 ad=0.2132p pd=1.34u as=0.3608p ps=2.52u w=0.82u l=0.6u
M10 ZN I VSS VPW nfet_05v0 ad=0.2132p pd=1.34u as=0.2132p ps=1.34u w=0.82u l=0.6u
M11 VSS I ZN VPW nfet_05v0 ad=0.2132p pd=1.34u as=0.2132p ps=1.34u w=0.82u l=0.6u
M12 VSS I ZN VPW nfet_05v0 ad=0.2132p pd=1.34u as=0.2132p ps=1.34u w=0.82u l=0.6u
M13 VDD I ZN VNW pfet_05v0 ad=0.3782p pd=1.84u as=0.3782p ps=1.84u w=1.22u l=0.5u
M14 ZN I VSS VPW nfet_05v0 ad=0.2132p pd=1.34u as=0.2132p ps=1.34u w=0.82u l=0.6u
M15 ZN I VSS VPW nfet_05v0 ad=0.2132p pd=1.34u as=0.2132p ps=1.34u w=0.82u l=0.6u
M16 VSS I ZN VPW nfet_05v0 ad=0.3608p pd=2.52u as=0.2132p ps=1.34u w=0.82u l=0.6u
M17 VDD I ZN VNW pfet_05v0 ad=0.5368p pd=3.32u as=0.3782p ps=1.84u w=1.22u l=0.5u
M18 ZN I VDD VNW pfet_05v0 ad=0.3782p pd=1.84u as=0.3782p ps=1.84u w=1.22u l=0.5u
M19 ZN I VSS VPW nfet_05v0 ad=0.2132p pd=1.34u as=0.2132p ps=1.34u w=0.82u l=0.6u
M20 VDD I ZN VNW pfet_05v0 ad=0.3782p pd=1.84u as=0.3782p ps=1.84u w=1.22u l=0.5u
M21 VDD I ZN VNW pfet_05v0 ad=0.3782p pd=1.84u as=0.3782p ps=1.84u w=1.22u l=0.5u
M22 VDD I ZN VNW pfet_05v0 ad=0.3782p pd=1.84u as=0.3782p ps=1.84u w=1.22u l=0.5u
M23 ZN I VDD VNW pfet_05v0 ad=0.3782p pd=1.84u as=0.3782p ps=1.84u w=1.22u l=0.5u
M24 ZN I VSS VPW nfet_05v0 ad=0.2132p pd=1.34u as=0.2132p ps=1.34u w=0.82u l=0.6u
M25 ZN I VDD VNW pfet_05v0 ad=0.3782p pd=1.84u as=0.3782p ps=1.84u w=1.22u l=0.5u
M26 VSS I ZN VPW nfet_05v0 ad=0.2132p pd=1.34u as=0.2132p ps=1.34u w=0.82u l=0.6u
M27 VDD I ZN VNW pfet_05v0 ad=0.3782p pd=1.84u as=0.3782p ps=1.84u w=1.22u l=0.5u
M28 VSS I ZN VPW nfet_05v0 ad=0.2132p pd=1.34u as=0.2132p ps=1.34u w=0.82u l=0.6u
M29 VDD I ZN VNW pfet_05v0 ad=0.3782p pd=1.84u as=0.3782p ps=1.84u w=1.22u l=0.5u
M30 VSS I ZN VPW nfet_05v0 ad=0.2132p pd=1.34u as=0.2132p ps=1.34u w=0.82u l=0.6u
M31 ZN I VDD VNW pfet_05v0 ad=0.3782p pd=1.84u as=0.3782p ps=1.84u w=1.22u l=0.5u
M32 ZN I VDD VNW pfet_05v0 ad=0.3782p pd=1.84u as=0.3782p ps=1.84u w=1.22u l=0.5u
M33 VSS I ZN VPW nfet_05v0 ad=0.2132p pd=1.34u as=0.2132p ps=1.34u w=0.82u l=0.6u
M34 ZN I VDD VNW pfet_05v0 ad=0.3782p pd=1.84u as=0.5368p ps=3.32u w=1.22u l=0.5u
M35 VDD I ZN VNW pfet_05v0 ad=0.3782p pd=1.84u as=0.3782p ps=1.84u w=1.22u l=0.5u
M36 VSS I ZN VPW nfet_05v0 ad=0.2132p pd=1.34u as=0.2132p ps=1.34u w=0.82u l=0.6u
M37 ZN I VSS VPW nfet_05v0 ad=0.2132p pd=1.34u as=0.2132p ps=1.34u w=0.82u l=0.6u
M38 ZN I VDD VNW pfet_05v0 ad=0.3782p pd=1.84u as=0.3782p ps=1.84u w=1.22u l=0.5u
M39 ZN I VSS VPW nfet_05v0 ad=0.2132p pd=1.34u as=0.2132p ps=1.34u w=0.82u l=0.6u
.ends

.subckt gf180mcu_fd_sc_mcu7t5v0__nor2_4 VDD VSS ZN A1 A2 VNW VPW
M0 a_1140_472# A2 VDD VNW pfet_05v0 ad=0.3172p pd=1.74u as=0.4392p ps=1.94u w=1.22u l=0.5u
M1 ZN A1 VSS VPW nfet_05v0 ad=0.1469p pd=1.085u as=0.1469p ps=1.085u w=0.565u l=0.6u
M2 ZN A1 a_1140_472# VNW pfet_05v0 ad=0.4392p pd=1.94u as=0.3172p ps=1.74u w=1.22u l=0.5u
M3 ZN A2 VSS VPW nfet_05v0 ad=0.1469p pd=1.085u as=0.2486p ps=2.01u w=0.565u l=0.6u
M4 a_1588_472# A1 ZN VNW pfet_05v0 ad=0.3172p pd=1.74u as=0.4392p ps=1.94u w=1.22u l=0.5u
M5 VDD A2 a_1588_472# VNW pfet_05v0 ad=0.5978p pd=3.42u as=0.3172p ps=1.74u w=1.22u l=0.5u
M6 ZN A1 VSS VPW nfet_05v0 ad=0.1469p pd=1.085u as=0.1469p ps=1.085u w=0.565u l=0.6u
M7 a_244_472# A2 VDD VNW pfet_05v0 ad=0.3172p pd=1.74u as=0.5978p ps=3.42u w=1.22u l=0.5u
M8 ZN A1 a_244_472# VNW pfet_05v0 ad=0.4392p pd=1.94u as=0.3172p ps=1.74u w=1.22u l=0.5u
M9 a_692_472# A1 ZN VNW pfet_05v0 ad=0.3172p pd=1.74u as=0.4392p ps=1.94u w=1.22u l=0.5u
M10 VSS A2 ZN VPW nfet_05v0 ad=0.2486p pd=2.01u as=0.1469p ps=1.085u w=0.565u l=0.6u
M11 VDD A2 a_692_472# VNW pfet_05v0 ad=0.4392p pd=1.94u as=0.3172p ps=1.74u w=1.22u l=0.5u
M12 VSS A1 ZN VPW nfet_05v0 ad=0.1469p pd=1.085u as=0.1469p ps=1.085u w=0.565u l=0.6u
M13 VSS A2 ZN VPW nfet_05v0 ad=0.1469p pd=1.085u as=0.1469p ps=1.085u w=0.565u l=0.6u
M14 VSS A1 ZN VPW nfet_05v0 ad=0.1469p pd=1.085u as=0.1469p ps=1.085u w=0.565u l=0.6u
M15 ZN A2 VSS VPW nfet_05v0 ad=0.1469p pd=1.085u as=0.1469p ps=1.085u w=0.565u l=0.6u
.ends

.subckt gf180mcu_fd_sc_mcu7t5v0__inv_1 VSS ZN I VDD VNW VPW
M0 ZN I VSS VPW nfet_05v0 ad=0.3608p pd=2.52u as=0.3608p ps=2.52u w=0.82u l=0.6u
M1 ZN I VDD VNW pfet_05v0 ad=0.5368p pd=3.32u as=0.5368p ps=3.32u w=1.22u l=0.5u
.ends

.subckt gf180mcu_fd_sc_mcu7t5v0__buf_12 Z I VDD VSS VNW VPW
M0 a_224_472# I VDD VNW pfet_05v0 ad=0.3782p pd=1.84u as=0.3782p ps=1.84u w=1.22u l=0.5u
M1 VDD a_224_472# Z VNW pfet_05v0 ad=0.3782p pd=1.84u as=0.3782p ps=1.84u w=1.22u l=0.5u
M2 Z a_224_472# VDD VNW pfet_05v0 ad=0.3782p pd=1.84u as=0.3782p ps=1.84u w=1.22u l=0.5u
M3 a_224_472# I VSS VPW nfet_05v0 ad=0.2132p pd=1.34u as=0.2132p ps=1.34u w=0.82u l=0.6u
M4 VSS a_224_472# Z VPW nfet_05v0 ad=0.2132p pd=1.34u as=0.2132p ps=1.34u w=0.82u l=0.6u
M5 VSS a_224_472# Z VPW nfet_05v0 ad=0.3608p pd=2.52u as=0.2132p ps=1.34u w=0.82u l=0.6u
M6 VDD I a_224_472# VNW pfet_05v0 ad=0.3782p pd=1.84u as=0.3782p ps=1.84u w=1.22u l=0.5u
M7 Z a_224_472# VDD VNW pfet_05v0 ad=0.3782p pd=1.84u as=0.3782p ps=1.84u w=1.22u l=0.5u
M8 a_224_472# I VSS VPW nfet_05v0 ad=0.2132p pd=1.34u as=0.3608p ps=2.52u w=0.82u l=0.6u
M9 Z a_224_472# VSS VPW nfet_05v0 ad=0.2132p pd=1.34u as=0.2132p ps=1.34u w=0.82u l=0.6u
M10 VSS a_224_472# Z VPW nfet_05v0 ad=0.2132p pd=1.34u as=0.2132p ps=1.34u w=0.82u l=0.6u
M11 VSS a_224_472# Z VPW nfet_05v0 ad=0.2132p pd=1.34u as=0.2132p ps=1.34u w=0.82u l=0.6u
M12 VDD a_224_472# Z VNW pfet_05v0 ad=0.3782p pd=1.84u as=0.3782p ps=1.84u w=1.22u l=0.5u
M13 Z a_224_472# VSS VPW nfet_05v0 ad=0.2132p pd=1.34u as=0.2132p ps=1.34u w=0.82u l=0.6u
M14 Z a_224_472# VSS VPW nfet_05v0 ad=0.2132p pd=1.34u as=0.2132p ps=1.34u w=0.82u l=0.6u
M15 Z a_224_472# VDD VNW pfet_05v0 ad=0.3782p pd=1.84u as=0.3782p ps=1.84u w=1.22u l=0.5u
M16 Z a_224_472# VSS VPW nfet_05v0 ad=0.2132p pd=1.34u as=0.2132p ps=1.34u w=0.82u l=0.6u
M17 VDD I a_224_472# VNW pfet_05v0 ad=0.3782p pd=1.84u as=0.3782p ps=1.84u w=1.22u l=0.5u
M18 VDD a_224_472# Z VNW pfet_05v0 ad=0.5368p pd=3.32u as=0.3782p ps=1.84u w=1.22u l=0.5u
M19 VDD a_224_472# Z VNW pfet_05v0 ad=0.3782p pd=1.84u as=0.3782p ps=1.84u w=1.22u l=0.5u
M20 Z a_224_472# VDD VNW pfet_05v0 ad=0.3782p pd=1.84u as=0.3782p ps=1.84u w=1.22u l=0.5u
M21 Z a_224_472# VSS VPW nfet_05v0 ad=0.2132p pd=1.34u as=0.2132p ps=1.34u w=0.82u l=0.6u
M22 a_224_472# I VDD VNW pfet_05v0 ad=0.3782p pd=1.84u as=0.3782p ps=1.84u w=1.22u l=0.5u
M23 VSS a_224_472# Z VPW nfet_05v0 ad=0.2132p pd=1.34u as=0.2132p ps=1.34u w=0.82u l=0.6u
M24 VDD I a_224_472# VNW pfet_05v0 ad=0.3782p pd=1.84u as=0.3782p ps=1.84u w=1.22u l=0.5u
M25 VSS I a_224_472# VPW nfet_05v0 ad=0.2132p pd=1.34u as=0.2132p ps=1.34u w=0.82u l=0.6u
M26 VDD a_224_472# Z VNW pfet_05v0 ad=0.3782p pd=1.84u as=0.3782p ps=1.84u w=1.22u l=0.5u
M27 VSS a_224_472# Z VPW nfet_05v0 ad=0.2132p pd=1.34u as=0.2132p ps=1.34u w=0.82u l=0.6u
M28 Z a_224_472# VDD VNW pfet_05v0 ad=0.3782p pd=1.84u as=0.3782p ps=1.84u w=1.22u l=0.5u
M29 VSS I a_224_472# VPW nfet_05v0 ad=0.2132p pd=1.34u as=0.2132p ps=1.34u w=0.82u l=0.6u
M30 a_224_472# I VDD VNW pfet_05v0 ad=0.3782p pd=1.84u as=0.5368p ps=3.32u w=1.22u l=0.5u
M31 VDD a_224_472# Z VNW pfet_05v0 ad=0.3782p pd=1.84u as=0.3782p ps=1.84u w=1.22u l=0.5u
M32 VSS I a_224_472# VPW nfet_05v0 ad=0.2132p pd=1.34u as=0.2132p ps=1.34u w=0.82u l=0.6u
M33 Z a_224_472# VSS VPW nfet_05v0 ad=0.2132p pd=1.34u as=0.2132p ps=1.34u w=0.82u l=0.6u
M34 Z a_224_472# VDD VNW pfet_05v0 ad=0.3782p pd=1.84u as=0.3782p ps=1.84u w=1.22u l=0.5u
M35 a_224_472# I VSS VPW nfet_05v0 ad=0.2132p pd=1.34u as=0.2132p ps=1.34u w=0.82u l=0.6u
.ends

.subckt gf180mcu_fd_sc_mcu7t5v0__nor4_1 A3 A4 VDD VSS ZN A1 A2 VNW VPW
M0 a_672_472# A2 a_448_472# VNW pfet_05v0 ad=0.3782p pd=1.84u as=0.3782p ps=1.84u w=1.22u l=0.5u
M1 VSS A1 ZN VPW nfet_05v0 ad=0.1584p pd=1.6u as=93.59999f ps=0.88u w=0.36u l=0.6u
M2 VSS A3 ZN VPW nfet_05v0 ad=93.59999f pd=0.88u as=93.59999f ps=0.88u w=0.36u l=0.6u
M3 a_244_472# A4 VDD VNW pfet_05v0 ad=0.3172p pd=1.74u as=0.5368p ps=3.32u w=1.22u l=0.5u
M4 a_448_472# A3 a_244_472# VNW pfet_05v0 ad=0.3782p pd=1.84u as=0.3172p ps=1.74u w=1.22u l=0.5u
M5 ZN A2 VSS VPW nfet_05v0 ad=93.59999f pd=0.88u as=93.59999f ps=0.88u w=0.36u l=0.6u
M6 ZN A4 VSS VPW nfet_05v0 ad=93.59999f pd=0.88u as=0.1584p ps=1.6u w=0.36u l=0.6u
M7 ZN A1 a_672_472# VNW pfet_05v0 ad=0.5368p pd=3.32u as=0.3782p ps=1.84u w=1.22u l=0.5u
.ends

.subckt gf180mcu_fd_sc_mcu7t5v0__clkinv_2 VDD VSS I ZN VNW VPW
M0 ZN I VSS VPW nfet_05v0 ad=0.1248p pd=1u as=0.2112p ps=1.84u w=0.48u l=0.6u
M1 VDD I ZN VNW pfet_05v0 ad=0.5368p pd=3.32u as=0.3782p ps=1.84u w=1.22u l=0.5u
M2 ZN I VDD VNW pfet_05v0 ad=0.3782p pd=1.84u as=0.5368p ps=3.32u w=1.22u l=0.5u
M3 VSS I ZN VPW nfet_05v0 ad=0.2112p pd=1.84u as=0.1248p ps=1u w=0.48u l=0.6u
.ends

.subckt gf180mcu_fd_sc_mcu7t5v0__and2_4 A2 VDD VSS Z A1 VNW VPW
M0 Z a_224_490# VSS VPW nfet_05v0 ad=0.2015p pd=1.295u as=0.2015p ps=1.295u w=0.775u l=0.6u
M1 VSS a_224_490# Z VPW nfet_05v0 ad=0.341p pd=2.43u as=0.2015p ps=1.295u w=0.775u l=0.6u
M2 a_224_490# A1 a_244_69# VPW nfet_05v0 ad=0.21505p pd=1.33u as=0.124p ps=1.095u w=0.775u l=0.6u
M3 a_659_69# A1 a_224_490# VPW nfet_05v0 ad=0.110425p pd=1.06u as=0.21505p ps=1.33u w=0.775u l=0.6u
M4 a_244_69# A2 VSS VPW nfet_05v0 ad=0.124p pd=1.095u as=0.341p ps=2.43u w=0.775u l=0.6u
M5 a_224_490# A2 VDD VNW pfet_05v0 ad=0.2925p pd=1.645u as=0.495p ps=3.13u w=1.125u l=0.5u
M6 Z a_224_490# VDD VNW pfet_05v0 ad=0.3159p pd=1.735u as=0.41175p ps=1.915u w=1.215u l=0.5u
M7 VSS a_224_490# Z VPW nfet_05v0 ad=0.2015p pd=1.295u as=0.2015p ps=1.295u w=0.775u l=0.6u
M8 VDD A1 a_224_490# VNW pfet_05v0 ad=0.2925p pd=1.645u as=0.2925p ps=1.645u w=1.125u l=0.5u
M9 VDD a_224_490# Z VNW pfet_05v0 ad=0.3159p pd=1.735u as=0.3159p ps=1.735u w=1.215u l=0.5u
M10 VSS A2 a_659_69# VPW nfet_05v0 ad=0.2015p pd=1.295u as=0.110425p ps=1.06u w=0.775u l=0.6u
M11 a_224_490# A1 VDD VNW pfet_05v0 ad=0.2925p pd=1.645u as=0.2925p ps=1.645u w=1.125u l=0.5u
M12 Z a_224_490# VDD VNW pfet_05v0 ad=0.3159p pd=1.735u as=0.3159p ps=1.735u w=1.215u l=0.5u
M13 VDD A2 a_224_490# VNW pfet_05v0 ad=0.41175p pd=1.915u as=0.2925p ps=1.645u w=1.125u l=0.5u
M14 VDD a_224_490# Z VNW pfet_05v0 ad=0.5346p pd=3.31u as=0.3159p ps=1.735u w=1.215u l=0.5u
M15 Z a_224_490# VSS VPW nfet_05v0 ad=0.2015p pd=1.295u as=0.2015p ps=1.295u w=0.775u l=0.6u
.ends

.subckt gf180mcu_fd_sc_mcu7t5v0__nand4_1 A3 A4 VDD VSS ZN A1 A2 VNW VPW
M0 ZN A4 VDD VNW pfet_05v0 ad=0.2197p pd=1.365u as=0.3718p ps=2.57u w=0.845u l=0.5u
M1 VDD A3 ZN VNW pfet_05v0 ad=0.2197p pd=1.365u as=0.2197p ps=1.365u w=0.845u l=0.5u
M2 ZN A2 VDD VNW pfet_05v0 ad=0.2197p pd=1.365u as=0.2197p ps=1.365u w=0.845u l=0.5u
M3 VDD A1 ZN VNW pfet_05v0 ad=0.3718p pd=2.57u as=0.2197p ps=1.365u w=0.845u l=0.5u
M4 a_275_68# A4 VSS VPW nfet_05v0 ad=0.1517p pd=1.19u as=0.3608p ps=2.52u w=0.82u l=0.6u
M5 a_673_68# A2 a_469_68# VPW nfet_05v0 ad=0.1517p pd=1.19u as=0.1722p ps=1.24u w=0.82u l=0.6u
M6 a_469_68# A3 a_275_68# VPW nfet_05v0 ad=0.1722p pd=1.24u as=0.1517p ps=1.19u w=0.82u l=0.6u
M7 ZN A1 a_673_68# VPW nfet_05v0 ad=0.3608p pd=2.52u as=0.1517p ps=1.19u w=0.82u l=0.6u
.ends

.subckt gf180mcu_fd_sc_mcu7t5v0__aoi221_4 A2 B1 B2 C VDD VSS ZN A1 VNW VPW
M0 VSS B2 a_1070_69# VPW nfet_05v0 ad=0.2002p pd=1.29u as=0.1232p ps=1.09u w=0.77u l=0.6u
M1 VDD B2 a_234_508# VNW pfet_05v0 ad=0.2691p pd=1.555u as=0.2691p ps=1.555u w=1.035u l=0.5u
M2 VSS A2 a_3728_69# VPW nfet_05v0 ad=0.2002p pd=1.29u as=0.1232p ps=1.09u w=0.77u l=0.6u
M3 a_234_508# C a_1822_472# VNW pfet_05v0 ad=0.346275p pd=1.785u as=0.3159p ps=1.735u w=1.215u l=0.5u
M4 a_1822_472# A1 ZN VNW pfet_05v0 ad=0.3159p pd=1.735u as=0.3159p ps=1.735u w=1.215u l=0.5u
M5 a_234_508# C a_1822_472# VNW pfet_05v0 ad=0.3159p pd=1.735u as=0.5346p ps=3.31u w=1.215u l=0.5u
M6 ZN A2 a_1822_472# VNW pfet_05v0 ad=0.3159p pd=1.735u as=0.3159p ps=1.735u w=1.215u l=0.5u
M7 a_1070_69# B1 ZN VPW nfet_05v0 ad=0.1232p pd=1.09u as=0.2002p ps=1.29u w=0.77u l=0.6u
M8 a_234_508# B2 VDD VNW pfet_05v0 ad=0.2691p pd=1.555u as=0.2691p ps=1.555u w=1.035u l=0.5u
M9 ZN A1 a_1822_472# VNW pfet_05v0 ad=0.3159p pd=1.735u as=0.3159p ps=1.735u w=1.215u l=0.5u
M10 a_1822_472# A1 ZN VNW pfet_05v0 ad=0.5346p pd=3.31u as=0.3159p ps=1.735u w=1.215u l=0.5u
M11 VDD B1 a_234_508# VNW pfet_05v0 ad=0.4554p pd=2.95u as=0.2691p ps=1.555u w=1.035u l=0.5u
M12 a_1822_472# A2 ZN VNW pfet_05v0 ad=0.3159p pd=1.735u as=0.3159p ps=1.735u w=1.215u l=0.5u
M13 a_2912_69# A1 ZN VPW nfet_05v0 ad=0.1232p pd=1.09u as=0.226p ps=1.47u w=0.77u l=0.6u
M14 VSS A2 a_2912_69# VPW nfet_05v0 ad=0.2002p pd=1.29u as=0.1232p ps=1.09u w=0.77u l=0.6u
M15 a_234_508# B1 VDD VNW pfet_05v0 ad=0.2691p pd=1.555u as=0.4554p ps=2.95u w=1.035u l=0.5u
M16 a_3728_69# A1 ZN VPW nfet_05v0 ad=0.1232p pd=1.09u as=0.2002p ps=1.29u w=0.77u l=0.6u
M17 ZN A1 a_4136_69# VPW nfet_05v0 ad=0.3388p pd=2.42u as=0.1232p ps=1.09u w=0.77u l=0.6u
M18 a_244_69# B1 ZN VPW nfet_05v0 ad=0.14245p pd=1.14u as=0.3388p ps=2.42u w=0.77u l=0.6u
M19 VSS C ZN VPW nfet_05v0 ad=0.1248p pd=1u as=0.1248p ps=1u w=0.48u l=0.6u
M20 VDD B2 a_234_508# VNW pfet_05v0 ad=0.2691p pd=1.555u as=0.2691p ps=1.555u w=1.035u l=0.5u
M21 ZN B1 a_1478_69# VPW nfet_05v0 ad=0.29915p pd=1.66u as=0.1617p ps=1.19u w=0.77u l=0.6u
M22 a_234_508# B2 VDD VNW pfet_05v0 ad=0.2691p pd=1.555u as=0.2691p ps=1.555u w=1.035u l=0.5u
M23 VSS B2 a_244_69# VPW nfet_05v0 ad=0.2002p pd=1.29u as=0.14245p ps=1.14u w=0.77u l=0.6u
M24 a_1478_69# B2 VSS VPW nfet_05v0 ad=0.1617p pd=1.19u as=0.2002p ps=1.29u w=0.77u l=0.6u
M25 VDD B1 a_234_508# VNW pfet_05v0 ad=0.2691p pd=1.555u as=0.2691p ps=1.555u w=1.035u l=0.5u
M26 ZN A1 a_1822_472# VNW pfet_05v0 ad=0.3159p pd=1.735u as=0.486p ps=2.015u w=1.215u l=0.5u
M27 ZN C VSS VPW nfet_05v0 ad=0.226p pd=1.47u as=0.1248p ps=1u w=0.48u l=0.6u
M28 a_3320_69# A2 VSS VPW nfet_05v0 ad=0.1232p pd=1.09u as=0.2002p ps=1.29u w=0.77u l=0.6u
M29 ZN A1 a_3320_69# VPW nfet_05v0 ad=0.2002p pd=1.29u as=0.1232p ps=1.09u w=0.77u l=0.6u
M30 a_234_508# B1 VDD VNW pfet_05v0 ad=0.2691p pd=1.555u as=0.2691p ps=1.555u w=1.035u l=0.5u
M31 ZN C VSS VPW nfet_05v0 ad=0.1248p pd=1u as=0.1248p ps=1u w=0.48u l=0.6u
M32 a_1822_472# C a_234_508# VNW pfet_05v0 ad=0.486p pd=2.015u as=0.346275p ps=1.785u w=1.215u l=0.5u
M33 a_1822_472# A2 ZN VNW pfet_05v0 ad=0.3159p pd=1.735u as=0.3159p ps=1.735u w=1.215u l=0.5u
M34 ZN B1 a_662_69# VPW nfet_05v0 ad=0.2002p pd=1.29u as=0.1232p ps=1.09u w=0.77u l=0.6u
M35 a_662_69# B2 VSS VPW nfet_05v0 ad=0.1232p pd=1.09u as=0.2002p ps=1.29u w=0.77u l=0.6u
M36 VSS C ZN VPW nfet_05v0 ad=0.1248p pd=1u as=0.29915p ps=1.66u w=0.48u l=0.6u
M37 a_1822_472# C a_234_508# VNW pfet_05v0 ad=0.3159p pd=1.735u as=0.3159p ps=1.735u w=1.215u l=0.5u
M38 ZN A2 a_1822_472# VNW pfet_05v0 ad=0.3159p pd=1.735u as=0.3159p ps=1.735u w=1.215u l=0.5u
M39 a_4136_69# A2 VSS VPW nfet_05v0 ad=0.1232p pd=1.09u as=0.2002p ps=1.29u w=0.77u l=0.6u
.ends

.subckt gf180mcu_fd_sc_mcu7t5v0__and4_1 A3 A4 VDD VSS Z A1 A2 VNW VPW
M0 a_48_148# A1 VDD VNW pfet_05v0 ad=0.156p pd=1.12u as=0.264p ps=2.08u w=0.6u l=0.5u
M1 a_440_148# A2 a_256_148# VPW nfet_05v0 ad=88.2f pd=0.84u as=67.2f ps=0.74u w=0.42u l=0.6u
M2 Z a_48_148# VSS VPW nfet_05v0 ad=0.3586p pd=2.51u as=0.226p ps=1.515u w=0.815u l=0.6u
M3 VDD A2 a_48_148# VNW pfet_05v0 ad=0.156p pd=1.12u as=0.156p ps=1.12u w=0.6u l=0.5u
M4 Z a_48_148# VDD VNW pfet_05v0 ad=0.5368p pd=3.32u as=0.395p ps=2.02u w=1.22u l=0.5u
M5 a_644_148# A3 a_440_148# VPW nfet_05v0 ad=88.2f pd=0.84u as=88.2f ps=0.84u w=0.42u l=0.6u
M6 a_48_148# A3 VDD VNW pfet_05v0 ad=0.156p pd=1.12u as=0.156p ps=1.12u w=0.6u l=0.5u
M7 VSS A4 a_644_148# VPW nfet_05v0 ad=0.226p pd=1.515u as=88.2f ps=0.84u w=0.42u l=0.6u
M8 VDD A4 a_48_148# VNW pfet_05v0 ad=0.395p pd=2.02u as=0.156p ps=1.12u w=0.6u l=0.5u
M9 a_256_148# A1 a_48_148# VPW nfet_05v0 ad=67.2f pd=0.74u as=0.1848p ps=1.72u w=0.42u l=0.6u
.ends

.subckt gf180mcu_fd_sc_mcu7t5v0__xnor2_1 VDD VSS ZN A1 A2 VNW VPW
M0 ZN a_64_93# VDD VNW pfet_05v0 ad=0.312075p pd=1.665u as=0.344375p ps=1.895u w=1.095u l=0.5u
M1 a_272_93# A2 a_64_93# VPW nfet_05v0 ad=57.599995f pd=0.68u as=0.1584p ps=1.6u w=0.36u l=0.6u
M2 VSS A1 a_272_93# VPW nfet_05v0 ad=0.218p pd=1.52u as=57.599995f ps=0.68u w=0.36u l=0.6u
M3 a_716_68# a_64_93# VSS VPW nfet_05v0 ad=0.2132p pd=1.34u as=0.218p ps=1.52u w=0.82u l=0.6u
M4 VDD A2 a_930_497# VNW pfet_05v0 ad=0.4818p pd=3.07u as=0.552975p ps=2.105u w=1.095u l=0.5u
M5 ZN A1 a_716_68# VPW nfet_05v0 ad=0.4161p pd=1.905u as=0.2132p ps=1.34u w=0.82u l=0.6u
M6 a_64_93# A2 VDD VNW pfet_05v0 ad=0.1456p pd=1.08u as=0.2464p ps=2u w=0.56u l=0.5u
M7 a_716_68# A2 ZN VPW nfet_05v0 ad=0.3608p pd=2.52u as=0.4161p ps=1.905u w=0.82u l=0.6u
M8 VDD A1 a_64_93# VNW pfet_05v0 ad=0.344375p pd=1.895u as=0.1456p ps=1.08u w=0.56u l=0.5u
M9 a_930_497# A1 ZN VNW pfet_05v0 ad=0.552975p pd=2.105u as=0.312075p ps=1.665u w=1.095u l=0.5u
.ends

.subckt gf180mcu_fd_sc_mcu7t5v0__oai32_4 A3 B1 B2 VDD VSS ZN A1 A2 VNW VPW
M0 VDD B2 a_4401_497# VNW pfet_05v0 ad=0.49275p pd=3.09u as=0.4599p ps=1.935u w=1.095u l=0.5u
M1 ZN B2 a_77_68# VPW nfet_05v0 ad=0.2132p pd=1.34u as=0.43265p ps=1.985u w=0.82u l=0.6u
M2 VSS A1 a_77_68# VPW nfet_05v0 ad=0.2132p pd=1.34u as=0.2132p ps=1.34u w=0.82u l=0.6u
M3 a_77_68# B1 ZN VPW nfet_05v0 ad=0.2132p pd=1.34u as=0.2132p ps=1.34u w=0.82u l=0.6u
M4 ZN A1 a_87_497# VNW pfet_05v0 ad=0.2847p pd=1.615u as=0.3942p ps=1.815u w=1.095u l=0.5u
M5 ZN B2 a_77_68# VPW nfet_05v0 ad=0.2132p pd=1.34u as=0.2132p ps=1.34u w=0.82u l=0.6u
M6 VDD A3 a_1161_497# VNW pfet_05v0 ad=0.2847p pd=1.615u as=0.3942p ps=1.815u w=1.095u l=0.5u
M7 a_77_68# B2 ZN VPW nfet_05v0 ad=0.3608p pd=2.52u as=0.30965p ps=1.685u w=0.82u l=0.6u
M8 ZN B1 a_77_68# VPW nfet_05v0 ad=0.2132p pd=1.34u as=0.2132p ps=1.34u w=0.82u l=0.6u
M9 a_87_497# A1 ZN VNW pfet_05v0 ad=0.4818p pd=3.07u as=0.2847p ps=1.615u w=1.095u l=0.5u
M10 a_77_68# A2 VSS VPW nfet_05v0 ad=0.2132p pd=1.34u as=0.2132p ps=1.34u w=0.82u l=0.6u
M11 a_1609_497# A3 VDD VNW pfet_05v0 ad=0.3942p pd=1.815u as=0.2847p ps=1.615u w=1.095u l=0.5u
M12 ZN B1 a_3077_497# VNW pfet_05v0 ad=0.2847p pd=1.615u as=0.33945p ps=1.715u w=1.095u l=0.5u
M13 ZN B1 a_77_68# VPW nfet_05v0 ad=0.30965p pd=1.685u as=0.2132p ps=1.34u w=0.82u l=0.6u
M14 a_1853_497# A2 a_1609_497# VNW pfet_05v0 ad=0.33945p pd=1.715u as=0.3942p ps=1.815u w=1.095u l=0.5u
M15 a_77_68# A3 VSS VPW nfet_05v0 ad=0.2132p pd=1.34u as=0.2132p ps=1.34u w=0.82u l=0.6u
M16 a_3505_497# B1 ZN VNW pfet_05v0 ad=0.3942p pd=1.815u as=0.2847p ps=1.615u w=1.095u l=0.5u
M17 ZN B1 a_3953_497# VNW pfet_05v0 ad=0.2847p pd=1.615u as=0.3942p ps=1.815u w=1.095u l=0.5u
M18 a_77_68# A1 VSS VPW nfet_05v0 ad=0.2132p pd=1.34u as=0.2132p ps=1.34u w=0.82u l=0.6u
M19 VDD B2 a_3505_497# VNW pfet_05v0 ad=0.2847p pd=1.615u as=0.3942p ps=1.815u w=1.095u l=0.5u
M20 VDD A3 a_285_497# VNW pfet_05v0 ad=0.2847p pd=1.615u as=0.33945p ps=1.715u w=1.095u l=0.5u
M21 a_77_68# A2 VSS VPW nfet_05v0 ad=0.2132p pd=1.34u as=0.2132p ps=1.34u w=0.82u l=0.6u
M22 a_77_68# B1 ZN VPW nfet_05v0 ad=0.2132p pd=1.34u as=0.2132p ps=1.34u w=0.82u l=0.6u
M23 a_713_497# A3 VDD VNW pfet_05v0 ad=0.3942p pd=1.815u as=0.2847p ps=1.615u w=1.095u l=0.5u
M24 a_3953_497# B2 VDD VNW pfet_05v0 ad=0.3942p pd=1.815u as=0.2847p ps=1.615u w=1.095u l=0.5u
M25 a_77_68# A3 VSS VPW nfet_05v0 ad=0.2132p pd=1.34u as=0.2132p ps=1.34u w=0.82u l=0.6u
M26 a_285_497# A2 a_87_497# VNW pfet_05v0 ad=0.33945p pd=1.715u as=0.53655p ps=3.17u w=1.095u l=0.5u
M27 VSS A2 a_77_68# VPW nfet_05v0 ad=0.2132p pd=1.34u as=0.2132p ps=1.34u w=0.82u l=0.6u
M28 a_87_497# A2 a_713_497# VNW pfet_05v0 ad=0.2847p pd=1.615u as=0.3942p ps=1.815u w=1.095u l=0.5u
M29 a_3077_497# B2 VDD VNW pfet_05v0 ad=0.33945p pd=1.715u as=0.4818p ps=3.07u w=1.095u l=0.5u
M30 a_4401_497# B1 ZN VNW pfet_05v0 ad=0.4599p pd=1.935u as=0.2847p ps=1.615u w=1.095u l=0.5u
M31 a_87_497# A1 ZN VNW pfet_05v0 ad=0.3942p pd=1.815u as=0.2847p ps=1.615u w=1.095u l=0.5u
M32 VSS A3 a_77_68# VPW nfet_05v0 ad=0.2132p pd=1.34u as=0.2132p ps=1.34u w=0.82u l=0.6u
M33 a_1161_497# A2 a_87_497# VNW pfet_05v0 ad=0.3942p pd=1.815u as=0.2847p ps=1.615u w=1.095u l=0.5u
M34 a_77_68# A1 VSS VPW nfet_05v0 ad=0.43265p pd=1.985u as=0.2132p ps=1.34u w=0.82u l=0.6u
M35 a_77_68# B2 ZN VPW nfet_05v0 ad=0.2132p pd=1.34u as=0.2132p ps=1.34u w=0.82u l=0.6u
M36 VSS A2 a_77_68# VPW nfet_05v0 ad=0.2132p pd=1.34u as=0.3608p ps=2.52u w=0.82u l=0.6u
M37 ZN A1 a_1853_497# VNW pfet_05v0 ad=0.2847p pd=1.615u as=0.33945p ps=1.715u w=1.095u l=0.5u
M38 VSS A1 a_77_68# VPW nfet_05v0 ad=0.2132p pd=1.34u as=0.2132p ps=1.34u w=0.82u l=0.6u
M39 VSS A3 a_77_68# VPW nfet_05v0 ad=0.2132p pd=1.34u as=0.2132p ps=1.34u w=0.82u l=0.6u
.ends

.subckt gf180mcu_fd_sc_mcu7t5v0__oai221_1 B1 C VDD VSS ZN A1 A2 B2 VNW VPW
M0 a_692_68# C a_36_68# VPW nfet_05v0 ad=0.246p pd=1.42u as=0.2132p ps=1.34u w=0.82u l=0.6u
M1 a_932_472# A2 VDD VNW pfet_05v0 ad=0.3172p pd=1.74u as=0.38575p ps=1.92u w=1.22u l=0.5u
M2 VSS B2 a_36_68# VPW nfet_05v0 ad=0.2132p pd=1.34u as=0.3608p ps=2.52u w=0.82u l=0.6u
M3 ZN A2 a_692_68# VPW nfet_05v0 ad=0.2132p pd=1.34u as=0.246p ps=1.42u w=0.82u l=0.6u
M4 a_244_472# B2 VDD VNW pfet_05v0 ad=0.3172p pd=1.74u as=0.6588p ps=3.52u w=1.22u l=0.5u
M5 ZN A1 a_932_472# VNW pfet_05v0 ad=0.5368p pd=3.32u as=0.3172p ps=1.74u w=1.22u l=0.5u
M6 VDD C ZN VNW pfet_05v0 ad=0.38575p pd=1.92u as=0.3952p ps=1.94u w=0.945u l=0.5u
M7 ZN B1 a_244_472# VNW pfet_05v0 ad=0.3952p pd=1.94u as=0.3172p ps=1.74u w=1.22u l=0.5u
M8 a_36_68# B1 VSS VPW nfet_05v0 ad=0.2132p pd=1.34u as=0.2132p ps=1.34u w=0.82u l=0.6u
M9 a_692_68# A1 ZN VPW nfet_05v0 ad=0.3608p pd=2.52u as=0.2132p ps=1.34u w=0.82u l=0.6u
.ends

.subckt gf180mcu_fd_sc_mcu7t5v0__nor2_2 VDD VSS ZN A1 A2 VNW VPW
M0 a_672_472# A1 ZN VNW pfet_05v0 ad=0.4087p pd=1.89u as=0.3477p ps=1.79u w=1.22u l=0.5u
M1 ZN A1 VSS VPW nfet_05v0 ad=0.1469p pd=1.085u as=0.1469p ps=1.085u w=0.565u l=0.6u
M2 ZN A1 a_234_472# VNW pfet_05v0 ad=0.3477p pd=1.79u as=0.3782p ps=1.84u w=1.22u l=0.5u
M3 VSS A1 ZN VPW nfet_05v0 ad=0.1469p pd=1.085u as=0.1469p ps=1.085u w=0.565u l=0.6u
M4 a_234_472# A2 VDD VNW pfet_05v0 ad=0.3782p pd=1.84u as=0.5368p ps=3.32u w=1.22u l=0.5u
M5 VDD A2 a_672_472# VNW pfet_05v0 ad=0.5368p pd=3.32u as=0.4087p ps=1.89u w=1.22u l=0.5u
M6 VSS A2 ZN VPW nfet_05v0 ad=0.2486p pd=2.01u as=0.1469p ps=1.085u w=0.565u l=0.6u
M7 ZN A2 VSS VPW nfet_05v0 ad=0.1469p pd=1.085u as=0.2486p ps=2.01u w=0.565u l=0.6u
.ends

.subckt gf180mcu_fd_sc_mcu7t5v0__nand2_2 VDD VSS ZN A1 A2 VNW VPW
M0 a_244_68# A2 VSS VPW nfet_05v0 ad=0.1312p pd=1.14u as=0.3608p ps=2.52u w=0.82u l=0.6u
M1 ZN A1 a_244_68# VPW nfet_05v0 ad=0.2132p pd=1.34u as=0.1312p ps=1.14u w=0.82u l=0.6u
M2 ZN A2 VDD VNW pfet_05v0 ad=0.2938p pd=1.65u as=0.4972p ps=3.14u w=1.13u l=0.5u
M3 VDD A1 ZN VNW pfet_05v0 ad=0.2938p pd=1.65u as=0.2938p ps=1.65u w=1.13u l=0.5u
M4 a_652_68# A1 ZN VPW nfet_05v0 ad=0.1312p pd=1.14u as=0.2132p ps=1.34u w=0.82u l=0.6u
M5 VSS A2 a_652_68# VPW nfet_05v0 ad=0.3608p pd=2.52u as=0.1312p ps=1.14u w=0.82u l=0.6u
M6 ZN A1 VDD VNW pfet_05v0 ad=0.2938p pd=1.65u as=0.2938p ps=1.65u w=1.13u l=0.5u
M7 VDD A2 ZN VNW pfet_05v0 ad=0.4972p pd=3.14u as=0.2938p ps=1.65u w=1.13u l=0.5u
.ends

.subckt gf180mcu_fd_sc_mcu7t5v0__and2_2 VDD VSS Z A1 A2 VNW VPW
M0 a_247_68# A1 a_39_68# VPW nfet_05v0 ad=0.1304p pd=1.135u as=0.3586p ps=2.51u w=0.815u l=0.6u
M1 Z a_39_68# VDD VNW pfet_05v0 ad=0.3159p pd=1.735u as=0.4278p ps=1.955u w=1.215u l=0.5u
M2 Z a_39_68# VSS VPW nfet_05v0 ad=0.22005p pd=1.355u as=0.2119p ps=1.335u w=0.815u l=0.6u
M3 VDD a_39_68# Z VNW pfet_05v0 ad=0.5346p pd=3.31u as=0.3159p ps=1.735u w=1.215u l=0.5u
M4 a_39_68# A1 VDD VNW pfet_05v0 ad=0.2782p pd=1.59u as=0.4708p ps=3.02u w=1.07u l=0.5u
M5 VSS a_39_68# Z VPW nfet_05v0 ad=0.3586p pd=2.51u as=0.22005p ps=1.355u w=0.815u l=0.6u
M6 VDD A2 a_39_68# VNW pfet_05v0 ad=0.4278p pd=1.955u as=0.2782p ps=1.59u w=1.07u l=0.5u
M7 VSS A2 a_247_68# VPW nfet_05v0 ad=0.2119p pd=1.335u as=0.1304p ps=1.135u w=0.815u l=0.6u
.ends

.subckt gf180mcu_fd_sc_mcu7t5v0__aoi221_2 B1 B2 VDD VSS ZN A1 A2 C VNW VPW
M0 a_56_492# A2 ZN VNW pfet_05v0 ad=0.2912p pd=1.64u as=0.2912p ps=1.64u w=1.12u l=0.5u
M1 a_512_68# B2 VSS VPW nfet_05v0 ad=0.16445p pd=1.175u as=0.21805p ps=1.455u w=0.715u l=0.6u
M2 ZN C VSS VPW nfet_05v0 ad=0.23355p pd=1.43u as=0.6525p ps=2.695u w=0.575u l=0.6u
M3 a_244_492# B2 VDD VNW pfet_05v0 ad=0.7056p pd=2.38u as=0.5664p ps=2.24u w=1.12u l=0.5u
M4 a_948_68# B1 ZN VPW nfet_05v0 ad=0.10725p pd=1.015u as=0.1859p ps=1.235u w=0.715u l=0.6u
M5 VSS B2 a_948_68# VPW nfet_05v0 ad=0.6525p pd=2.695u as=0.10725p ps=1.015u w=0.715u l=0.6u
M6 a_56_492# C a_244_492# VNW pfet_05v0 ad=0.3108p pd=1.675u as=0.7056p ps=2.38u w=1.12u l=0.5u
M7 VSS C ZN VPW nfet_05v0 ad=0.21805p pd=1.455u as=0.1782p ps=1.69u w=0.405u l=0.6u
M8 VDD B1 a_244_492# VNW pfet_05v0 ad=0.5664p pd=2.24u as=0.3024p ps=1.66u w=1.12u l=0.5u
M9 a_2267_68# A2 VSS VPW nfet_05v0 ad=85.799995f pd=0.955u as=0.1859p ps=1.235u w=0.715u l=0.6u
M10 a_1875_68# A1 ZN VPW nfet_05v0 ad=85.799995f pd=0.955u as=0.23355p ps=1.43u w=0.715u l=0.6u
M11 VSS A2 a_1875_68# VPW nfet_05v0 ad=0.1859p pd=1.235u as=85.799995f ps=0.955u w=0.715u l=0.6u
M12 ZN A1 a_2267_68# VPW nfet_05v0 ad=0.3146p pd=2.31u as=85.799995f ps=0.955u w=0.715u l=0.6u
M13 a_244_492# B1 VDD VNW pfet_05v0 ad=0.3024p pd=1.66u as=0.5664p ps=2.24u w=1.12u l=0.5u
M14 ZN B1 a_512_68# VPW nfet_05v0 ad=0.1859p pd=1.235u as=0.16445p ps=1.175u w=0.715u l=0.6u
M15 a_244_492# C a_56_492# VNW pfet_05v0 ad=0.2912p pd=1.64u as=0.4928p ps=3.12u w=1.12u l=0.5u
M16 ZN A2 a_56_492# VNW pfet_05v0 ad=0.2912p pd=1.64u as=0.2912p ps=1.64u w=1.12u l=0.5u
M17 VDD B2 a_244_492# VNW pfet_05v0 ad=0.5664p pd=2.24u as=0.2912p ps=1.64u w=1.12u l=0.5u
M18 ZN A1 a_56_492# VNW pfet_05v0 ad=0.2912p pd=1.64u as=0.3108p ps=1.675u w=1.12u l=0.5u
M19 a_56_492# A1 ZN VNW pfet_05v0 ad=0.4928p pd=3.12u as=0.2912p ps=1.64u w=1.12u l=0.5u
.ends

.subckt gf180mcu_fd_sc_mcu7t5v0__oai32_2 A3 B1 B2 VDD VSS ZN A1 A2 VNW VPW
M0 a_468_497# A2 a_244_497# VNW pfet_05v0 ad=0.33945p pd=1.715u as=0.33945p ps=1.715u w=1.095u l=0.5u
M1 VSS A1 a_36_68# VPW nfet_05v0 ad=0.2132p pd=1.34u as=0.2132p ps=1.34u w=0.82u l=0.6u
M2 VSS A3 a_36_68# VPW nfet_05v0 ad=0.2132p pd=1.34u as=0.3608p ps=2.52u w=0.82u l=0.6u
M3 VDD B2 a_2060_497# VNW pfet_05v0 ad=0.4818p pd=3.07u as=0.4599p ps=1.935u w=1.095u l=0.5u
M4 VDD A3 a_1120_497# VNW pfet_05v0 ad=0.3942p pd=1.815u as=0.33945p ps=1.715u w=1.095u l=0.5u
M5 a_1588_497# B2 VDD VNW pfet_05v0 ad=0.4599p pd=1.935u as=0.3942p ps=1.815u w=1.095u l=0.5u
M6 ZN B2 a_36_68# VPW nfet_05v0 ad=0.30965p pd=1.685u as=0.2132p ps=1.34u w=0.82u l=0.6u
M7 a_244_497# A3 VDD VNW pfet_05v0 ad=0.33945p pd=1.715u as=0.4818p ps=3.07u w=1.095u l=0.5u
M8 a_36_68# B1 ZN VPW nfet_05v0 ad=0.2132p pd=1.34u as=0.30965p ps=1.685u w=0.82u l=0.6u
M9 ZN A1 a_468_497# VNW pfet_05v0 ad=0.2847p pd=1.615u as=0.33945p ps=1.715u w=1.095u l=0.5u
M10 a_1120_497# A2 a_896_497# VNW pfet_05v0 ad=0.33945p pd=1.715u as=0.33945p ps=1.715u w=1.095u l=0.5u
M11 a_36_68# A3 VSS VPW nfet_05v0 ad=0.2132p pd=1.34u as=0.2132p ps=1.34u w=0.82u l=0.6u
M12 a_896_497# A1 ZN VNW pfet_05v0 ad=0.33945p pd=1.715u as=0.2847p ps=1.615u w=1.095u l=0.5u
M13 ZN B1 a_36_68# VPW nfet_05v0 ad=0.30965p pd=1.685u as=0.2132p ps=1.34u w=0.82u l=0.6u
M14 a_36_68# A1 VSS VPW nfet_05v0 ad=0.2132p pd=1.34u as=0.2132p ps=1.34u w=0.82u l=0.6u
M15 a_36_68# B2 ZN VPW nfet_05v0 ad=0.3608p pd=2.52u as=0.30965p ps=1.685u w=0.82u l=0.6u
M16 ZN B1 a_1588_497# VNW pfet_05v0 ad=0.2847p pd=1.615u as=0.4599p ps=1.935u w=1.095u l=0.5u
M17 a_36_68# A2 VSS VPW nfet_05v0 ad=0.2132p pd=1.34u as=0.2132p ps=1.34u w=0.82u l=0.6u
M18 a_2060_497# B1 ZN VNW pfet_05v0 ad=0.4599p pd=1.935u as=0.2847p ps=1.615u w=1.095u l=0.5u
M19 VSS A2 a_36_68# VPW nfet_05v0 ad=0.2132p pd=1.34u as=0.2132p ps=1.34u w=0.82u l=0.6u
.ends

.subckt gf180mcu_fd_sc_mcu7t5v0__or2_1 VDD VSS Z A1 A2 VNW VPW
M0 a_255_603# A1 a_67_603# VNW pfet_05v0 ad=0.1469p pd=1.085u as=0.2486p ps=2.01u w=0.565u l=0.5u
M1 Z a_67_603# VSS VPW nfet_05v0 ad=0.3608p pd=2.52u as=0.2288p ps=1.58u w=0.82u l=0.6u
M2 VDD A2 a_255_603# VNW pfet_05v0 ad=0.38705p pd=2.08u as=0.1469p ps=1.085u w=0.565u l=0.5u
M3 VSS A2 a_67_603# VPW nfet_05v0 ad=0.2288p pd=1.58u as=93.59999f ps=0.88u w=0.36u l=0.6u
M4 Z a_67_603# VDD VNW pfet_05v0 ad=0.5368p pd=3.32u as=0.38705p ps=2.08u w=1.22u l=0.5u
M5 a_67_603# A1 VSS VPW nfet_05v0 ad=93.59999f pd=0.88u as=0.1584p ps=1.6u w=0.36u l=0.6u
.ends

.subckt gf180mcu_fd_sc_mcu7t5v0__buf_8 Z I VDD VSS VNW VPW
M0 a_224_472# I VDD VNW pfet_05v0 ad=0.3782p pd=1.84u as=0.3782p ps=1.84u w=1.22u l=0.5u
M1 Z a_224_472# VDD VNW pfet_05v0 ad=0.3782p pd=1.84u as=0.3782p ps=1.84u w=1.22u l=0.5u
M2 a_224_472# I VSS VPW nfet_05v0 ad=0.2132p pd=1.34u as=0.2132p ps=1.34u w=0.82u l=0.6u
M3 VSS a_224_472# Z VPW nfet_05v0 ad=0.3608p pd=2.52u as=0.2132p ps=1.34u w=0.82u l=0.6u
M4 VDD a_224_472# Z VNW pfet_05v0 ad=0.3782p pd=1.84u as=0.3782p ps=1.84u w=1.22u l=0.5u
M5 Z a_224_472# VDD VNW pfet_05v0 ad=0.3782p pd=1.84u as=0.3782p ps=1.84u w=1.22u l=0.5u
M6 a_224_472# I VSS VPW nfet_05v0 ad=0.2132p pd=1.34u as=0.3608p ps=2.52u w=0.82u l=0.6u
M7 Z a_224_472# VSS VPW nfet_05v0 ad=0.2132p pd=1.34u as=0.2132p ps=1.34u w=0.82u l=0.6u
M8 VDD a_224_472# Z VNW pfet_05v0 ad=0.3782p pd=1.84u as=0.3782p ps=1.84u w=1.22u l=0.5u
M9 Z a_224_472# VSS VPW nfet_05v0 ad=0.2132p pd=1.34u as=0.2132p ps=1.34u w=0.82u l=0.6u
M10 Z a_224_472# VSS VPW nfet_05v0 ad=0.2132p pd=1.34u as=0.2132p ps=1.34u w=0.82u l=0.6u
M11 VDD I a_224_472# VNW pfet_05v0 ad=0.3782p pd=1.84u as=0.3782p ps=1.84u w=1.22u l=0.5u
M12 VDD a_224_472# Z VNW pfet_05v0 ad=0.3782p pd=1.84u as=0.3782p ps=1.84u w=1.22u l=0.5u
M13 Z a_224_472# VDD VNW pfet_05v0 ad=0.3782p pd=1.84u as=0.3782p ps=1.84u w=1.22u l=0.5u
M14 VSS a_224_472# Z VPW nfet_05v0 ad=0.2132p pd=1.34u as=0.2132p ps=1.34u w=0.82u l=0.6u
M15 VDD I a_224_472# VNW pfet_05v0 ad=0.3782p pd=1.84u as=0.3782p ps=1.84u w=1.22u l=0.5u
M16 VSS a_224_472# Z VPW nfet_05v0 ad=0.2132p pd=1.34u as=0.2132p ps=1.34u w=0.82u l=0.6u
M17 VDD a_224_472# Z VNW pfet_05v0 ad=0.5368p pd=3.32u as=0.3782p ps=1.84u w=1.22u l=0.5u
M18 VSS a_224_472# Z VPW nfet_05v0 ad=0.2132p pd=1.34u as=0.2132p ps=1.34u w=0.82u l=0.6u
M19 Z a_224_472# VDD VNW pfet_05v0 ad=0.3782p pd=1.84u as=0.3782p ps=1.84u w=1.22u l=0.5u
M20 VSS I a_224_472# VPW nfet_05v0 ad=0.2132p pd=1.34u as=0.2132p ps=1.34u w=0.82u l=0.6u
M21 a_224_472# I VDD VNW pfet_05v0 ad=0.3782p pd=1.84u as=0.5368p ps=3.32u w=1.22u l=0.5u
M22 VSS I a_224_472# VPW nfet_05v0 ad=0.2132p pd=1.34u as=0.2132p ps=1.34u w=0.82u l=0.6u
M23 Z a_224_472# VSS VPW nfet_05v0 ad=0.2132p pd=1.34u as=0.2132p ps=1.34u w=0.82u l=0.6u
.ends

.subckt gf180mcu_fd_sc_mcu7t5v0__inv_8 VSS ZN I VDD VNW VPW
M0 ZN I VDD VNW pfet_05v0 ad=0.4392p pd=1.94u as=0.3172p ps=1.74u w=1.22u l=0.5u
M1 VDD I ZN VNW pfet_05v0 ad=0.5368p pd=3.32u as=0.4392p ps=1.94u w=1.22u l=0.5u
M2 ZN I VSS VPW nfet_05v0 ad=0.2132p pd=1.34u as=0.2132p ps=1.34u w=0.82u l=0.6u
M3 ZN I VSS VPW nfet_05v0 ad=0.2132p pd=1.34u as=0.3608p ps=2.52u w=0.82u l=0.6u
M4 ZN I VSS VPW nfet_05v0 ad=0.2132p pd=1.34u as=0.2132p ps=1.34u w=0.82u l=0.6u
M5 VDD I ZN VNW pfet_05v0 ad=0.3172p pd=1.74u as=0.4392p ps=1.94u w=1.22u l=0.5u
M6 ZN I VDD VNW pfet_05v0 ad=0.4392p pd=1.94u as=0.3172p ps=1.74u w=1.22u l=0.5u
M7 VSS I ZN VPW nfet_05v0 ad=0.3608p pd=2.52u as=0.2132p ps=1.34u w=0.82u l=0.6u
M8 VDD I ZN VNW pfet_05v0 ad=0.3172p pd=1.74u as=0.4392p ps=1.94u w=1.22u l=0.5u
M9 VSS I ZN VPW nfet_05v0 ad=0.2132p pd=1.34u as=0.2132p ps=1.34u w=0.82u l=0.6u
M10 ZN I VDD VNW pfet_05v0 ad=0.4392p pd=1.94u as=0.3172p ps=1.74u w=1.22u l=0.5u
M11 VSS I ZN VPW nfet_05v0 ad=0.2132p pd=1.34u as=0.2132p ps=1.34u w=0.82u l=0.6u
M12 ZN I VDD VNW pfet_05v0 ad=0.4392p pd=1.94u as=0.5368p ps=3.32u w=1.22u l=0.5u
M13 VSS I ZN VPW nfet_05v0 ad=0.2132p pd=1.34u as=0.2132p ps=1.34u w=0.82u l=0.6u
M14 ZN I VSS VPW nfet_05v0 ad=0.2132p pd=1.34u as=0.2132p ps=1.34u w=0.82u l=0.6u
M15 VDD I ZN VNW pfet_05v0 ad=0.3172p pd=1.74u as=0.4392p ps=1.94u w=1.22u l=0.5u
.ends

.subckt gf180mcu_fd_sc_mcu7t5v0__aoi22_4 A2 B1 B2 VDD VSS ZN A1 VNW VPW
M0 a_36_497# B1 VDD VNW pfet_05v0 ad=0.2847p pd=1.615u as=0.2847p ps=1.615u w=1.095u l=0.5u
M1 a_2356_68# A1 ZN VPW nfet_05v0 ad=0.1312p pd=1.14u as=0.2132p ps=1.34u w=0.82u l=0.6u
M2 VDD B1 a_36_497# VNW pfet_05v0 ad=0.2847p pd=1.615u as=0.2847p ps=1.615u w=1.095u l=0.5u
M3 a_244_68# B2 VSS VPW nfet_05v0 ad=0.1312p pd=1.14u as=0.3608p ps=2.52u w=0.82u l=0.6u
M4 ZN B1 a_244_68# VPW nfet_05v0 ad=0.2132p pd=1.34u as=0.1312p ps=1.14u w=0.82u l=0.6u
M5 a_1468_68# B1 ZN VPW nfet_05v0 ad=0.1312p pd=1.14u as=0.2132p ps=1.34u w=0.82u l=0.6u
M6 a_36_497# B2 VDD VNW pfet_05v0 ad=0.2847p pd=1.615u as=0.2847p ps=1.615u w=1.095u l=0.5u
M7 ZN A1 a_2764_68# VPW nfet_05v0 ad=0.4161p pd=1.905u as=0.1312p ps=1.14u w=0.82u l=0.6u
M8 a_2764_68# A2 VSS VPW nfet_05v0 ad=0.1312p pd=1.14u as=0.2132p ps=1.34u w=0.82u l=0.6u
M9 VDD B2 a_36_497# VNW pfet_05v0 ad=0.2847p pd=1.615u as=0.2847p ps=1.615u w=1.095u l=0.5u
M10 ZN A1 a_36_497# VNW pfet_05v0 ad=0.2847p pd=1.615u as=0.5256p ps=2.055u w=1.095u l=0.5u
M11 ZN A1 a_1948_68# VPW nfet_05v0 ad=0.2132p pd=1.34u as=0.1312p ps=1.14u w=0.82u l=0.6u
M12 a_652_68# B1 ZN VPW nfet_05v0 ad=0.1312p pd=1.14u as=0.2132p ps=1.34u w=0.82u l=0.6u
M13 VSS B2 a_652_68# VPW nfet_05v0 ad=0.2132p pd=1.34u as=0.1312p ps=1.14u w=0.82u l=0.6u
M14 VSS A2 a_3260_68# VPW nfet_05v0 ad=0.3608p pd=2.52u as=0.1312p ps=1.14u w=0.82u l=0.6u
M15 a_36_497# A2 ZN VNW pfet_05v0 ad=0.4818p pd=3.07u as=0.2847p ps=1.615u w=1.095u l=0.5u
M16 a_3260_68# A1 ZN VPW nfet_05v0 ad=0.1312p pd=1.14u as=0.4161p ps=1.905u w=0.82u l=0.6u
M17 a_36_497# A1 ZN VNW pfet_05v0 ad=0.2847p pd=1.615u as=0.2847p ps=1.615u w=1.095u l=0.5u
M18 a_36_497# B1 VDD VNW pfet_05v0 ad=0.2847p pd=1.615u as=0.2847p ps=1.615u w=1.095u l=0.5u
M19 ZN B1 a_1060_68# VPW nfet_05v0 ad=0.2132p pd=1.34u as=0.1312p ps=1.14u w=0.82u l=0.6u
M20 ZN A1 a_36_497# VNW pfet_05v0 ad=0.2847p pd=1.615u as=0.2847p ps=1.615u w=1.095u l=0.5u
M21 a_1948_68# A2 VSS VPW nfet_05v0 ad=0.1312p pd=1.14u as=0.3608p ps=1.7u w=0.82u l=0.6u
M22 VSS A2 a_2356_68# VPW nfet_05v0 ad=0.2132p pd=1.34u as=0.1312p ps=1.14u w=0.82u l=0.6u
M23 a_1060_68# B2 VSS VPW nfet_05v0 ad=0.1312p pd=1.14u as=0.2132p ps=1.34u w=0.82u l=0.6u
M24 VDD B1 a_36_497# VNW pfet_05v0 ad=0.2847p pd=1.615u as=0.2847p ps=1.615u w=1.095u l=0.5u
M25 ZN A2 a_36_497# VNW pfet_05v0 ad=0.2847p pd=1.615u as=0.4818p ps=1.975u w=1.095u l=0.5u
M26 a_36_497# A2 ZN VNW pfet_05v0 ad=0.2847p pd=1.615u as=0.2847p ps=1.615u w=1.095u l=0.5u
M27 a_36_497# B2 VDD VNW pfet_05v0 ad=0.4818p pd=1.975u as=0.2847p ps=1.615u w=1.095u l=0.5u
M28 VSS B2 a_1468_68# VPW nfet_05v0 ad=0.3608p pd=1.7u as=0.1312p ps=1.14u w=0.82u l=0.6u
M29 ZN A2 a_36_497# VNW pfet_05v0 ad=0.2847p pd=1.615u as=0.2847p ps=1.615u w=1.095u l=0.5u
M30 a_36_497# A1 ZN VNW pfet_05v0 ad=0.5256p pd=2.055u as=0.2847p ps=1.615u w=1.095u l=0.5u
M31 VDD B2 a_36_497# VNW pfet_05v0 ad=0.2847p pd=1.615u as=0.4818p ps=3.07u w=1.095u l=0.5u
.ends

.subckt gf180mcu_fd_sc_mcu7t5v0__mux4_2 I0 VSS VDD I2 I1 S0 I3 S1 Z VNW VPW
M0 VSS I0 a_3176_509# VPW nfet_05v0 ad=94.899994f pd=0.885u as=94.899994f ps=0.885u w=0.365u l=0.6u
M1 a_3176_509# S0 a_2147_156# VNW pfet_05v0 ad=0.2142p pd=1.315u as=0.1547p ps=1.115u w=0.595u l=0.5u
M2 Z a_1108_112# VSS VPW nfet_05v0 ad=98.799995f pd=0.9u as=98.799995f ps=0.9u w=0.38u l=0.6u
M3 a_728_472# a_348_112# a_468_156# VNW pfet_05v0 ad=0.3042p pd=1.56u as=0.2028p ps=1.3u w=0.78u l=0.5u
M4 VSS I3 a_728_472# VPW nfet_05v0 ad=98.799995f pd=0.9u as=98.799995f ps=0.9u w=0.38u l=0.6u
M5 a_2768_156# I1 VDD VNW pfet_05v0 ad=0.1547p pd=1.115u as=0.18445p ps=1.215u w=0.595u l=0.5u
M6 Z a_1108_112# VDD VNW pfet_05v0 ad=0.2808p pd=1.5u as=0.2418p ps=1.4u w=0.78u l=0.5u
M7 a_2147_156# a_348_112# a_2768_156# VNW pfet_05v0 ad=0.1547p pd=1.115u as=0.1547p ps=1.115u w=0.595u l=0.5u
M8 a_3176_509# a_348_112# a_2147_156# VPW nfet_05v0 ad=94.899994f pd=0.885u as=94.899994f ps=0.885u w=0.365u l=0.6u
M9 VDD I3 a_728_472# VNW pfet_05v0 ad=0.2418p pd=1.4u as=0.3042p ps=1.56u w=0.78u l=0.5u
M10 VDD a_1108_112# Z VNW pfet_05v0 ad=0.3432p pd=2.44u as=0.2808p ps=1.5u w=0.78u l=0.5u
M11 a_2768_156# I1 VSS VPW nfet_05v0 ad=94.899994f pd=0.885u as=94.899994f ps=0.885u w=0.365u l=0.6u
M12 a_468_156# a_348_112# a_224_472# VPW nfet_05v0 ad=0.1824p pd=1.34u as=98.799995f ps=0.9u w=0.38u l=0.6u
M13 VDD I0 a_3176_509# VNW pfet_05v0 ad=0.18445p pd=1.215u as=0.2142p ps=1.315u w=0.595u l=0.5u
M14 a_2147_156# S1 a_1108_112# VNW pfet_05v0 ad=0.2618p pd=2.07u as=0.2618p ps=1.475u w=0.595u l=0.5u
M15 a_2147_156# a_1772_369# a_1108_112# VPW nfet_05v0 ad=0.162425p pd=1.62u as=0.112225p ps=0.98u w=0.365u l=0.6u
M16 a_728_472# S0 a_468_156# VPW nfet_05v0 ad=98.799995f pd=0.9u as=0.1824p ps=1.34u w=0.38u l=0.6u
M17 a_1108_112# S1 a_468_156# VPW nfet_05v0 ad=0.112225p pd=0.98u as=0.27375p ps=2.23u w=0.365u l=0.6u
M18 VDD S1 a_1772_369# VNW pfet_05v0 ad=0.18445p pd=1.215u as=0.2618p ps=2.07u w=0.595u l=0.5u
M19 VSS a_1108_112# Z VPW nfet_05v0 ad=0.1672p pd=1.64u as=98.799995f ps=0.9u w=0.38u l=0.6u
M20 a_348_112# S0 VSS VPW nfet_05v0 ad=0.1606p pd=1.61u as=94.899994f ps=0.885u w=0.365u l=0.6u
M21 VSS S1 a_1772_369# VPW nfet_05v0 ad=94.899994f pd=0.885u as=0.1606p ps=1.61u w=0.365u l=0.6u
M22 a_1108_112# a_1772_369# a_468_156# VNW pfet_05v0 ad=0.2618p pd=1.475u as=0.401625p ps=2.54u w=0.595u l=0.5u
M23 a_224_472# I2 VSS VPW nfet_05v0 ad=98.799995f pd=0.9u as=0.1672p ps=1.64u w=0.38u l=0.6u
M24 a_2147_156# S0 a_2768_156# VPW nfet_05v0 ad=94.899994f pd=0.885u as=94.899994f ps=0.885u w=0.365u l=0.6u
M25 a_224_472# I2 VDD VNW pfet_05v0 ad=0.39p pd=1.78u as=0.3432p ps=2.44u w=0.78u l=0.5u
M26 a_468_156# S0 a_224_472# VNW pfet_05v0 ad=0.2028p pd=1.3u as=0.39p ps=1.78u w=0.78u l=0.5u
M27 a_348_112# S0 VDD VNW pfet_05v0 ad=0.2618p pd=2.07u as=0.18445p ps=1.215u w=0.595u l=0.5u
.ends

.subckt gf180mcu_fd_sc_mcu7t5v0__mux2_1 S VDD VSS Z I0 I1 VNW VPW
M0 a_896_593# S a_124_24# VNW pfet_05v0 ad=73.799995f pd=0.855u as=0.1599p ps=1.135u w=0.615u l=0.5u
M1 VSS a_124_24# Z VPW nfet_05v0 ad=0.218p pd=1.52u as=0.3608p ps=2.52u w=0.82u l=0.6u
M2 a_124_24# S a_504_104# VPW nfet_05v0 ad=93.59999f pd=0.88u as=43.199997f ps=0.6u w=0.36u l=0.6u
M3 VDD a_124_24# Z VNW pfet_05v0 ad=0.429825p pd=2.185u as=0.5368p ps=3.32u w=1.22u l=0.5u
M4 VDD I0 a_896_593# VNW pfet_05v0 ad=0.1599p pd=1.135u as=73.799995f ps=0.855u w=0.615u l=0.5u
M5 a_592_407# S VSS VPW nfet_05v0 ad=0.1584p pd=1.6u as=93.59999f ps=0.88u w=0.36u l=0.6u
M6 a_504_104# I1 VSS VPW nfet_05v0 ad=43.199997f pd=0.6u as=0.218p ps=1.52u w=0.36u l=0.6u
M7 a_592_407# S VDD VNW pfet_05v0 ad=0.2706p pd=2.11u as=0.1599p ps=1.135u w=0.615u l=0.5u
M8 a_537_593# I1 VDD VNW pfet_05v0 ad=84.549995f pd=0.89u as=0.429825p ps=2.185u w=0.615u l=0.5u
M9 VSS I0 a_896_104# VPW nfet_05v0 ad=93.59999f pd=0.88u as=43.199997f ps=0.6u w=0.36u l=0.6u
M10 a_896_104# a_592_407# a_124_24# VPW nfet_05v0 ad=43.199997f pd=0.6u as=93.59999f ps=0.88u w=0.36u l=0.6u
M11 a_124_24# a_592_407# a_537_593# VNW pfet_05v0 ad=0.1599p pd=1.135u as=84.549995f ps=0.89u w=0.615u l=0.5u
.ends

.subckt gf180mcu_fd_sc_mcu7t5v0__and3_1 A3 VDD VSS Z A1 A2 VNW VPW
M0 Z a_36_148# VDD VNW pfet_05v0 ad=0.5346p pd=3.31u as=0.4268p ps=2.175u w=1.215u l=0.5u
M1 a_428_148# A2 a_244_148# VPW nfet_05v0 ad=79.799995f pd=0.8u as=60.8f ps=0.7u w=0.38u l=0.6u
M2 Z a_36_148# VSS VPW nfet_05v0 ad=0.341p pd=2.43u as=0.2424p ps=1.635u w=0.775u l=0.6u
M3 VSS A3 a_428_148# VPW nfet_05v0 ad=0.2424p pd=1.635u as=79.799995f ps=0.8u w=0.38u l=0.6u
M4 a_244_148# A1 a_36_148# VPW nfet_05v0 ad=60.8f pd=0.7u as=0.1672p ps=1.64u w=0.38u l=0.6u
M5 VDD A1 a_36_148# VNW pfet_05v0 ad=0.1391p pd=1.055u as=0.2354p ps=1.95u w=0.535u l=0.5u
M6 a_36_148# A2 VDD VNW pfet_05v0 ad=0.1391p pd=1.055u as=0.1391p ps=1.055u w=0.535u l=0.5u
M7 VDD A3 a_36_148# VNW pfet_05v0 ad=0.4268p pd=2.175u as=0.1391p ps=1.055u w=0.535u l=0.5u
.ends

.subckt gf180mcu_fd_sc_mcu7t5v0__aoi211_4 A2 B C VDD VSS ZN A1 VNW VPW
M0 a_170_472# B a_3662_472# VNW pfet_05v0 ad=0.5978p pd=3.42u as=0.3172p ps=1.74u w=1.22u l=0.5u
M1 a_1194_69# A2 VSS VPW nfet_05v0 ad=0.1232p pd=1.09u as=0.2002p ps=1.29u w=0.77u l=0.6u
M2 ZN A1 a_1194_69# VPW nfet_05v0 ad=0.2002p pd=1.29u as=0.1232p ps=1.09u w=0.77u l=0.6u
M3 VSS C ZN VPW nfet_05v0 ad=0.2541p pd=1.605u as=0.1196p ps=0.98u w=0.46u l=0.6u
M4 a_170_472# A1 ZN VNW pfet_05v0 ad=0.3172p pd=1.74u as=0.3172p ps=1.74u w=1.22u l=0.5u
M5 ZN B VSS VPW nfet_05v0 ad=0.1196p pd=0.98u as=0.2384p ps=1.51u w=0.46u l=0.6u
M6 a_3126_472# B a_170_472# VNW pfet_05v0 ad=0.3172p pd=1.74u as=0.7076p ps=2.38u w=1.22u l=0.5u
M7 ZN A1 a_170_472# VNW pfet_05v0 ad=0.3172p pd=1.74u as=0.3172p ps=1.74u w=1.22u l=0.5u
M8 ZN A1 a_358_69# VPW nfet_05v0 ad=0.2002p pd=1.29u as=0.1617p ps=1.19u w=0.77u l=0.6u
M9 ZN C VSS VPW nfet_05v0 ad=0.1196p pd=0.98u as=0.2541p ps=1.605u w=0.46u l=0.6u
M10 VDD C a_3126_472# VNW pfet_05v0 ad=0.7076p pd=2.38u as=0.3172p ps=1.74u w=1.22u l=0.5u
M11 VSS A2 a_1602_69# VPW nfet_05v0 ad=0.2384p pd=1.51u as=0.1232p ps=1.09u w=0.77u l=0.6u
M12 VSS B ZN VPW nfet_05v0 ad=0.2541p pd=1.605u as=0.1196p ps=0.98u w=0.46u l=0.6u
M13 a_1602_69# A1 ZN VPW nfet_05v0 ad=0.1232p pd=1.09u as=0.2002p ps=1.29u w=0.77u l=0.6u
M14 a_170_472# A2 ZN VNW pfet_05v0 ad=0.4514p pd=1.96u as=0.3172p ps=1.74u w=1.22u l=0.5u
M15 a_2034_472# B a_170_472# VNW pfet_05v0 ad=0.3782p pd=1.84u as=0.4514p ps=1.96u w=1.22u l=0.5u
M16 a_2590_472# C VDD VNW pfet_05v0 ad=0.3172p pd=1.74u as=0.7076p ps=2.38u w=1.22u l=0.5u
M17 a_358_69# A2 VSS VPW nfet_05v0 ad=0.1617p pd=1.19u as=0.4466p ps=2.7u w=0.77u l=0.6u
M18 VSS A2 a_786_69# VPW nfet_05v0 ad=0.2002p pd=1.29u as=0.1232p ps=1.09u w=0.77u l=0.6u
M19 a_170_472# B a_2590_472# VNW pfet_05v0 ad=0.7076p pd=2.38u as=0.3172p ps=1.74u w=1.22u l=0.5u
M20 VSS C ZN VPW nfet_05v0 ad=0.264p pd=1.66u as=0.1196p ps=0.98u w=0.46u l=0.6u
M21 ZN B VSS VPW nfet_05v0 ad=0.1196p pd=0.98u as=0.2541p ps=1.605u w=0.46u l=0.6u
M22 ZN A2 a_170_472# VNW pfet_05v0 ad=0.3172p pd=1.74u as=0.5368p ps=3.32u w=1.22u l=0.5u
M23 a_170_472# A1 ZN VNW pfet_05v0 ad=0.3172p pd=1.74u as=0.3172p ps=1.74u w=1.22u l=0.5u
M24 ZN C VSS VPW nfet_05v0 ad=0.1196p pd=0.98u as=0.264p ps=1.66u w=0.46u l=0.6u
M25 VDD C a_2034_472# VNW pfet_05v0 ad=0.7076p pd=2.38u as=0.3782p ps=1.84u w=1.22u l=0.5u
M26 ZN A1 a_170_472# VNW pfet_05v0 ad=0.3172p pd=1.74u as=0.3172p ps=1.74u w=1.22u l=0.5u
M27 a_170_472# A2 ZN VNW pfet_05v0 ad=0.3172p pd=1.74u as=0.3172p ps=1.74u w=1.22u l=0.5u
M28 VSS B ZN VPW nfet_05v0 ad=0.2024p pd=1.8u as=0.1196p ps=0.98u w=0.46u l=0.6u
M29 a_786_69# A1 ZN VPW nfet_05v0 ad=0.1232p pd=1.09u as=0.2002p ps=1.29u w=0.77u l=0.6u
M30 a_3662_472# C VDD VNW pfet_05v0 ad=0.3172p pd=1.74u as=0.7076p ps=2.38u w=1.22u l=0.5u
M31 ZN A2 a_170_472# VNW pfet_05v0 ad=0.3172p pd=1.74u as=0.3172p ps=1.74u w=1.22u l=0.5u
.ends

.subckt gf180mcu_fd_sc_mcu7t5v0__oai31_4 A3 B VDD VSS ZN A1 A2 VNW VPW
M0 ZN A1 a_2060_497# VNW pfet_05v0 ad=0.2847p pd=1.615u as=0.3942p ps=1.815u w=1.095u l=0.5u
M1 a_36_68# B VSS VPW nfet_05v0 ad=0.2132p pd=1.34u as=0.2132p ps=1.34u w=0.82u l=0.6u
M2 VDD B ZN VNW pfet_05v0 ad=0.3942p pd=1.815u as=0.2847p ps=1.615u w=1.095u l=0.5u
M3 ZN A3 a_36_68# VPW nfet_05v0 ad=0.2132p pd=1.34u as=0.2132p ps=1.34u w=0.82u l=0.6u
M4 VSS B a_36_68# VPW nfet_05v0 ad=0.2132p pd=1.34u as=0.43265p ps=1.985u w=0.82u l=0.6u
M5 a_2508_497# A1 ZN VNW pfet_05v0 ad=0.33945p pd=1.715u as=0.2847p ps=1.615u w=1.095u l=0.5u
M6 ZN B VDD VNW pfet_05v0 ad=0.2847p pd=1.615u as=0.4818p ps=3.07u w=1.095u l=0.5u
M7 ZN A3 a_36_68# VPW nfet_05v0 ad=0.30965p pd=1.685u as=0.3608p ps=2.52u w=0.82u l=0.6u
M8 a_56_497# A3 VDD VNW pfet_05v0 ad=0.3942p pd=1.815u as=0.40515p ps=1.835u w=1.095u l=0.5u
M9 a_36_68# A3 ZN VPW nfet_05v0 ad=0.2132p pd=1.34u as=0.2132p ps=1.34u w=0.82u l=0.6u
M10 ZN A1 a_36_68# VPW nfet_05v0 ad=0.2132p pd=1.34u as=0.2132p ps=1.34u w=0.82u l=0.6u
M11 ZN B VDD VNW pfet_05v0 ad=0.2847p pd=1.615u as=0.3942p ps=1.815u w=1.095u l=0.5u
M12 a_36_68# A3 ZN VPW nfet_05v0 ad=0.2132p pd=1.34u as=0.30965p ps=1.685u w=0.82u l=0.6u
M13 VDD A3 a_56_497# VNW pfet_05v0 ad=0.40515p pd=1.835u as=0.4818p ps=3.07u w=1.095u l=0.5u
M14 VDD B ZN VNW pfet_05v0 ad=0.53655p pd=3.17u as=0.2847p ps=1.615u w=1.095u l=0.5u
M15 a_36_68# A2 ZN VPW nfet_05v0 ad=0.2132p pd=1.34u as=0.2132p ps=1.34u w=0.82u l=0.6u
M16 VDD A3 a_56_497# VNW pfet_05v0 ad=0.2847p pd=1.615u as=0.3942p ps=1.815u w=1.095u l=0.5u
M17 a_36_68# A1 ZN VPW nfet_05v0 ad=0.2132p pd=1.34u as=0.2132p ps=1.34u w=0.82u l=0.6u
M18 a_36_68# A2 ZN VPW nfet_05v0 ad=0.43265p pd=1.985u as=0.2132p ps=1.34u w=0.82u l=0.6u
M19 a_940_497# A3 VDD VNW pfet_05v0 ad=0.3942p pd=1.815u as=0.2847p ps=1.615u w=1.095u l=0.5u
M20 VSS B a_36_68# VPW nfet_05v0 ad=0.2132p pd=1.34u as=0.2132p ps=1.34u w=0.82u l=0.6u
M21 ZN A1 a_1184_497# VNW pfet_05v0 ad=0.2847p pd=1.615u as=0.33945p ps=1.715u w=1.095u l=0.5u
M22 a_56_497# A2 a_2508_497# VNW pfet_05v0 ad=0.4818p pd=3.07u as=0.33945p ps=1.715u w=1.095u l=0.5u
M23 a_36_68# A1 ZN VPW nfet_05v0 ad=0.2132p pd=1.34u as=0.2132p ps=1.34u w=0.82u l=0.6u
M24 ZN A2 a_36_68# VPW nfet_05v0 ad=0.2132p pd=1.34u as=0.2132p ps=1.34u w=0.82u l=0.6u
M25 a_1612_497# A1 ZN VNW pfet_05v0 ad=0.3942p pd=1.815u as=0.2847p ps=1.615u w=1.095u l=0.5u
M26 ZN A1 a_36_68# VPW nfet_05v0 ad=0.2132p pd=1.34u as=0.2132p ps=1.34u w=0.82u l=0.6u
M27 a_1184_497# A2 a_940_497# VNW pfet_05v0 ad=0.33945p pd=1.715u as=0.3942p ps=1.815u w=1.095u l=0.5u
M28 a_56_497# A2 a_1612_497# VNW pfet_05v0 ad=0.2847p pd=1.615u as=0.3942p ps=1.815u w=1.095u l=0.5u
M29 ZN A2 a_36_68# VPW nfet_05v0 ad=0.2132p pd=1.34u as=0.2132p ps=1.34u w=0.82u l=0.6u
M30 a_2060_497# A2 a_56_497# VNW pfet_05v0 ad=0.3942p pd=1.815u as=0.2847p ps=1.615u w=1.095u l=0.5u
M31 a_36_68# B VSS VPW nfet_05v0 ad=0.3608p pd=2.52u as=0.2132p ps=1.34u w=0.82u l=0.6u
.ends

.subckt gf180mcu_fd_sc_mcu7t5v0__oai22_4 B1 VDD VSS ZN A1 A2 B2 VNW VPW
M0 ZN A1 a_2036_497# VNW pfet_05v0 ad=0.2847p pd=1.615u as=0.4599p ps=1.935u w=1.095u l=0.5u
M1 ZN B1 a_244_497# VNW pfet_05v0 ad=0.2847p pd=1.615u as=0.33945p ps=1.715u w=1.095u l=0.5u
M2 a_672_497# B1 ZN VNW pfet_05v0 ad=0.3942p pd=1.815u as=0.2847p ps=1.615u w=1.095u l=0.5u
M3 a_2508_497# A1 ZN VNW pfet_05v0 ad=0.3942p pd=1.815u as=0.2847p ps=1.615u w=1.095u l=0.5u
M4 VSS B1 a_36_68# VPW nfet_05v0 ad=0.2132p pd=1.34u as=0.2132p ps=1.34u w=0.82u l=0.6u
M5 VDD A2 a_2508_497# VNW pfet_05v0 ad=0.2847p pd=1.615u as=0.3942p ps=1.815u w=1.095u l=0.5u
M6 VSS B2 a_36_68# VPW nfet_05v0 ad=0.2132p pd=1.34u as=0.3608p ps=2.52u w=0.82u l=0.6u
M7 ZN A2 a_36_68# VPW nfet_05v0 ad=0.30965p pd=1.685u as=0.2132p ps=1.34u w=0.82u l=0.6u
M8 ZN A2 a_36_68# VPW nfet_05v0 ad=0.2132p pd=1.34u as=0.2132p ps=1.34u w=0.82u l=0.6u
M9 a_2956_497# A2 VDD VNW pfet_05v0 ad=0.3942p pd=1.815u as=0.2847p ps=1.615u w=1.095u l=0.5u
M10 VSS B1 a_36_68# VPW nfet_05v0 ad=0.2132p pd=1.34u as=0.2132p ps=1.34u w=0.82u l=0.6u
M11 ZN A1 a_2956_497# VNW pfet_05v0 ad=0.2847p pd=1.615u as=0.3942p ps=1.815u w=1.095u l=0.5u
M12 ZN A1 a_36_68# VPW nfet_05v0 ad=0.2132p pd=1.34u as=0.2132p ps=1.34u w=0.82u l=0.6u
M13 VDD B2 a_1568_497# VNW pfet_05v0 ad=0.3942p pd=1.815u as=0.33945p ps=1.715u w=1.095u l=0.5u
M14 a_244_497# B2 VDD VNW pfet_05v0 ad=0.33945p pd=1.715u as=0.4818p ps=3.07u w=1.095u l=0.5u
M15 ZN A1 a_36_68# VPW nfet_05v0 ad=0.30965p pd=1.685u as=0.2132p ps=1.34u w=0.82u l=0.6u
M16 VDD B2 a_672_497# VNW pfet_05v0 ad=0.2847p pd=1.615u as=0.3942p ps=1.815u w=1.095u l=0.5u
M17 a_3404_497# A1 ZN VNW pfet_05v0 ad=0.4599p pd=1.935u as=0.2847p ps=1.615u w=1.095u l=0.5u
M18 a_36_68# B2 VSS VPW nfet_05v0 ad=0.2132p pd=1.34u as=0.2132p ps=1.34u w=0.82u l=0.6u
M19 a_36_68# A2 ZN VPW nfet_05v0 ad=0.2132p pd=1.34u as=0.2132p ps=1.34u w=0.82u l=0.6u
M20 a_1120_497# B2 VDD VNW pfet_05v0 ad=0.3942p pd=1.815u as=0.2847p ps=1.615u w=1.095u l=0.5u
M21 a_36_68# B1 VSS VPW nfet_05v0 ad=0.2132p pd=1.34u as=0.2132p ps=1.34u w=0.82u l=0.6u
M22 a_36_68# A1 ZN VPW nfet_05v0 ad=0.2132p pd=1.34u as=0.30965p ps=1.685u w=0.82u l=0.6u
M23 ZN B1 a_1120_497# VNW pfet_05v0 ad=0.2847p pd=1.615u as=0.3942p ps=1.815u w=1.095u l=0.5u
M24 VDD A2 a_3404_497# VNW pfet_05v0 ad=0.4818p pd=3.07u as=0.4599p ps=1.935u w=1.095u l=0.5u
M25 a_2036_497# A2 VDD VNW pfet_05v0 ad=0.4599p pd=1.935u as=0.3942p ps=1.815u w=1.095u l=0.5u
M26 a_36_68# A1 ZN VPW nfet_05v0 ad=0.2132p pd=1.34u as=0.2132p ps=1.34u w=0.82u l=0.6u
M27 a_36_68# B2 VSS VPW nfet_05v0 ad=0.2132p pd=1.34u as=0.2132p ps=1.34u w=0.82u l=0.6u
M28 a_1568_497# B1 ZN VNW pfet_05v0 ad=0.33945p pd=1.715u as=0.2847p ps=1.615u w=1.095u l=0.5u
M29 a_36_68# B1 VSS VPW nfet_05v0 ad=0.2132p pd=1.34u as=0.2132p ps=1.34u w=0.82u l=0.6u
M30 a_36_68# A2 ZN VPW nfet_05v0 ad=0.3608p pd=2.52u as=0.30965p ps=1.685u w=0.82u l=0.6u
M31 VSS B2 a_36_68# VPW nfet_05v0 ad=0.2132p pd=1.34u as=0.2132p ps=1.34u w=0.82u l=0.6u
.ends

.subckt gf180mcu_fd_sc_mcu7t5v0__inv_4 VSS ZN I VDD VNW VPW
M0 ZN I VDD VNW pfet_05v0 ad=0.4392p pd=1.94u as=0.3172p ps=1.74u w=1.22u l=0.5u
M1 ZN I VSS VPW nfet_05v0 ad=0.2132p pd=1.34u as=0.2132p ps=1.34u w=0.82u l=0.6u
M2 ZN I VSS VPW nfet_05v0 ad=0.2132p pd=1.34u as=0.3608p ps=2.52u w=0.82u l=0.6u
M3 VDD I ZN VNW pfet_05v0 ad=0.5368p pd=3.32u as=0.4392p ps=1.94u w=1.22u l=0.5u
M4 VSS I ZN VPW nfet_05v0 ad=0.3608p pd=2.52u as=0.2132p ps=1.34u w=0.82u l=0.6u
M5 ZN I VDD VNW pfet_05v0 ad=0.4392p pd=1.94u as=0.5368p ps=3.32u w=1.22u l=0.5u
M6 VSS I ZN VPW nfet_05v0 ad=0.2132p pd=1.34u as=0.2132p ps=1.34u w=0.82u l=0.6u
M7 VDD I ZN VNW pfet_05v0 ad=0.3172p pd=1.74u as=0.4392p ps=1.94u w=1.22u l=0.5u
.ends

.subckt gf180mcu_fd_sc_mcu7t5v0__aoi222_1 VSS VDD C2 C1 B2 B1 A2 A1 ZN VNW VPW
M0 a_291_68# C2 VSS VPW nfet_05v0 ad=98.399994f pd=1.06u as=0.3608p ps=2.52u w=0.82u l=0.6u
M1 a_1235_68# A2 VSS VPW nfet_05v0 ad=0.1722p pd=1.24u as=0.2132p ps=1.34u w=0.82u l=0.6u
M2 a_619_484# A1 ZN VNW pfet_05v0 ad=0.5104p pd=3.2u as=0.3596p ps=1.78u w=1.16u l=0.5u
M3 a_255_484# B1 a_619_484# VNW pfet_05v0 ad=0.3016p pd=1.68u as=0.5104p ps=3.2u w=1.16u l=0.5u
M4 a_619_484# B2 a_255_484# VNW pfet_05v0 ad=0.3016p pd=1.68u as=0.3016p ps=1.68u w=1.16u l=0.5u
M5 a_255_484# C2 VDD VNW pfet_05v0 ad=0.3016p pd=1.68u as=0.5104p ps=3.2u w=1.16u l=0.5u
M6 ZN C1 a_291_68# VPW nfet_05v0 ad=0.33825p pd=1.645u as=98.399994f ps=1.06u w=0.82u l=0.6u
M7 ZN A1 a_1235_68# VPW nfet_05v0 ad=0.3608p pd=2.52u as=0.1722p ps=1.24u w=0.82u l=0.6u
M8 VSS B2 a_744_68# VPW nfet_05v0 ad=0.2132p pd=1.34u as=0.30135p ps=1.555u w=0.82u l=0.6u
M9 VDD C1 a_255_484# VNW pfet_05v0 ad=0.5104p pd=3.2u as=0.3016p ps=1.68u w=1.16u l=0.5u
M10 ZN A2 a_619_484# VNW pfet_05v0 ad=0.3596p pd=1.78u as=0.3016p ps=1.68u w=1.16u l=0.5u
M11 a_744_68# B1 ZN VPW nfet_05v0 ad=0.30135p pd=1.555u as=0.33825p ps=1.645u w=0.82u l=0.6u
.ends

.subckt gf180mcu_fd_sc_mcu7t5v0__nor4_4 A3 A4 VDD VSS ZN A1 A2 VNW VPW
M0 a_66_473# A3 a_692_473# VNW pfet_05v0 ad=0.486p pd=2.015u as=0.486p ps=2.015u w=1.215u l=0.5u
M1 VSS A3 ZN VPW nfet_05v0 ad=0.126p pd=1.06u as=0.126p ps=1.06u w=0.36u l=0.6u
M2 a_2180_473# A2 a_1920_473# VNW pfet_05v0 ad=0.486p pd=2.015u as=0.486p ps=2.015u w=1.215u l=0.5u
M3 a_3220_473# A2 a_66_473# VNW pfet_05v0 ad=0.486p pd=2.015u as=0.486p ps=2.015u w=1.215u l=0.5u
M4 a_3740_473# A1 ZN VNW pfet_05v0 ad=0.455625p pd=1.965u as=0.486p ps=2.015u w=1.215u l=0.5u
M5 a_1212_473# A3 a_66_473# VNW pfet_05v0 ad=0.37665p pd=1.835u as=0.486p ps=2.015u w=1.215u l=0.5u
M6 VSS A3 ZN VPW nfet_05v0 ad=0.126p pd=1.06u as=0.126p ps=1.06u w=0.36u l=0.6u
M7 a_66_473# A2 a_2700_473# VNW pfet_05v0 ad=0.486p pd=2.015u as=0.486p ps=2.015u w=1.215u l=0.5u
M8 a_66_473# A2 a_3740_473# VNW pfet_05v0 ad=0.5346p pd=3.31u as=0.455625p ps=1.965u w=1.215u l=0.5u
M9 ZN A1 a_2180_473# VNW pfet_05v0 ad=0.486p pd=2.015u as=0.486p ps=2.015u w=1.215u l=0.5u
M10 ZN A2 VSS VPW nfet_05v0 ad=0.126p pd=1.06u as=0.126p ps=1.06u w=0.36u l=0.6u
M11 VDD A4 a_254_473# VNW pfet_05v0 ad=0.37665p pd=1.835u as=0.346275p ps=1.785u w=1.215u l=0.5u
M12 VSS A4 ZN VPW nfet_05v0 ad=93.59999f pd=0.88u as=93.59999f ps=0.88u w=0.36u l=0.6u
M13 ZN A1 VSS VPW nfet_05v0 ad=0.126p pd=1.06u as=0.126p ps=1.06u w=0.36u l=0.6u
M14 a_1660_473# A4 VDD VNW pfet_05v0 ad=0.486p pd=2.015u as=0.37665p ps=1.835u w=1.215u l=0.5u
M15 a_2700_473# A1 ZN VNW pfet_05v0 ad=0.486p pd=2.015u as=0.486p ps=2.015u w=1.215u l=0.5u
M16 VSS A1 ZN VPW nfet_05v0 ad=0.126p pd=1.06u as=0.126p ps=1.06u w=0.36u l=0.6u
M17 a_254_473# A3 a_66_473# VNW pfet_05v0 ad=0.346275p pd=1.785u as=0.5346p ps=3.31u w=1.215u l=0.5u
M18 VSS A4 ZN VPW nfet_05v0 ad=93.59999f pd=0.88u as=93.59999f ps=0.88u w=0.36u l=0.6u
M19 a_1920_473# A3 a_1660_473# VNW pfet_05v0 ad=0.486p pd=2.015u as=0.486p ps=2.015u w=1.215u l=0.5u
M20 VSS A2 ZN VPW nfet_05v0 ad=0.126p pd=1.06u as=0.126p ps=1.06u w=0.36u l=0.6u
M21 ZN A4 VSS VPW nfet_05v0 ad=0.126p pd=1.06u as=93.59999f ps=0.88u w=0.36u l=0.6u
M22 ZN A3 VSS VPW nfet_05v0 ad=93.59999f pd=0.88u as=0.126p ps=1.06u w=0.36u l=0.6u
M23 ZN A4 VSS VPW nfet_05v0 ad=0.126p pd=1.06u as=93.59999f ps=0.88u w=0.36u l=0.6u
M24 ZN A3 VSS VPW nfet_05v0 ad=93.59999f pd=0.88u as=0.1584p ps=1.6u w=0.36u l=0.6u
M25 VDD A4 a_1212_473# VNW pfet_05v0 ad=0.37665p pd=1.835u as=0.37665p ps=1.835u w=1.215u l=0.5u
M26 VSS A1 ZN VPW nfet_05v0 ad=0.126p pd=1.06u as=0.126p ps=1.06u w=0.36u l=0.6u
M27 a_692_473# A4 VDD VNW pfet_05v0 ad=0.486p pd=2.015u as=0.37665p ps=1.835u w=1.215u l=0.5u
M28 ZN A2 VSS VPW nfet_05v0 ad=0.126p pd=1.06u as=0.126p ps=1.06u w=0.36u l=0.6u
M29 VSS A2 ZN VPW nfet_05v0 ad=0.1584p pd=1.6u as=0.126p ps=1.06u w=0.36u l=0.6u
M30 ZN A1 a_3220_473# VNW pfet_05v0 ad=0.486p pd=2.015u as=0.486p ps=2.015u w=1.215u l=0.5u
M31 ZN A1 VSS VPW nfet_05v0 ad=0.126p pd=1.06u as=0.126p ps=1.06u w=0.36u l=0.6u
.ends

.subckt gf180mcu_fd_sc_mcu7t5v0__oai211_1 B C VDD VSS ZN A1 A2 VNW VPW
M0 a_692_68# B a_36_68# VPW nfet_05v0 ad=0.2132p pd=1.34u as=0.2132p ps=1.34u w=0.82u l=0.6u
M1 ZN A2 a_36_68# VPW nfet_05v0 ad=0.2132p pd=1.34u as=0.3608p ps=2.52u w=0.82u l=0.6u
M2 a_244_472# A2 VDD VNW pfet_05v0 ad=0.3172p pd=1.74u as=0.5978p ps=3.42u w=1.22u l=0.5u
M3 VDD B ZN VNW pfet_05v0 ad=0.2561p pd=1.505u as=0.4016p ps=1.94u w=0.985u l=0.5u
M4 ZN A1 a_244_472# VNW pfet_05v0 ad=0.4016p pd=1.94u as=0.3172p ps=1.74u w=1.22u l=0.5u
M5 ZN C VDD VNW pfet_05v0 ad=0.44325p pd=2.87u as=0.2561p ps=1.505u w=0.985u l=0.5u
M6 VSS C a_692_68# VPW nfet_05v0 ad=0.3608p pd=2.52u as=0.2132p ps=1.34u w=0.82u l=0.6u
M7 a_36_68# A1 ZN VPW nfet_05v0 ad=0.2132p pd=1.34u as=0.2132p ps=1.34u w=0.82u l=0.6u
.ends

.subckt gf180mcu_fd_sc_mcu7t5v0__nand4_4 A3 A4 VDD VSS ZN A1 A2 VNW VPW
M0 ZN A2 VDD VNW pfet_05v0 ad=0.2197p pd=1.365u as=0.2197p ps=1.365u w=0.845u l=0.5u
M1 VDD A1 ZN VNW pfet_05v0 ad=0.4056p pd=1.805u as=0.2197p ps=1.365u w=0.845u l=0.5u
M2 ZN A3 VDD VNW pfet_05v0 ad=0.2197p pd=1.365u as=0.3718p ps=2.57u w=0.845u l=0.5u
M3 a_244_68# A3 a_36_68# VPW nfet_05v0 ad=0.1312p pd=1.14u as=0.3608p ps=2.52u w=0.82u l=0.6u
M4 VSS A4 a_244_68# VPW nfet_05v0 ad=0.2132p pd=1.34u as=0.1312p ps=1.14u w=0.82u l=0.6u
M5 a_1468_68# A4 VSS VPW nfet_05v0 ad=0.1517p pd=1.19u as=0.2132p ps=1.34u w=0.82u l=0.6u
M6 VDD A4 ZN VNW pfet_05v0 ad=0.2197p pd=1.365u as=0.2197p ps=1.365u w=0.845u l=0.5u
M7 a_1866_68# A2 a_1662_68# VPW nfet_05v0 ad=0.1517p pd=1.19u as=0.1722p ps=1.24u w=0.82u l=0.6u
M8 ZN A4 VDD VNW pfet_05v0 ad=0.2197p pd=1.365u as=0.2197p ps=1.365u w=0.845u l=0.5u
M9 ZN A1 VDD VNW pfet_05v0 ad=0.2197p pd=1.365u as=0.4056p ps=1.805u w=0.845u l=0.5u
M10 a_3276_68# A1 ZN VPW nfet_05v0 ad=0.1312p pd=1.14u as=0.4161p ps=1.905u w=0.82u l=0.6u
M11 a_652_68# A4 VSS VPW nfet_05v0 ad=0.1312p pd=1.14u as=0.2132p ps=1.34u w=0.82u l=0.6u
M12 a_36_68# A3 a_652_68# VPW nfet_05v0 ad=0.2132p pd=1.34u as=0.1312p ps=1.14u w=0.82u l=0.6u
M13 VDD A2 ZN VNW pfet_05v0 ad=0.3718p pd=2.57u as=0.2197p ps=1.365u w=0.845u l=0.5u
M14 VDD A3 ZN VNW pfet_05v0 ad=0.2197p pd=1.365u as=0.2197p ps=1.365u w=0.845u l=0.5u
M15 VSS A4 a_1060_68# VPW nfet_05v0 ad=0.2132p pd=1.34u as=0.1312p ps=1.14u w=0.82u l=0.6u
M16 ZN A3 VDD VNW pfet_05v0 ad=0.2197p pd=1.365u as=0.2197p ps=1.365u w=0.845u l=0.5u
M17 a_2372_68# A1 ZN VPW nfet_05v0 ad=0.1312p pd=1.14u as=0.4161p ps=1.905u w=0.82u l=0.6u
M18 a_36_68# A2 a_2372_68# VPW nfet_05v0 ad=0.2132p pd=1.34u as=0.1312p ps=1.14u w=0.82u l=0.6u
M19 ZN A1 VDD VNW pfet_05v0 ad=0.2197p pd=1.365u as=0.4056p ps=1.805u w=0.845u l=0.5u
M20 a_1060_68# A3 a_36_68# VPW nfet_05v0 ad=0.1312p pd=1.14u as=0.2132p ps=1.34u w=0.82u l=0.6u
M21 VDD A2 ZN VNW pfet_05v0 ad=0.2197p pd=1.365u as=0.2197p ps=1.365u w=0.845u l=0.5u
M22 VDD A4 ZN VNW pfet_05v0 ad=0.2197p pd=1.365u as=0.2197p ps=1.365u w=0.845u l=0.5u
M23 ZN A2 VDD VNW pfet_05v0 ad=0.2197p pd=1.365u as=0.2197p ps=1.365u w=0.845u l=0.5u
M24 ZN A1 a_2780_68# VPW nfet_05v0 ad=0.4161p pd=1.905u as=0.1312p ps=1.14u w=0.82u l=0.6u
M25 a_2780_68# A2 a_36_68# VPW nfet_05v0 ad=0.1312p pd=1.14u as=0.2132p ps=1.34u w=0.82u l=0.6u
M26 ZN A4 VDD VNW pfet_05v0 ad=0.2197p pd=1.365u as=0.2197p ps=1.365u w=0.845u l=0.5u
M27 VDD A1 ZN VNW pfet_05v0 ad=0.4056p pd=1.805u as=0.2197p ps=1.365u w=0.845u l=0.5u
M28 a_36_68# A2 a_3276_68# VPW nfet_05v0 ad=0.3608p pd=2.52u as=0.1312p ps=1.14u w=0.82u l=0.6u
M29 VDD A3 ZN VNW pfet_05v0 ad=0.2197p pd=1.365u as=0.2197p ps=1.365u w=0.845u l=0.5u
M30 a_1662_68# A3 a_1468_68# VPW nfet_05v0 ad=0.1722p pd=1.24u as=0.1517p ps=1.19u w=0.82u l=0.6u
M31 ZN A1 a_1866_68# VPW nfet_05v0 ad=0.4161p pd=1.905u as=0.1517p ps=1.19u w=0.82u l=0.6u
.ends

.subckt gf180mcu_fd_sc_mcu7t5v0__buf_20 VDD VSS Z I VNW VPW
M0 Z a_224_472# VSS VPW nfet_05v0 ad=0.2132p pd=1.34u as=0.2132p ps=1.34u w=0.82u l=0.6u
M1 VSS a_224_472# Z VPW nfet_05v0 ad=0.2132p pd=1.34u as=0.2132p ps=1.34u w=0.82u l=0.6u
M2 a_224_472# I VDD VNW pfet_05v0 ad=0.3782p pd=1.84u as=0.3782p ps=1.84u w=1.22u l=0.5u
M3 VDD a_224_472# Z VNW pfet_05v0 ad=0.3782p pd=1.84u as=0.3782p ps=1.84u w=1.22u l=0.5u
M4 Z a_224_472# VDD VNW pfet_05v0 ad=0.3782p pd=1.84u as=0.3782p ps=1.84u w=1.22u l=0.5u
M5 Z a_224_472# VSS VPW nfet_05v0 ad=0.2132p pd=1.34u as=0.2132p ps=1.34u w=0.82u l=0.6u
M6 Z a_224_472# VSS VPW nfet_05v0 ad=0.2132p pd=1.34u as=0.2132p ps=1.34u w=0.82u l=0.6u
M7 VDD a_224_472# Z VNW pfet_05v0 ad=0.3782p pd=1.84u as=0.3782p ps=1.84u w=1.22u l=0.5u
M8 a_224_472# I VSS VPW nfet_05v0 ad=0.2132p pd=1.34u as=0.2132p ps=1.34u w=0.82u l=0.6u
M9 VSS a_224_472# Z VPW nfet_05v0 ad=0.2132p pd=1.34u as=0.2132p ps=1.34u w=0.82u l=0.6u
M10 VSS a_224_472# Z VPW nfet_05v0 ad=0.2132p pd=1.34u as=0.2132p ps=1.34u w=0.82u l=0.6u
M11 VDD I a_224_472# VNW pfet_05v0 ad=0.3782p pd=1.84u as=0.3782p ps=1.84u w=1.22u l=0.5u
M12 Z a_224_472# VDD VNW pfet_05v0 ad=0.3782p pd=1.84u as=0.3782p ps=1.84u w=1.22u l=0.5u
M13 a_224_472# I VDD VNW pfet_05v0 ad=0.3782p pd=1.84u as=0.3782p ps=1.84u w=1.22u l=0.5u
M14 VDD a_224_472# Z VNW pfet_05v0 ad=0.3782p pd=1.84u as=0.3782p ps=1.84u w=1.22u l=0.5u
M15 a_224_472# I VSS VPW nfet_05v0 ad=0.2132p pd=1.34u as=0.3608p ps=2.52u w=0.82u l=0.6u
M16 Z a_224_472# VSS VPW nfet_05v0 ad=0.2132p pd=1.34u as=0.2132p ps=1.34u w=0.82u l=0.6u
M17 a_224_472# I VSS VPW nfet_05v0 ad=0.2132p pd=1.34u as=0.2132p ps=1.34u w=0.82u l=0.6u
M18 VSS a_224_472# Z VPW nfet_05v0 ad=0.2132p pd=1.34u as=0.2132p ps=1.34u w=0.82u l=0.6u
M19 Z a_224_472# VDD VNW pfet_05v0 ad=0.3782p pd=1.84u as=0.3782p ps=1.84u w=1.22u l=0.5u
M20 VSS a_224_472# Z VPW nfet_05v0 ad=0.2132p pd=1.34u as=0.2132p ps=1.34u w=0.82u l=0.6u
M21 VDD I a_224_472# VNW pfet_05v0 ad=0.3782p pd=1.84u as=0.3782p ps=1.84u w=1.22u l=0.5u
M22 a_224_472# I VSS VPW nfet_05v0 ad=0.2132p pd=1.34u as=0.2132p ps=1.34u w=0.82u l=0.6u
M23 Z a_224_472# VSS VPW nfet_05v0 ad=0.2132p pd=1.34u as=0.2132p ps=1.34u w=0.82u l=0.6u
M24 VSS a_224_472# Z VPW nfet_05v0 ad=0.2132p pd=1.34u as=0.2132p ps=1.34u w=0.82u l=0.6u
M25 VDD a_224_472# Z VNW pfet_05v0 ad=0.3782p pd=1.84u as=0.3782p ps=1.84u w=1.22u l=0.5u
M26 Z a_224_472# VDD VNW pfet_05v0 ad=0.3782p pd=1.84u as=0.3782p ps=1.84u w=1.22u l=0.5u
M27 Z a_224_472# VSS VPW nfet_05v0 ad=0.2132p pd=1.34u as=0.2132p ps=1.34u w=0.82u l=0.6u
M28 VDD I a_224_472# VNW pfet_05v0 ad=0.3782p pd=1.84u as=0.3782p ps=1.84u w=1.22u l=0.5u
M29 VDD a_224_472# Z VNW pfet_05v0 ad=0.3782p pd=1.84u as=0.3782p ps=1.84u w=1.22u l=0.5u
M30 VDD I a_224_472# VNW pfet_05v0 ad=0.3782p pd=1.84u as=0.3782p ps=1.84u w=1.22u l=0.5u
M31 Z a_224_472# VSS VPW nfet_05v0 ad=0.2132p pd=1.34u as=0.2132p ps=1.34u w=0.82u l=0.6u
M32 Z a_224_472# VDD VNW pfet_05v0 ad=0.3782p pd=1.84u as=0.3782p ps=1.84u w=1.22u l=0.5u
M33 VDD a_224_472# Z VNW pfet_05v0 ad=0.5368p pd=3.32u as=0.3782p ps=1.84u w=1.22u l=0.5u
M34 Z a_224_472# VSS VPW nfet_05v0 ad=0.2132p pd=1.34u as=0.2132p ps=1.34u w=0.82u l=0.6u
M35 a_224_472# I VDD VNW pfet_05v0 ad=0.3782p pd=1.84u as=0.3782p ps=1.84u w=1.22u l=0.5u
M36 VSS I a_224_472# VPW nfet_05v0 ad=0.2132p pd=1.34u as=0.2132p ps=1.34u w=0.82u l=0.6u
M37 Z a_224_472# VDD VNW pfet_05v0 ad=0.3782p pd=1.84u as=0.3782p ps=1.84u w=1.22u l=0.5u
M38 VDD I a_224_472# VNW pfet_05v0 ad=0.3782p pd=1.84u as=0.3782p ps=1.84u w=1.22u l=0.5u
M39 VSS I a_224_472# VPW nfet_05v0 ad=0.2132p pd=1.34u as=0.2132p ps=1.34u w=0.82u l=0.6u
M40 VDD a_224_472# Z VNW pfet_05v0 ad=0.3782p pd=1.84u as=0.3782p ps=1.84u w=1.22u l=0.5u
M41 VSS a_224_472# Z VPW nfet_05v0 ad=0.2132p pd=1.34u as=0.2132p ps=1.34u w=0.82u l=0.6u
M42 Z a_224_472# VSS VPW nfet_05v0 ad=0.2132p pd=1.34u as=0.2132p ps=1.34u w=0.82u l=0.6u
M43 Z a_224_472# VDD VNW pfet_05v0 ad=0.3782p pd=1.84u as=0.3782p ps=1.84u w=1.22u l=0.5u
M44 VSS I a_224_472# VPW nfet_05v0 ad=0.2132p pd=1.34u as=0.2132p ps=1.34u w=0.82u l=0.6u
M45 a_224_472# I VDD VNW pfet_05v0 ad=0.3782p pd=1.84u as=0.3782p ps=1.84u w=1.22u l=0.5u
M46 VDD a_224_472# Z VNW pfet_05v0 ad=0.3782p pd=1.84u as=0.3782p ps=1.84u w=1.22u l=0.5u
M47 VSS a_224_472# Z VPW nfet_05v0 ad=0.2132p pd=1.34u as=0.2132p ps=1.34u w=0.82u l=0.6u
M48 Z a_224_472# VDD VNW pfet_05v0 ad=0.3782p pd=1.84u as=0.3782p ps=1.84u w=1.22u l=0.5u
M49 Z a_224_472# VDD VNW pfet_05v0 ad=0.3782p pd=1.84u as=0.3782p ps=1.84u w=1.22u l=0.5u
M50 VSS I a_224_472# VPW nfet_05v0 ad=0.2132p pd=1.34u as=0.2132p ps=1.34u w=0.82u l=0.6u
M51 VDD a_224_472# Z VNW pfet_05v0 ad=0.3782p pd=1.84u as=0.3782p ps=1.84u w=1.22u l=0.5u
M52 a_224_472# I VDD VNW pfet_05v0 ad=0.3782p pd=1.84u as=0.5368p ps=3.32u w=1.22u l=0.5u
M53 VDD a_224_472# Z VNW pfet_05v0 ad=0.3782p pd=1.84u as=0.3782p ps=1.84u w=1.22u l=0.5u
M54 VSS I a_224_472# VPW nfet_05v0 ad=0.2132p pd=1.34u as=0.2132p ps=1.34u w=0.82u l=0.6u
M55 Z a_224_472# VSS VPW nfet_05v0 ad=0.2132p pd=1.34u as=0.2132p ps=1.34u w=0.82u l=0.6u
M56 VSS a_224_472# Z VPW nfet_05v0 ad=0.2132p pd=1.34u as=0.2132p ps=1.34u w=0.82u l=0.6u
M57 VSS a_224_472# Z VPW nfet_05v0 ad=0.3608p pd=2.52u as=0.2132p ps=1.34u w=0.82u l=0.6u
M58 Z a_224_472# VDD VNW pfet_05v0 ad=0.3782p pd=1.84u as=0.3782p ps=1.84u w=1.22u l=0.5u
M59 a_224_472# I VSS VPW nfet_05v0 ad=0.2132p pd=1.34u as=0.2132p ps=1.34u w=0.82u l=0.6u
.ends

.subckt gf180mcu_fd_sc_mcu7t5v0__oai31_2 A2 A3 B VDD VSS ZN A1 VNW VPW
M0 VDD A3 a_1612_497# VNW pfet_05v0 ad=0.4818p pd=3.07u as=0.4599p ps=1.935u w=1.095u l=0.5u
M1 a_960_497# A2 a_692_497# VNW pfet_05v0 ad=0.33945p pd=1.715u as=0.4599p ps=1.935u w=1.095u l=0.5u
M2 ZN A3 a_36_68# VPW nfet_05v0 ad=0.30965p pd=1.685u as=0.2132p ps=1.34u w=0.82u l=0.6u
M3 VSS B a_36_68# VPW nfet_05v0 ad=0.2132p pd=1.34u as=0.3608p ps=2.52u w=0.82u l=0.6u
M4 a_36_68# A3 ZN VPW nfet_05v0 ad=0.3608p pd=2.52u as=0.30965p ps=1.685u w=0.82u l=0.6u
M5 a_36_68# A2 ZN VPW nfet_05v0 ad=0.2132p pd=1.34u as=0.30965p ps=1.685u w=0.82u l=0.6u
M6 ZN B VDD VNW pfet_05v0 ad=0.2808p pd=1.6u as=0.5292p ps=3.14u w=1.08u l=0.5u
M7 a_36_68# A1 ZN VPW nfet_05v0 ad=0.2132p pd=1.34u as=0.2132p ps=1.34u w=0.82u l=0.6u
M8 a_692_497# A3 VDD VNW pfet_05v0 ad=0.4599p pd=1.935u as=0.3918p ps=1.815u w=1.095u l=0.5u
M9 VDD B ZN VNW pfet_05v0 ad=0.3918p pd=1.815u as=0.2808p ps=1.6u w=1.08u l=0.5u
M10 a_1612_497# A2 a_1388_497# VNW pfet_05v0 ad=0.4599p pd=1.935u as=0.33945p ps=1.715u w=1.095u l=0.5u
M11 ZN A2 a_36_68# VPW nfet_05v0 ad=0.30965p pd=1.685u as=0.2132p ps=1.34u w=0.82u l=0.6u
M12 ZN A1 a_960_497# VNW pfet_05v0 ad=0.2847p pd=1.615u as=0.33945p ps=1.715u w=1.095u l=0.5u
M13 a_36_68# B VSS VPW nfet_05v0 ad=0.2132p pd=1.34u as=0.2132p ps=1.34u w=0.82u l=0.6u
M14 ZN A1 a_36_68# VPW nfet_05v0 ad=0.2132p pd=1.34u as=0.2132p ps=1.34u w=0.82u l=0.6u
M15 a_1388_497# A1 ZN VNW pfet_05v0 ad=0.33945p pd=1.715u as=0.2847p ps=1.615u w=1.095u l=0.5u
.ends

.subckt gf180mcu_fd_sc_mcu7t5v0__oai22_2 B2 VDD VSS ZN A1 A2 B1 VNW VPW
M0 VDD A2 a_1612_497# VNW pfet_05v0 ad=0.4818p pd=3.07u as=0.4599p ps=1.935u w=1.095u l=0.5u
M1 ZN B1 a_244_497# VNW pfet_05v0 ad=0.2847p pd=1.615u as=0.33945p ps=1.715u w=1.095u l=0.5u
M2 a_672_497# B1 ZN VNW pfet_05v0 ad=0.33945p pd=1.715u as=0.2847p ps=1.615u w=1.095u l=0.5u
M3 a_1140_497# A2 VDD VNW pfet_05v0 ad=0.4599p pd=1.935u as=0.3942p ps=1.815u w=1.095u l=0.5u
M4 VSS B1 a_36_68# VPW nfet_05v0 ad=0.2132p pd=1.34u as=0.2132p ps=1.34u w=0.82u l=0.6u
M5 VSS B2 a_36_68# VPW nfet_05v0 ad=0.2132p pd=1.34u as=0.3608p ps=2.52u w=0.82u l=0.6u
M6 a_36_68# A2 ZN VPW nfet_05v0 ad=0.3608p pd=2.52u as=0.30965p ps=1.685u w=0.82u l=0.6u
M7 a_244_497# B2 VDD VNW pfet_05v0 ad=0.33945p pd=1.715u as=0.4818p ps=3.07u w=1.095u l=0.5u
M8 a_36_68# A1 ZN VPW nfet_05v0 ad=0.2132p pd=1.34u as=0.30965p ps=1.685u w=0.82u l=0.6u
M9 ZN A1 a_1140_497# VNW pfet_05v0 ad=0.2847p pd=1.615u as=0.4599p ps=1.935u w=1.095u l=0.5u
M10 VDD B2 a_672_497# VNW pfet_05v0 ad=0.3942p pd=1.815u as=0.33945p ps=1.715u w=1.095u l=0.5u
M11 a_1612_497# A1 ZN VNW pfet_05v0 ad=0.4599p pd=1.935u as=0.2847p ps=1.615u w=1.095u l=0.5u
M12 ZN A1 a_36_68# VPW nfet_05v0 ad=0.30965p pd=1.685u as=0.2132p ps=1.34u w=0.82u l=0.6u
M13 a_36_68# B2 VSS VPW nfet_05v0 ad=0.2132p pd=1.34u as=0.2132p ps=1.34u w=0.82u l=0.6u
M14 a_36_68# B1 VSS VPW nfet_05v0 ad=0.2132p pd=1.34u as=0.2132p ps=1.34u w=0.82u l=0.6u
M15 ZN A2 a_36_68# VPW nfet_05v0 ad=0.30965p pd=1.685u as=0.2132p ps=1.34u w=0.82u l=0.6u
.ends

.subckt gf180mcu_fd_sc_mcu7t5v0__inv_2 VSS ZN I VDD VNW VPW
M0 VDD I ZN VNW pfet_05v0 ad=0.5368p pd=3.32u as=0.4575p ps=1.97u w=1.22u l=0.5u
M1 ZN I VSS VPW nfet_05v0 ad=0.2255p pd=1.37u as=0.3608p ps=2.52u w=0.82u l=0.6u
M2 VSS I ZN VPW nfet_05v0 ad=0.3608p pd=2.52u as=0.2255p ps=1.37u w=0.82u l=0.6u
M3 ZN I VDD VNW pfet_05v0 ad=0.4575p pd=1.97u as=0.5368p ps=3.32u w=1.22u l=0.5u
.ends

.subckt gf180mcu_fd_sc_mcu7t5v0__nor4_2 A3 A4 VDD VSS ZN A1 A2 VNW VPW
M0 VSS A3 ZN VPW nfet_05v0 ad=0.126p pd=1.06u as=0.126p ps=1.06u w=0.36u l=0.6u
M1 a_1213_472# A2 a_943_472# VNW pfet_05v0 ad=0.3477p pd=1.79u as=0.5185p ps=2.07u w=1.22u l=0.5u
M2 VSS A2 ZN VPW nfet_05v0 ad=0.1584p pd=1.6u as=93.59999f ps=0.88u w=0.36u l=0.6u
M3 a_943_472# A3 a_683_472# VNW pfet_05v0 ad=0.5185p pd=2.07u as=0.488p ps=2.02u w=1.22u l=0.5u
M4 VSS A1 ZN VPW nfet_05v0 ad=93.59999f pd=0.88u as=93.59999f ps=0.88u w=0.36u l=0.6u
M5 a_1661_472# A1 ZN VNW pfet_05v0 ad=0.3172p pd=1.74u as=0.4087p ps=1.89u w=1.22u l=0.5u
M6 VSS A4 ZN VPW nfet_05v0 ad=93.59999f pd=0.88u as=93.59999f ps=0.88u w=0.36u l=0.6u
M7 a_57_472# A2 a_1661_472# VNW pfet_05v0 ad=0.5368p pd=3.32u as=0.3172p ps=1.74u w=1.22u l=0.5u
M8 ZN A1 VSS VPW nfet_05v0 ad=93.59999f pd=0.88u as=93.59999f ps=0.88u w=0.36u l=0.6u
M9 VDD A4 a_245_472# VNW pfet_05v0 ad=0.3782p pd=1.84u as=0.3477p ps=1.79u w=1.22u l=0.5u
M10 ZN A2 VSS VPW nfet_05v0 ad=93.59999f pd=0.88u as=0.126p ps=1.06u w=0.36u l=0.6u
M11 ZN A4 VSS VPW nfet_05v0 ad=0.126p pd=1.06u as=93.59999f ps=0.88u w=0.36u l=0.6u
M12 a_245_472# A3 a_57_472# VNW pfet_05v0 ad=0.3477p pd=1.79u as=0.5368p ps=3.32u w=1.22u l=0.5u
M13 ZN A3 VSS VPW nfet_05v0 ad=93.59999f pd=0.88u as=0.1584p ps=1.6u w=0.36u l=0.6u
M14 ZN A1 a_1213_472# VNW pfet_05v0 ad=0.4087p pd=1.89u as=0.3477p ps=1.79u w=1.22u l=0.5u
M15 a_683_472# A4 VDD VNW pfet_05v0 ad=0.488p pd=2.02u as=0.3782p ps=1.84u w=1.22u l=0.5u
.ends

.subckt gf180mcu_fd_sc_mcu7t5v0__or3_4 A3 VDD VSS Z A1 A2 VNW VPW
M0 VSS a_244_68# Z VPW nfet_05v0 ad=0.3608p pd=2.52u as=0.2132p ps=1.34u w=0.82u l=0.6u
M1 Z a_244_68# VSS VPW nfet_05v0 ad=0.2132p pd=1.34u as=0.2132p ps=1.34u w=0.82u l=0.6u
M2 a_244_68# A1 VSS VPW nfet_05v0 ad=0.1729p pd=1.185u as=0.1729p ps=1.185u w=0.665u l=0.6u
M3 VDD A3 a_1120_472# VNW pfet_05v0 ad=0.549p pd=2.12u as=0.3782p ps=1.84u w=1.22u l=0.5u
M4 Z a_244_68# VSS VPW nfet_05v0 ad=0.2132p pd=1.34u as=0.26375p ps=1.52u w=0.82u l=0.6u
M5 Z a_244_68# VDD VNW pfet_05v0 ad=0.3477p pd=1.79u as=0.3782p ps=1.84u w=1.22u l=0.5u
M6 a_244_68# A3 VSS VPW nfet_05v0 ad=0.1729p pd=1.185u as=0.2926p ps=2.21u w=0.665u l=0.6u
M7 a_458_472# A2 a_244_472# VNW pfet_05v0 ad=0.3782p pd=1.84u as=0.3477p ps=1.79u w=1.22u l=0.5u
M8 a_244_472# A3 VDD VNW pfet_05v0 ad=0.3477p pd=1.79u as=0.5368p ps=3.32u w=1.22u l=0.5u
M9 a_1120_472# A2 a_906_472# VNW pfet_05v0 ad=0.3782p pd=1.84u as=0.3477p ps=1.79u w=1.22u l=0.5u
M10 VDD a_244_68# Z VNW pfet_05v0 ad=0.3782p pd=1.84u as=0.3477p ps=1.79u w=1.22u l=0.5u
M11 VSS A3 a_244_68# VPW nfet_05v0 ad=0.26375p pd=1.52u as=0.1729p ps=1.185u w=0.665u l=0.6u
M12 a_906_472# A1 a_244_68# VNW pfet_05v0 ad=0.3477p pd=1.79u as=0.3782p ps=1.84u w=1.22u l=0.5u
M13 Z a_244_68# VDD VNW pfet_05v0 ad=0.3477p pd=1.79u as=0.549p ps=2.12u w=1.22u l=0.5u
M14 a_244_68# A1 a_458_472# VNW pfet_05v0 ad=0.3782p pd=1.84u as=0.3782p ps=1.84u w=1.22u l=0.5u
M15 VDD a_244_68# Z VNW pfet_05v0 ad=0.5368p pd=3.32u as=0.3477p ps=1.79u w=1.22u l=0.5u
M16 VSS A1 a_244_68# VPW nfet_05v0 ad=0.1729p pd=1.185u as=0.1729p ps=1.185u w=0.665u l=0.6u
M17 VSS a_244_68# Z VPW nfet_05v0 ad=0.2132p pd=1.34u as=0.2132p ps=1.34u w=0.82u l=0.6u
M18 VSS A2 a_244_68# VPW nfet_05v0 ad=0.1729p pd=1.185u as=0.1729p ps=1.185u w=0.665u l=0.6u
M19 a_244_68# A2 VSS VPW nfet_05v0 ad=0.1729p pd=1.185u as=0.1729p ps=1.185u w=0.665u l=0.6u
.ends

.subckt gf180mcu_fd_sc_mcu7t5v0__nand4_2 A3 A4 VDD VSS ZN A1 A2 VNW VPW
M0 a_1458_68# A3 a_1254_68# VPW nfet_05v0 ad=0.1517p pd=1.19u as=0.1722p ps=1.24u w=0.82u l=0.6u
M1 a_632_68# A2 a_438_68# VPW nfet_05v0 ad=0.1722p pd=1.24u as=0.1517p ps=1.19u w=0.82u l=0.6u
M2 VDD A4 ZN VNW pfet_05v0 ad=0.2197p pd=1.365u as=0.3718p ps=2.57u w=0.845u l=0.5u
M3 a_244_68# A4 VSS VPW nfet_05v0 ad=0.1517p pd=1.19u as=0.3608p ps=2.52u w=0.82u l=0.6u
M4 ZN A3 VDD VNW pfet_05v0 ad=0.2197p pd=1.365u as=0.2197p ps=1.365u w=0.845u l=0.5u
M5 a_438_68# A3 a_244_68# VPW nfet_05v0 ad=0.1517p pd=1.19u as=0.1517p ps=1.19u w=0.82u l=0.6u
M6 VDD A2 ZN VNW pfet_05v0 ad=0.2197p pd=1.365u as=0.2197p ps=1.365u w=0.845u l=0.5u
M7 ZN A1 a_632_68# VPW nfet_05v0 ad=0.2132p pd=1.34u as=0.1722p ps=1.24u w=0.82u l=0.6u
M8 ZN A1 VDD VNW pfet_05v0 ad=0.2197p pd=1.365u as=0.2197p ps=1.365u w=0.845u l=0.5u
M9 VDD A1 ZN VNW pfet_05v0 ad=0.2197p pd=1.365u as=0.2197p ps=1.365u w=0.845u l=0.5u
M10 a_1060_68# A1 ZN VPW nfet_05v0 ad=0.1517p pd=1.19u as=0.2132p ps=1.34u w=0.82u l=0.6u
M11 a_1254_68# A2 a_1060_68# VPW nfet_05v0 ad=0.1722p pd=1.24u as=0.1517p ps=1.19u w=0.82u l=0.6u
M12 ZN A2 VDD VNW pfet_05v0 ad=0.2197p pd=1.365u as=0.2197p ps=1.365u w=0.845u l=0.5u
M13 VSS A4 a_1458_68# VPW nfet_05v0 ad=0.3608p pd=2.52u as=0.1517p ps=1.19u w=0.82u l=0.6u
M14 VDD A3 ZN VNW pfet_05v0 ad=0.2197p pd=1.365u as=0.2197p ps=1.365u w=0.845u l=0.5u
M15 ZN A4 VDD VNW pfet_05v0 ad=0.3718p pd=2.57u as=0.2197p ps=1.365u w=0.845u l=0.5u
.ends

.subckt gf180mcu_fd_sc_mcu7t5v0__and4_2 A3 A4 VDD VSS Z A1 A2 VNW VPW
M0 a_643_68# A3 a_439_68# VPW nfet_05v0 ad=0.1722p pd=1.24u as=0.1722p ps=1.24u w=0.82u l=0.6u
M1 a_255_68# A1 a_47_68# VPW nfet_05v0 ad=0.1312p pd=1.14u as=0.3608p ps=2.52u w=0.82u l=0.6u
M2 a_439_68# A2 a_255_68# VPW nfet_05v0 ad=0.1722p pd=1.24u as=0.1312p ps=1.14u w=0.82u l=0.6u
M3 VSS a_47_68# Z VPW nfet_05v0 ad=0.3608p pd=2.52u as=0.2132p ps=1.34u w=0.82u l=0.6u
M4 a_47_68# A1 VDD VNW pfet_05v0 ad=0.2223p pd=1.375u as=0.3762p ps=2.59u w=0.855u l=0.5u
M5 Z a_47_68# VDD VNW pfet_05v0 ad=0.3172p pd=1.74u as=0.37225p ps=1.92u w=1.22u l=0.5u
M6 VDD A2 a_47_68# VNW pfet_05v0 ad=0.2223p pd=1.375u as=0.2223p ps=1.375u w=0.855u l=0.5u
M7 VSS A4 a_643_68# VPW nfet_05v0 ad=0.2132p pd=1.34u as=0.1722p ps=1.24u w=0.82u l=0.6u
M8 a_47_68# A3 VDD VNW pfet_05v0 ad=0.2223p pd=1.375u as=0.2223p ps=1.375u w=0.855u l=0.5u
M9 VDD a_47_68# Z VNW pfet_05v0 ad=0.5368p pd=3.32u as=0.3172p ps=1.74u w=1.22u l=0.5u
M10 VDD A4 a_47_68# VNW pfet_05v0 ad=0.37225p pd=1.92u as=0.2223p ps=1.375u w=0.855u l=0.5u
M11 Z a_47_68# VSS VPW nfet_05v0 ad=0.2132p pd=1.34u as=0.2132p ps=1.34u w=0.82u l=0.6u
.ends

.subckt gf180mcu_fd_sc_mcu7t5v0__aoi22_2 B1 B2 VDD VSS ZN A1 A2 VNW VPW
M0 VDD B1 a_36_472# VNW pfet_05v0 ad=0.3159p pd=1.735u as=0.3159p ps=1.735u w=1.215u l=0.5u
M1 VSS A2 a_1468_69# VPW nfet_05v0 ad=0.3586p pd=2.51u as=0.1304p ps=1.135u w=0.815u l=0.6u
M2 a_36_472# B2 VDD VNW pfet_05v0 ad=0.3159p pd=1.735u as=0.3159p ps=1.735u w=1.215u l=0.5u
M3 ZN A2 a_36_472# VNW pfet_05v0 ad=0.3159p pd=1.735u as=0.3159p ps=1.735u w=1.215u l=0.5u
M4 a_36_472# A1 ZN VNW pfet_05v0 ad=0.3159p pd=1.735u as=0.3159p ps=1.735u w=1.215u l=0.5u
M5 ZN B1 a_244_69# VPW nfet_05v0 ad=0.22615p pd=1.37u as=0.1304p ps=1.135u w=0.815u l=0.6u
M6 a_659_69# B1 ZN VPW nfet_05v0 ad=0.116125p pd=1.1u as=0.22615p ps=1.37u w=0.815u l=0.6u
M7 a_244_69# B2 VSS VPW nfet_05v0 ad=0.1304p pd=1.135u as=0.3586p ps=2.51u w=0.815u l=0.6u
M8 ZN A1 a_36_472# VNW pfet_05v0 ad=0.3159p pd=1.735u as=0.3159p ps=1.735u w=1.215u l=0.5u
M9 a_1468_69# A1 ZN VPW nfet_05v0 ad=0.1304p pd=1.135u as=0.2119p ps=1.335u w=0.815u l=0.6u
M10 a_36_472# A2 ZN VNW pfet_05v0 ad=0.5346p pd=3.31u as=0.3159p ps=1.735u w=1.215u l=0.5u
M11 VSS B2 a_659_69# VPW nfet_05v0 ad=0.2119p pd=1.335u as=0.116125p ps=1.1u w=0.815u l=0.6u
M12 VDD B2 a_36_472# VNW pfet_05v0 ad=0.3159p pd=1.735u as=0.5346p ps=3.31u w=1.215u l=0.5u
M13 ZN A1 a_1060_69# VPW nfet_05v0 ad=0.2119p pd=1.335u as=0.1304p ps=1.135u w=0.815u l=0.6u
M14 a_36_472# B1 VDD VNW pfet_05v0 ad=0.3159p pd=1.735u as=0.3159p ps=1.735u w=1.215u l=0.5u
M15 a_1060_69# A2 VSS VPW nfet_05v0 ad=0.1304p pd=1.135u as=0.2119p ps=1.335u w=0.815u l=0.6u
.ends

.subckt gf180mcu_fd_sc_mcu7t5v0__oai221_2 A2 A1 B1 C B2 ZN VSS VDD VNW VPW
M0 ZN B1 a_224_497# VNW pfet_05v0 ad=0.2847p pd=1.615u as=0.3942p ps=1.815u w=1.095u l=0.5u
M1 a_672_497# B1 ZN VNW pfet_05v0 ad=0.3942p pd=1.815u as=0.2847p ps=1.615u w=1.095u l=0.5u
M2 a_244_68# B1 VSS VPW nfet_05v0 ad=0.2132p pd=1.34u as=0.2132p ps=1.34u w=0.82u l=0.6u
M3 a_244_68# B2 VSS VPW nfet_05v0 ad=0.2132p pd=1.34u as=0.3608p ps=2.52u w=0.82u l=0.6u
M4 a_1076_93# A2 ZN VPW nfet_05v0 ad=0.2132p pd=1.34u as=0.2132p ps=1.34u w=0.82u l=0.6u
M5 a_1076_93# C a_244_68# VPW nfet_05v0 ad=0.2132p pd=1.34u as=0.2132p ps=1.34u w=0.82u l=0.6u
M6 VDD C ZN VNW pfet_05v0 ad=0.2561p pd=1.505u as=0.5319p ps=3.05u w=0.985u l=0.5u
M7 a_2160_497# A2 VDD VNW pfet_05v0 ad=0.4599p pd=1.935u as=0.2847p ps=1.615u w=1.095u l=0.5u
M8 ZN C VDD VNW pfet_05v0 ad=0.3766p pd=1.815u as=0.2561p ps=1.505u w=0.985u l=0.5u
M9 VDD B2 a_672_497# VNW pfet_05v0 ad=0.4818p pd=3.07u as=0.3942p ps=1.815u w=1.095u l=0.5u
M10 VDD A2 a_1732_497# VNW pfet_05v0 ad=0.2847p pd=1.615u as=0.33945p ps=1.715u w=1.095u l=0.5u
M11 ZN A1 a_1076_93# VPW nfet_05v0 ad=0.2132p pd=1.34u as=0.2132p ps=1.34u w=0.82u l=0.6u
M12 a_1076_93# A1 ZN VPW nfet_05v0 ad=0.3608p pd=2.52u as=0.30965p ps=1.685u w=0.82u l=0.6u
M13 a_244_68# C a_1076_93# VPW nfet_05v0 ad=0.2132p pd=1.34u as=0.3608p ps=2.52u w=0.82u l=0.6u
M14 ZN A2 a_1076_93# VPW nfet_05v0 ad=0.30965p pd=1.685u as=0.2132p ps=1.34u w=0.82u l=0.6u
M15 VSS B2 a_244_68# VPW nfet_05v0 ad=0.3608p pd=2.52u as=0.2132p ps=1.34u w=0.82u l=0.6u
M16 VSS B1 a_244_68# VPW nfet_05v0 ad=0.2132p pd=1.34u as=0.2132p ps=1.34u w=0.82u l=0.6u
M17 ZN A1 a_2160_497# VNW pfet_05v0 ad=0.4818p pd=3.07u as=0.4599p ps=1.935u w=1.095u l=0.5u
M18 a_224_497# B2 VDD VNW pfet_05v0 ad=0.3942p pd=1.815u as=0.4818p ps=3.07u w=1.095u l=0.5u
M19 a_1732_497# A1 ZN VNW pfet_05v0 ad=0.33945p pd=1.715u as=0.3766p ps=1.815u w=1.095u l=0.5u
.ends

.subckt gf180mcu_fd_sc_mcu7t5v0__xor3_2 A3 VDD VSS Z A1 A2 VNW VPW
M0 VDD a_725_93# a_2153_497# VNW pfet_05v0 ad=0.5694p pd=3.23u as=0.312075p ps=1.665u w=1.095u l=0.5u
M1 a_89_534# A2 VSS VPW nfet_05v0 ad=93.59999f pd=0.88u as=0.1584p ps=1.6u w=0.36u l=0.6u
M2 VSS A2 a_949_93# VPW nfet_05v0 ad=0.1584p pd=1.6u as=57.599995f ps=0.68u w=0.36u l=0.6u
M3 a_1943_497# A3 a_1949_68# VPW nfet_05v0 ad=0.4161p pd=1.905u as=0.2132p ps=1.34u w=0.82u l=0.6u
M4 Z a_1943_497# VDD VNW pfet_05v0 ad=0.5368p pd=3.32u as=0.3782p ps=1.84u w=1.22u l=0.5u
M5 a_1297_93# a_725_93# VDD VNW pfet_05v0 ad=0.1456p pd=1.08u as=0.2464p ps=2u w=0.56u l=0.5u
M6 a_2153_497# A3 a_1943_497# VNW pfet_05v0 ad=0.312075p pd=1.665u as=0.301125p ps=1.645u w=1.095u l=0.5u
M7 VSS A1 a_89_534# VPW nfet_05v0 ad=93.59999f pd=0.88u as=93.59999f ps=0.88u w=0.36u l=0.6u
M8 VDD A3 a_1297_93# VNW pfet_05v0 ad=0.3249p pd=1.835u as=0.1456p ps=1.08u w=0.56u l=0.5u
M9 a_1943_497# a_1297_93# VDD VNW pfet_05v0 ad=0.301125p pd=1.645u as=0.3249p ps=1.835u w=1.095u l=0.5u
M10 a_1949_68# a_725_93# a_1943_497# VPW nfet_05v0 ad=0.3608p pd=2.52u as=0.4161p ps=1.905u w=0.82u l=0.6u
M11 VSS A3 a_1505_93# VPW nfet_05v0 ad=0.218p pd=1.52u as=57.599995f ps=0.68u w=0.36u l=0.6u
M12 a_1505_93# a_725_93# a_1297_93# VPW nfet_05v0 ad=57.599995f pd=0.68u as=0.1584p ps=1.6u w=0.36u l=0.6u
M13 VDD a_1943_497# Z VNW pfet_05v0 ad=0.3782p pd=1.84u as=0.5368p ps=3.32u w=1.22u l=0.5u
M14 VDD A1 a_277_534# VNW pfet_05v0 ad=0.166p pd=1.26u as=0.1026p ps=0.93u w=0.36u l=0.5u
M15 a_1949_68# a_1297_93# VSS VPW nfet_05v0 ad=0.2132p pd=1.34u as=0.218p ps=1.52u w=0.82u l=0.6u
M16 a_949_93# A1 a_725_93# VPW nfet_05v0 ad=57.599995f pd=0.68u as=93.59999f ps=0.88u w=0.36u l=0.6u
M17 Z a_1943_497# VSS VPW nfet_05v0 ad=0.3608p pd=2.52u as=0.2132p ps=1.34u w=0.82u l=0.6u
M18 a_731_494# a_89_534# VDD VNW pfet_05v0 ad=0.1456p pd=1.08u as=0.166p ps=1.26u w=0.56u l=0.5u
M19 a_277_534# A2 a_89_534# VNW pfet_05v0 ad=0.1026p pd=0.93u as=0.1584p ps=1.6u w=0.36u l=0.5u
M20 a_725_93# A1 a_731_494# VNW pfet_05v0 ad=0.1456p pd=1.08u as=0.1456p ps=1.08u w=0.56u l=0.5u
M21 a_725_93# a_89_534# VSS VPW nfet_05v0 ad=93.59999f pd=0.88u as=93.59999f ps=0.88u w=0.36u l=0.6u
M22 VSS a_1943_497# Z VPW nfet_05v0 ad=0.2132p pd=1.34u as=0.3608p ps=2.52u w=0.82u l=0.6u
M23 a_731_494# A2 a_725_93# VNW pfet_05v0 ad=0.2464p pd=2u as=0.1456p ps=1.08u w=0.56u l=0.5u
.ends

.subckt gf180mcu_fd_sc_mcu7t5v0__or3_2 A3 VDD VSS Z A1 A2 VNW VPW
M0 VDD A3 a_448_472# VNW pfet_05v0 ad=0.488p pd=2.02u as=0.3782p ps=1.84u w=1.22u l=0.5u
M1 VSS A3 a_36_68# VPW nfet_05v0 ad=0.26375p pd=1.52u as=0.1729p ps=1.185u w=0.665u l=0.6u
M2 Z a_36_68# VDD VNW pfet_05v0 ad=0.3782p pd=1.84u as=0.488p ps=2.02u w=1.22u l=0.5u
M3 VSS A1 a_36_68# VPW nfet_05v0 ad=0.1729p pd=1.185u as=0.2926p ps=2.21u w=0.665u l=0.6u
M4 VSS a_36_68# Z VPW nfet_05v0 ad=0.3608p pd=2.52u as=0.2132p ps=1.34u w=0.82u l=0.6u
M5 a_244_472# A1 a_36_68# VNW pfet_05v0 ad=0.3172p pd=1.74u as=0.5368p ps=3.32u w=1.22u l=0.5u
M6 a_448_472# A2 a_244_472# VNW pfet_05v0 ad=0.3782p pd=1.84u as=0.3172p ps=1.74u w=1.22u l=0.5u
M7 Z a_36_68# VSS VPW nfet_05v0 ad=0.2132p pd=1.34u as=0.26375p ps=1.52u w=0.82u l=0.6u
M8 VDD a_36_68# Z VNW pfet_05v0 ad=0.5368p pd=3.32u as=0.3782p ps=1.84u w=1.22u l=0.5u
M9 a_36_68# A2 VSS VPW nfet_05v0 ad=0.1729p pd=1.185u as=0.1729p ps=1.185u w=0.665u l=0.6u
.ends

.subckt gf180mcu_fd_sc_mcu7t5v0__inv_12 VSS ZN I VDD VNW VPW
M0 ZN I VDD VNW pfet_05v0 ad=0.3782p pd=1.84u as=0.3782p ps=1.84u w=1.22u l=0.5u
M1 ZN I VDD VNW pfet_05v0 ad=0.3782p pd=1.84u as=0.3782p ps=1.84u w=1.22u l=0.5u
M2 ZN I VSS VPW nfet_05v0 ad=0.2132p pd=1.34u as=0.2132p ps=1.34u w=0.82u l=0.6u
M3 VSS I ZN VPW nfet_05v0 ad=0.3608p pd=2.52u as=0.2132p ps=1.34u w=0.82u l=0.6u
M4 VDD I ZN VNW pfet_05v0 ad=0.3782p pd=1.84u as=0.3782p ps=1.84u w=1.22u l=0.5u
M5 ZN I VDD VNW pfet_05v0 ad=0.3782p pd=1.84u as=0.3782p ps=1.84u w=1.22u l=0.5u
M6 ZN I VSS VPW nfet_05v0 ad=0.2132p pd=1.34u as=0.3608p ps=2.52u w=0.82u l=0.6u
M7 ZN I VSS VPW nfet_05v0 ad=0.2132p pd=1.34u as=0.2132p ps=1.34u w=0.82u l=0.6u
M8 VDD I ZN VNW pfet_05v0 ad=0.3782p pd=1.84u as=0.3782p ps=1.84u w=1.22u l=0.5u
M9 ZN I VSS VPW nfet_05v0 ad=0.2132p pd=1.34u as=0.2132p ps=1.34u w=0.82u l=0.6u
M10 ZN I VSS VPW nfet_05v0 ad=0.2132p pd=1.34u as=0.2132p ps=1.34u w=0.82u l=0.6u
M11 VDD I ZN VNW pfet_05v0 ad=0.3782p pd=1.84u as=0.3782p ps=1.84u w=1.22u l=0.5u
M12 VDD I ZN VNW pfet_05v0 ad=0.3782p pd=1.84u as=0.3782p ps=1.84u w=1.22u l=0.5u
M13 ZN I VDD VNW pfet_05v0 ad=0.3782p pd=1.84u as=0.3782p ps=1.84u w=1.22u l=0.5u
M14 VSS I ZN VPW nfet_05v0 ad=0.2132p pd=1.34u as=0.2132p ps=1.34u w=0.82u l=0.6u
M15 VDD I ZN VNW pfet_05v0 ad=0.3782p pd=1.84u as=0.3782p ps=1.84u w=1.22u l=0.5u
M16 VSS I ZN VPW nfet_05v0 ad=0.2132p pd=1.34u as=0.2132p ps=1.34u w=0.82u l=0.6u
M17 VDD I ZN VNW pfet_05v0 ad=0.5368p pd=3.32u as=0.3782p ps=1.84u w=1.22u l=0.5u
M18 VSS I ZN VPW nfet_05v0 ad=0.2132p pd=1.34u as=0.2132p ps=1.34u w=0.82u l=0.6u
M19 ZN I VDD VNW pfet_05v0 ad=0.3782p pd=1.84u as=0.3782p ps=1.84u w=1.22u l=0.5u
M20 VSS I ZN VPW nfet_05v0 ad=0.2132p pd=1.34u as=0.2132p ps=1.34u w=0.82u l=0.6u
M21 ZN I VDD VNW pfet_05v0 ad=0.3782p pd=1.84u as=0.5368p ps=3.32u w=1.22u l=0.5u
M22 VSS I ZN VPW nfet_05v0 ad=0.2132p pd=1.34u as=0.2132p ps=1.34u w=0.82u l=0.6u
M23 ZN I VSS VPW nfet_05v0 ad=0.2132p pd=1.34u as=0.2132p ps=1.34u w=0.82u l=0.6u
.ends

.subckt gf180mcu_fd_sc_mcu7t5v0__clkbuf_16 VDD VSS Z I VNW VPW
M0 VSS I a_224_552# VPW nfet_05v0 ad=0.1053p pd=0.925u as=0.1053p ps=0.925u w=0.405u l=0.6u
M1 VSS a_224_552# Z VPW nfet_05v0 ad=0.1261p pd=1.005u as=0.1261p ps=1.005u w=0.485u l=0.6u
M2 a_224_552# I VDD VNW pfet_05v0 ad=0.2542p pd=1.44u as=0.2542p ps=1.44u w=0.82u l=0.5u
M3 Z a_224_552# VDD VNW pfet_05v0 ad=0.3782p pd=1.84u as=0.3782p ps=1.84u w=1.22u l=0.5u
M4 Z a_224_552# VSS VPW nfet_05v0 ad=0.1261p pd=1.005u as=0.1261p ps=1.005u w=0.485u l=0.6u
M5 VDD a_224_552# Z VNW pfet_05v0 ad=0.3782p pd=1.84u as=0.3782p ps=1.84u w=1.22u l=0.5u
M6 VDD a_224_552# Z VNW pfet_05v0 ad=0.3782p pd=1.84u as=0.3782p ps=1.84u w=1.22u l=0.5u
M7 Z a_224_552# VDD VNW pfet_05v0 ad=0.3782p pd=1.84u as=0.3782p ps=1.84u w=1.22u l=0.5u
M8 a_224_552# I VDD VNW pfet_05v0 ad=0.2542p pd=1.44u as=0.3608p ps=2.52u w=0.82u l=0.5u
M9 VDD a_224_552# Z VNW pfet_05v0 ad=0.3782p pd=1.84u as=0.3782p ps=1.84u w=1.22u l=0.5u
M10 Z a_224_552# VSS VPW nfet_05v0 ad=0.1261p pd=1.005u as=0.1261p ps=1.005u w=0.485u l=0.6u
M11 VSS a_224_552# Z VPW nfet_05v0 ad=0.1261p pd=1.005u as=0.1261p ps=1.005u w=0.485u l=0.6u
M12 VSS a_224_552# Z VPW nfet_05v0 ad=0.1261p pd=1.005u as=0.1261p ps=1.005u w=0.485u l=0.6u
M13 VDD a_224_552# Z VNW pfet_05v0 ad=0.5368p pd=3.32u as=0.3782p ps=1.84u w=1.22u l=0.5u
M14 Z a_224_552# VSS VPW nfet_05v0 ad=0.1261p pd=1.005u as=0.1261p ps=1.005u w=0.485u l=0.6u
M15 VSS I a_224_552# VPW nfet_05v0 ad=0.1053p pd=0.925u as=0.1782p ps=1.69u w=0.405u l=0.6u
M16 a_224_552# I VDD VNW pfet_05v0 ad=0.2542p pd=1.44u as=0.2542p ps=1.44u w=0.82u l=0.5u
M17 a_224_552# I VSS VPW nfet_05v0 ad=0.1053p pd=0.925u as=0.1053p ps=0.925u w=0.405u l=0.6u
M18 VSS a_224_552# Z VPW nfet_05v0 ad=0.1261p pd=1.005u as=0.1261p ps=1.005u w=0.485u l=0.6u
M19 Z a_224_552# VDD VNW pfet_05v0 ad=0.3782p pd=1.84u as=0.428p ps=2.02u w=1.22u l=0.5u
M20 VDD I a_224_552# VNW pfet_05v0 ad=0.2542p pd=1.44u as=0.2542p ps=1.44u w=0.82u l=0.5u
M21 Z a_224_552# VDD VNW pfet_05v0 ad=0.3782p pd=1.84u as=0.3782p ps=1.84u w=1.22u l=0.5u
M22 Z a_224_552# VDD VNW pfet_05v0 ad=0.3782p pd=1.84u as=0.3782p ps=1.84u w=1.22u l=0.5u
M23 VSS I a_224_552# VPW nfet_05v0 ad=0.1053p pd=0.925u as=0.1053p ps=0.925u w=0.405u l=0.6u
M24 VDD a_224_552# Z VNW pfet_05v0 ad=0.3782p pd=1.84u as=0.3782p ps=1.84u w=1.22u l=0.5u
M25 Z a_224_552# VSS VPW nfet_05v0 ad=0.1261p pd=1.005u as=0.1261p ps=1.005u w=0.485u l=0.6u
M26 VSS a_224_552# Z VPW nfet_05v0 ad=0.1261p pd=1.005u as=0.1261p ps=1.005u w=0.485u l=0.6u
M27 VSS a_224_552# Z VPW nfet_05v0 ad=0.1261p pd=1.005u as=0.1261p ps=1.005u w=0.485u l=0.6u
M28 VDD I a_224_552# VNW pfet_05v0 ad=0.428p pd=2.02u as=0.2542p ps=1.44u w=0.82u l=0.5u
M29 Z a_224_552# VDD VNW pfet_05v0 ad=0.3782p pd=1.84u as=0.3782p ps=1.84u w=1.22u l=0.5u
M30 a_224_552# I VSS VPW nfet_05v0 ad=0.1782p pd=1.69u as=0.1053p ps=0.925u w=0.405u l=0.6u
M31 Z a_224_552# VSS VPW nfet_05v0 ad=0.1261p pd=1.005u as=0.1261p ps=1.005u w=0.485u l=0.6u
M32 VSS a_224_552# Z VPW nfet_05v0 ad=0.1261p pd=1.005u as=0.1261p ps=1.005u w=0.485u l=0.6u
M33 Z a_224_552# VDD VNW pfet_05v0 ad=0.3782p pd=1.84u as=0.3782p ps=1.84u w=1.22u l=0.5u
M34 VSS a_224_552# Z VPW nfet_05v0 ad=0.2134p pd=1.85u as=0.1261p ps=1.005u w=0.485u l=0.6u
M35 VDD I a_224_552# VNW pfet_05v0 ad=0.2542p pd=1.44u as=0.2542p ps=1.44u w=0.82u l=0.5u
M36 VDD a_224_552# Z VNW pfet_05v0 ad=0.3782p pd=1.84u as=0.3782p ps=1.84u w=1.22u l=0.5u
M37 VDD a_224_552# Z VNW pfet_05v0 ad=0.3782p pd=1.84u as=0.3782p ps=1.84u w=1.22u l=0.5u
M38 Z a_224_552# VDD VNW pfet_05v0 ad=0.3782p pd=1.84u as=0.3782p ps=1.84u w=1.22u l=0.5u
M39 a_224_552# I VDD VNW pfet_05v0 ad=0.2542p pd=1.44u as=0.2542p ps=1.44u w=0.82u l=0.5u
M40 a_224_552# I VSS VPW nfet_05v0 ad=0.1053p pd=0.925u as=0.1053p ps=0.925u w=0.405u l=0.6u
M41 Z a_224_552# VSS VPW nfet_05v0 ad=0.1261p pd=1.005u as=0.2134p ps=1.85u w=0.485u l=0.6u
M42 VDD I a_224_552# VNW pfet_05v0 ad=0.2542p pd=1.44u as=0.2542p ps=1.44u w=0.82u l=0.5u
M43 VDD a_224_552# Z VNW pfet_05v0 ad=0.3782p pd=1.84u as=0.3782p ps=1.84u w=1.22u l=0.5u
M44 Z a_224_552# VSS VPW nfet_05v0 ad=0.1261p pd=1.005u as=0.1261p ps=1.005u w=0.485u l=0.6u
M45 Z a_224_552# VSS VPW nfet_05v0 ad=0.1261p pd=1.005u as=0.1261p ps=1.005u w=0.485u l=0.6u
.ends

.subckt gf180mcu_fd_sc_mcu7t5v0__aoi222_4 A1 ZN VSS VDD C2 C1 B2 B1 A2 VNW VPW
M0 ZN A2 a_1812_472# VNW pfet_05v0 ad=0.3172p pd=1.74u as=0.3172p ps=1.74u w=1.22u l=0.5u
M1 a_224_472# C2 VDD VNW pfet_05v0 ad=0.3172p pd=1.74u as=0.3172p ps=1.74u w=1.22u l=0.5u
M2 ZN A1 a_4876_68# VPW nfet_05v0 ad=0.3608p pd=2.52u as=0.1312p ps=1.14u w=0.82u l=0.6u
M3 a_1812_472# A1 ZN VNW pfet_05v0 ad=0.5368p pd=3.32u as=0.3172p ps=1.74u w=1.22u l=0.5u
M4 a_2010_68# B1 ZN VPW nfet_05v0 ad=0.1517p pd=1.19u as=0.4879p ps=2.01u w=0.82u l=0.6u
M5 VSS A2 a_3652_68# VPW nfet_05v0 ad=0.2132p pd=1.34u as=0.1312p ps=1.14u w=0.82u l=0.6u
M6 a_3652_68# A1 ZN VPW nfet_05v0 ad=0.1312p pd=1.14u as=0.2132p ps=1.34u w=0.82u l=0.6u
M7 VDD C1 a_224_472# VNW pfet_05v0 ad=0.3172p pd=1.74u as=0.3172p ps=1.74u w=1.22u l=0.5u
M8 a_244_68# C1 ZN VPW nfet_05v0 ad=0.1312p pd=1.14u as=0.3608p ps=2.52u w=0.82u l=0.6u
M9 VSS C2 a_244_68# VPW nfet_05v0 ad=0.2132p pd=1.34u as=0.1312p ps=1.14u w=0.82u l=0.6u
M10 a_1812_472# B2 a_224_472# VNW pfet_05v0 ad=0.3172p pd=1.74u as=0.3172p ps=1.74u w=1.22u l=0.5u
M11 a_1468_68# C2 VSS VPW nfet_05v0 ad=0.1312p pd=1.14u as=0.2132p ps=1.34u w=0.82u l=0.6u
M12 a_2428_68# B2 VSS VPW nfet_05v0 ad=0.1312p pd=1.14u as=0.2132p ps=1.34u w=0.82u l=0.6u
M13 a_224_472# C1 VDD VNW pfet_05v0 ad=0.3172p pd=1.74u as=0.3172p ps=1.74u w=1.22u l=0.5u
M14 a_4468_68# A1 ZN VPW nfet_05v0 ad=0.1312p pd=1.14u as=0.2132p ps=1.34u w=0.82u l=0.6u
M15 a_224_472# B2 a_1812_472# VNW pfet_05v0 ad=0.3172p pd=1.74u as=0.3172p ps=1.74u w=1.22u l=0.5u
M16 a_224_472# B1 a_1812_472# VNW pfet_05v0 ad=0.3172p pd=1.74u as=0.5368p ps=3.32u w=1.22u l=0.5u
M17 a_4060_68# A2 VSS VPW nfet_05v0 ad=0.1312p pd=1.14u as=0.2132p ps=1.34u w=0.82u l=0.6u
M18 a_1812_472# B1 a_224_472# VNW pfet_05v0 ad=0.3172p pd=1.74u as=0.3172p ps=1.74u w=1.22u l=0.5u
M19 a_652_68# C2 VSS VPW nfet_05v0 ad=0.1312p pd=1.14u as=0.2132p ps=1.34u w=0.82u l=0.6u
M20 ZN C1 a_652_68# VPW nfet_05v0 ad=0.2132p pd=1.34u as=0.1312p ps=1.14u w=0.82u l=0.6u
M21 VDD C2 a_224_472# VNW pfet_05v0 ad=0.3172p pd=1.74u as=0.3172p ps=1.74u w=1.22u l=0.5u
M22 a_2836_68# B1 ZN VPW nfet_05v0 ad=0.1312p pd=1.14u as=0.2132p ps=1.34u w=0.82u l=0.6u
M23 a_224_472# B2 a_1812_472# VNW pfet_05v0 ad=0.3172p pd=1.74u as=0.3172p ps=1.74u w=1.22u l=0.5u
M24 a_224_472# B1 a_1812_472# VNW pfet_05v0 ad=0.3172p pd=1.74u as=0.3172p ps=1.74u w=1.22u l=0.5u
M25 VSS C2 a_1060_68# VPW nfet_05v0 ad=0.2132p pd=1.34u as=0.1312p ps=1.14u w=0.82u l=0.6u
M26 a_224_472# C2 VDD VNW pfet_05v0 ad=0.3172p pd=1.74u as=0.3172p ps=1.74u w=1.22u l=0.5u
M27 VSS B2 a_2010_68# VPW nfet_05v0 ad=0.2132p pd=1.34u as=0.1517p ps=1.19u w=0.82u l=0.6u
M28 a_4876_68# A2 VSS VPW nfet_05v0 ad=0.1312p pd=1.14u as=0.2132p ps=1.34u w=0.82u l=0.6u
M29 a_1812_472# B1 a_224_472# VNW pfet_05v0 ad=0.3172p pd=1.74u as=0.3172p ps=1.74u w=1.22u l=0.5u
M30 a_1812_472# B2 a_224_472# VNW pfet_05v0 ad=0.3172p pd=1.74u as=0.3172p ps=1.74u w=1.22u l=0.5u
M31 a_1060_68# C1 ZN VPW nfet_05v0 ad=0.1312p pd=1.14u as=0.2132p ps=1.34u w=0.82u l=0.6u
M32 ZN A1 a_4060_68# VPW nfet_05v0 ad=0.2132p pd=1.34u as=0.1312p ps=1.14u w=0.82u l=0.6u
M33 VDD C1 a_224_472# VNW pfet_05v0 ad=0.5368p pd=3.32u as=0.3172p ps=1.74u w=1.22u l=0.5u
M34 ZN A1 a_1812_472# VNW pfet_05v0 ad=0.3172p pd=1.74u as=0.3172p ps=1.74u w=1.22u l=0.5u
M35 a_1812_472# A1 ZN VNW pfet_05v0 ad=0.3172p pd=1.74u as=0.3172p ps=1.74u w=1.22u l=0.5u
M36 ZN C1 a_1468_68# VPW nfet_05v0 ad=0.4879p pd=2.01u as=0.1312p ps=1.14u w=0.82u l=0.6u
M37 a_1812_472# A2 ZN VNW pfet_05v0 ad=0.3172p pd=1.74u as=0.3172p ps=1.74u w=1.22u l=0.5u
M38 ZN B1 a_2428_68# VPW nfet_05v0 ad=0.2132p pd=1.34u as=0.1312p ps=1.14u w=0.82u l=0.6u
M39 ZN A2 a_1812_472# VNW pfet_05v0 ad=0.3172p pd=1.74u as=0.3172p ps=1.74u w=1.22u l=0.5u
M40 ZN A1 a_1812_472# VNW pfet_05v0 ad=0.3172p pd=1.74u as=0.3172p ps=1.74u w=1.22u l=0.5u
M41 VSS A2 a_4468_68# VPW nfet_05v0 ad=0.2132p pd=1.34u as=0.1312p ps=1.14u w=0.82u l=0.6u
M42 a_224_472# C1 VDD VNW pfet_05v0 ad=0.3172p pd=1.74u as=0.5368p ps=3.32u w=1.22u l=0.5u
M43 a_1812_472# A2 ZN VNW pfet_05v0 ad=0.3172p pd=1.74u as=0.3172p ps=1.74u w=1.22u l=0.5u
M44 ZN B1 a_3244_68# VPW nfet_05v0 ad=0.2132p pd=1.34u as=0.1312p ps=1.14u w=0.82u l=0.6u
M45 a_3244_68# B2 VSS VPW nfet_05v0 ad=0.1312p pd=1.14u as=0.2132p ps=1.34u w=0.82u l=0.6u
M46 VDD C2 a_224_472# VNW pfet_05v0 ad=0.3172p pd=1.74u as=0.3172p ps=1.74u w=1.22u l=0.5u
M47 VSS B2 a_2836_68# VPW nfet_05v0 ad=0.2132p pd=1.34u as=0.1312p ps=1.14u w=0.82u l=0.6u
.ends

.subckt gf180mcu_fd_sc_mcu7t5v0__oai211_4 B C VDD VSS ZN A1 A2 VNW VPW
M0 VDD A2 a_1612_497# VNW pfet_05v0 ad=0.3766p pd=1.815u as=0.4599p ps=1.935u w=1.095u l=0.5u
M1 VDD C ZN VNW pfet_05v0 ad=0.2561p pd=1.505u as=0.2561p ps=1.505u w=0.985u l=0.5u
M2 ZN A1 a_36_68# VPW nfet_05v0 ad=0.2132p pd=1.34u as=0.2132p ps=1.34u w=0.82u l=0.6u
M3 a_716_497# A1 ZN VNW pfet_05v0 ad=0.3942p pd=1.815u as=0.2847p ps=1.615u w=1.095u l=0.5u
M4 VDD A2 a_716_497# VNW pfet_05v0 ad=0.2847p pd=1.615u as=0.3942p ps=1.815u w=1.095u l=0.5u
M5 ZN C VDD VNW pfet_05v0 ad=0.2561p pd=1.505u as=0.2561p ps=1.505u w=0.985u l=0.5u
M6 a_2124_68# B a_36_68# VPW nfet_05v0 ad=0.1722p pd=1.24u as=0.2132p ps=1.34u w=0.82u l=0.6u
M7 VDD C ZN VNW pfet_05v0 ad=0.2561p pd=1.505u as=0.2561p ps=1.505u w=0.985u l=0.5u
M8 ZN A2 a_36_68# VPW nfet_05v0 ad=0.30965p pd=1.685u as=0.3608p ps=2.52u w=0.82u l=0.6u
M9 a_36_68# A2 ZN VPW nfet_05v0 ad=0.2132p pd=1.34u as=0.30965p ps=1.685u w=0.82u l=0.6u
M10 VSS C a_2960_68# VPW nfet_05v0 ad=0.2132p pd=1.34u as=0.1312p ps=1.14u w=0.82u l=0.6u
M11 VDD B ZN VNW pfet_05v0 ad=0.2561p pd=1.505u as=0.2561p ps=1.505u w=0.985u l=0.5u
M12 ZN C VDD VNW pfet_05v0 ad=0.2561p pd=1.505u as=0.2561p ps=1.505u w=0.985u l=0.5u
M13 a_36_68# A2 ZN VPW nfet_05v0 ad=0.2132p pd=1.34u as=0.2132p ps=1.34u w=0.82u l=0.6u
M14 a_1164_497# A2 VDD VNW pfet_05v0 ad=0.3942p pd=1.815u as=0.2847p ps=1.615u w=1.095u l=0.5u
M15 ZN B VDD VNW pfet_05v0 ad=0.2561p pd=1.505u as=0.2561p ps=1.505u w=0.985u l=0.5u
M16 VDD B ZN VNW pfet_05v0 ad=0.4334p pd=2.85u as=0.2561p ps=1.505u w=0.985u l=0.5u
M17 a_36_68# A1 ZN VPW nfet_05v0 ad=0.2132p pd=1.34u as=0.30965p ps=1.685u w=0.82u l=0.6u
M18 a_36_68# B a_3368_68# VPW nfet_05v0 ad=0.3608p pd=2.52u as=0.1312p ps=1.14u w=0.82u l=0.6u
M19 a_244_497# A2 VDD VNW pfet_05v0 ad=0.4599p pd=1.935u as=0.4818p ps=3.07u w=1.095u l=0.5u
M20 VSS C a_2124_68# VPW nfet_05v0 ad=0.2132p pd=1.34u as=0.1722p ps=1.24u w=0.82u l=0.6u
M21 a_36_68# A1 ZN VPW nfet_05v0 ad=0.2132p pd=1.34u as=0.2132p ps=1.34u w=0.82u l=0.6u
M22 ZN A1 a_1164_497# VNW pfet_05v0 ad=0.2847p pd=1.615u as=0.3942p ps=1.815u w=1.095u l=0.5u
M23 a_36_68# B a_2552_68# VPW nfet_05v0 ad=0.2132p pd=1.34u as=0.1312p ps=1.14u w=0.82u l=0.6u
M24 a_2552_68# C VSS VPW nfet_05v0 ad=0.1312p pd=1.14u as=0.2132p ps=1.34u w=0.82u l=0.6u
M25 a_1612_497# A1 ZN VNW pfet_05v0 ad=0.4599p pd=1.935u as=0.2847p ps=1.615u w=1.095u l=0.5u
M26 ZN A1 a_36_68# VPW nfet_05v0 ad=0.30965p pd=1.685u as=0.2132p ps=1.34u w=0.82u l=0.6u
M27 ZN A2 a_36_68# VPW nfet_05v0 ad=0.2132p pd=1.34u as=0.2132p ps=1.34u w=0.82u l=0.6u
M28 a_3368_68# C VSS VPW nfet_05v0 ad=0.1312p pd=1.14u as=0.2132p ps=1.34u w=0.82u l=0.6u
M29 ZN B VDD VNW pfet_05v0 ad=0.2561p pd=1.505u as=0.3766p ps=1.815u w=0.985u l=0.5u
M30 a_2960_68# B a_36_68# VPW nfet_05v0 ad=0.1312p pd=1.14u as=0.2132p ps=1.34u w=0.82u l=0.6u
M31 ZN A1 a_244_497# VNW pfet_05v0 ad=0.2847p pd=1.615u as=0.4599p ps=1.935u w=1.095u l=0.5u
.ends

.subckt gf180mcu_fd_sc_mcu7t5v0__mux2_4 S VDD VSS Z I0 I1 VNW VPW
M0 VSS a_135_24# Z VPW nfet_05v0 ad=0.2132p pd=1.34u as=0.2132p ps=1.34u w=0.82u l=0.6u
M1 a_1151_68# I1 VSS VPW nfet_05v0 ad=98.399994f pd=1.06u as=0.2132p ps=1.34u w=0.82u l=0.6u
M2 VDD a_135_24# Z VNW pfet_05v0 ad=0.3782p pd=1.84u as=0.3782p ps=1.84u w=1.22u l=0.5u
M3 VSS I0 a_1543_68# VPW nfet_05v0 ad=0.2132p pd=1.34u as=0.1968p ps=1.3u w=0.82u l=0.6u
M4 Z a_135_24# VSS VPW nfet_05v0 ad=0.2132p pd=1.34u as=0.2132p ps=1.34u w=0.82u l=0.6u
M5 Z a_135_24# VSS VPW nfet_05v0 ad=0.2132p pd=1.34u as=0.3608p ps=2.52u w=0.82u l=0.6u
M6 a_135_24# a_1307_380# a_1151_472# VNW pfet_05v0 ad=0.3172p pd=1.74u as=0.4758p ps=2u w=1.22u l=0.5u
M7 a_1307_380# S VSS VPW nfet_05v0 ad=0.3608p pd=2.52u as=0.2132p ps=1.34u w=0.82u l=0.6u
M8 a_1611_472# S a_135_24# VNW pfet_05v0 ad=0.1464p pd=1.46u as=0.3172p ps=1.74u w=1.22u l=0.5u
M9 Z a_135_24# VDD VNW pfet_05v0 ad=0.3782p pd=1.84u as=0.5368p ps=3.32u w=1.22u l=0.5u
M10 VDD I0 a_1611_472# VNW pfet_05v0 ad=0.3172p pd=1.74u as=0.1464p ps=1.46u w=1.22u l=0.5u
M11 a_135_24# S a_1151_68# VPW nfet_05v0 ad=0.2132p pd=1.34u as=98.399994f ps=1.06u w=0.82u l=0.6u
M12 a_1307_380# S VDD VNW pfet_05v0 ad=0.5368p pd=3.32u as=0.3172p ps=1.74u w=1.22u l=0.5u
M13 Z a_135_24# VDD VNW pfet_05v0 ad=0.3477p pd=1.79u as=0.3782p ps=1.84u w=1.22u l=0.5u
M14 a_1543_68# a_1307_380# a_135_24# VPW nfet_05v0 ad=0.1968p pd=1.3u as=0.2132p ps=1.34u w=0.82u l=0.6u
M15 VDD a_135_24# Z VNW pfet_05v0 ad=0.4392p pd=1.94u as=0.3477p ps=1.79u w=1.22u l=0.5u
M16 VSS a_135_24# Z VPW nfet_05v0 ad=0.2132p pd=1.34u as=0.2132p ps=1.34u w=0.82u l=0.6u
M17 a_1151_472# I1 VDD VNW pfet_05v0 ad=0.4758p pd=2u as=0.4392p ps=1.94u w=1.22u l=0.5u
.ends

.subckt gf180mcu_fd_sc_mcu7t5v0__clkinv_8 VDD VSS ZN I VNW VPW
M0 ZN I VDD VNW pfet_05v0 ad=0.3782p pd=1.84u as=0.3782p ps=1.84u w=1.22u l=0.5u
M1 ZN I VSS VPW nfet_05v0 ad=0.1248p pd=1u as=0.1248p ps=1u w=0.48u l=0.6u
M2 VSS I ZN VPW nfet_05v0 ad=0.1248p pd=1u as=0.1248p ps=1u w=0.48u l=0.6u
M3 VDD I ZN VNW pfet_05v0 ad=0.3782p pd=1.84u as=0.3782p ps=1.84u w=1.22u l=0.5u
M4 ZN I VSS VPW nfet_05v0 ad=0.1248p pd=1u as=0.1248p ps=1u w=0.48u l=0.6u
M5 VDD I ZN VNW pfet_05v0 ad=0.5368p pd=3.32u as=0.3782p ps=1.84u w=1.22u l=0.5u
M6 ZN I VSS VPW nfet_05v0 ad=0.1248p pd=1u as=0.2112p ps=1.84u w=0.48u l=0.6u
M7 VDD I ZN VNW pfet_05v0 ad=0.3782p pd=1.84u as=0.3782p ps=1.84u w=1.22u l=0.5u
M8 ZN I VSS VPW nfet_05v0 ad=0.1248p pd=1u as=0.1248p ps=1u w=0.48u l=0.6u
M9 ZN I VDD VNW pfet_05v0 ad=0.3782p pd=1.84u as=0.3782p ps=1.84u w=1.22u l=0.5u
M10 VDD I ZN VNW pfet_05v0 ad=0.3782p pd=1.84u as=0.3782p ps=1.84u w=1.22u l=0.5u
M11 VSS I ZN VPW nfet_05v0 ad=0.1248p pd=1u as=0.1248p ps=1u w=0.48u l=0.6u
M12 ZN I VDD VNW pfet_05v0 ad=0.3782p pd=1.84u as=0.3782p ps=1.84u w=1.22u l=0.5u
M13 VSS I ZN VPW nfet_05v0 ad=0.2112p pd=1.84u as=0.1248p ps=1u w=0.48u l=0.6u
M14 ZN I VDD VNW pfet_05v0 ad=0.3782p pd=1.84u as=0.5368p ps=3.32u w=1.22u l=0.5u
M15 VSS I ZN VPW nfet_05v0 ad=0.1248p pd=1u as=0.1248p ps=1u w=0.48u l=0.6u
.ends

.subckt gf180mcu_fd_sc_mcu7t5v0__or2_4 VDD VSS Z A1 A2 VNW VPW
M0 Z a_244_68# VSS VPW nfet_05v0 ad=0.2132p pd=1.34u as=0.2706p ps=1.48u w=0.82u l=0.6u
M1 a_244_68# A1 VSS VPW nfet_05v0 ad=0.2132p pd=1.34u as=0.2132p ps=1.34u w=0.82u l=0.6u
M2 VSS a_244_68# Z VPW nfet_05v0 ad=0.3608p pd=2.52u as=0.2132p ps=1.34u w=0.82u l=0.6u
M3 a_244_68# A2 VSS VPW nfet_05v0 ad=0.2132p pd=1.34u as=0.3608p ps=2.52u w=0.82u l=0.6u
M4 a_244_68# A1 a_244_472# VNW pfet_05v0 ad=0.3782p pd=1.84u as=0.3477p ps=1.79u w=1.22u l=0.5u
M5 VSS a_244_68# Z VPW nfet_05v0 ad=0.2132p pd=1.34u as=0.2132p ps=1.34u w=0.82u l=0.6u
M6 a_244_472# A2 VDD VNW pfet_05v0 ad=0.3477p pd=1.79u as=0.5368p ps=3.32u w=1.22u l=0.5u
M7 VDD a_244_68# Z VNW pfet_05v0 ad=0.5368p pd=3.32u as=0.3477p ps=1.79u w=1.22u l=0.5u
M8 VDD a_244_68# Z VNW pfet_05v0 ad=0.3477p pd=1.79u as=0.3782p ps=1.84u w=1.22u l=0.5u
M9 VDD A2 a_682_472# VNW pfet_05v0 ad=0.5246p pd=2.08u as=0.3477p ps=1.79u w=1.22u l=0.5u
M10 Z a_244_68# VDD VNW pfet_05v0 ad=0.3477p pd=1.79u as=0.3477p ps=1.79u w=1.22u l=0.5u
M11 a_682_472# A1 a_244_68# VNW pfet_05v0 ad=0.3477p pd=1.79u as=0.3782p ps=1.84u w=1.22u l=0.5u
M12 VSS A2 a_244_68# VPW nfet_05v0 ad=0.2706p pd=1.48u as=0.2132p ps=1.34u w=0.82u l=0.6u
M13 VSS A1 a_244_68# VPW nfet_05v0 ad=0.2132p pd=1.34u as=0.2132p ps=1.34u w=0.82u l=0.6u
M14 Z a_244_68# VDD VNW pfet_05v0 ad=0.3782p pd=1.84u as=0.5246p ps=2.08u w=1.22u l=0.5u
M15 Z a_244_68# VSS VPW nfet_05v0 ad=0.2132p pd=1.34u as=0.2132p ps=1.34u w=0.82u l=0.6u
.ends

.subckt gf180mcu_fd_sc_mcu7t5v0__or4_1 A3 A4 VDD VSS Z A1 A2 VNW VPW
M0 VSS A4 a_56_604# VPW nfet_05v0 ad=0.218p pd=1.52u as=93.59999f ps=0.88u w=0.36u l=0.6u
M1 Z a_56_604# VSS VPW nfet_05v0 ad=0.3608p pd=2.52u as=0.218p ps=1.52u w=0.82u l=0.6u
M2 Z a_56_604# VDD VNW pfet_05v0 ad=0.5368p pd=3.32u as=0.389p ps=2.02u w=1.22u l=0.5u
M3 VSS A2 a_56_604# VPW nfet_05v0 ad=93.59999f pd=0.88u as=0.126p ps=1.06u w=0.36u l=0.6u
M4 VDD A4 a_708_604# VNW pfet_05v0 ad=0.389p pd=2.02u as=0.1736p ps=1.18u w=0.56u l=0.5u
M5 a_244_604# A1 a_56_604# VNW pfet_05v0 ad=0.196p pd=1.26u as=0.2464p ps=2u w=0.56u l=0.5u
M6 a_56_604# A1 VSS VPW nfet_05v0 ad=0.126p pd=1.06u as=0.1584p ps=1.6u w=0.36u l=0.6u
M7 a_56_604# A3 VSS VPW nfet_05v0 ad=93.59999f pd=0.88u as=93.59999f ps=0.88u w=0.36u l=0.6u
M8 a_708_604# A3 a_484_604# VNW pfet_05v0 ad=0.1736p pd=1.18u as=0.1736p ps=1.18u w=0.56u l=0.5u
M9 a_484_604# A2 a_244_604# VNW pfet_05v0 ad=0.1736p pd=1.18u as=0.196p ps=1.26u w=0.56u l=0.5u
.ends

.subckt gf180mcu_fd_sc_mcu7t5v0__and3_2 A3 VDD VSS Z A1 A2 VNW VPW
M0 Z a_47_69# VSS VPW nfet_05v0 ad=0.2119p pd=1.335u as=0.2119p ps=1.335u w=0.815u l=0.6u
M1 VDD A1 a_47_69# VNW pfet_05v0 ad=0.2561p pd=1.505u as=0.4334p ps=2.85u w=0.985u l=0.5u
M2 Z a_47_69# VDD VNW pfet_05v0 ad=0.3159p pd=1.735u as=0.39075p ps=1.915u w=1.215u l=0.5u
M3 a_47_69# A2 VDD VNW pfet_05v0 ad=0.2561p pd=1.505u as=0.2561p ps=1.505u w=0.985u l=0.5u
M4 VDD a_47_69# Z VNW pfet_05v0 ad=0.5346p pd=3.31u as=0.3159p ps=1.735u w=1.215u l=0.5u
M5 VSS a_47_69# Z VPW nfet_05v0 ad=0.3586p pd=2.51u as=0.2119p ps=1.335u w=0.815u l=0.6u
M6 VSS A3 a_439_69# VPW nfet_05v0 ad=0.2119p pd=1.335u as=0.17115p ps=1.235u w=0.815u l=0.6u
M7 VDD A3 a_47_69# VNW pfet_05v0 ad=0.39075p pd=1.915u as=0.2561p ps=1.505u w=0.985u l=0.5u
M8 a_255_69# A1 a_47_69# VPW nfet_05v0 ad=0.1304p pd=1.135u as=0.3586p ps=2.51u w=0.815u l=0.6u
M9 a_439_69# A2 a_255_69# VPW nfet_05v0 ad=0.17115p pd=1.235u as=0.1304p ps=1.135u w=0.815u l=0.6u
.ends

.subckt gf180mcu_fd_sc_mcu7t5v0__mux2_2 S VDD VSS Z I0 I1 VNW VPW
M0 a_1152_472# S a_124_24# VNW pfet_05v0 ad=0.1464p pd=1.46u as=0.3172p ps=1.74u w=1.22u l=0.5u
M1 a_692_68# I1 VSS VPW nfet_05v0 ad=98.399994f pd=1.06u as=0.2132p ps=1.34u w=0.82u l=0.6u
M2 a_124_24# S a_692_68# VPW nfet_05v0 ad=0.2132p pd=1.34u as=98.399994f ps=1.06u w=0.82u l=0.6u
M3 Z a_124_24# VSS VPW nfet_05v0 ad=0.2132p pd=1.34u as=0.3608p ps=2.52u w=0.82u l=0.6u
M4 a_848_380# S VSS VPW nfet_05v0 ad=0.3608p pd=2.52u as=0.2132p ps=1.34u w=0.82u l=0.6u
M5 VDD a_124_24# Z VNW pfet_05v0 ad=0.4392p pd=1.94u as=0.3477p ps=1.79u w=1.22u l=0.5u
M6 VDD I0 a_1152_472# VNW pfet_05v0 ad=0.3172p pd=1.74u as=0.1464p ps=1.46u w=1.22u l=0.5u
M7 a_692_472# I1 VDD VNW pfet_05v0 ad=0.4758p pd=2u as=0.4392p ps=1.94u w=1.22u l=0.5u
M8 a_848_380# S VDD VNW pfet_05v0 ad=0.5368p pd=3.32u as=0.3172p ps=1.74u w=1.22u l=0.5u
M9 Z a_124_24# VDD VNW pfet_05v0 ad=0.3477p pd=1.79u as=0.5368p ps=3.32u w=1.22u l=0.5u
M10 VSS I0 a_1084_68# VPW nfet_05v0 ad=0.2132p pd=1.34u as=0.1968p ps=1.3u w=0.82u l=0.6u
M11 a_1084_68# a_848_380# a_124_24# VPW nfet_05v0 ad=0.1968p pd=1.3u as=0.2132p ps=1.34u w=0.82u l=0.6u
M12 VSS a_124_24# Z VPW nfet_05v0 ad=0.2132p pd=1.34u as=0.2132p ps=1.34u w=0.82u l=0.6u
M13 a_124_24# a_848_380# a_692_472# VNW pfet_05v0 ad=0.3172p pd=1.74u as=0.4758p ps=2u w=1.22u l=0.5u
.ends

.subckt gf180mcu_fd_sc_mcu7t5v0__or2_2 VDD VSS Z A1 A2 VNW VPW
M0 Z a_56_472# VSS VPW nfet_05v0 ad=0.2132p pd=1.34u as=0.2132p ps=1.34u w=0.82u l=0.6u
M1 a_56_472# A1 VSS VPW nfet_05v0 ad=0.2132p pd=1.34u as=0.3608p ps=2.52u w=0.82u l=0.6u
M2 a_244_472# A1 a_56_472# VNW pfet_05v0 ad=0.3172p pd=1.74u as=0.5368p ps=3.32u w=1.22u l=0.5u
M3 VDD A2 a_244_472# VNW pfet_05v0 ad=0.4087p pd=1.89u as=0.3172p ps=1.74u w=1.22u l=0.5u
M4 VDD a_56_472# Z VNW pfet_05v0 ad=0.5368p pd=3.32u as=0.3477p ps=1.79u w=1.22u l=0.5u
M5 Z a_56_472# VDD VNW pfet_05v0 ad=0.3477p pd=1.79u as=0.4087p ps=1.89u w=1.22u l=0.5u
M6 VSS a_56_472# Z VPW nfet_05v0 ad=0.3608p pd=2.52u as=0.2132p ps=1.34u w=0.82u l=0.6u
M7 VSS A2 a_56_472# VPW nfet_05v0 ad=0.2132p pd=1.34u as=0.2132p ps=1.34u w=0.82u l=0.6u
.ends

.subckt NanoCGRA_Lite clk clk_PD clk_PU rst_n rst_n_PD rst_n_PU uart_rx uart_rx_PD
+ uart_rx_PU uart_tx_CS uart_tx_IE uart_tx_IN uart_tx_OE uart_tx_OUT uart_tx_PD uart_tx_PDRV0
+ uart_tx_PDRV1 uart_tx_PU uart_tx_SL vdd vss
Xgf180mcu_fd_sc_mcu7t5v0__clkinv_1_310 vdd vss gf180mcu_fd_sc_mcu7t5v0__dffq_1_351/Q
+ gf180mcu_fd_sc_mcu7t5v0__nand4_1_6/A3 vdd vss gf180mcu_fd_sc_mcu7t5v0__clkinv_1
Xgf180mcu_fd_sc_mcu7t5v0__clkinv_1_321 vdd vss gf180mcu_fd_sc_mcu7t5v0__dffq_1_406/Q
+ gf180mcu_fd_sc_mcu7t5v0__nand4_1_9/A2 vdd vss gf180mcu_fd_sc_mcu7t5v0__clkinv_1
Xgf180mcu_fd_sc_mcu7t5v0__clkinv_1_332 vdd vss gf180mcu_fd_sc_mcu7t5v0__oai32_1_8/B1
+ gf180mcu_fd_sc_mcu7t5v0__xor2_1_137/A1 vdd vss gf180mcu_fd_sc_mcu7t5v0__clkinv_1
Xgf180mcu_fd_sc_mcu7t5v0__clkinv_1_343 vdd vss gf180mcu_fd_sc_mcu7t5v0__xor2_1_155/Z
+ gf180mcu_fd_sc_mcu7t5v0__xor2_1_154/A2 vdd vss gf180mcu_fd_sc_mcu7t5v0__clkinv_1
Xgf180mcu_fd_sc_mcu7t5v0__clkinv_1_354 vdd vss gf180mcu_fd_sc_mcu7t5v0__xor3_1_132/A1
+ gf180mcu_fd_sc_mcu7t5v0__aoi21_1_336/A1 vdd vss gf180mcu_fd_sc_mcu7t5v0__clkinv_1
Xgf180mcu_fd_sc_mcu7t5v0__clkinv_1_365 vdd vss gf180mcu_fd_sc_mcu7t5v0__dffq_1_185/Q
+ gf180mcu_fd_sc_mcu7t5v0__oai22_1_177/B2 vdd vss gf180mcu_fd_sc_mcu7t5v0__clkinv_1
Xgf180mcu_fd_sc_mcu7t5v0__nand2_4_40 vdd vss gf180mcu_fd_sc_mcu7t5v0__nand2_4_40/ZN
+ gf180mcu_fd_sc_mcu7t5v0__or2_1_20/A1 gf180mcu_fd_sc_mcu7t5v0__or2_1_21/A1 vdd vss
+ gf180mcu_fd_sc_mcu7t5v0__nand2_4
Xgf180mcu_fd_sc_mcu7t5v0__clkinv_3_15 vdd gf180mcu_fd_sc_mcu7t5v0__nor3_2_11/A2 gf180mcu_fd_sc_mcu7t5v0__or2_2_1/A1
+ vss vdd vss gf180mcu_fd_sc_mcu7t5v0__clkinv_3
Xgf180mcu_fd_sc_mcu7t5v0__dffq_4_1 gf180mcu_fd_sc_mcu7t5v0__dffq_4_1/D gf180mcu_fd_sc_mcu7t5v0__or2_4_0/A1
+ vdd vss gf180mcu_fd_sc_mcu7t5v0__dffq_4_1/CLK vdd vss gf180mcu_fd_sc_mcu7t5v0__dffq_4
Xgf180mcu_fd_sc_mcu7t5v0__nand2_1_160 vdd vss gf180mcu_fd_sc_mcu7t5v0__oai21_1_62/B
+ gf180mcu_fd_sc_mcu7t5v0__inv_8_0/I gf180mcu_fd_sc_mcu7t5v0__xor2_1_49/Z vdd vss
+ gf180mcu_fd_sc_mcu7t5v0__nand2_1
Xgf180mcu_fd_sc_mcu7t5v0__nand2_1_171 vdd vss gf180mcu_fd_sc_mcu7t5v0__nand2_1_171/ZN
+ gf180mcu_fd_sc_mcu7t5v0__or3_1_6/Z gf180mcu_fd_sc_mcu7t5v0__and3_1_6/A2 vdd vss
+ gf180mcu_fd_sc_mcu7t5v0__nand2_1
Xgf180mcu_fd_sc_mcu7t5v0__nand2_1_182 vdd vss gf180mcu_fd_sc_mcu7t5v0__xor2_1_54/A2
+ gf180mcu_fd_sc_mcu7t5v0__oai31_1_2/B gf180mcu_fd_sc_mcu7t5v0__or4_1_1/Z vdd vss
+ gf180mcu_fd_sc_mcu7t5v0__nand2_1
Xgf180mcu_fd_sc_mcu7t5v0__nand2_1_193 vdd vss gf180mcu_fd_sc_mcu7t5v0__aoi211_1_18/B
+ gf180mcu_fd_sc_mcu7t5v0__nand3_4_7/ZN gf180mcu_fd_sc_mcu7t5v0__oai32_1_2/ZN vdd
+ vss gf180mcu_fd_sc_mcu7t5v0__nand2_1
Xgf180mcu_fd_sc_mcu7t5v0__aoi221_1_9 gf180mcu_fd_sc_mcu7t5v0__nor2_2_2/ZN gf180mcu_fd_sc_mcu7t5v0__nor2_4_0/ZN
+ vdd vss gf180mcu_fd_sc_mcu7t5v0__oai21_1_52/B gf180mcu_fd_sc_mcu7t5v0__inv_8_2/I
+ gf180mcu_fd_sc_mcu7t5v0__nor2_4_1/ZN gf180mcu_fd_sc_mcu7t5v0__oai21_1_52/A2 vdd
+ vss gf180mcu_fd_sc_mcu7t5v0__aoi221_1
Xgf180mcu_fd_sc_mcu7t5v0__clkinv_4_0 vdd vss gf180mcu_fd_sc_mcu7t5v0__oai31_4_1/A1
+ gf180mcu_fd_sc_mcu7t5v0__nor2_2_8/A2 vdd vss gf180mcu_fd_sc_mcu7t5v0__clkinv_4
Xgf180mcu_fd_sc_mcu7t5v0__dffq_1_290 vdd gf180mcu_fd_sc_mcu7t5v0__mux2_2_0/I1 gf180mcu_fd_sc_mcu7t5v0__dffq_2_58/CLK
+ vss gf180mcu_fd_sc_mcu7t5v0__dffq_1_290/D vdd vss gf180mcu_fd_sc_mcu7t5v0__dffq_1
Xgf180mcu_fd_sc_mcu7t5v0__nand3_2_5 gf180mcu_fd_sc_mcu7t5v0__and2_2_2/A2 vdd vss gf180mcu_fd_sc_mcu7t5v0__xnor3_1_7/A3
+ gf180mcu_fd_sc_mcu7t5v0__inv_8_0/I gf180mcu_fd_sc_mcu7t5v0__or3_2_0/Z vdd vss gf180mcu_fd_sc_mcu7t5v0__nand3_2
Xgf180mcu_fd_sc_mcu7t5v0__xor2_1_19 vdd vss gf180mcu_fd_sc_mcu7t5v0__xor2_1_19/Z gf180mcu_fd_sc_mcu7t5v0__xor2_1_19/A1
+ gf180mcu_fd_sc_mcu7t5v0__xor2_1_19/A2 vdd vss gf180mcu_fd_sc_mcu7t5v0__xor2_1
Xgf180mcu_fd_sc_mcu7t5v0__xor2_1_104 vdd vss gf180mcu_fd_sc_mcu7t5v0__xor2_1_104/Z
+ gf180mcu_fd_sc_mcu7t5v0__xor2_1_104/A1 gf180mcu_fd_sc_mcu7t5v0__xor2_1_107/Z vdd
+ vss gf180mcu_fd_sc_mcu7t5v0__xor2_1
Xgf180mcu_fd_sc_mcu7t5v0__xor2_1_115 vdd vss gf180mcu_fd_sc_mcu7t5v0__xor3_1_79/A3
+ gf180mcu_fd_sc_mcu7t5v0__xor3_1_78/Z gf180mcu_fd_sc_mcu7t5v0__xor2_1_145/Z vdd vss
+ gf180mcu_fd_sc_mcu7t5v0__xor2_1
Xgf180mcu_fd_sc_mcu7t5v0__xor2_1_126 vdd vss gf180mcu_fd_sc_mcu7t5v0__or3_1_16/A3
+ gf180mcu_fd_sc_mcu7t5v0__dffq_4_37/Q gf180mcu_fd_sc_mcu7t5v0__xor2_1_124/Z vdd vss
+ gf180mcu_fd_sc_mcu7t5v0__xor2_1
Xgf180mcu_fd_sc_mcu7t5v0__xor2_1_137 vdd vss gf180mcu_fd_sc_mcu7t5v0__xor2_1_137/Z
+ gf180mcu_fd_sc_mcu7t5v0__xor2_1_137/A1 gf180mcu_fd_sc_mcu7t5v0__xor2_1_137/A2 vdd
+ vss gf180mcu_fd_sc_mcu7t5v0__xor2_1
Xgf180mcu_fd_sc_mcu7t5v0__xor2_1_148 vdd vss gf180mcu_fd_sc_mcu7t5v0__xor2_1_148/Z
+ gf180mcu_fd_sc_mcu7t5v0__dffq_2_79/Q gf180mcu_fd_sc_mcu7t5v0__xor2_1_148/A2 vdd
+ vss gf180mcu_fd_sc_mcu7t5v0__xor2_1
Xgf180mcu_fd_sc_mcu7t5v0__xor2_1_159 vdd vss gf180mcu_fd_sc_mcu7t5v0__xor2_1_159/Z
+ gf180mcu_fd_sc_mcu7t5v0__or3_1_21/Z gf180mcu_fd_sc_mcu7t5v0__xor3_2_2/A3 vdd vss
+ gf180mcu_fd_sc_mcu7t5v0__xor2_1
Xgf180mcu_fd_sc_mcu7t5v0__nor3_1_10 gf180mcu_fd_sc_mcu7t5v0__nor3_1_10/A3 vdd vss
+ gf180mcu_fd_sc_mcu7t5v0__nor3_1_10/ZN gf180mcu_fd_sc_mcu7t5v0__nor3_1_10/A1 gf180mcu_fd_sc_mcu7t5v0__or3_4_0/A1
+ vdd vss gf180mcu_fd_sc_mcu7t5v0__nor3_1
Xgf180mcu_fd_sc_mcu7t5v0__nor3_1_21 gf180mcu_fd_sc_mcu7t5v0__and3_1_12/Z vdd vss gf180mcu_fd_sc_mcu7t5v0__nor3_1_21/ZN
+ gf180mcu_fd_sc_mcu7t5v0__oai31_4_2/ZN gf180mcu_fd_sc_mcu7t5v0__nor3_1_21/A2 vdd
+ vss gf180mcu_fd_sc_mcu7t5v0__nor3_1
Xgf180mcu_fd_sc_mcu7t5v0__nor3_1_32 gf180mcu_fd_sc_mcu7t5v0__xor3_1_174/Z vdd vss
+ gf180mcu_fd_sc_mcu7t5v0__nor3_1_32/ZN gf180mcu_fd_sc_mcu7t5v0__nor3_1_32/A1 gf180mcu_fd_sc_mcu7t5v0__nor3_1_32/A2
+ vdd vss gf180mcu_fd_sc_mcu7t5v0__nor3_1
Xgf180mcu_fd_sc_mcu7t5v0__clkinv_1_140 vdd vss gf180mcu_fd_sc_mcu7t5v0__dffq_1_122/Q
+ gf180mcu_fd_sc_mcu7t5v0__oai22_1_129/B2 vdd vss gf180mcu_fd_sc_mcu7t5v0__clkinv_1
Xgf180mcu_fd_sc_mcu7t5v0__nor3_1_43 gf180mcu_fd_sc_mcu7t5v0__mux4_4_9/Z vdd vss gf180mcu_fd_sc_mcu7t5v0__nor3_1_43/ZN
+ gf180mcu_fd_sc_mcu7t5v0__mux4_4_6/Z gf180mcu_fd_sc_mcu7t5v0__mux4_4_19/Z vdd vss
+ gf180mcu_fd_sc_mcu7t5v0__nor3_1
Xgf180mcu_fd_sc_mcu7t5v0__clkinv_1_151 vdd vss gf180mcu_fd_sc_mcu7t5v0__dffq_1_129/Q
+ gf180mcu_fd_sc_mcu7t5v0__oai22_1_138/B2 vdd vss gf180mcu_fd_sc_mcu7t5v0__clkinv_1
Xgf180mcu_fd_sc_mcu7t5v0__clkinv_1_162 vdd vss gf180mcu_fd_sc_mcu7t5v0__dffq_1_145/Q
+ gf180mcu_fd_sc_mcu7t5v0__oai22_1_151/B2 vdd vss gf180mcu_fd_sc_mcu7t5v0__clkinv_1
Xgf180mcu_fd_sc_mcu7t5v0__clkinv_1_173 vdd vss gf180mcu_fd_sc_mcu7t5v0__dffq_1_152/Q
+ gf180mcu_fd_sc_mcu7t5v0__oai22_1_156/B2 vdd vss gf180mcu_fd_sc_mcu7t5v0__clkinv_1
Xgf180mcu_fd_sc_mcu7t5v0__clkinv_1_184 vdd vss gf180mcu_fd_sc_mcu7t5v0__dffq_1_187/Q
+ gf180mcu_fd_sc_mcu7t5v0__oai22_1_169/B2 vdd vss gf180mcu_fd_sc_mcu7t5v0__clkinv_1
Xgf180mcu_fd_sc_mcu7t5v0__clkinv_1_195 vdd vss gf180mcu_fd_sc_mcu7t5v0__dffq_1_174/Q
+ gf180mcu_fd_sc_mcu7t5v0__oai22_1_186/B2 vdd vss gf180mcu_fd_sc_mcu7t5v0__clkinv_1
Xgf180mcu_fd_sc_mcu7t5v0__nand3_1_19 gf180mcu_fd_sc_mcu7t5v0__xnor3_1_12/A2 vdd vss
+ gf180mcu_fd_sc_mcu7t5v0__nand3_1_19/ZN gf180mcu_fd_sc_mcu7t5v0__inv_4_6/I gf180mcu_fd_sc_mcu7t5v0__and2_4_0/Z
+ vdd vss gf180mcu_fd_sc_mcu7t5v0__nand3_1
Xgf180mcu_fd_sc_mcu7t5v0__inv_3_1 vss gf180mcu_fd_sc_mcu7t5v0__inv_3_1/ZN gf180mcu_fd_sc_mcu7t5v0__inv_3_1/I
+ vdd vdd vss gf180mcu_fd_sc_mcu7t5v0__inv_3
Xgf180mcu_fd_sc_mcu7t5v0__oai32_1_9 gf180mcu_fd_sc_mcu7t5v0__oai32_1_9/A3 gf180mcu_fd_sc_mcu7t5v0__xor3_1_136/Z
+ gf180mcu_fd_sc_mcu7t5v0__oai32_1_9/B2 vdd vss gf180mcu_fd_sc_mcu7t5v0__oai32_1_9/ZN
+ gf180mcu_fd_sc_mcu7t5v0__oai32_1_9/A1 gf180mcu_fd_sc_mcu7t5v0__oai32_1_9/A2 vdd
+ vss gf180mcu_fd_sc_mcu7t5v0__oai32_1
Xgf180mcu_fd_sc_mcu7t5v0__xnor3_1_50 gf180mcu_fd_sc_mcu7t5v0__nor3_1_1/A3 vdd vss
+ gf180mcu_fd_sc_mcu7t5v0__xor2_1_4/A2 gf180mcu_fd_sc_mcu7t5v0__xnor3_1_50/A1 gf180mcu_fd_sc_mcu7t5v0__xnor3_1_50/A2
+ vdd vss gf180mcu_fd_sc_mcu7t5v0__xnor3_1
Xgf180mcu_fd_sc_mcu7t5v0__aoi221_1_14 gf180mcu_fd_sc_mcu7t5v0__nor2_2_9/ZN gf180mcu_fd_sc_mcu7t5v0__nor2_4_3/ZN
+ vdd vss gf180mcu_fd_sc_mcu7t5v0__nand4_1_5/A4 gf180mcu_fd_sc_mcu7t5v0__inv_4_6/I
+ gf180mcu_fd_sc_mcu7t5v0__nor3_4_4/ZN gf180mcu_fd_sc_mcu7t5v0__inv_1_4/ZN vdd vss
+ gf180mcu_fd_sc_mcu7t5v0__aoi221_1
Xgf180mcu_fd_sc_mcu7t5v0__aoi221_1_25 gf180mcu_fd_sc_mcu7t5v0__oai21_1_130/A2 gf180mcu_fd_sc_mcu7t5v0__nor2_2_20/ZN
+ vdd vss gf180mcu_fd_sc_mcu7t5v0__oai21_1_130/B gf180mcu_fd_sc_mcu7t5v0__dffq_4_37/Q
+ gf180mcu_fd_sc_mcu7t5v0__oai21_1_125/B gf180mcu_fd_sc_mcu7t5v0__oai31_1_9/A2 vdd
+ vss gf180mcu_fd_sc_mcu7t5v0__aoi221_1
Xgf180mcu_fd_sc_mcu7t5v0__aoi221_1_36 gf180mcu_fd_sc_mcu7t5v0__nor2_2_20/ZN gf180mcu_fd_sc_mcu7t5v0__oai32_1_4/ZN
+ vdd vss gf180mcu_fd_sc_mcu7t5v0__oai221_1_6/C gf180mcu_fd_sc_mcu7t5v0__or2_1_7/A1
+ gf180mcu_fd_sc_mcu7t5v0__nor2_2_23/ZN gf180mcu_fd_sc_mcu7t5v0__or2_1_19/Z vdd vss
+ gf180mcu_fd_sc_mcu7t5v0__aoi221_1
Xgf180mcu_fd_sc_mcu7t5v0__aoi221_1_47 gf180mcu_fd_sc_mcu7t5v0__aoi221_1_49/ZN gf180mcu_fd_sc_mcu7t5v0__or2_4_4/Z
+ vdd vss gf180mcu_fd_sc_mcu7t5v0__aoi21_1_271/B gf180mcu_fd_sc_mcu7t5v0__nor2_4_38/ZN
+ gf180mcu_fd_sc_mcu7t5v0__xor3_1_107/Z gf180mcu_fd_sc_mcu7t5v0__oai22_1_273/ZN vdd
+ vss gf180mcu_fd_sc_mcu7t5v0__aoi221_1
Xgf180mcu_fd_sc_mcu7t5v0__aoi221_1_58 gf180mcu_fd_sc_mcu7t5v0__nor2_1_387/ZN gf180mcu_fd_sc_mcu7t5v0__nor2_4_42/ZN
+ vdd vss gf180mcu_fd_sc_mcu7t5v0__nand2_1_653/A2 gf180mcu_fd_sc_mcu7t5v0__or4_1_0/A1
+ gf180mcu_fd_sc_mcu7t5v0__nor2_2_55/ZN gf180mcu_fd_sc_mcu7t5v0__nor3_1_41/A3 vdd
+ vss gf180mcu_fd_sc_mcu7t5v0__aoi221_1
Xgf180mcu_fd_sc_mcu7t5v0__nor3_4_9 gf180mcu_fd_sc_mcu7t5v0__inv_3_2/I vdd vss gf180mcu_fd_sc_mcu7t5v0__nor3_4_9/ZN
+ gf180mcu_fd_sc_mcu7t5v0__nor3_4_9/A1 gf180mcu_fd_sc_mcu7t5v0__inv_3_1/ZN vdd vss
+ gf180mcu_fd_sc_mcu7t5v0__nor3_4
Xgf180mcu_fd_sc_mcu7t5v0__oai21_4_11 gf180mcu_fd_sc_mcu7t5v0__inv_4_4/ZN vdd vss gf180mcu_fd_sc_mcu7t5v0__inv_3_3/I
+ gf180mcu_fd_sc_mcu7t5v0__aoi21_4_7/A2 gf180mcu_fd_sc_mcu7t5v0__oai22_4_3/A1 vdd
+ vss gf180mcu_fd_sc_mcu7t5v0__oai21_4
Xgf180mcu_fd_sc_mcu7t5v0__xnor3_1_7 gf180mcu_fd_sc_mcu7t5v0__xnor3_1_7/A3 vdd vss
+ gf180mcu_fd_sc_mcu7t5v0__xnor3_1_7/ZN gf180mcu_fd_sc_mcu7t5v0__or2_1_2/A2 gf180mcu_fd_sc_mcu7t5v0__xnor3_1_7/A2
+ vdd vss gf180mcu_fd_sc_mcu7t5v0__xnor3_1
Xgf180mcu_fd_sc_mcu7t5v0__oai31_1_13 vdd gf180mcu_fd_sc_mcu7t5v0__oai31_1_13/ZN gf180mcu_fd_sc_mcu7t5v0__and3_2_3/Z
+ gf180mcu_fd_sc_mcu7t5v0__or2_1_31/A1 gf180mcu_fd_sc_mcu7t5v0__or2_1_31/A2 vss gf180mcu_fd_sc_mcu7t5v0__xor3_1_159/Z
+ vdd vss gf180mcu_fd_sc_mcu7t5v0__oai31_1
Xgf180mcu_fd_sc_mcu7t5v0__nand2_1_30 vdd vss gf180mcu_fd_sc_mcu7t5v0__nand2_1_30/ZN
+ gf180mcu_fd_sc_mcu7t5v0__or2_1_2/A2 gf180mcu_fd_sc_mcu7t5v0__xnor3_1_7/A3 vdd vss
+ gf180mcu_fd_sc_mcu7t5v0__nand2_1
Xgf180mcu_fd_sc_mcu7t5v0__nand2_1_41 vdd vss gf180mcu_fd_sc_mcu7t5v0__nor3_2_14/A3
+ gf180mcu_fd_sc_mcu7t5v0__inv_12_1/I gf180mcu_fd_sc_mcu7t5v0__and2_2_1/Z vdd vss
+ gf180mcu_fd_sc_mcu7t5v0__nand2_1
Xgf180mcu_fd_sc_mcu7t5v0__nand2_1_52 vdd vss gf180mcu_fd_sc_mcu7t5v0__nor2_2_3/A2
+ gf180mcu_fd_sc_mcu7t5v0__or3_2_2/Z gf180mcu_fd_sc_mcu7t5v0__and2_4_2/A2 vdd vss
+ gf180mcu_fd_sc_mcu7t5v0__nand2_1
Xgf180mcu_fd_sc_mcu7t5v0__nand2_1_63 vdd vss gf180mcu_fd_sc_mcu7t5v0__nand2_1_63/ZN
+ gf180mcu_fd_sc_mcu7t5v0__or2_1_4/A1 gf180mcu_fd_sc_mcu7t5v0__xor3_1_26/Z vdd vss
+ gf180mcu_fd_sc_mcu7t5v0__nand2_1
Xgf180mcu_fd_sc_mcu7t5v0__nand2_1_74 vdd vss gf180mcu_fd_sc_mcu7t5v0__xor2_1_27/A1
+ gf180mcu_fd_sc_mcu7t5v0__inv_8_1/I gf180mcu_fd_sc_mcu7t5v0__mux4_4_1/Z vdd vss gf180mcu_fd_sc_mcu7t5v0__nand2_1
Xgf180mcu_fd_sc_mcu7t5v0__nand2_1_85 vdd vss gf180mcu_fd_sc_mcu7t5v0__nand2_1_85/ZN
+ gf180mcu_fd_sc_mcu7t5v0__nor2_4_38/ZN gf180mcu_fd_sc_mcu7t5v0__xor3_1_22/Z vdd vss
+ gf180mcu_fd_sc_mcu7t5v0__nand2_1
Xgf180mcu_fd_sc_mcu7t5v0__nand2_1_96 vdd vss gf180mcu_fd_sc_mcu7t5v0__nand2_1_96/ZN
+ gf180mcu_fd_sc_mcu7t5v0__xnor2_1_14/A1 gf180mcu_fd_sc_mcu7t5v0__xor2_1_36/Z vdd
+ vss gf180mcu_fd_sc_mcu7t5v0__nand2_1
Xgf180mcu_fd_sc_mcu7t5v0__aoi222_2_4 gf180mcu_fd_sc_mcu7t5v0__nor2_4_13/ZN gf180mcu_fd_sc_mcu7t5v0__aoi222_2_4/B1
+ gf180mcu_fd_sc_mcu7t5v0__aoi222_2_4/A2 gf180mcu_fd_sc_mcu7t5v0__nor2_4_6/ZN gf180mcu_fd_sc_mcu7t5v0__nand3_1_46/A2
+ vss vdd gf180mcu_fd_sc_mcu7t5v0__nor2_4_7/ZN gf180mcu_fd_sc_mcu7t5v0__aoi222_2_4/C1
+ vdd vss gf180mcu_fd_sc_mcu7t5v0__aoi222_2
Xgf180mcu_fd_sc_mcu7t5v0__nor3_2_6 gf180mcu_fd_sc_mcu7t5v0__nor3_2_6/A3 vdd vss gf180mcu_fd_sc_mcu7t5v0__nor3_2_6/ZN
+ gf180mcu_fd_sc_mcu7t5v0__nor3_2_6/A1 gf180mcu_fd_sc_mcu7t5v0__nor3_2_6/A2 vdd vss
+ gf180mcu_fd_sc_mcu7t5v0__nor3_2
Xgf180mcu_fd_sc_mcu7t5v0__aoi21_4_7 gf180mcu_fd_sc_mcu7t5v0__aoi21_4_7/A2 gf180mcu_fd_sc_mcu7t5v0__aoi21_4_7/B
+ vdd vss gf180mcu_fd_sc_mcu7t5v0__nor4_2_5/A4 gf180mcu_fd_sc_mcu7t5v0__aoi21_4_7/A1
+ vdd vss gf180mcu_fd_sc_mcu7t5v0__aoi21_4
Xgf180mcu_fd_sc_mcu7t5v0__nand2_1_704 vdd vss gf180mcu_fd_sc_mcu7t5v0__nand2_1_704/ZN
+ gf180mcu_fd_sc_mcu7t5v0__oai31_1_19/B gf180mcu_fd_sc_mcu7t5v0__xor2_1_192/A1 vdd
+ vss gf180mcu_fd_sc_mcu7t5v0__nand2_1
Xgf180mcu_fd_sc_mcu7t5v0__nand2_1_715 vdd vss gf180mcu_fd_sc_mcu7t5v0__oai31_1_6/B
+ gf180mcu_fd_sc_mcu7t5v0__xor2_1_76/Z gf180mcu_fd_sc_mcu7t5v0__xor2_1_78/A2 vdd vss
+ gf180mcu_fd_sc_mcu7t5v0__nand2_1
Xgf180mcu_fd_sc_mcu7t5v0__nand2_1_726 vdd vss gf180mcu_fd_sc_mcu7t5v0__or3_1_29/A2
+ gf180mcu_fd_sc_mcu7t5v0__inv_12_1/I gf180mcu_fd_sc_mcu7t5v0__inv_1_5/I vdd vss gf180mcu_fd_sc_mcu7t5v0__nand2_1
Xgf180mcu_fd_sc_mcu7t5v0__and2_1_12 vdd vss gf180mcu_fd_sc_mcu7t5v0__and2_1_12/Z gf180mcu_fd_sc_mcu7t5v0__or2_1_5/A1
+ gf180mcu_fd_sc_mcu7t5v0__or2_1_5/A2 vdd vss gf180mcu_fd_sc_mcu7t5v0__and2_1
Xgf180mcu_fd_sc_mcu7t5v0__and2_1_23 vdd vss gf180mcu_fd_sc_mcu7t5v0__and2_1_23/Z gf180mcu_fd_sc_mcu7t5v0__xor3_1_57/A1
+ gf180mcu_fd_sc_mcu7t5v0__oai22_1_7/ZN vdd vss gf180mcu_fd_sc_mcu7t5v0__and2_1
Xgf180mcu_fd_sc_mcu7t5v0__and2_1_34 vdd vss gf180mcu_fd_sc_mcu7t5v0__nor3_1_7/A1 gf180mcu_fd_sc_mcu7t5v0__or4_1_0/A1
+ gf180mcu_fd_sc_mcu7t5v0__xor2_1_70/Z vdd vss gf180mcu_fd_sc_mcu7t5v0__and2_1
Xgf180mcu_fd_sc_mcu7t5v0__and2_1_45 vdd vss gf180mcu_fd_sc_mcu7t5v0__dffq_2_30/D gf180mcu_fd_sc_mcu7t5v0__buf_8_5/I
+ gf180mcu_fd_sc_mcu7t5v0__and2_1_45/A2 vdd vss gf180mcu_fd_sc_mcu7t5v0__and2_1
Xgf180mcu_fd_sc_mcu7t5v0__and2_1_56 vdd vss gf180mcu_fd_sc_mcu7t5v0__and2_1_56/Z gf180mcu_fd_sc_mcu7t5v0__nor4_1_0/A4
+ gf180mcu_fd_sc_mcu7t5v0__and2_1_59/Z vdd vss gf180mcu_fd_sc_mcu7t5v0__and2_1
Xgf180mcu_fd_sc_mcu7t5v0__and2_1_67 vdd vss gf180mcu_fd_sc_mcu7t5v0__and2_1_67/Z gf180mcu_fd_sc_mcu7t5v0__nor4_1_2/A4
+ gf180mcu_fd_sc_mcu7t5v0__and2_1_68/Z vdd vss gf180mcu_fd_sc_mcu7t5v0__and2_1
Xgf180mcu_fd_sc_mcu7t5v0__and2_1_78 vdd vss gf180mcu_fd_sc_mcu7t5v0__and2_1_78/Z gf180mcu_fd_sc_mcu7t5v0__and2_1_78/A1
+ gf180mcu_fd_sc_mcu7t5v0__xor3_1_74/Z vdd vss gf180mcu_fd_sc_mcu7t5v0__and2_1
Xgf180mcu_fd_sc_mcu7t5v0__and2_1_89 vdd vss gf180mcu_fd_sc_mcu7t5v0__and2_1_89/Z gf180mcu_fd_sc_mcu7t5v0__inv_8_0/I
+ gf180mcu_fd_sc_mcu7t5v0__mux4_4_9/Z vdd vss gf180mcu_fd_sc_mcu7t5v0__and2_1
Xgf180mcu_fd_sc_mcu7t5v0__aoi211_1_13 gf180mcu_fd_sc_mcu7t5v0__nor2_1_49/ZN gf180mcu_fd_sc_mcu7t5v0__or2_1_23/A1
+ vdd vss gf180mcu_fd_sc_mcu7t5v0__dffq_1_6/D gf180mcu_fd_sc_mcu7t5v0__nor2_1_411/A1
+ gf180mcu_fd_sc_mcu7t5v0__nor2_4_16/ZN vdd vss gf180mcu_fd_sc_mcu7t5v0__aoi211_1
Xgf180mcu_fd_sc_mcu7t5v0__aoi211_1_24 gf180mcu_fd_sc_mcu7t5v0__nor2_1_107/ZN gf180mcu_fd_sc_mcu7t5v0__or2_1_23/A1
+ vdd vss gf180mcu_fd_sc_mcu7t5v0__dffq_1_448/D gf180mcu_fd_sc_mcu7t5v0__nor2_1_144/A1
+ gf180mcu_fd_sc_mcu7t5v0__nor2_4_22/ZN vdd vss gf180mcu_fd_sc_mcu7t5v0__aoi211_1
Xgf180mcu_fd_sc_mcu7t5v0__aoi211_1_35 gf180mcu_fd_sc_mcu7t5v0__nor2_1_138/ZN gf180mcu_fd_sc_mcu7t5v0__or2_1_23/A1
+ vdd vss gf180mcu_fd_sc_mcu7t5v0__dffq_1_281/D gf180mcu_fd_sc_mcu7t5v0__nor2_1_411/A1
+ gf180mcu_fd_sc_mcu7t5v0__nor2_4_20/ZN vdd vss gf180mcu_fd_sc_mcu7t5v0__aoi211_1
Xgf180mcu_fd_sc_mcu7t5v0__aoi211_1_46 gf180mcu_fd_sc_mcu7t5v0__nor2_1_166/ZN gf180mcu_fd_sc_mcu7t5v0__or2_1_23/A1
+ vdd vss gf180mcu_fd_sc_mcu7t5v0__dffq_1_311/D gf180mcu_fd_sc_mcu7t5v0__nor2_1_236/A1
+ gf180mcu_fd_sc_mcu7t5v0__nor2_4_28/ZN vdd vss gf180mcu_fd_sc_mcu7t5v0__aoi211_1
Xgf180mcu_fd_sc_mcu7t5v0__aoi211_1_57 gf180mcu_fd_sc_mcu7t5v0__nor2_1_295/ZN gf180mcu_fd_sc_mcu7t5v0__or2_1_23/A1
+ vdd vss gf180mcu_fd_sc_mcu7t5v0__dffq_1_422/D gf180mcu_fd_sc_mcu7t5v0__nor2_1_144/A1
+ gf180mcu_fd_sc_mcu7t5v0__nor2_4_18/ZN vdd vss gf180mcu_fd_sc_mcu7t5v0__aoi211_1
Xgf180mcu_fd_sc_mcu7t5v0__aoi211_1_68 gf180mcu_fd_sc_mcu7t5v0__mux2_1_10/Z gf180mcu_fd_sc_mcu7t5v0__nor2_2_44/ZN
+ vdd vss gf180mcu_fd_sc_mcu7t5v0__aoi21_1_275/B gf180mcu_fd_sc_mcu7t5v0__inv_8_1/I
+ gf180mcu_fd_sc_mcu7t5v0__nor2_2_42/ZN vdd vss gf180mcu_fd_sc_mcu7t5v0__aoi211_1
Xgf180mcu_fd_sc_mcu7t5v0__aoi211_1_79 gf180mcu_fd_sc_mcu7t5v0__nor2_1_338/ZN gf180mcu_fd_sc_mcu7t5v0__or2_4_4/Z
+ vdd vss gf180mcu_fd_sc_mcu7t5v0__nor2_1_336/A1 gf180mcu_fd_sc_mcu7t5v0__oai211_1_43/C
+ gf180mcu_fd_sc_mcu7t5v0__nand3_1_85/ZN vdd vss gf180mcu_fd_sc_mcu7t5v0__aoi211_1
Xgf180mcu_fd_sc_mcu7t5v0__clkinv_1_70 vdd vss gf180mcu_fd_sc_mcu7t5v0__dffq_1_60/Q
+ gf180mcu_fd_sc_mcu7t5v0__oai22_1_54/B2 vdd vss gf180mcu_fd_sc_mcu7t5v0__clkinv_1
Xgf180mcu_fd_sc_mcu7t5v0__aoi21_1_201 gf180mcu_fd_sc_mcu7t5v0__aoi21_1_201/B vdd vss
+ gf180mcu_fd_sc_mcu7t5v0__dffq_1_402/D gf180mcu_fd_sc_mcu7t5v0__nor3_4_15/ZN gf180mcu_fd_sc_mcu7t5v0__aoi22_2_6/ZN
+ vdd vss gf180mcu_fd_sc_mcu7t5v0__aoi21_1
Xgf180mcu_fd_sc_mcu7t5v0__clkinv_1_81 vdd vss gf180mcu_fd_sc_mcu7t5v0__dffq_1_73/Q
+ gf180mcu_fd_sc_mcu7t5v0__oai22_1_68/B2 vdd vss gf180mcu_fd_sc_mcu7t5v0__clkinv_1
Xgf180mcu_fd_sc_mcu7t5v0__aoi21_1_212 gf180mcu_fd_sc_mcu7t5v0__nor3_4_14/ZN vdd vss
+ gf180mcu_fd_sc_mcu7t5v0__nor2_1_233/A2 gf180mcu_fd_sc_mcu7t5v0__inv_1_11/I gf180mcu_fd_sc_mcu7t5v0__nor3_4_15/A2
+ vdd vss gf180mcu_fd_sc_mcu7t5v0__aoi21_1
Xgf180mcu_fd_sc_mcu7t5v0__clkinv_1_92 vdd vss gf180mcu_fd_sc_mcu7t5v0__dffq_1_261/Q
+ gf180mcu_fd_sc_mcu7t5v0__oai22_1_105/B2 vdd vss gf180mcu_fd_sc_mcu7t5v0__clkinv_1
Xgf180mcu_fd_sc_mcu7t5v0__aoi21_1_223 gf180mcu_fd_sc_mcu7t5v0__nor2_1_256/ZN vdd vss
+ gf180mcu_fd_sc_mcu7t5v0__xor3_1_80/A1 gf180mcu_fd_sc_mcu7t5v0__xor3_1_82/A1 gf180mcu_fd_sc_mcu7t5v0__nand2_1_443/ZN
+ vdd vss gf180mcu_fd_sc_mcu7t5v0__aoi21_1
Xgf180mcu_fd_sc_mcu7t5v0__aoi21_1_234 gf180mcu_fd_sc_mcu7t5v0__or2_4_4/Z vdd vss gf180mcu_fd_sc_mcu7t5v0__aoi221_1_40/B2
+ gf180mcu_fd_sc_mcu7t5v0__nor2_2_31/ZN gf180mcu_fd_sc_mcu7t5v0__xor2_1_125/Z vdd
+ vss gf180mcu_fd_sc_mcu7t5v0__aoi21_1
Xgf180mcu_fd_sc_mcu7t5v0__aoi21_1_245 gf180mcu_fd_sc_mcu7t5v0__nand4_1_15/ZN vdd vss
+ gf180mcu_fd_sc_mcu7t5v0__nand2_1_469/A2 gf180mcu_fd_sc_mcu7t5v0__nand3_1_71/ZN gf180mcu_fd_sc_mcu7t5v0__nor2_1_277/ZN
+ vdd vss gf180mcu_fd_sc_mcu7t5v0__aoi21_1
Xgf180mcu_fd_sc_mcu7t5v0__aoi21_1_256 gf180mcu_fd_sc_mcu7t5v0__aoi21_1_256/B vdd vss
+ gf180mcu_fd_sc_mcu7t5v0__dffq_4_40/D gf180mcu_fd_sc_mcu7t5v0__nand2_2_66/A2 gf180mcu_fd_sc_mcu7t5v0__buf_20_0/Z
+ vdd vss gf180mcu_fd_sc_mcu7t5v0__aoi21_1
Xgf180mcu_fd_sc_mcu7t5v0__aoi21_1_267 gf180mcu_fd_sc_mcu7t5v0__aoi21_1_267/B vdd vss
+ gf180mcu_fd_sc_mcu7t5v0__dffq_4_25/D gf180mcu_fd_sc_mcu7t5v0__xor3_1_159/A1 gf180mcu_fd_sc_mcu7t5v0__buf_20_0/Z
+ vdd vss gf180mcu_fd_sc_mcu7t5v0__aoi21_1
Xgf180mcu_fd_sc_mcu7t5v0__aoi21_1_278 gf180mcu_fd_sc_mcu7t5v0__or2_4_4/Z vdd vss gf180mcu_fd_sc_mcu7t5v0__aoi221_1_48/B2
+ gf180mcu_fd_sc_mcu7t5v0__nor2_4_38/ZN gf180mcu_fd_sc_mcu7t5v0__xor2_1_152/Z vdd
+ vss gf180mcu_fd_sc_mcu7t5v0__aoi21_1
Xgf180mcu_fd_sc_mcu7t5v0__aoi21_1_289 gf180mcu_fd_sc_mcu7t5v0__aoi21_1_289/B vdd vss
+ gf180mcu_fd_sc_mcu7t5v0__dffq_2_70/D gf180mcu_fd_sc_mcu7t5v0__aoi21_1_289/A1 gf180mcu_fd_sc_mcu7t5v0__buf_20_0/I
+ vdd vss gf180mcu_fd_sc_mcu7t5v0__aoi21_1
Xgf180mcu_fd_sc_mcu7t5v0__oai33_2_4 gf180mcu_fd_sc_mcu7t5v0__oai33_2_4/A3 gf180mcu_fd_sc_mcu7t5v0__xor3_1_130/Z
+ gf180mcu_fd_sc_mcu7t5v0__xor3_2_2/A2 gf180mcu_fd_sc_mcu7t5v0__xor2_1_171/Z vdd vss
+ gf180mcu_fd_sc_mcu7t5v0__oai33_2_4/ZN gf180mcu_fd_sc_mcu7t5v0__oai33_2_4/A1 gf180mcu_fd_sc_mcu7t5v0__oai33_2_4/A2
+ vdd vss gf180mcu_fd_sc_mcu7t5v0__oai33_2
Xgf180mcu_fd_sc_mcu7t5v0__oai21_1_12 vdd gf180mcu_fd_sc_mcu7t5v0__or2_1_2/Z gf180mcu_fd_sc_mcu7t5v0__aoi22_1_4/ZN
+ gf180mcu_fd_sc_mcu7t5v0__xor3_1_4/A3 gf180mcu_fd_sc_mcu7t5v0__xor3_1_62/A1 vss vdd
+ vss gf180mcu_fd_sc_mcu7t5v0__oai21_1
Xgf180mcu_fd_sc_mcu7t5v0__oai21_1_23 vdd gf180mcu_fd_sc_mcu7t5v0__buf_8_5/Z gf180mcu_fd_sc_mcu7t5v0__buf_20_0/Z
+ gf180mcu_fd_sc_mcu7t5v0__aoi21_1_33/B gf180mcu_fd_sc_mcu7t5v0__dffq_1_0/Q vss vdd
+ vss gf180mcu_fd_sc_mcu7t5v0__oai21_1
Xgf180mcu_fd_sc_mcu7t5v0__oai21_1_34 vdd gf180mcu_fd_sc_mcu7t5v0__buf_8_5/Z gf180mcu_fd_sc_mcu7t5v0__buf_20_0/Z
+ gf180mcu_fd_sc_mcu7t5v0__aoi21_1_75/B gf180mcu_fd_sc_mcu7t5v0__dffq_1_6/Q vss vdd
+ vss gf180mcu_fd_sc_mcu7t5v0__oai21_1
Xgf180mcu_fd_sc_mcu7t5v0__oai21_1_45 vdd gf180mcu_fd_sc_mcu7t5v0__or2_1_12/Z gf180mcu_fd_sc_mcu7t5v0__or2_1_10/A2
+ gf180mcu_fd_sc_mcu7t5v0__xnor2_1_9/A1 gf180mcu_fd_sc_mcu7t5v0__or2_1_9/Z vss vdd
+ vss gf180mcu_fd_sc_mcu7t5v0__oai21_1
Xgf180mcu_fd_sc_mcu7t5v0__oai21_1_56 vdd gf180mcu_fd_sc_mcu7t5v0__oai21_1_56/B gf180mcu_fd_sc_mcu7t5v0__aoi21_2_3/ZN
+ gf180mcu_fd_sc_mcu7t5v0__xor2_1_66/A1 gf180mcu_fd_sc_mcu7t5v0__and2_1_26/Z vss vdd
+ vss gf180mcu_fd_sc_mcu7t5v0__oai21_1
Xgf180mcu_fd_sc_mcu7t5v0__oai21_1_67 vdd gf180mcu_fd_sc_mcu7t5v0__oai31_1_2/B gf180mcu_fd_sc_mcu7t5v0__or4_1_1/Z
+ gf180mcu_fd_sc_mcu7t5v0__xor2_1_58/A2 gf180mcu_fd_sc_mcu7t5v0__and4_1_0/A4 vss vdd
+ vss gf180mcu_fd_sc_mcu7t5v0__oai21_1
Xgf180mcu_fd_sc_mcu7t5v0__oai21_1_78 vdd gf180mcu_fd_sc_mcu7t5v0__oai21_1_78/B gf180mcu_fd_sc_mcu7t5v0__and2_2_3/Z
+ gf180mcu_fd_sc_mcu7t5v0__oai221_1_15/C gf180mcu_fd_sc_mcu7t5v0__inv_8_2/I vss vdd
+ vss gf180mcu_fd_sc_mcu7t5v0__oai21_1
Xgf180mcu_fd_sc_mcu7t5v0__oai21_1_89 vdd gf180mcu_fd_sc_mcu7t5v0__buf_8_4/Z gf180mcu_fd_sc_mcu7t5v0__buf_20_0/Z
+ gf180mcu_fd_sc_mcu7t5v0__oai21_1_89/ZN gf180mcu_fd_sc_mcu7t5v0__dffq_1_280/Q vss
+ vdd vss gf180mcu_fd_sc_mcu7t5v0__oai21_1
Xgf180mcu_fd_sc_mcu7t5v0__dffq_1_108 vdd gf180mcu_fd_sc_mcu7t5v0__dffq_1_108/Q gf180mcu_fd_sc_mcu7t5v0__dffq_1_96/CLK
+ vss gf180mcu_fd_sc_mcu7t5v0__dffq_1_108/D vdd vss gf180mcu_fd_sc_mcu7t5v0__dffq_1
Xgf180mcu_fd_sc_mcu7t5v0__dffq_1_119 vdd gf180mcu_fd_sc_mcu7t5v0__dffq_1_119/Q gf180mcu_fd_sc_mcu7t5v0__dffq_1_96/CLK
+ vss gf180mcu_fd_sc_mcu7t5v0__dffq_1_119/D vdd vss gf180mcu_fd_sc_mcu7t5v0__dffq_1
Xgf180mcu_fd_sc_mcu7t5v0__nor2_1_308 vdd vss gf180mcu_fd_sc_mcu7t5v0__nor2_1_308/ZN
+ gf180mcu_fd_sc_mcu7t5v0__dffq_2_65/Q gf180mcu_fd_sc_mcu7t5v0__xor2_1_222/Z vdd vss
+ gf180mcu_fd_sc_mcu7t5v0__nor2_1
Xgf180mcu_fd_sc_mcu7t5v0__nor2_1_319 vdd vss gf180mcu_fd_sc_mcu7t5v0__oai32_4_0/A2
+ gf180mcu_fd_sc_mcu7t5v0__inv_1_21/ZN gf180mcu_fd_sc_mcu7t5v0__inv_4_5/I vdd vss
+ gf180mcu_fd_sc_mcu7t5v0__nor2_1
Xgf180mcu_fd_sc_mcu7t5v0__aoi21_2_4 gf180mcu_fd_sc_mcu7t5v0__nor4_2_1/ZN vdd vss gf180mcu_fd_sc_mcu7t5v0__nor2_1_57/A1
+ gf180mcu_fd_sc_mcu7t5v0__xor2_1_63/Z gf180mcu_fd_sc_mcu7t5v0__oai22_2_0/ZN vdd vss
+ gf180mcu_fd_sc_mcu7t5v0__aoi21_2
Xgf180mcu_fd_sc_mcu7t5v0__nand2_1_501 vdd vss gf180mcu_fd_sc_mcu7t5v0__xor3_1_101/A3
+ gf180mcu_fd_sc_mcu7t5v0__inv_12_1/I gf180mcu_fd_sc_mcu7t5v0__oai32_1_8/B1 vdd vss
+ gf180mcu_fd_sc_mcu7t5v0__nand2_1
Xgf180mcu_fd_sc_mcu7t5v0__nand2_1_512 vdd vss gf180mcu_fd_sc_mcu7t5v0__xnor2_1_48/A2
+ gf180mcu_fd_sc_mcu7t5v0__inv_12_1/I gf180mcu_fd_sc_mcu7t5v0__xnor2_1_47/A1 vdd vss
+ gf180mcu_fd_sc_mcu7t5v0__nand2_1
Xgf180mcu_fd_sc_mcu7t5v0__nand2_1_523 vdd vss gf180mcu_fd_sc_mcu7t5v0__oai21_1_243/B
+ gf180mcu_fd_sc_mcu7t5v0__mux4_4_9/I3 gf180mcu_fd_sc_mcu7t5v0__xor3_1_107/A3 vdd
+ vss gf180mcu_fd_sc_mcu7t5v0__nand2_1
Xgf180mcu_fd_sc_mcu7t5v0__nand2_1_534 vdd vss gf180mcu_fd_sc_mcu7t5v0__oai21_1_247/A2
+ gf180mcu_fd_sc_mcu7t5v0__nor2_1_315/A2 gf180mcu_fd_sc_mcu7t5v0__and3_1_16/A2 vdd
+ vss gf180mcu_fd_sc_mcu7t5v0__nand2_1
Xgf180mcu_fd_sc_mcu7t5v0__nand2_1_545 vdd vss gf180mcu_fd_sc_mcu7t5v0__oai32_4_1/A3
+ gf180mcu_fd_sc_mcu7t5v0__or2_2_1/Z gf180mcu_fd_sc_mcu7t5v0__nand3_1_84/ZN vdd vss
+ gf180mcu_fd_sc_mcu7t5v0__nand2_1
Xgf180mcu_fd_sc_mcu7t5v0__nand2_1_556 vdd vss gf180mcu_fd_sc_mcu7t5v0__nand2_1_556/ZN
+ gf180mcu_fd_sc_mcu7t5v0__dffq_2_29/Q gf180mcu_fd_sc_mcu7t5v0__nor3_4_12/ZN vdd vss
+ gf180mcu_fd_sc_mcu7t5v0__nand2_1
Xgf180mcu_fd_sc_mcu7t5v0__nand2_1_567 vdd vss gf180mcu_fd_sc_mcu7t5v0__nand4_1_18/A2
+ gf180mcu_fd_sc_mcu7t5v0__nor3_4_22/ZN gf180mcu_fd_sc_mcu7t5v0__or2_1_44/A2 vdd vss
+ gf180mcu_fd_sc_mcu7t5v0__nand2_1
Xgf180mcu_fd_sc_mcu7t5v0__aoi21_2_14 gf180mcu_fd_sc_mcu7t5v0__or2_1_36/A2 vdd vss
+ gf180mcu_fd_sc_mcu7t5v0__aoi221_4_0/C gf180mcu_fd_sc_mcu7t5v0__inv_4_4/ZN gf180mcu_fd_sc_mcu7t5v0__or2_1_53/A1
+ vdd vss gf180mcu_fd_sc_mcu7t5v0__aoi21_2
Xgf180mcu_fd_sc_mcu7t5v0__nand2_1_578 vdd vss gf180mcu_fd_sc_mcu7t5v0__nand2_1_578/ZN
+ gf180mcu_fd_sc_mcu7t5v0__dffq_2_81/Q gf180mcu_fd_sc_mcu7t5v0__or2_4_4/Z vdd vss
+ gf180mcu_fd_sc_mcu7t5v0__nand2_1
Xgf180mcu_fd_sc_mcu7t5v0__nand2_1_589 vdd vss gf180mcu_fd_sc_mcu7t5v0__xnor2_1_58/A2
+ gf180mcu_fd_sc_mcu7t5v0__xor2_1_181/A2 gf180mcu_fd_sc_mcu7t5v0__nand2_1_632/ZN vdd
+ vss gf180mcu_fd_sc_mcu7t5v0__nand2_1
Xgf180mcu_fd_sc_mcu7t5v0__xor2_2_3 vdd vss gf180mcu_fd_sc_mcu7t5v0__xor2_2_3/Z gf180mcu_fd_sc_mcu7t5v0__xor2_2_3/A1
+ gf180mcu_fd_sc_mcu7t5v0__xor2_2_3/A2 vdd vss gf180mcu_fd_sc_mcu7t5v0__xor2_2
Xgf180mcu_fd_sc_mcu7t5v0__oai211_2_4 gf180mcu_fd_sc_mcu7t5v0__oai31_4_1/ZN gf180mcu_fd_sc_mcu7t5v0__xor3_1_68/A1
+ gf180mcu_fd_sc_mcu7t5v0__oai21_4_8/A1 gf180mcu_fd_sc_mcu7t5v0__or4_1_0/A1 gf180mcu_fd_sc_mcu7t5v0__or3_2_3/Z
+ vdd vss vdd vss gf180mcu_fd_sc_mcu7t5v0__oai211_2
Xgf180mcu_fd_sc_mcu7t5v0__mux4_4_17 gf180mcu_fd_sc_mcu7t5v0__dffq_2_74/Q vss vdd gf180mcu_fd_sc_mcu7t5v0__dffq_2_80/Q
+ gf180mcu_fd_sc_mcu7t5v0__dffq_2_79/Q gf180mcu_fd_sc_mcu7t5v0__inv_4_5/I gf180mcu_fd_sc_mcu7t5v0__dffq_2_41/Q
+ gf180mcu_fd_sc_mcu7t5v0__or2_2_1/A1 gf180mcu_fd_sc_mcu7t5v0__or3_1_12/A2 vdd vss
+ gf180mcu_fd_sc_mcu7t5v0__mux4_4
Xgf180mcu_fd_sc_mcu7t5v0__oai21_2_7 gf180mcu_fd_sc_mcu7t5v0__inv_3_0/ZN gf180mcu_fd_sc_mcu7t5v0__oai21_2_7/ZN
+ gf180mcu_fd_sc_mcu7t5v0__inv_2_10/I vss gf180mcu_fd_sc_mcu7t5v0__inv_4_1/ZN vdd
+ vdd vss gf180mcu_fd_sc_mcu7t5v0__oai21_2
Xgf180mcu_fd_sc_mcu7t5v0__or3_1_10 gf180mcu_fd_sc_mcu7t5v0__or3_1_10/A3 vdd vss gf180mcu_fd_sc_mcu7t5v0__or3_1_10/Z
+ gf180mcu_fd_sc_mcu7t5v0__or3_1_10/A1 gf180mcu_fd_sc_mcu7t5v0__or3_4_0/Z vdd vss
+ gf180mcu_fd_sc_mcu7t5v0__or3_1
Xgf180mcu_fd_sc_mcu7t5v0__or3_1_21 gf180mcu_fd_sc_mcu7t5v0__or3_1_24/A3 vdd vss gf180mcu_fd_sc_mcu7t5v0__or3_1_21/Z
+ gf180mcu_fd_sc_mcu7t5v0__or4_1_0/A2 gf180mcu_fd_sc_mcu7t5v0__or3_1_24/A2 vdd vss
+ gf180mcu_fd_sc_mcu7t5v0__or3_1
Xgf180mcu_fd_sc_mcu7t5v0__nor3_4_10 gf180mcu_fd_sc_mcu7t5v0__inv_3_2/I vdd vss gf180mcu_fd_sc_mcu7t5v0__nor3_4_10/ZN
+ gf180mcu_fd_sc_mcu7t5v0__nor3_4_9/A1 gf180mcu_fd_sc_mcu7t5v0__inv_3_1/I vdd vss
+ gf180mcu_fd_sc_mcu7t5v0__nor3_4
Xgf180mcu_fd_sc_mcu7t5v0__nor3_4_21 gf180mcu_fd_sc_mcu7t5v0__dffq_2_87/Q vdd vss gf180mcu_fd_sc_mcu7t5v0__nor3_4_21/ZN
+ gf180mcu_fd_sc_mcu7t5v0__inv_3_4/ZN gf180mcu_fd_sc_mcu7t5v0__dffq_2_86/Q vdd vss
+ gf180mcu_fd_sc_mcu7t5v0__nor3_4
Xgf180mcu_fd_sc_mcu7t5v0__tiel_5 uart_rx_PD vdd vss vdd vss gf180mcu_fd_sc_mcu7t5v0__tiel
Xgf180mcu_fd_sc_mcu7t5v0__nor2_1_105 vdd vss gf180mcu_fd_sc_mcu7t5v0__xor2_1_75/A1
+ gf180mcu_fd_sc_mcu7t5v0__and2_1_37/Z gf180mcu_fd_sc_mcu7t5v0__and2_1_36/Z vdd vss
+ gf180mcu_fd_sc_mcu7t5v0__nor2_1
Xgf180mcu_fd_sc_mcu7t5v0__nor2_1_116 vdd vss gf180mcu_fd_sc_mcu7t5v0__nor2_1_116/ZN
+ gf180mcu_fd_sc_mcu7t5v0__xor3_1_67/A1 gf180mcu_fd_sc_mcu7t5v0__xor2_1_81/Z vdd vss
+ gf180mcu_fd_sc_mcu7t5v0__nor2_1
Xgf180mcu_fd_sc_mcu7t5v0__nor2_1_127 vdd vss gf180mcu_fd_sc_mcu7t5v0__aoi21_2_5/B
+ gf180mcu_fd_sc_mcu7t5v0__xor2_1_83/A2 gf180mcu_fd_sc_mcu7t5v0__xnor3_1_18/A1 vdd
+ vss gf180mcu_fd_sc_mcu7t5v0__nor2_1
Xgf180mcu_fd_sc_mcu7t5v0__nor2_1_138 vdd vss gf180mcu_fd_sc_mcu7t5v0__nor2_1_138/ZN
+ gf180mcu_fd_sc_mcu7t5v0__dffq_1_281/Q gf180mcu_fd_sc_mcu7t5v0__nor2_4_20/ZN vdd
+ vss gf180mcu_fd_sc_mcu7t5v0__nor2_1
Xgf180mcu_fd_sc_mcu7t5v0__nor2_1_149 vdd vss gf180mcu_fd_sc_mcu7t5v0__nor2_1_149/ZN
+ gf180mcu_fd_sc_mcu7t5v0__inv_4_3/ZN gf180mcu_fd_sc_mcu7t5v0__inv_2_8/I vdd vss gf180mcu_fd_sc_mcu7t5v0__nor2_1
Xgf180mcu_fd_sc_mcu7t5v0__xor3_1_106 gf180mcu_fd_sc_mcu7t5v0__or2_1_40/A2 vdd vss
+ gf180mcu_fd_sc_mcu7t5v0__xor3_1_106/Z gf180mcu_fd_sc_mcu7t5v0__inv_1_3/I gf180mcu_fd_sc_mcu7t5v0__xor3_1_106/A2
+ vdd vss gf180mcu_fd_sc_mcu7t5v0__xor3_1
Xgf180mcu_fd_sc_mcu7t5v0__xor3_1_117 gf180mcu_fd_sc_mcu7t5v0__xor3_1_117/A3 vdd vss
+ gf180mcu_fd_sc_mcu7t5v0__xor3_1_117/Z gf180mcu_fd_sc_mcu7t5v0__xor3_1_117/A1 gf180mcu_fd_sc_mcu7t5v0__xor3_1_117/A2
+ vdd vss gf180mcu_fd_sc_mcu7t5v0__xor3_1
Xgf180mcu_fd_sc_mcu7t5v0__xor3_1_128 gf180mcu_fd_sc_mcu7t5v0__xor3_1_123/Z vdd vss
+ gf180mcu_fd_sc_mcu7t5v0__xor3_1_128/Z gf180mcu_fd_sc_mcu7t5v0__mux2_1_12/Z gf180mcu_fd_sc_mcu7t5v0__xor3_1_128/A2
+ vdd vss gf180mcu_fd_sc_mcu7t5v0__xor3_1
Xgf180mcu_fd_sc_mcu7t5v0__xor3_1_139 gf180mcu_fd_sc_mcu7t5v0__xor3_1_139/A3 vdd vss
+ gf180mcu_fd_sc_mcu7t5v0__xor3_1_139/Z gf180mcu_fd_sc_mcu7t5v0__xor3_1_139/A1 gf180mcu_fd_sc_mcu7t5v0__xor3_1_139/A2
+ vdd vss gf180mcu_fd_sc_mcu7t5v0__xor3_1
Xgf180mcu_fd_sc_mcu7t5v0__nand2_1_320 vdd vss gf180mcu_fd_sc_mcu7t5v0__nand2_1_320/ZN
+ gf180mcu_fd_sc_mcu7t5v0__mux4_4_1/I0 gf180mcu_fd_sc_mcu7t5v0__or2_4_4/Z vdd vss
+ gf180mcu_fd_sc_mcu7t5v0__nand2_1
Xgf180mcu_fd_sc_mcu7t5v0__nand2_1_331 vdd vss gf180mcu_fd_sc_mcu7t5v0__oai21_1_130/A2
+ gf180mcu_fd_sc_mcu7t5v0__dffq_4_37/Q gf180mcu_fd_sc_mcu7t5v0__mux4_4_16/Z vdd vss
+ gf180mcu_fd_sc_mcu7t5v0__nand2_1
Xgf180mcu_fd_sc_mcu7t5v0__nand2_1_342 vdd vss gf180mcu_fd_sc_mcu7t5v0__nand2_1_342/ZN
+ gf180mcu_fd_sc_mcu7t5v0__dffq_1_331/Q gf180mcu_fd_sc_mcu7t5v0__nand3_1_60/ZN vdd
+ vss gf180mcu_fd_sc_mcu7t5v0__nand2_1
Xgf180mcu_fd_sc_mcu7t5v0__nand2_1_353 vdd vss gf180mcu_fd_sc_mcu7t5v0__nand3_1_55/A3
+ gf180mcu_fd_sc_mcu7t5v0__dffq_1_344/Q gf180mcu_fd_sc_mcu7t5v0__dffq_1_387/Q vdd
+ vss gf180mcu_fd_sc_mcu7t5v0__nand2_1
Xgf180mcu_fd_sc_mcu7t5v0__nand2_1_364 vdd vss gf180mcu_fd_sc_mcu7t5v0__nor2_1_203/A2
+ gf180mcu_fd_sc_mcu7t5v0__buf_8_7/Z gf180mcu_fd_sc_mcu7t5v0__dffq_1_377/Q vdd vss
+ gf180mcu_fd_sc_mcu7t5v0__nand2_1
Xgf180mcu_fd_sc_mcu7t5v0__nand2_1_375 vdd vss gf180mcu_fd_sc_mcu7t5v0__aoi221_1_32/C
+ gf180mcu_fd_sc_mcu7t5v0__oai221_1_8/A1 gf180mcu_fd_sc_mcu7t5v0__aoi222_1_9/ZN vdd
+ vss gf180mcu_fd_sc_mcu7t5v0__nand2_1
Xgf180mcu_fd_sc_mcu7t5v0__nand3_4_19 gf180mcu_fd_sc_mcu7t5v0__oai22_4_3/ZN vdd vss
+ gf180mcu_fd_sc_mcu7t5v0__nor3_4_16/A3 gf180mcu_fd_sc_mcu7t5v0__inv_8_0/I gf180mcu_fd_sc_mcu7t5v0__and2_2_10/A1
+ vdd vss gf180mcu_fd_sc_mcu7t5v0__nand3_4
Xgf180mcu_fd_sc_mcu7t5v0__nand2_1_386 vdd vss gf180mcu_fd_sc_mcu7t5v0__xor3_1_72/A3
+ gf180mcu_fd_sc_mcu7t5v0__inv_12_1/I gf180mcu_fd_sc_mcu7t5v0__inv_1_14/I vdd vss
+ gf180mcu_fd_sc_mcu7t5v0__nand2_1
Xgf180mcu_fd_sc_mcu7t5v0__nand2_1_397 vdd vss gf180mcu_fd_sc_mcu7t5v0__xnor2_1_36/A1
+ gf180mcu_fd_sc_mcu7t5v0__or4_1_0/A1 gf180mcu_fd_sc_mcu7t5v0__or3_1_12/A2 vdd vss
+ gf180mcu_fd_sc_mcu7t5v0__nand2_1
Xgf180mcu_fd_sc_mcu7t5v0__oai21_1_209 vdd gf180mcu_fd_sc_mcu7t5v0__oai31_1_15/B gf180mcu_fd_sc_mcu7t5v0__mux4_4_19/Z
+ gf180mcu_fd_sc_mcu7t5v0__xor2_1_119/A2 gf180mcu_fd_sc_mcu7t5v0__mux4_4_6/Z vss vdd
+ vss gf180mcu_fd_sc_mcu7t5v0__oai21_1
Xgf180mcu_fd_sc_mcu7t5v0__dffq_1_450 vdd gf180mcu_fd_sc_mcu7t5v0__dffq_1_450/Q gf180mcu_fd_sc_mcu7t5v0__dffq_2_58/CLK
+ vss gf180mcu_fd_sc_mcu7t5v0__dffq_1_450/D vdd vss gf180mcu_fd_sc_mcu7t5v0__dffq_1
Xgf180mcu_fd_sc_mcu7t5v0__nand3_4_9 gf180mcu_fd_sc_mcu7t5v0__nor2_2_14/A1 vdd vss
+ gf180mcu_fd_sc_mcu7t5v0__oai32_1_3/B2 gf180mcu_fd_sc_mcu7t5v0__nor3_4_5/A1 gf180mcu_fd_sc_mcu7t5v0__inv_2_6/I
+ vdd vss gf180mcu_fd_sc_mcu7t5v0__nand3_4
Xgf180mcu_fd_sc_mcu7t5v0__clkinv_1_300 vdd vss gf180mcu_fd_sc_mcu7t5v0__dffq_1_328/Q
+ gf180mcu_fd_sc_mcu7t5v0__aoi21_1_148/A1 vdd vss gf180mcu_fd_sc_mcu7t5v0__clkinv_1
Xgf180mcu_fd_sc_mcu7t5v0__clkinv_1_311 vdd vss gf180mcu_fd_sc_mcu7t5v0__dffq_1_358/Q
+ gf180mcu_fd_sc_mcu7t5v0__xor2_1_94/A1 vdd vss gf180mcu_fd_sc_mcu7t5v0__clkinv_1
Xgf180mcu_fd_sc_mcu7t5v0__clkinv_1_322 vdd vss gf180mcu_fd_sc_mcu7t5v0__or3_1_12/A2
+ gf180mcu_fd_sc_mcu7t5v0__xor3_1_74/A2 vdd vss gf180mcu_fd_sc_mcu7t5v0__clkinv_1
Xgf180mcu_fd_sc_mcu7t5v0__clkinv_1_333 vdd vss gf180mcu_fd_sc_mcu7t5v0__nand2_1_485/ZN
+ gf180mcu_fd_sc_mcu7t5v0__nor2_1_279/A1 vdd vss gf180mcu_fd_sc_mcu7t5v0__clkinv_1
Xgf180mcu_fd_sc_mcu7t5v0__clkinv_1_344 vdd vss gf180mcu_fd_sc_mcu7t5v0__or2_1_41/A1
+ gf180mcu_fd_sc_mcu7t5v0__oai31_4_4/A1 vdd vss gf180mcu_fd_sc_mcu7t5v0__clkinv_1
Xgf180mcu_fd_sc_mcu7t5v0__clkinv_1_355 vdd vss gf180mcu_fd_sc_mcu7t5v0__xor3_1_139/A3
+ gf180mcu_fd_sc_mcu7t5v0__and3_1_22/A3 vdd vss gf180mcu_fd_sc_mcu7t5v0__clkinv_1
Xgf180mcu_fd_sc_mcu7t5v0__clkinv_1_366 vdd vss gf180mcu_fd_sc_mcu7t5v0__or2_4_0/A2
+ gf180mcu_fd_sc_mcu7t5v0__aoi21_1_268/A1 vdd vss gf180mcu_fd_sc_mcu7t5v0__clkinv_1
Xgf180mcu_fd_sc_mcu7t5v0__nand2_4_30 vdd vss gf180mcu_fd_sc_mcu7t5v0__nor3_4_9/A1
+ gf180mcu_fd_sc_mcu7t5v0__buf_8_5/Z gf180mcu_fd_sc_mcu7t5v0__nand2_4_30/A2 vdd vss
+ gf180mcu_fd_sc_mcu7t5v0__nand2_4
Xgf180mcu_fd_sc_mcu7t5v0__nand2_4_41 vdd vss gf180mcu_fd_sc_mcu7t5v0__nand3_1_55/A2
+ gf180mcu_fd_sc_mcu7t5v0__dffq_2_53/Q gf180mcu_fd_sc_mcu7t5v0__or2_1_21/A1 vdd vss
+ gf180mcu_fd_sc_mcu7t5v0__nand2_4
Xgf180mcu_fd_sc_mcu7t5v0__clkinv_3_16 vdd gf180mcu_fd_sc_mcu7t5v0__oai31_4_5/A2 gf180mcu_fd_sc_mcu7t5v0__dffq_4_35/Q
+ vss vdd vss gf180mcu_fd_sc_mcu7t5v0__clkinv_3
Xgf180mcu_fd_sc_mcu7t5v0__dffq_4_2 gf180mcu_fd_sc_mcu7t5v0__dffq_4_2/D gf180mcu_fd_sc_mcu7t5v0__inv_3_0/I
+ vdd vss gf180mcu_fd_sc_mcu7t5v0__dffq_4_6/CLK vdd vss gf180mcu_fd_sc_mcu7t5v0__dffq_4
Xgf180mcu_fd_sc_mcu7t5v0__nand2_1_150 vdd vss gf180mcu_fd_sc_mcu7t5v0__oai21_4_4/B
+ gf180mcu_fd_sc_mcu7t5v0__inv_3_0/I gf180mcu_fd_sc_mcu7t5v0__or2_1_5/A1 vdd vss gf180mcu_fd_sc_mcu7t5v0__nand2_1
Xgf180mcu_fd_sc_mcu7t5v0__nand2_1_161 vdd vss gf180mcu_fd_sc_mcu7t5v0__oai21_1_63/A1
+ gf180mcu_fd_sc_mcu7t5v0__nor3_2_5/A1 gf180mcu_fd_sc_mcu7t5v0__or4_1_1/A1 vdd vss
+ gf180mcu_fd_sc_mcu7t5v0__nand2_1
Xgf180mcu_fd_sc_mcu7t5v0__nand2_1_172 vdd vss gf180mcu_fd_sc_mcu7t5v0__nand2_1_175/A1
+ gf180mcu_fd_sc_mcu7t5v0__inv_2_2/I gf180mcu_fd_sc_mcu7t5v0__nand2_1_172/A2 vdd vss
+ gf180mcu_fd_sc_mcu7t5v0__nand2_1
Xgf180mcu_fd_sc_mcu7t5v0__nand2_1_183 vdd vss gf180mcu_fd_sc_mcu7t5v0__xnor2_1_21/A2
+ gf180mcu_fd_sc_mcu7t5v0__xor2_1_58/A2 gf180mcu_fd_sc_mcu7t5v0__nand2_1_184/ZN vdd
+ vss gf180mcu_fd_sc_mcu7t5v0__nand2_1
Xgf180mcu_fd_sc_mcu7t5v0__nand2_1_194 vdd vss gf180mcu_fd_sc_mcu7t5v0__mux2_1_5/I1
+ gf180mcu_fd_sc_mcu7t5v0__or2_1_7/A1 gf180mcu_fd_sc_mcu7t5v0__or4_1_1/A1 vdd vss
+ gf180mcu_fd_sc_mcu7t5v0__nand2_1
Xgf180mcu_fd_sc_mcu7t5v0__clkinv_4_1 vdd vss gf180mcu_fd_sc_mcu7t5v0__oai22_4_3/A1
+ gf180mcu_fd_sc_mcu7t5v0__or2_1_36/A2 vdd vss gf180mcu_fd_sc_mcu7t5v0__clkinv_4
Xgf180mcu_fd_sc_mcu7t5v0__dffq_1_280 vdd gf180mcu_fd_sc_mcu7t5v0__dffq_1_280/Q gf180mcu_fd_sc_mcu7t5v0__dffq_4_9/CLK
+ vss gf180mcu_fd_sc_mcu7t5v0__dffq_1_280/D vdd vss gf180mcu_fd_sc_mcu7t5v0__dffq_1
Xgf180mcu_fd_sc_mcu7t5v0__dffq_1_291 vdd gf180mcu_fd_sc_mcu7t5v0__mux2_4_2/I1 gf180mcu_fd_sc_mcu7t5v0__dffq_2_58/CLK
+ vss gf180mcu_fd_sc_mcu7t5v0__dffq_1_291/D vdd vss gf180mcu_fd_sc_mcu7t5v0__dffq_1
Xgf180mcu_fd_sc_mcu7t5v0__nand3_2_6 gf180mcu_fd_sc_mcu7t5v0__and2_2_2/A2 vdd vss gf180mcu_fd_sc_mcu7t5v0__or2_1_2/A1
+ gf180mcu_fd_sc_mcu7t5v0__inv_12_1/I gf180mcu_fd_sc_mcu7t5v0__or3_2_0/Z vdd vss gf180mcu_fd_sc_mcu7t5v0__nand3_2
Xgf180mcu_fd_sc_mcu7t5v0__xor2_1_105 vdd vss gf180mcu_fd_sc_mcu7t5v0__or2_1_27/A2
+ gf180mcu_fd_sc_mcu7t5v0__xor2_1_105/A1 gf180mcu_fd_sc_mcu7t5v0__xor3_1_126/Z vdd
+ vss gf180mcu_fd_sc_mcu7t5v0__xor2_1
Xgf180mcu_fd_sc_mcu7t5v0__xor2_1_116 vdd vss gf180mcu_fd_sc_mcu7t5v0__xor2_1_116/Z
+ gf180mcu_fd_sc_mcu7t5v0__xor2_1_116/A1 gf180mcu_fd_sc_mcu7t5v0__xor2_1_110/Z vdd
+ vss gf180mcu_fd_sc_mcu7t5v0__xor2_1
Xgf180mcu_fd_sc_mcu7t5v0__xor2_1_127 vdd vss gf180mcu_fd_sc_mcu7t5v0__xor2_1_127/Z
+ gf180mcu_fd_sc_mcu7t5v0__and2_2_9/Z gf180mcu_fd_sc_mcu7t5v0__xor3_1_88/A3 vdd vss
+ gf180mcu_fd_sc_mcu7t5v0__xor2_1
Xgf180mcu_fd_sc_mcu7t5v0__xor2_1_138 vdd vss gf180mcu_fd_sc_mcu7t5v0__xor2_1_138/Z
+ gf180mcu_fd_sc_mcu7t5v0__or3_1_9/A1 gf180mcu_fd_sc_mcu7t5v0__xor2_1_138/A2 vdd vss
+ gf180mcu_fd_sc_mcu7t5v0__xor2_1
Xgf180mcu_fd_sc_mcu7t5v0__xor2_1_149 vdd vss gf180mcu_fd_sc_mcu7t5v0__xor2_1_149/Z
+ gf180mcu_fd_sc_mcu7t5v0__inv_1_5/I gf180mcu_fd_sc_mcu7t5v0__aoi22_2_7/ZN vdd vss
+ gf180mcu_fd_sc_mcu7t5v0__xor2_1
Xgf180mcu_fd_sc_mcu7t5v0__nor3_1_11 gf180mcu_fd_sc_mcu7t5v0__oai31_2_0/ZN vdd vss
+ gf180mcu_fd_sc_mcu7t5v0__nor3_1_11/ZN gf180mcu_fd_sc_mcu7t5v0__nor3_1_11/A1 gf180mcu_fd_sc_mcu7t5v0__and2_1_53/Z
+ vdd vss gf180mcu_fd_sc_mcu7t5v0__nor3_1
Xgf180mcu_fd_sc_mcu7t5v0__nor3_1_22 gf180mcu_fd_sc_mcu7t5v0__nor3_1_22/A3 vdd vss
+ gf180mcu_fd_sc_mcu7t5v0__nor3_1_22/ZN gf180mcu_fd_sc_mcu7t5v0__inv_1_11/ZN gf180mcu_fd_sc_mcu7t5v0__inv_1_12/I
+ vdd vss gf180mcu_fd_sc_mcu7t5v0__nor3_1
Xgf180mcu_fd_sc_mcu7t5v0__nor3_1_33 gf180mcu_fd_sc_mcu7t5v0__or3_1_20/A2 vdd vss gf180mcu_fd_sc_mcu7t5v0__nor3_1_33/ZN
+ gf180mcu_fd_sc_mcu7t5v0__nor3_1_33/A1 gf180mcu_fd_sc_mcu7t5v0__nor3_1_33/A2 vdd
+ vss gf180mcu_fd_sc_mcu7t5v0__nor3_1
Xgf180mcu_fd_sc_mcu7t5v0__clkinv_1_130 vdd vss gf180mcu_fd_sc_mcu7t5v0__dffq_1_113/Q
+ gf180mcu_fd_sc_mcu7t5v0__oai22_1_113/B2 vdd vss gf180mcu_fd_sc_mcu7t5v0__clkinv_1
Xgf180mcu_fd_sc_mcu7t5v0__nor3_1_44 gf180mcu_fd_sc_mcu7t5v0__nor3_1_44/A3 vdd vss
+ gf180mcu_fd_sc_mcu7t5v0__nor3_1_44/ZN gf180mcu_fd_sc_mcu7t5v0__nor3_1_44/A1 gf180mcu_fd_sc_mcu7t5v0__oai21_2_8/ZN
+ vdd vss gf180mcu_fd_sc_mcu7t5v0__nor3_1
Xgf180mcu_fd_sc_mcu7t5v0__clkinv_1_141 vdd vss gf180mcu_fd_sc_mcu7t5v0__dffq_1_269/Q
+ gf180mcu_fd_sc_mcu7t5v0__oai22_1_55/B2 vdd vss gf180mcu_fd_sc_mcu7t5v0__clkinv_1
Xgf180mcu_fd_sc_mcu7t5v0__clkinv_1_152 vdd vss gf180mcu_fd_sc_mcu7t5v0__dffq_1_128/Q
+ gf180mcu_fd_sc_mcu7t5v0__oai22_1_195/B2 vdd vss gf180mcu_fd_sc_mcu7t5v0__clkinv_1
Xgf180mcu_fd_sc_mcu7t5v0__clkinv_1_163 vdd vss gf180mcu_fd_sc_mcu7t5v0__dffq_1_144/Q
+ gf180mcu_fd_sc_mcu7t5v0__oai22_1_150/B2 vdd vss gf180mcu_fd_sc_mcu7t5v0__clkinv_1
Xgf180mcu_fd_sc_mcu7t5v0__dffq_1_90 vdd gf180mcu_fd_sc_mcu7t5v0__dffq_1_90/Q gf180mcu_fd_sc_mcu7t5v0__dffq_1_95/CLK
+ vss gf180mcu_fd_sc_mcu7t5v0__dffq_1_90/D vdd vss gf180mcu_fd_sc_mcu7t5v0__dffq_1
Xgf180mcu_fd_sc_mcu7t5v0__clkinv_1_174 vdd vss gf180mcu_fd_sc_mcu7t5v0__dffq_1_183/Q
+ gf180mcu_fd_sc_mcu7t5v0__oai22_1_140/B2 vdd vss gf180mcu_fd_sc_mcu7t5v0__clkinv_1
Xgf180mcu_fd_sc_mcu7t5v0__clkinv_1_185 vdd vss gf180mcu_fd_sc_mcu7t5v0__dffq_1_191/Q
+ gf180mcu_fd_sc_mcu7t5v0__oai22_1_171/B2 vdd vss gf180mcu_fd_sc_mcu7t5v0__clkinv_1
Xgf180mcu_fd_sc_mcu7t5v0__clkinv_1_196 vdd vss gf180mcu_fd_sc_mcu7t5v0__dffq_1_167/Q
+ gf180mcu_fd_sc_mcu7t5v0__oai22_1_181/B2 vdd vss gf180mcu_fd_sc_mcu7t5v0__clkinv_1
Xgf180mcu_fd_sc_mcu7t5v0__inv_3_2 vss gf180mcu_fd_sc_mcu7t5v0__inv_3_2/ZN gf180mcu_fd_sc_mcu7t5v0__inv_3_2/I
+ vdd vdd vss gf180mcu_fd_sc_mcu7t5v0__inv_3
Xgf180mcu_fd_sc_mcu7t5v0__oai22_1_190 gf180mcu_fd_sc_mcu7t5v0__nand2_4_22/ZN gf180mcu_fd_sc_mcu7t5v0__nand2_2_29/ZN
+ gf180mcu_fd_sc_mcu7t5v0__oai22_1_190/B2 vdd vss gf180mcu_fd_sc_mcu7t5v0__dffq_1_173/D
+ gf180mcu_fd_sc_mcu7t5v0__aoi21_4_5/ZN vdd vss gf180mcu_fd_sc_mcu7t5v0__oai22_1
Xgf180mcu_fd_sc_mcu7t5v0__xnor3_1_40 gf180mcu_fd_sc_mcu7t5v0__xor3_1_133/Z vdd vss
+ gf180mcu_fd_sc_mcu7t5v0__xor3_1_131/A3 gf180mcu_fd_sc_mcu7t5v0__and3_1_22/Z gf180mcu_fd_sc_mcu7t5v0__xor3_1_138/Z
+ vdd vss gf180mcu_fd_sc_mcu7t5v0__xnor3_1
Xgf180mcu_fd_sc_mcu7t5v0__xnor3_1_51 gf180mcu_fd_sc_mcu7t5v0__xor3_1_141/Z vdd vss
+ gf180mcu_fd_sc_mcu7t5v0__xor3_1_69/A3 gf180mcu_fd_sc_mcu7t5v0__xnor3_1_51/A1 gf180mcu_fd_sc_mcu7t5v0__xnor3_1_51/A2
+ vdd vss gf180mcu_fd_sc_mcu7t5v0__xnor3_1
Xgf180mcu_fd_sc_mcu7t5v0__aoi221_1_15 gf180mcu_fd_sc_mcu7t5v0__nor2_1_111/ZN gf180mcu_fd_sc_mcu7t5v0__aoi21_1_7/B
+ vdd vss gf180mcu_fd_sc_mcu7t5v0__dffq_1_236/D gf180mcu_fd_sc_mcu7t5v0__oai22_4_0/A2
+ gf180mcu_fd_sc_mcu7t5v0__or2_4_4/Z gf180mcu_fd_sc_mcu7t5v0__oai21_1_76/ZN vdd vss
+ gf180mcu_fd_sc_mcu7t5v0__aoi221_1
Xgf180mcu_fd_sc_mcu7t5v0__aoi221_1_26 gf180mcu_fd_sc_mcu7t5v0__oai31_1_9/A2 gf180mcu_fd_sc_mcu7t5v0__nor2_2_20/ZN
+ vdd vss gf180mcu_fd_sc_mcu7t5v0__clkinv_1_287/I gf180mcu_fd_sc_mcu7t5v0__inv_4_6/I
+ gf180mcu_fd_sc_mcu7t5v0__oai21_1_127/ZN gf180mcu_fd_sc_mcu7t5v0__nand2_1_332/ZN
+ vdd vss gf180mcu_fd_sc_mcu7t5v0__aoi221_1
Xgf180mcu_fd_sc_mcu7t5v0__aoi221_1_37 gf180mcu_fd_sc_mcu7t5v0__mux2_1_8/I0 gf180mcu_fd_sc_mcu7t5v0__nor2_2_31/ZN
+ vdd vss gf180mcu_fd_sc_mcu7t5v0__nand4_1_11/A4 gf180mcu_fd_sc_mcu7t5v0__inv_8_0/I
+ gf180mcu_fd_sc_mcu7t5v0__nor2_2_28/ZN gf180mcu_fd_sc_mcu7t5v0__and2_1_89/Z vdd vss
+ gf180mcu_fd_sc_mcu7t5v0__aoi221_1
Xgf180mcu_fd_sc_mcu7t5v0__aoi221_1_48 gf180mcu_fd_sc_mcu7t5v0__aoi221_1_48/B2 gf180mcu_fd_sc_mcu7t5v0__aoi21_1_7/B
+ vdd vss gf180mcu_fd_sc_mcu7t5v0__dffq_2_68/D gf180mcu_fd_sc_mcu7t5v0__nor3_2_10/A1
+ gf180mcu_fd_sc_mcu7t5v0__or2_4_4/Z gf180mcu_fd_sc_mcu7t5v0__oai211_1_36/ZN vdd vss
+ gf180mcu_fd_sc_mcu7t5v0__aoi221_1
Xgf180mcu_fd_sc_mcu7t5v0__aoi221_1_59 gf180mcu_fd_sc_mcu7t5v0__nor2_2_53/ZN gf180mcu_fd_sc_mcu7t5v0__nor2_4_42/ZN
+ vdd vss gf180mcu_fd_sc_mcu7t5v0__oai221_1_14/C gf180mcu_fd_sc_mcu7t5v0__inv_8_1/I
+ gf180mcu_fd_sc_mcu7t5v0__nor2_2_55/ZN gf180mcu_fd_sc_mcu7t5v0__xor2_1_193/Z vdd
+ vss gf180mcu_fd_sc_mcu7t5v0__aoi221_1
Xgf180mcu_fd_sc_mcu7t5v0__oai21_4_12 gf180mcu_fd_sc_mcu7t5v0__oai21_4_12/B vdd vss
+ gf180mcu_fd_sc_mcu7t5v0__aoi21_4_9/ZN gf180mcu_fd_sc_mcu7t5v0__nor2_2_49/A2 gf180mcu_fd_sc_mcu7t5v0__oai31_4_4/ZN
+ vdd vss gf180mcu_fd_sc_mcu7t5v0__oai21_4
Xgf180mcu_fd_sc_mcu7t5v0__xnor3_1_8 gf180mcu_fd_sc_mcu7t5v0__and3_1_1/Z vdd vss gf180mcu_fd_sc_mcu7t5v0__nor3_1_4/A1
+ gf180mcu_fd_sc_mcu7t5v0__xnor3_1_8/A1 gf180mcu_fd_sc_mcu7t5v0__xnor3_1_8/A2 vdd
+ vss gf180mcu_fd_sc_mcu7t5v0__xnor3_1
Xgf180mcu_fd_sc_mcu7t5v0__oai31_1_14 vdd gf180mcu_fd_sc_mcu7t5v0__oai31_1_14/ZN gf180mcu_fd_sc_mcu7t5v0__oai31_1_14/B
+ gf180mcu_fd_sc_mcu7t5v0__and2_1_97/Z gf180mcu_fd_sc_mcu7t5v0__oai31_1_14/A2 vss
+ gf180mcu_fd_sc_mcu7t5v0__oai31_1_14/A3 vdd vss gf180mcu_fd_sc_mcu7t5v0__oai31_1
Xgf180mcu_fd_sc_mcu7t5v0__nand2_1_20 vdd vss gf180mcu_fd_sc_mcu7t5v0__nand2_1_20/ZN
+ gf180mcu_fd_sc_mcu7t5v0__aoi22_1_3/ZN gf180mcu_fd_sc_mcu7t5v0__oai22_1_0/ZN vdd
+ vss gf180mcu_fd_sc_mcu7t5v0__nand2_1
Xgf180mcu_fd_sc_mcu7t5v0__nand2_1_31 vdd vss gf180mcu_fd_sc_mcu7t5v0__nand2_1_31/ZN
+ gf180mcu_fd_sc_mcu7t5v0__dffq_2_6/Q gf180mcu_fd_sc_mcu7t5v0__or2_4_4/Z vdd vss gf180mcu_fd_sc_mcu7t5v0__nand2_1
Xgf180mcu_fd_sc_mcu7t5v0__nand2_1_42 vdd vss gf180mcu_fd_sc_mcu7t5v0__oai21_1_11/B
+ gf180mcu_fd_sc_mcu7t5v0__dffq_2_7/Q gf180mcu_fd_sc_mcu7t5v0__xor2_1_7/Z vdd vss
+ gf180mcu_fd_sc_mcu7t5v0__nand2_1
Xgf180mcu_fd_sc_mcu7t5v0__nand2_1_53 vdd vss gf180mcu_fd_sc_mcu7t5v0__oai22_1_2/A2
+ gf180mcu_fd_sc_mcu7t5v0__or2_1_7/A1 gf180mcu_fd_sc_mcu7t5v0__nand2_1_89/ZN vdd vss
+ gf180mcu_fd_sc_mcu7t5v0__nand2_1
Xgf180mcu_fd_sc_mcu7t5v0__nand2_1_64 vdd vss gf180mcu_fd_sc_mcu7t5v0__oai21_2_2/B
+ gf180mcu_fd_sc_mcu7t5v0__mux4_4_5/I3 gf180mcu_fd_sc_mcu7t5v0__dffq_4_4/Q vdd vss
+ gf180mcu_fd_sc_mcu7t5v0__nand2_1
Xgf180mcu_fd_sc_mcu7t5v0__nand2_1_75 vdd vss gf180mcu_fd_sc_mcu7t5v0__nand4_1_1/A3
+ gf180mcu_fd_sc_mcu7t5v0__nor2_1_315/A2 gf180mcu_fd_sc_mcu7t5v0__nor2_1_36/ZN vdd
+ vss gf180mcu_fd_sc_mcu7t5v0__nand2_1
Xgf180mcu_fd_sc_mcu7t5v0__nand2_1_86 vdd vss gf180mcu_fd_sc_mcu7t5v0__nand2_1_88/A2
+ gf180mcu_fd_sc_mcu7t5v0__oai31_1_4/B gf180mcu_fd_sc_mcu7t5v0__xor2_1_64/A1 vdd vss
+ gf180mcu_fd_sc_mcu7t5v0__nand2_1
Xgf180mcu_fd_sc_mcu7t5v0__nand2_1_97 vdd vss gf180mcu_fd_sc_mcu7t5v0__xor3_1_38/A3
+ gf180mcu_fd_sc_mcu7t5v0__inv_8_1/I gf180mcu_fd_sc_mcu7t5v0__xor2_1_58/A1 vdd vss
+ gf180mcu_fd_sc_mcu7t5v0__nand2_1
Xgf180mcu_fd_sc_mcu7t5v0__aoi22_1_90 gf180mcu_fd_sc_mcu7t5v0__nor2_4_11/ZN gf180mcu_fd_sc_mcu7t5v0__dffq_1_162/Q
+ vdd vss gf180mcu_fd_sc_mcu7t5v0__aoi22_1_90/ZN gf180mcu_fd_sc_mcu7t5v0__dffq_1_163/Q
+ gf180mcu_fd_sc_mcu7t5v0__nor2_4_10/ZN vdd vss gf180mcu_fd_sc_mcu7t5v0__aoi22_1
Xgf180mcu_fd_sc_mcu7t5v0__nand3_2_30 gf180mcu_fd_sc_mcu7t5v0__xnor3_1_43/ZN vdd vss
+ gf180mcu_fd_sc_mcu7t5v0__nor3_2_13/A1 gf180mcu_fd_sc_mcu7t5v0__and2_1_144/Z gf180mcu_fd_sc_mcu7t5v0__and2_1_143/Z
+ vdd vss gf180mcu_fd_sc_mcu7t5v0__nand3_2
Xgf180mcu_fd_sc_mcu7t5v0__aoi222_2_5 gf180mcu_fd_sc_mcu7t5v0__nor3_4_6/ZN gf180mcu_fd_sc_mcu7t5v0__aoi222_2_5/B1
+ gf180mcu_fd_sc_mcu7t5v0__aoi222_2_5/A2 gf180mcu_fd_sc_mcu7t5v0__nor3_4_11/ZN gf180mcu_fd_sc_mcu7t5v0__nand3_1_38/A3
+ vss vdd gf180mcu_fd_sc_mcu7t5v0__nor2_4_13/ZN gf180mcu_fd_sc_mcu7t5v0__aoi222_2_5/C1
+ vdd vss gf180mcu_fd_sc_mcu7t5v0__aoi222_2
Xgf180mcu_fd_sc_mcu7t5v0__nor3_2_7 gf180mcu_fd_sc_mcu7t5v0__nor3_2_7/A3 vdd vss gf180mcu_fd_sc_mcu7t5v0__nor3_2_7/ZN
+ gf180mcu_fd_sc_mcu7t5v0__xor3_2_1/A1 gf180mcu_fd_sc_mcu7t5v0__nor3_2_7/A2 vdd vss
+ gf180mcu_fd_sc_mcu7t5v0__nor3_2
Xgf180mcu_fd_sc_mcu7t5v0__aoi21_4_8 gf180mcu_fd_sc_mcu7t5v0__or2_2_1/A1 gf180mcu_fd_sc_mcu7t5v0__inv_4_5/I
+ vdd vss gf180mcu_fd_sc_mcu7t5v0__aoi21_4_8/ZN gf180mcu_fd_sc_mcu7t5v0__nor3_1_35/A1
+ vdd vss gf180mcu_fd_sc_mcu7t5v0__aoi21_4
Xgf180mcu_fd_sc_mcu7t5v0__nand2_1_705 vdd vss gf180mcu_fd_sc_mcu7t5v0__oai21_1_288/B
+ gf180mcu_fd_sc_mcu7t5v0__inv_12_1/I gf180mcu_fd_sc_mcu7t5v0__inv_1_23/I vdd vss
+ gf180mcu_fd_sc_mcu7t5v0__nand2_1
Xgf180mcu_fd_sc_mcu7t5v0__nand2_1_716 vdd vss gf180mcu_fd_sc_mcu7t5v0__xor3_1_170/A1
+ gf180mcu_fd_sc_mcu7t5v0__or4_1_0/A1 gf180mcu_fd_sc_mcu7t5v0__mux4_4_0/Z vdd vss
+ gf180mcu_fd_sc_mcu7t5v0__nand2_1
Xgf180mcu_fd_sc_mcu7t5v0__nand2_1_727 vdd vss gf180mcu_fd_sc_mcu7t5v0__oai21_1_340/B
+ gf180mcu_fd_sc_mcu7t5v0__or4_1_0/A1 gf180mcu_fd_sc_mcu7t5v0__xor2_1_229/A2 vdd vss
+ gf180mcu_fd_sc_mcu7t5v0__nand2_1
Xgf180mcu_fd_sc_mcu7t5v0__and2_1_13 vdd vss gf180mcu_fd_sc_mcu7t5v0__and2_1_13/Z gf180mcu_fd_sc_mcu7t5v0__or2_1_7/Z
+ gf180mcu_fd_sc_mcu7t5v0__and2_1_13/A2 vdd vss gf180mcu_fd_sc_mcu7t5v0__and2_1
Xgf180mcu_fd_sc_mcu7t5v0__and2_1_24 vdd vss gf180mcu_fd_sc_mcu7t5v0__and2_1_24/Z gf180mcu_fd_sc_mcu7t5v0__or2_1_14/A2
+ gf180mcu_fd_sc_mcu7t5v0__oai22_1_5/A1 vdd vss gf180mcu_fd_sc_mcu7t5v0__and2_1
Xgf180mcu_fd_sc_mcu7t5v0__and2_1_35 vdd vss gf180mcu_fd_sc_mcu7t5v0__and2_1_35/Z gf180mcu_fd_sc_mcu7t5v0__nor2_2_15/ZN
+ gf180mcu_fd_sc_mcu7t5v0__oai32_1_3/B1 vdd vss gf180mcu_fd_sc_mcu7t5v0__and2_1
Xgf180mcu_fd_sc_mcu7t5v0__and2_1_46 vdd vss gf180mcu_fd_sc_mcu7t5v0__dffq_2_29/D gf180mcu_fd_sc_mcu7t5v0__buf_8_5/I
+ gf180mcu_fd_sc_mcu7t5v0__and2_1_46/A2 vdd vss gf180mcu_fd_sc_mcu7t5v0__and2_1
Xgf180mcu_fd_sc_mcu7t5v0__and2_1_57 vdd vss gf180mcu_fd_sc_mcu7t5v0__and2_1_57/Z gf180mcu_fd_sc_mcu7t5v0__buf_8_8/I
+ gf180mcu_fd_sc_mcu7t5v0__and2_1_57/A2 vdd vss gf180mcu_fd_sc_mcu7t5v0__and2_1
Xgf180mcu_fd_sc_mcu7t5v0__and2_1_68 vdd vss gf180mcu_fd_sc_mcu7t5v0__and2_1_68/Z gf180mcu_fd_sc_mcu7t5v0__nor4_1_2/A3
+ gf180mcu_fd_sc_mcu7t5v0__and2_1_69/Z vdd vss gf180mcu_fd_sc_mcu7t5v0__and2_1
Xgf180mcu_fd_sc_mcu7t5v0__and2_1_79 vdd vss gf180mcu_fd_sc_mcu7t5v0__or3_1_12/A3 gf180mcu_fd_sc_mcu7t5v0__dffq_2_40/Q
+ gf180mcu_fd_sc_mcu7t5v0__and2_1_79/A2 vdd vss gf180mcu_fd_sc_mcu7t5v0__and2_1
Xgf180mcu_fd_sc_mcu7t5v0__aoi211_1_14 gf180mcu_fd_sc_mcu7t5v0__nor2_1_50/ZN gf180mcu_fd_sc_mcu7t5v0__or2_1_23/A1
+ vdd vss gf180mcu_fd_sc_mcu7t5v0__dffq_1_8/D gf180mcu_fd_sc_mcu7t5v0__nor2_1_236/A1
+ gf180mcu_fd_sc_mcu7t5v0__nor2_4_16/ZN vdd vss gf180mcu_fd_sc_mcu7t5v0__aoi211_1
Xgf180mcu_fd_sc_mcu7t5v0__aoi211_1_25 gf180mcu_fd_sc_mcu7t5v0__nor2_1_110/ZN gf180mcu_fd_sc_mcu7t5v0__or2_1_23/A1
+ vdd vss gf180mcu_fd_sc_mcu7t5v0__dffq_1_242/D gf180mcu_fd_sc_mcu7t5v0__nor2_1_144/A1
+ gf180mcu_fd_sc_mcu7t5v0__nor2_4_19/ZN vdd vss gf180mcu_fd_sc_mcu7t5v0__aoi211_1
Xgf180mcu_fd_sc_mcu7t5v0__aoi211_1_36 gf180mcu_fd_sc_mcu7t5v0__nor2_1_139/ZN gf180mcu_fd_sc_mcu7t5v0__or2_1_23/A1
+ vdd vss gf180mcu_fd_sc_mcu7t5v0__dffq_1_282/D gf180mcu_fd_sc_mcu7t5v0__nor2_1_236/A1
+ gf180mcu_fd_sc_mcu7t5v0__nor2_4_20/ZN vdd vss gf180mcu_fd_sc_mcu7t5v0__aoi211_1
Xgf180mcu_fd_sc_mcu7t5v0__aoi211_1_47 gf180mcu_fd_sc_mcu7t5v0__or2_4_4/Z gf180mcu_fd_sc_mcu7t5v0__aoi211_1_47/C
+ vdd vss gf180mcu_fd_sc_mcu7t5v0__nor2_1_169/A1 gf180mcu_fd_sc_mcu7t5v0__nor2_4_30/ZN
+ gf180mcu_fd_sc_mcu7t5v0__xor2_1_89/Z vdd vss gf180mcu_fd_sc_mcu7t5v0__aoi211_1
Xgf180mcu_fd_sc_mcu7t5v0__aoi211_1_58 gf180mcu_fd_sc_mcu7t5v0__nor2_1_296/ZN gf180mcu_fd_sc_mcu7t5v0__or2_1_23/A1
+ vdd vss gf180mcu_fd_sc_mcu7t5v0__dffq_1_446/D gf180mcu_fd_sc_mcu7t5v0__nor2_1_411/A1
+ gf180mcu_fd_sc_mcu7t5v0__nor2_4_18/ZN vdd vss gf180mcu_fd_sc_mcu7t5v0__aoi211_1
Xgf180mcu_fd_sc_mcu7t5v0__aoi211_1_69 gf180mcu_fd_sc_mcu7t5v0__aoi211_1_69/B gf180mcu_fd_sc_mcu7t5v0__nor2_4_38/ZN
+ vdd vss gf180mcu_fd_sc_mcu7t5v0__oai21_1_247/B gf180mcu_fd_sc_mcu7t5v0__nor3_4_18/ZN
+ gf180mcu_fd_sc_mcu7t5v0__xor2_1_84/Z vdd vss gf180mcu_fd_sc_mcu7t5v0__aoi211_1
Xgf180mcu_fd_sc_mcu7t5v0__clkinv_1_60 vdd vss gf180mcu_fd_sc_mcu7t5v0__dffq_1_18/Q
+ gf180mcu_fd_sc_mcu7t5v0__oai22_1_13/B2 vdd vss gf180mcu_fd_sc_mcu7t5v0__clkinv_1
Xgf180mcu_fd_sc_mcu7t5v0__clkinv_1_71 vdd vss gf180mcu_fd_sc_mcu7t5v0__dffq_1_62/Q
+ gf180mcu_fd_sc_mcu7t5v0__oai22_1_51/B2 vdd vss gf180mcu_fd_sc_mcu7t5v0__clkinv_1
Xgf180mcu_fd_sc_mcu7t5v0__aoi21_1_202 gf180mcu_fd_sc_mcu7t5v0__aoi21_1_202/B vdd vss
+ gf180mcu_fd_sc_mcu7t5v0__dffq_1_403/D gf180mcu_fd_sc_mcu7t5v0__nor3_4_15/ZN gf180mcu_fd_sc_mcu7t5v0__aoi22_4_6/ZN
+ vdd vss gf180mcu_fd_sc_mcu7t5v0__aoi21_1
Xgf180mcu_fd_sc_mcu7t5v0__clkinv_1_82 vdd vss gf180mcu_fd_sc_mcu7t5v0__dffq_1_55/Q
+ gf180mcu_fd_sc_mcu7t5v0__oai22_1_95/B2 vdd vss gf180mcu_fd_sc_mcu7t5v0__clkinv_1
Xgf180mcu_fd_sc_mcu7t5v0__aoi21_1_213 gf180mcu_fd_sc_mcu7t5v0__aoi21_1_213/B vdd vss
+ gf180mcu_fd_sc_mcu7t5v0__nor2_1_208/A2 gf180mcu_fd_sc_mcu7t5v0__dffq_1_302/Q gf180mcu_fd_sc_mcu7t5v0__inv_2_8/ZN
+ vdd vss gf180mcu_fd_sc_mcu7t5v0__aoi21_1
Xgf180mcu_fd_sc_mcu7t5v0__clkinv_1_93 vdd vss gf180mcu_fd_sc_mcu7t5v0__dffq_1_93/Q
+ gf180mcu_fd_sc_mcu7t5v0__oai22_1_94/B2 vdd vss gf180mcu_fd_sc_mcu7t5v0__clkinv_1
Xgf180mcu_fd_sc_mcu7t5v0__aoi21_1_224 gf180mcu_fd_sc_mcu7t5v0__aoi21_1_224/B vdd vss
+ gf180mcu_fd_sc_mcu7t5v0__nor2_1_258/A2 gf180mcu_fd_sc_mcu7t5v0__inv_1_2/I gf180mcu_fd_sc_mcu7t5v0__or2_4_4/Z
+ vdd vss gf180mcu_fd_sc_mcu7t5v0__aoi21_1
Xgf180mcu_fd_sc_mcu7t5v0__aoi21_1_235 gf180mcu_fd_sc_mcu7t5v0__aoi21_1_235/B vdd vss
+ gf180mcu_fd_sc_mcu7t5v0__dffq_4_24/D gf180mcu_fd_sc_mcu7t5v0__oai22_4_3/A1 gf180mcu_fd_sc_mcu7t5v0__buf_20_0/Z
+ vdd vss gf180mcu_fd_sc_mcu7t5v0__aoi21_1
Xgf180mcu_fd_sc_mcu7t5v0__aoi21_1_246 gf180mcu_fd_sc_mcu7t5v0__aoi21_2_11/B vdd vss
+ gf180mcu_fd_sc_mcu7t5v0__xnor2_1_47/A2 gf180mcu_fd_sc_mcu7t5v0__xor2_1_137/A1 gf180mcu_fd_sc_mcu7t5v0__nor4_2_5/ZN
+ vdd vss gf180mcu_fd_sc_mcu7t5v0__aoi21_1
Xgf180mcu_fd_sc_mcu7t5v0__aoi21_1_257 gf180mcu_fd_sc_mcu7t5v0__and2_1_103/Z vdd vss
+ gf180mcu_fd_sc_mcu7t5v0__xor3_1_81/A2 gf180mcu_fd_sc_mcu7t5v0__xor3_1_78/Z gf180mcu_fd_sc_mcu7t5v0__xor2_1_145/Z
+ vdd vss gf180mcu_fd_sc_mcu7t5v0__aoi21_1
Xgf180mcu_fd_sc_mcu7t5v0__aoi21_1_268 gf180mcu_fd_sc_mcu7t5v0__aoi21_1_268/B vdd vss
+ gf180mcu_fd_sc_mcu7t5v0__dffq_4_42/D gf180mcu_fd_sc_mcu7t5v0__aoi21_1_268/A1 gf180mcu_fd_sc_mcu7t5v0__buf_20_0/Z
+ vdd vss gf180mcu_fd_sc_mcu7t5v0__aoi21_1
Xgf180mcu_fd_sc_mcu7t5v0__aoi21_1_279 gf180mcu_fd_sc_mcu7t5v0__aoi21_1_279/B vdd vss
+ gf180mcu_fd_sc_mcu7t5v0__dffq_4_38/D gf180mcu_fd_sc_mcu7t5v0__or4_1_0/A2 gf180mcu_fd_sc_mcu7t5v0__buf_20_0/Z
+ vdd vss gf180mcu_fd_sc_mcu7t5v0__aoi21_1
Xgf180mcu_fd_sc_mcu7t5v0__oai21_1_13 vdd gf180mcu_fd_sc_mcu7t5v0__nor3_1_5/A1 gf180mcu_fd_sc_mcu7t5v0__or2_1_3/A2
+ gf180mcu_fd_sc_mcu7t5v0__oai21_1_13/ZN gf180mcu_fd_sc_mcu7t5v0__or2_1_3/A1 vss vdd
+ vss gf180mcu_fd_sc_mcu7t5v0__oai21_1
Xgf180mcu_fd_sc_mcu7t5v0__oai21_1_24 vdd gf180mcu_fd_sc_mcu7t5v0__oai21_1_24/B gf180mcu_fd_sc_mcu7t5v0__xor3_1_64/Z
+ gf180mcu_fd_sc_mcu7t5v0__oai21_1_24/ZN gf180mcu_fd_sc_mcu7t5v0__oai21_1_24/A1 vss
+ vdd vss gf180mcu_fd_sc_mcu7t5v0__oai21_1
Xgf180mcu_fd_sc_mcu7t5v0__oai21_1_35 vdd gf180mcu_fd_sc_mcu7t5v0__buf_8_5/Z gf180mcu_fd_sc_mcu7t5v0__buf_20_0/Z
+ gf180mcu_fd_sc_mcu7t5v0__aoi21_1_71/B gf180mcu_fd_sc_mcu7t5v0__dffq_1_3/Q vss vdd
+ vss gf180mcu_fd_sc_mcu7t5v0__oai21_1
Xgf180mcu_fd_sc_mcu7t5v0__oai21_1_46 vdd gf180mcu_fd_sc_mcu7t5v0__oai21_1_46/B gf180mcu_fd_sc_mcu7t5v0__oai21_1_46/A2
+ gf180mcu_fd_sc_mcu7t5v0__xor3_1_29/A2 gf180mcu_fd_sc_mcu7t5v0__xor2_1_33/A1 vss
+ vdd vss gf180mcu_fd_sc_mcu7t5v0__oai21_1
Xgf180mcu_fd_sc_mcu7t5v0__oai21_1_57 vdd gf180mcu_fd_sc_mcu7t5v0__buf_8_5/Z gf180mcu_fd_sc_mcu7t5v0__buf_20_0/Z
+ gf180mcu_fd_sc_mcu7t5v0__aoi21_1_70/B gf180mcu_fd_sc_mcu7t5v0__dffq_1_5/Q vss vdd
+ vss gf180mcu_fd_sc_mcu7t5v0__oai21_1
Xgf180mcu_fd_sc_mcu7t5v0__oai21_1_68 vdd gf180mcu_fd_sc_mcu7t5v0__inv_2_4/I gf180mcu_fd_sc_mcu7t5v0__inv_4_0/I
+ gf180mcu_fd_sc_mcu7t5v0__and2_2_8/A2 gf180mcu_fd_sc_mcu7t5v0__nor3_4_4/A1 vss vdd
+ vss gf180mcu_fd_sc_mcu7t5v0__oai21_1
Xgf180mcu_fd_sc_mcu7t5v0__oai21_1_79 vdd gf180mcu_fd_sc_mcu7t5v0__oai21_1_79/B gf180mcu_fd_sc_mcu7t5v0__oai21_1_79/A2
+ gf180mcu_fd_sc_mcu7t5v0__oai21_1_78/B gf180mcu_fd_sc_mcu7t5v0__oai32_1_3/B2 vss
+ vdd vss gf180mcu_fd_sc_mcu7t5v0__oai21_1
Xgf180mcu_fd_sc_mcu7t5v0__dffq_1_109 vdd gf180mcu_fd_sc_mcu7t5v0__dffq_1_109/Q gf180mcu_fd_sc_mcu7t5v0__dffq_2_26/CLK
+ vss gf180mcu_fd_sc_mcu7t5v0__dffq_1_109/D vdd vss gf180mcu_fd_sc_mcu7t5v0__dffq_1
Xgf180mcu_fd_sc_mcu7t5v0__nor2_1_309 vdd vss gf180mcu_fd_sc_mcu7t5v0__nor2_1_309/ZN
+ gf180mcu_fd_sc_mcu7t5v0__mux4_4_9/I3 gf180mcu_fd_sc_mcu7t5v0__xor3_1_107/A3 vdd
+ vss gf180mcu_fd_sc_mcu7t5v0__nor2_1
Xgf180mcu_fd_sc_mcu7t5v0__aoi21_2_5 gf180mcu_fd_sc_mcu7t5v0__aoi21_2_5/B vdd vss gf180mcu_fd_sc_mcu7t5v0__nor3_1_8/A3
+ gf180mcu_fd_sc_mcu7t5v0__aoi21_2_5/A1 gf180mcu_fd_sc_mcu7t5v0__aoi21_2_5/A2 vdd
+ vss gf180mcu_fd_sc_mcu7t5v0__aoi21_2
Xgf180mcu_fd_sc_mcu7t5v0__nand2_1_502 vdd vss gf180mcu_fd_sc_mcu7t5v0__xor3_1_98/A2
+ gf180mcu_fd_sc_mcu7t5v0__nand3_1_77/ZN gf180mcu_fd_sc_mcu7t5v0__nand3_1_76/ZN vdd
+ vss gf180mcu_fd_sc_mcu7t5v0__nand2_1
Xgf180mcu_fd_sc_mcu7t5v0__nand2_1_513 vdd vss gf180mcu_fd_sc_mcu7t5v0__xor3_1_97/A1
+ gf180mcu_fd_sc_mcu7t5v0__or4_1_0/A1 gf180mcu_fd_sc_mcu7t5v0__and2_2_9/Z vdd vss
+ gf180mcu_fd_sc_mcu7t5v0__nand2_1
Xgf180mcu_fd_sc_mcu7t5v0__nand2_1_524 vdd vss gf180mcu_fd_sc_mcu7t5v0__and3_1_16/A1
+ gf180mcu_fd_sc_mcu7t5v0__or4_1_0/A1 gf180mcu_fd_sc_mcu7t5v0__xor2_1_223/Z vdd vss
+ gf180mcu_fd_sc_mcu7t5v0__nand2_1
Xgf180mcu_fd_sc_mcu7t5v0__nand2_1_535 vdd vss gf180mcu_fd_sc_mcu7t5v0__nand2_1_535/ZN
+ gf180mcu_fd_sc_mcu7t5v0__mux4_4_5/I3 gf180mcu_fd_sc_mcu7t5v0__clkinv_3_9/ZN vdd
+ vss gf180mcu_fd_sc_mcu7t5v0__nand2_1
Xgf180mcu_fd_sc_mcu7t5v0__nand2_1_546 vdd vss gf180mcu_fd_sc_mcu7t5v0__nand2_1_546/ZN
+ gf180mcu_fd_sc_mcu7t5v0__dffq_2_26/Q gf180mcu_fd_sc_mcu7t5v0__nor3_4_12/ZN vdd vss
+ gf180mcu_fd_sc_mcu7t5v0__nand2_1
Xgf180mcu_fd_sc_mcu7t5v0__nand2_1_557 vdd vss gf180mcu_fd_sc_mcu7t5v0__oai21_1_287/B
+ gf180mcu_fd_sc_mcu7t5v0__mux4_4_8/I0 gf180mcu_fd_sc_mcu7t5v0__xor3_2_2/Z vdd vss
+ gf180mcu_fd_sc_mcu7t5v0__nand2_1
Xgf180mcu_fd_sc_mcu7t5v0__nand2_1_568 vdd vss gf180mcu_fd_sc_mcu7t5v0__xnor2_1_65/A1
+ gf180mcu_fd_sc_mcu7t5v0__nand2_1_635/ZN gf180mcu_fd_sc_mcu7t5v0__nand3_1_87/A2 vdd
+ vss gf180mcu_fd_sc_mcu7t5v0__nand2_1
Xgf180mcu_fd_sc_mcu7t5v0__aoi21_2_15 gf180mcu_fd_sc_mcu7t5v0__or2_2_1/A1 vdd vss gf180mcu_fd_sc_mcu7t5v0__oai32_4_0/A3
+ gf180mcu_fd_sc_mcu7t5v0__aoi21_2_15/A1 gf180mcu_fd_sc_mcu7t5v0__inv_4_5/I vdd vss
+ gf180mcu_fd_sc_mcu7t5v0__aoi21_2
Xgf180mcu_fd_sc_mcu7t5v0__nand2_1_579 vdd vss gf180mcu_fd_sc_mcu7t5v0__nor2_2_46/A2
+ gf180mcu_fd_sc_mcu7t5v0__dffq_2_86/Q gf180mcu_fd_sc_mcu7t5v0__dffq_2_87/Q vdd vss
+ gf180mcu_fd_sc_mcu7t5v0__nand2_1
Xgf180mcu_fd_sc_mcu7t5v0__xor2_2_4 vdd vss gf180mcu_fd_sc_mcu7t5v0__xor2_2_4/Z gf180mcu_fd_sc_mcu7t5v0__xor2_2_4/A1
+ gf180mcu_fd_sc_mcu7t5v0__xor2_2_4/A2 vdd vss gf180mcu_fd_sc_mcu7t5v0__xor2_2
Xgf180mcu_fd_sc_mcu7t5v0__oai211_2_5 gf180mcu_fd_sc_mcu7t5v0__oai211_2_6/A2 gf180mcu_fd_sc_mcu7t5v0__or2_1_38/A2
+ gf180mcu_fd_sc_mcu7t5v0__and2_1_105/Z gf180mcu_fd_sc_mcu7t5v0__oai211_2_6/B gf180mcu_fd_sc_mcu7t5v0__inv_8_1/I
+ vdd vss vdd vss gf180mcu_fd_sc_mcu7t5v0__oai211_2
Xgf180mcu_fd_sc_mcu7t5v0__mux4_4_18 gf180mcu_fd_sc_mcu7t5v0__dffq_2_81/Q vss vdd gf180mcu_fd_sc_mcu7t5v0__inv_1_0/I
+ gf180mcu_fd_sc_mcu7t5v0__mux4_4_18/I1 gf180mcu_fd_sc_mcu7t5v0__mux4_4_9/S0 gf180mcu_fd_sc_mcu7t5v0__dffq_2_65/Q
+ gf180mcu_fd_sc_mcu7t5v0__inv_1_16/I gf180mcu_fd_sc_mcu7t5v0__mux4_4_18/Z vdd vss
+ gf180mcu_fd_sc_mcu7t5v0__mux4_4
Xgf180mcu_fd_sc_mcu7t5v0__oai21_2_8 gf180mcu_fd_sc_mcu7t5v0__oai21_2_8/A2 gf180mcu_fd_sc_mcu7t5v0__oai21_2_8/ZN
+ gf180mcu_fd_sc_mcu7t5v0__oai31_2_0/A2 vss gf180mcu_fd_sc_mcu7t5v0__buf_8_8/I vdd
+ vdd vss gf180mcu_fd_sc_mcu7t5v0__oai21_2
Xgf180mcu_fd_sc_mcu7t5v0__or3_1_11 gf180mcu_fd_sc_mcu7t5v0__or3_1_11/A3 vdd vss gf180mcu_fd_sc_mcu7t5v0__or3_1_11/Z
+ gf180mcu_fd_sc_mcu7t5v0__or3_1_11/A1 gf180mcu_fd_sc_mcu7t5v0__or3_1_11/A2 vdd vss
+ gf180mcu_fd_sc_mcu7t5v0__or3_1
Xgf180mcu_fd_sc_mcu7t5v0__or3_1_22 gf180mcu_fd_sc_mcu7t5v0__or3_1_22/A3 vdd vss gf180mcu_fd_sc_mcu7t5v0__or3_1_22/Z
+ gf180mcu_fd_sc_mcu7t5v0__or3_1_22/A1 gf180mcu_fd_sc_mcu7t5v0__or3_1_22/A2 vdd vss
+ gf180mcu_fd_sc_mcu7t5v0__or3_1
Xgf180mcu_fd_sc_mcu7t5v0__nor3_4_11 gf180mcu_fd_sc_mcu7t5v0__nor2_4_7/A1 vdd vss gf180mcu_fd_sc_mcu7t5v0__nor3_4_11/ZN
+ gf180mcu_fd_sc_mcu7t5v0__mux2_2_0/Z gf180mcu_fd_sc_mcu7t5v0__or2_2_0/A2 vdd vss
+ gf180mcu_fd_sc_mcu7t5v0__nor3_4
Xgf180mcu_fd_sc_mcu7t5v0__nor3_4_22 gf180mcu_fd_sc_mcu7t5v0__nor3_4_22/A3 vdd vss
+ gf180mcu_fd_sc_mcu7t5v0__nor3_4_22/ZN gf180mcu_fd_sc_mcu7t5v0__inv_3_4/ZN gf180mcu_fd_sc_mcu7t5v0__dffq_2_86/Q
+ vdd vss gf180mcu_fd_sc_mcu7t5v0__nor3_4
Xgf180mcu_fd_sc_mcu7t5v0__tiel_6 uart_tx_SL vdd vss vdd vss gf180mcu_fd_sc_mcu7t5v0__tiel
Xgf180mcu_fd_sc_mcu7t5v0__nor2_1_106 vdd vss gf180mcu_fd_sc_mcu7t5v0__nor2_1_106/ZN
+ gf180mcu_fd_sc_mcu7t5v0__dffq_1_229/Q gf180mcu_fd_sc_mcu7t5v0__nor2_4_22/ZN vdd
+ vss gf180mcu_fd_sc_mcu7t5v0__nor2_1
Xgf180mcu_fd_sc_mcu7t5v0__nor2_1_117 vdd vss gf180mcu_fd_sc_mcu7t5v0__aoi21_4_4/B
+ gf180mcu_fd_sc_mcu7t5v0__inv_4_3/ZN gf180mcu_fd_sc_mcu7t5v0__or3_4_0/Z vdd vss gf180mcu_fd_sc_mcu7t5v0__nor2_1
Xgf180mcu_fd_sc_mcu7t5v0__nor2_1_128 vdd vss gf180mcu_fd_sc_mcu7t5v0__xor3_1_68/A3
+ gf180mcu_fd_sc_mcu7t5v0__inv_8_2/ZN gf180mcu_fd_sc_mcu7t5v0__nor2_4_45/A2 vdd vss
+ gf180mcu_fd_sc_mcu7t5v0__nor2_1
Xgf180mcu_fd_sc_mcu7t5v0__nor2_1_139 vdd vss gf180mcu_fd_sc_mcu7t5v0__nor2_1_139/ZN
+ gf180mcu_fd_sc_mcu7t5v0__dffq_1_282/Q gf180mcu_fd_sc_mcu7t5v0__nor2_4_20/ZN vdd
+ vss gf180mcu_fd_sc_mcu7t5v0__nor2_1
Xgf180mcu_fd_sc_mcu7t5v0__xor3_1_107 gf180mcu_fd_sc_mcu7t5v0__xor3_1_107/A3 vdd vss
+ gf180mcu_fd_sc_mcu7t5v0__xor3_1_107/Z gf180mcu_fd_sc_mcu7t5v0__mux4_4_9/I3 gf180mcu_fd_sc_mcu7t5v0__and2_1_114/Z
+ vdd vss gf180mcu_fd_sc_mcu7t5v0__xor3_1
Xgf180mcu_fd_sc_mcu7t5v0__xor3_1_118 gf180mcu_fd_sc_mcu7t5v0__xor3_1_118/A3 vdd vss
+ gf180mcu_fd_sc_mcu7t5v0__xor3_1_118/Z gf180mcu_fd_sc_mcu7t5v0__xor2_1_160/Z gf180mcu_fd_sc_mcu7t5v0__xor3_1_118/A2
+ vdd vss gf180mcu_fd_sc_mcu7t5v0__xor3_1
Xgf180mcu_fd_sc_mcu7t5v0__xor3_1_129 gf180mcu_fd_sc_mcu7t5v0__xor3_1_129/A3 vdd vss
+ gf180mcu_fd_sc_mcu7t5v0__or3_1_23/A3 gf180mcu_fd_sc_mcu7t5v0__or4_1_0/A1 gf180mcu_fd_sc_mcu7t5v0__mux4_4_15/Z
+ vdd vss gf180mcu_fd_sc_mcu7t5v0__xor3_1
Xgf180mcu_fd_sc_mcu7t5v0__nand2_1_310 vdd vss gf180mcu_fd_sc_mcu7t5v0__nor4_4_1/A4
+ gf180mcu_fd_sc_mcu7t5v0__dffq_2_34/Q gf180mcu_fd_sc_mcu7t5v0__inv_1_8/ZN vdd vss
+ gf180mcu_fd_sc_mcu7t5v0__nand2_1
Xgf180mcu_fd_sc_mcu7t5v0__nand2_1_321 vdd vss gf180mcu_fd_sc_mcu7t5v0__nand2_1_321/ZN
+ gf180mcu_fd_sc_mcu7t5v0__nor2_4_30/ZN gf180mcu_fd_sc_mcu7t5v0__xor3_1_69/Z vdd vss
+ gf180mcu_fd_sc_mcu7t5v0__nand2_1
Xgf180mcu_fd_sc_mcu7t5v0__nand2_1_332 vdd vss gf180mcu_fd_sc_mcu7t5v0__nand2_1_332/ZN
+ gf180mcu_fd_sc_mcu7t5v0__inv_4_6/I gf180mcu_fd_sc_mcu7t5v0__xor2_1_224/A1 vdd vss
+ gf180mcu_fd_sc_mcu7t5v0__nand2_1
Xgf180mcu_fd_sc_mcu7t5v0__nand2_1_343 vdd vss gf180mcu_fd_sc_mcu7t5v0__aoi222_4_0/C1
+ gf180mcu_fd_sc_mcu7t5v0__nand2_1_343/A1 gf180mcu_fd_sc_mcu7t5v0__nand2_1_343/A2
+ vdd vss gf180mcu_fd_sc_mcu7t5v0__nand2_1
Xgf180mcu_fd_sc_mcu7t5v0__nand2_1_354 vdd vss gf180mcu_fd_sc_mcu7t5v0__or3_1_11/A1
+ gf180mcu_fd_sc_mcu7t5v0__nor4_1_1/ZN gf180mcu_fd_sc_mcu7t5v0__nor4_1_0/ZN vdd vss
+ gf180mcu_fd_sc_mcu7t5v0__nand2_1
Xgf180mcu_fd_sc_mcu7t5v0__nand2_1_365 vdd vss gf180mcu_fd_sc_mcu7t5v0__nand4_1_7/A2
+ gf180mcu_fd_sc_mcu7t5v0__dffq_1_377/Q gf180mcu_fd_sc_mcu7t5v0__nor2_1_203/A1 vdd
+ vss gf180mcu_fd_sc_mcu7t5v0__nand2_1
Xgf180mcu_fd_sc_mcu7t5v0__nand2_1_376 vdd vss gf180mcu_fd_sc_mcu7t5v0__aoi21_1_183/B
+ gf180mcu_fd_sc_mcu7t5v0__oai31_1_9/A3 gf180mcu_fd_sc_mcu7t5v0__or2_1_57/Z vdd vss
+ gf180mcu_fd_sc_mcu7t5v0__nand2_1
Xgf180mcu_fd_sc_mcu7t5v0__nand2_1_387 vdd vss gf180mcu_fd_sc_mcu7t5v0__xor2_1_101/A1
+ gf180mcu_fd_sc_mcu7t5v0__nand2_1_387/A1 gf180mcu_fd_sc_mcu7t5v0__nand2_1_387/A2
+ vdd vss gf180mcu_fd_sc_mcu7t5v0__nand2_1
Xgf180mcu_fd_sc_mcu7t5v0__nand2_1_398 vdd vss gf180mcu_fd_sc_mcu7t5v0__xnor2_1_86/A1
+ gf180mcu_fd_sc_mcu7t5v0__nand2_1_398/A1 gf180mcu_fd_sc_mcu7t5v0__nand3_1_64/A3 vdd
+ vss gf180mcu_fd_sc_mcu7t5v0__nand2_1
Xgf180mcu_fd_sc_mcu7t5v0__dffq_1_440 vdd gf180mcu_fd_sc_mcu7t5v0__dffq_1_440/Q gf180mcu_fd_sc_mcu7t5v0__dffq_4_44/CLK
+ vss gf180mcu_fd_sc_mcu7t5v0__dffq_1_440/D vdd vss gf180mcu_fd_sc_mcu7t5v0__dffq_1
Xgf180mcu_fd_sc_mcu7t5v0__dffq_1_451 vdd gf180mcu_fd_sc_mcu7t5v0__mux2_4_3/I1 gf180mcu_fd_sc_mcu7t5v0__dffq_2_58/CLK
+ vss gf180mcu_fd_sc_mcu7t5v0__dffq_1_451/D vdd vss gf180mcu_fd_sc_mcu7t5v0__dffq_1
Xgf180mcu_fd_sc_mcu7t5v0__clkinv_1_301 vdd vss gf180mcu_fd_sc_mcu7t5v0__dffq_1_383/Q
+ gf180mcu_fd_sc_mcu7t5v0__aoi21_1_176/A1 vdd vss gf180mcu_fd_sc_mcu7t5v0__clkinv_1
Xgf180mcu_fd_sc_mcu7t5v0__clkinv_1_312 vdd vss gf180mcu_fd_sc_mcu7t5v0__oai21_1_164/ZN
+ gf180mcu_fd_sc_mcu7t5v0__dffq_1_367/D vdd vss gf180mcu_fd_sc_mcu7t5v0__clkinv_1
Xgf180mcu_fd_sc_mcu7t5v0__clkinv_1_323 vdd vss gf180mcu_fd_sc_mcu7t5v0__clkinv_1_323/I
+ gf180mcu_fd_sc_mcu7t5v0__aoi22_4_7/B1 vdd vss gf180mcu_fd_sc_mcu7t5v0__clkinv_1
Xgf180mcu_fd_sc_mcu7t5v0__clkinv_1_334 vdd vss gf180mcu_fd_sc_mcu7t5v0__xor3_2_1/A2
+ gf180mcu_fd_sc_mcu7t5v0__nor3_2_8/A1 vdd vss gf180mcu_fd_sc_mcu7t5v0__clkinv_1
Xgf180mcu_fd_sc_mcu7t5v0__clkinv_1_345 vdd vss gf180mcu_fd_sc_mcu7t5v0__mux4_4_16/I0
+ gf180mcu_fd_sc_mcu7t5v0__aoi21_1_303/A1 vdd vss gf180mcu_fd_sc_mcu7t5v0__clkinv_1
Xgf180mcu_fd_sc_mcu7t5v0__clkinv_1_356 vdd vss gf180mcu_fd_sc_mcu7t5v0__dffq_2_95/Q
+ gf180mcu_fd_sc_mcu7t5v0__xor3_1_149/A1 vdd vss gf180mcu_fd_sc_mcu7t5v0__clkinv_1
Xgf180mcu_fd_sc_mcu7t5v0__clkinv_1_367 vdd vss gf180mcu_fd_sc_mcu7t5v0__mux4_4_13/I0
+ gf180mcu_fd_sc_mcu7t5v0__aoi21_1_287/A1 vdd vss gf180mcu_fd_sc_mcu7t5v0__clkinv_1
Xgf180mcu_fd_sc_mcu7t5v0__nand2_4_20 vdd vss gf180mcu_fd_sc_mcu7t5v0__nand2_4_20/ZN
+ gf180mcu_fd_sc_mcu7t5v0__nor3_4_7/ZN gf180mcu_fd_sc_mcu7t5v0__nor2_4_12/ZN vdd vss
+ gf180mcu_fd_sc_mcu7t5v0__nand2_4
Xgf180mcu_fd_sc_mcu7t5v0__nand2_4_31 vdd vss gf180mcu_fd_sc_mcu7t5v0__nand2_4_31/ZN
+ gf180mcu_fd_sc_mcu7t5v0__nor3_4_10/ZN gf180mcu_fd_sc_mcu7t5v0__nor2_4_4/ZN vdd vss
+ gf180mcu_fd_sc_mcu7t5v0__nand2_4
Xgf180mcu_fd_sc_mcu7t5v0__nand2_4_42 vdd vss gf180mcu_fd_sc_mcu7t5v0__oai31_1_14/B
+ gf180mcu_fd_sc_mcu7t5v0__dffq_2_98/Q gf180mcu_fd_sc_mcu7t5v0__nor2_2_29/ZN vdd vss
+ gf180mcu_fd_sc_mcu7t5v0__nand2_4
Xgf180mcu_fd_sc_mcu7t5v0__clkinv_3_17 vdd gf180mcu_fd_sc_mcu7t5v0__aoi21_4_9/A1 gf180mcu_fd_sc_mcu7t5v0__mux4_4_8/I0
+ vss vdd vss gf180mcu_fd_sc_mcu7t5v0__clkinv_3
Xgf180mcu_fd_sc_mcu7t5v0__dffq_4_3 gf180mcu_fd_sc_mcu7t5v0__dffq_4_3/D gf180mcu_fd_sc_mcu7t5v0__dffq_4_3/Q
+ vdd vss gf180mcu_fd_sc_mcu7t5v0__dffq_4_6/CLK vdd vss gf180mcu_fd_sc_mcu7t5v0__dffq_4
Xgf180mcu_fd_sc_mcu7t5v0__nand2_1_140 vdd vss gf180mcu_fd_sc_mcu7t5v0__xor2_1_62/A2
+ gf180mcu_fd_sc_mcu7t5v0__or4_1_0/Z gf180mcu_fd_sc_mcu7t5v0__oai22_2_0/ZN vdd vss
+ gf180mcu_fd_sc_mcu7t5v0__nand2_1
Xgf180mcu_fd_sc_mcu7t5v0__nand2_1_151 vdd vss gf180mcu_fd_sc_mcu7t5v0__aoi22_4_1/B1
+ gf180mcu_fd_sc_mcu7t5v0__dffq_2_9/Q gf180mcu_fd_sc_mcu7t5v0__and2_2_6/Z vdd vss
+ gf180mcu_fd_sc_mcu7t5v0__nand2_1
Xgf180mcu_fd_sc_mcu7t5v0__nand2_1_162 vdd vss gf180mcu_fd_sc_mcu7t5v0__clkinv_1_16/I
+ gf180mcu_fd_sc_mcu7t5v0__or4_1_0/A1 gf180mcu_fd_sc_mcu7t5v0__xor2_1_52/Z vdd vss
+ gf180mcu_fd_sc_mcu7t5v0__nand2_1
Xgf180mcu_fd_sc_mcu7t5v0__nand2_1_173 vdd vss gf180mcu_fd_sc_mcu7t5v0__nand4_1_4/A1
+ gf180mcu_fd_sc_mcu7t5v0__nor2_2_10/ZN gf180mcu_fd_sc_mcu7t5v0__xor2_1_61/A2 vdd
+ vss gf180mcu_fd_sc_mcu7t5v0__nand2_1
Xgf180mcu_fd_sc_mcu7t5v0__nand2_1_184 vdd vss gf180mcu_fd_sc_mcu7t5v0__nand2_1_184/ZN
+ gf180mcu_fd_sc_mcu7t5v0__oai31_1_2/B gf180mcu_fd_sc_mcu7t5v0__xor2_1_58/A1 vdd vss
+ gf180mcu_fd_sc_mcu7t5v0__nand2_1
Xgf180mcu_fd_sc_mcu7t5v0__nand2_1_195 vdd vss gf180mcu_fd_sc_mcu7t5v0__nand2_1_195/ZN
+ gf180mcu_fd_sc_mcu7t5v0__dffq_2_21/Q gf180mcu_fd_sc_mcu7t5v0__xor2_1_37/Z vdd vss
+ gf180mcu_fd_sc_mcu7t5v0__nand2_1
Xgf180mcu_fd_sc_mcu7t5v0__clkinv_4_2 vdd vss gf180mcu_fd_sc_mcu7t5v0__nor3_4_18/A1
+ gf180mcu_fd_sc_mcu7t5v0__dffq_4_28/Q vdd vss gf180mcu_fd_sc_mcu7t5v0__clkinv_4
Xgf180mcu_fd_sc_mcu7t5v0__dffq_1_270 vdd gf180mcu_fd_sc_mcu7t5v0__dffq_1_270/Q gf180mcu_fd_sc_mcu7t5v0__dffq_1_96/CLK
+ vss gf180mcu_fd_sc_mcu7t5v0__dffq_1_270/D vdd vss gf180mcu_fd_sc_mcu7t5v0__dffq_1
Xgf180mcu_fd_sc_mcu7t5v0__dffq_1_281 vdd gf180mcu_fd_sc_mcu7t5v0__dffq_1_281/Q gf180mcu_fd_sc_mcu7t5v0__dffq_4_9/CLK
+ vss gf180mcu_fd_sc_mcu7t5v0__dffq_1_281/D vdd vss gf180mcu_fd_sc_mcu7t5v0__dffq_1
Xgf180mcu_fd_sc_mcu7t5v0__oai211_2_10 gf180mcu_fd_sc_mcu7t5v0__oai31_4_4/ZN gf180mcu_fd_sc_mcu7t5v0__xnor3_1_38/A3
+ gf180mcu_fd_sc_mcu7t5v0__aoi21_4_9/ZN gf180mcu_fd_sc_mcu7t5v0__oai21_4_12/B gf180mcu_fd_sc_mcu7t5v0__inv_8_0/I
+ vdd vss vdd vss gf180mcu_fd_sc_mcu7t5v0__oai211_2
Xgf180mcu_fd_sc_mcu7t5v0__dffq_1_292 vdd gf180mcu_fd_sc_mcu7t5v0__mux2_4_1/I1 gf180mcu_fd_sc_mcu7t5v0__dffq_2_58/CLK
+ vss gf180mcu_fd_sc_mcu7t5v0__dffq_1_292/D vdd vss gf180mcu_fd_sc_mcu7t5v0__dffq_1
Xgf180mcu_fd_sc_mcu7t5v0__nand3_2_7 gf180mcu_fd_sc_mcu7t5v0__nor2_4_1/A2 vdd vss gf180mcu_fd_sc_mcu7t5v0__nor2_1_22/A1
+ gf180mcu_fd_sc_mcu7t5v0__nor2_2_6/A2 gf180mcu_fd_sc_mcu7t5v0__mux2_1_2/I0 vdd vss
+ gf180mcu_fd_sc_mcu7t5v0__nand3_2
Xgf180mcu_fd_sc_mcu7t5v0__xor2_1_106 vdd vss gf180mcu_fd_sc_mcu7t5v0__xor2_1_106/Z
+ gf180mcu_fd_sc_mcu7t5v0__or3_1_14/Z gf180mcu_fd_sc_mcu7t5v0__xor2_1_106/A2 vdd vss
+ gf180mcu_fd_sc_mcu7t5v0__xor2_1
Xgf180mcu_fd_sc_mcu7t5v0__xor2_1_117 vdd vss gf180mcu_fd_sc_mcu7t5v0__xor2_1_117/Z
+ gf180mcu_fd_sc_mcu7t5v0__mux4_4_19/Z gf180mcu_fd_sc_mcu7t5v0__oai31_2_1/ZN vdd vss
+ gf180mcu_fd_sc_mcu7t5v0__xor2_1
Xgf180mcu_fd_sc_mcu7t5v0__xor2_1_128 vdd vss gf180mcu_fd_sc_mcu7t5v0__xor2_1_128/Z
+ gf180mcu_fd_sc_mcu7t5v0__or2_1_32/Z gf180mcu_fd_sc_mcu7t5v0__xor3_1_103/Z vdd vss
+ gf180mcu_fd_sc_mcu7t5v0__xor2_1
Xgf180mcu_fd_sc_mcu7t5v0__xor2_1_139 vdd vss gf180mcu_fd_sc_mcu7t5v0__xor3_1_95/A1
+ gf180mcu_fd_sc_mcu7t5v0__xor2_1_139/A1 gf180mcu_fd_sc_mcu7t5v0__xor2_1_139/A2 vdd
+ vss gf180mcu_fd_sc_mcu7t5v0__xor2_1
Xgf180mcu_fd_sc_mcu7t5v0__nor3_1_12 gf180mcu_fd_sc_mcu7t5v0__nor3_1_12/A3 vdd vss
+ gf180mcu_fd_sc_mcu7t5v0__nor3_1_12/ZN gf180mcu_fd_sc_mcu7t5v0__oai21_2_8/ZN gf180mcu_fd_sc_mcu7t5v0__and3_1_10/Z
+ vdd vss gf180mcu_fd_sc_mcu7t5v0__nor3_1
Xgf180mcu_fd_sc_mcu7t5v0__nor3_1_23 gf180mcu_fd_sc_mcu7t5v0__nor3_1_24/A3 vdd vss
+ gf180mcu_fd_sc_mcu7t5v0__dffq_2_59/D gf180mcu_fd_sc_mcu7t5v0__nor3_1_23/A1 gf180mcu_fd_sc_mcu7t5v0__nor3_1_24/A2
+ vdd vss gf180mcu_fd_sc_mcu7t5v0__nor3_1
Xgf180mcu_fd_sc_mcu7t5v0__clkinv_1_120 vdd vss gf180mcu_fd_sc_mcu7t5v0__dffq_1_103/Q
+ gf180mcu_fd_sc_mcu7t5v0__oai22_1_109/B2 vdd vss gf180mcu_fd_sc_mcu7t5v0__clkinv_1
Xgf180mcu_fd_sc_mcu7t5v0__clkinv_1_131 vdd vss gf180mcu_fd_sc_mcu7t5v0__dffq_1_263/Q
+ gf180mcu_fd_sc_mcu7t5v0__oai22_1_99/B2 vdd vss gf180mcu_fd_sc_mcu7t5v0__clkinv_1
Xgf180mcu_fd_sc_mcu7t5v0__nor3_1_34 gf180mcu_fd_sc_mcu7t5v0__or2_1_37/A2 vdd vss gf180mcu_fd_sc_mcu7t5v0__nor3_1_34/ZN
+ gf180mcu_fd_sc_mcu7t5v0__oai21_4_5/A1 gf180mcu_fd_sc_mcu7t5v0__or2_1_37/A1 vdd vss
+ gf180mcu_fd_sc_mcu7t5v0__nor3_1
Xgf180mcu_fd_sc_mcu7t5v0__clkinv_1_142 vdd vss gf180mcu_fd_sc_mcu7t5v0__dffq_1_121/Q
+ gf180mcu_fd_sc_mcu7t5v0__oai22_1_127/B2 vdd vss gf180mcu_fd_sc_mcu7t5v0__clkinv_1
Xgf180mcu_fd_sc_mcu7t5v0__dffq_1_80 vdd gf180mcu_fd_sc_mcu7t5v0__dffq_1_80/Q gf180mcu_fd_sc_mcu7t5v0__dffq_1_96/CLK
+ vss gf180mcu_fd_sc_mcu7t5v0__dffq_1_80/D vdd vss gf180mcu_fd_sc_mcu7t5v0__dffq_1
Xgf180mcu_fd_sc_mcu7t5v0__clkinv_1_153 vdd vss gf180mcu_fd_sc_mcu7t5v0__dffq_1_116/Q
+ gf180mcu_fd_sc_mcu7t5v0__oai22_1_123/B2 vdd vss gf180mcu_fd_sc_mcu7t5v0__clkinv_1
Xgf180mcu_fd_sc_mcu7t5v0__clkinv_1_164 vdd vss gf180mcu_fd_sc_mcu7t5v0__dffq_1_146/Q
+ gf180mcu_fd_sc_mcu7t5v0__oai22_1_149/B2 vdd vss gf180mcu_fd_sc_mcu7t5v0__clkinv_1
Xgf180mcu_fd_sc_mcu7t5v0__clkinv_1_175 vdd vss gf180mcu_fd_sc_mcu7t5v0__dffq_1_156/Q
+ gf180mcu_fd_sc_mcu7t5v0__oai22_1_163/B2 vdd vss gf180mcu_fd_sc_mcu7t5v0__clkinv_1
Xgf180mcu_fd_sc_mcu7t5v0__dffq_1_91 vdd gf180mcu_fd_sc_mcu7t5v0__dffq_1_91/Q gf180mcu_fd_sc_mcu7t5v0__dffq_1_95/CLK
+ vss gf180mcu_fd_sc_mcu7t5v0__dffq_1_91/D vdd vss gf180mcu_fd_sc_mcu7t5v0__dffq_1
Xgf180mcu_fd_sc_mcu7t5v0__clkinv_1_186 vdd vss gf180mcu_fd_sc_mcu7t5v0__dffq_1_172/Q
+ gf180mcu_fd_sc_mcu7t5v0__oai22_1_174/B2 vdd vss gf180mcu_fd_sc_mcu7t5v0__clkinv_1
Xgf180mcu_fd_sc_mcu7t5v0__clkinv_1_197 vdd vss gf180mcu_fd_sc_mcu7t5v0__dffq_1_171/Q
+ gf180mcu_fd_sc_mcu7t5v0__oai22_1_185/B2 vdd vss gf180mcu_fd_sc_mcu7t5v0__clkinv_1
Xgf180mcu_fd_sc_mcu7t5v0__tieh_0 uart_tx_OE vdd vss vdd vss gf180mcu_fd_sc_mcu7t5v0__tieh
Xgf180mcu_fd_sc_mcu7t5v0__aoi211_1_0 gf180mcu_fd_sc_mcu7t5v0__aoi211_1_0/B gf180mcu_fd_sc_mcu7t5v0__nor3_4_2/ZN
+ vdd vss gf180mcu_fd_sc_mcu7t5v0__nand2_1_9/A2 gf180mcu_fd_sc_mcu7t5v0__nor2_2_6/ZN
+ gf180mcu_fd_sc_mcu7t5v0__xor3_1_7/Z vdd vss gf180mcu_fd_sc_mcu7t5v0__aoi211_1
Xgf180mcu_fd_sc_mcu7t5v0__inv_3_3 vss gf180mcu_fd_sc_mcu7t5v0__inv_3_3/ZN gf180mcu_fd_sc_mcu7t5v0__inv_3_3/I
+ vdd vdd vss gf180mcu_fd_sc_mcu7t5v0__inv_3
Xgf180mcu_fd_sc_mcu7t5v0__dffq_2_0 gf180mcu_fd_sc_mcu7t5v0__dffq_2_0/D vdd vss gf180mcu_fd_sc_mcu7t5v0__dffq_4_6/CLK
+ gf180mcu_fd_sc_mcu7t5v0__inv_1_0/I vdd vss gf180mcu_fd_sc_mcu7t5v0__dffq_2
Xgf180mcu_fd_sc_mcu7t5v0__oai22_1_180 gf180mcu_fd_sc_mcu7t5v0__nand2_4_36/ZN gf180mcu_fd_sc_mcu7t5v0__nand2_2_31/ZN
+ gf180mcu_fd_sc_mcu7t5v0__oai22_1_180/B2 vdd vss gf180mcu_fd_sc_mcu7t5v0__dffq_1_457/D
+ gf180mcu_fd_sc_mcu7t5v0__aoi21_4_5/ZN vdd vss gf180mcu_fd_sc_mcu7t5v0__oai22_1
Xgf180mcu_fd_sc_mcu7t5v0__oai22_1_191 gf180mcu_fd_sc_mcu7t5v0__nand2_4_15/ZN gf180mcu_fd_sc_mcu7t5v0__nand2_2_21/ZN
+ gf180mcu_fd_sc_mcu7t5v0__oai22_1_191/B2 vdd vss gf180mcu_fd_sc_mcu7t5v0__dffq_1_176/D
+ gf180mcu_fd_sc_mcu7t5v0__aoi21_4_5/ZN vdd vss gf180mcu_fd_sc_mcu7t5v0__oai22_1
Xgf180mcu_fd_sc_mcu7t5v0__xnor3_1_30 gf180mcu_fd_sc_mcu7t5v0__xnor3_1_32/ZN vdd vss
+ gf180mcu_fd_sc_mcu7t5v0__xor2_2_3/A2 gf180mcu_fd_sc_mcu7t5v0__and2_1_109/Z gf180mcu_fd_sc_mcu7t5v0__xnor3_1_30/A2
+ vdd vss gf180mcu_fd_sc_mcu7t5v0__xnor3_1
Xgf180mcu_fd_sc_mcu7t5v0__xnor3_1_41 gf180mcu_fd_sc_mcu7t5v0__or2_1_48/A2 vdd vss
+ gf180mcu_fd_sc_mcu7t5v0__xor2_1_174/A2 gf180mcu_fd_sc_mcu7t5v0__or2_1_48/A1 gf180mcu_fd_sc_mcu7t5v0__xnor3_1_41/A2
+ vdd vss gf180mcu_fd_sc_mcu7t5v0__xnor3_1
Xgf180mcu_fd_sc_mcu7t5v0__aoi221_1_16 gf180mcu_fd_sc_mcu7t5v0__dffq_1_318/Q gf180mcu_fd_sc_mcu7t5v0__nor2_1_159/ZN
+ vdd vss gf180mcu_fd_sc_mcu7t5v0__nor2_1_158/A2 gf180mcu_fd_sc_mcu7t5v0__dffq_1_294/Q
+ gf180mcu_fd_sc_mcu7t5v0__or2_4_3/Z gf180mcu_fd_sc_mcu7t5v0__nor2_4_32/ZN vdd vss
+ gf180mcu_fd_sc_mcu7t5v0__aoi221_1
Xgf180mcu_fd_sc_mcu7t5v0__aoi221_1_27 gf180mcu_fd_sc_mcu7t5v0__nor2_4_26/A2 gf180mcu_fd_sc_mcu7t5v0__or2_1_23/A1
+ vdd vss gf180mcu_fd_sc_mcu7t5v0__dffq_2_45/D gf180mcu_fd_sc_mcu7t5v0__inv_2_7/ZN
+ gf180mcu_fd_sc_mcu7t5v0__nor2_4_26/ZN gf180mcu_fd_sc_mcu7t5v0__nand2_1_308/ZN vdd
+ vss gf180mcu_fd_sc_mcu7t5v0__aoi221_1
Xgf180mcu_fd_sc_mcu7t5v0__aoi221_1_38 gf180mcu_fd_sc_mcu7t5v0__oai21_1_214/A2 gf180mcu_fd_sc_mcu7t5v0__nor2_2_26/ZN
+ vdd vss gf180mcu_fd_sc_mcu7t5v0__oai21_1_214/B gf180mcu_fd_sc_mcu7t5v0__inv_4_6/I
+ gf180mcu_fd_sc_mcu7t5v0__nor2_2_27/ZN gf180mcu_fd_sc_mcu7t5v0__mux2_1_8/I1 vdd vss
+ gf180mcu_fd_sc_mcu7t5v0__aoi221_1
Xgf180mcu_fd_sc_mcu7t5v0__aoi221_1_49 gf180mcu_fd_sc_mcu7t5v0__nor2_1_315/A2 gf180mcu_fd_sc_mcu7t5v0__aoi221_1_49/C
+ vdd vss gf180mcu_fd_sc_mcu7t5v0__aoi221_1_49/ZN gf180mcu_fd_sc_mcu7t5v0__nor3_4_18/ZN
+ gf180mcu_fd_sc_mcu7t5v0__xor3_1_107/A3 gf180mcu_fd_sc_mcu7t5v0__xnor2_1_54/ZN vdd
+ vss gf180mcu_fd_sc_mcu7t5v0__aoi221_1
Xgf180mcu_fd_sc_mcu7t5v0__oai21_4_13 gf180mcu_fd_sc_mcu7t5v0__oai21_4_13/B vdd vss
+ gf180mcu_fd_sc_mcu7t5v0__aoi21_4_8/ZN gf180mcu_fd_sc_mcu7t5v0__or2_1_24/A2 gf180mcu_fd_sc_mcu7t5v0__oai31_4_3/ZN
+ vdd vss gf180mcu_fd_sc_mcu7t5v0__oai21_4
Xgf180mcu_fd_sc_mcu7t5v0__xnor3_1_9 gf180mcu_fd_sc_mcu7t5v0__xnor3_1_9/A3 vdd vss
+ gf180mcu_fd_sc_mcu7t5v0__xor3_1_24/A3 gf180mcu_fd_sc_mcu7t5v0__xnor3_1_9/A1 gf180mcu_fd_sc_mcu7t5v0__xnor3_1_9/A2
+ vdd vss gf180mcu_fd_sc_mcu7t5v0__xnor3_1
Xgf180mcu_fd_sc_mcu7t5v0__oai31_1_0 vdd gf180mcu_fd_sc_mcu7t5v0__oai31_1_0/ZN gf180mcu_fd_sc_mcu7t5v0__oai31_1_0/B
+ gf180mcu_fd_sc_mcu7t5v0__oai31_1_0/A1 gf180mcu_fd_sc_mcu7t5v0__oai31_1_0/A2 vss
+ gf180mcu_fd_sc_mcu7t5v0__oai31_1_0/A3 vdd vss gf180mcu_fd_sc_mcu7t5v0__oai31_1
Xgf180mcu_fd_sc_mcu7t5v0__inv_20_0 vss gf180mcu_fd_sc_mcu7t5v0__or2_1_23/A1 gf180mcu_fd_sc_mcu7t5v0__buf_8_1/Z
+ vdd vdd vss gf180mcu_fd_sc_mcu7t5v0__inv_20
Xgf180mcu_fd_sc_mcu7t5v0__nand2_1_10 vdd vss gf180mcu_fd_sc_mcu7t5v0__nand3_1_0/A2
+ gf180mcu_fd_sc_mcu7t5v0__nor3_4_2/ZN gf180mcu_fd_sc_mcu7t5v0__xor3_1_13/Z vdd vss
+ gf180mcu_fd_sc_mcu7t5v0__nand2_1
Xgf180mcu_fd_sc_mcu7t5v0__oai31_1_15 vdd gf180mcu_fd_sc_mcu7t5v0__xor2_1_124/A2 gf180mcu_fd_sc_mcu7t5v0__oai31_1_15/B
+ gf180mcu_fd_sc_mcu7t5v0__mux4_4_8/Z gf180mcu_fd_sc_mcu7t5v0__xnor2_1_44/A2 vss gf180mcu_fd_sc_mcu7t5v0__mux4_4_18/Z
+ vdd vss gf180mcu_fd_sc_mcu7t5v0__oai31_1
Xgf180mcu_fd_sc_mcu7t5v0__nand2_1_21 vdd vss gf180mcu_fd_sc_mcu7t5v0__xor2_1_30/A1
+ gf180mcu_fd_sc_mcu7t5v0__nand2_1_26/ZN gf180mcu_fd_sc_mcu7t5v0__oai21_1_10/ZN vdd
+ vss gf180mcu_fd_sc_mcu7t5v0__nand2_1
Xgf180mcu_fd_sc_mcu7t5v0__nand2_1_32 vdd vss gf180mcu_fd_sc_mcu7t5v0__xor3_1_4/A1
+ gf180mcu_fd_sc_mcu7t5v0__dffq_4_37/Q gf180mcu_fd_sc_mcu7t5v0__and2_4_2/Z vdd vss
+ gf180mcu_fd_sc_mcu7t5v0__nand2_1
Xgf180mcu_fd_sc_mcu7t5v0__nand2_1_43 vdd vss gf180mcu_fd_sc_mcu7t5v0__nand3_1_9/A1
+ gf180mcu_fd_sc_mcu7t5v0__inv_4_6/I gf180mcu_fd_sc_mcu7t5v0__xor2_1_20/Z vdd vss
+ gf180mcu_fd_sc_mcu7t5v0__nand2_1
Xgf180mcu_fd_sc_mcu7t5v0__nand2_1_54 vdd vss gf180mcu_fd_sc_mcu7t5v0__nor2_1_24/A2
+ gf180mcu_fd_sc_mcu7t5v0__or3_2_1/Z gf180mcu_fd_sc_mcu7t5v0__and3_1_1/A3 vdd vss
+ gf180mcu_fd_sc_mcu7t5v0__nand2_1
Xgf180mcu_fd_sc_mcu7t5v0__nand2_1_65 vdd vss gf180mcu_fd_sc_mcu7t5v0__nand2_1_65/ZN
+ gf180mcu_fd_sc_mcu7t5v0__or2_1_5/A1 gf180mcu_fd_sc_mcu7t5v0__or2_4_4/Z vdd vss gf180mcu_fd_sc_mcu7t5v0__nand2_1
Xgf180mcu_fd_sc_mcu7t5v0__nand2_1_76 vdd vss gf180mcu_fd_sc_mcu7t5v0__oai21_2_3/B
+ gf180mcu_fd_sc_mcu7t5v0__mux4_4_0/I3 gf180mcu_fd_sc_mcu7t5v0__dffq_4_4/Q vdd vss
+ gf180mcu_fd_sc_mcu7t5v0__nand2_1
Xgf180mcu_fd_sc_mcu7t5v0__nand2_1_87 vdd vss gf180mcu_fd_sc_mcu7t5v0__oai21_2_6/B
+ gf180mcu_fd_sc_mcu7t5v0__dffq_2_23/Q gf180mcu_fd_sc_mcu7t5v0__and2_2_7/Z vdd vss
+ gf180mcu_fd_sc_mcu7t5v0__nand2_1
Xgf180mcu_fd_sc_mcu7t5v0__nand2_1_98 vdd vss gf180mcu_fd_sc_mcu7t5v0__xor3_1_38/A2
+ gf180mcu_fd_sc_mcu7t5v0__dffq_4_37/Q gf180mcu_fd_sc_mcu7t5v0__or4_1_1/A2 vdd vss
+ gf180mcu_fd_sc_mcu7t5v0__nand2_1
Xgf180mcu_fd_sc_mcu7t5v0__nor2_4_0 vdd vss gf180mcu_fd_sc_mcu7t5v0__nor2_4_0/ZN gf180mcu_fd_sc_mcu7t5v0__dffq_4_3/Q
+ gf180mcu_fd_sc_mcu7t5v0__nor2_4_1/A2 vdd vss gf180mcu_fd_sc_mcu7t5v0__nor2_4
Xgf180mcu_fd_sc_mcu7t5v0__oai22_1_0 gf180mcu_fd_sc_mcu7t5v0__and2_4_0/Z gf180mcu_fd_sc_mcu7t5v0__nor2_4_0/ZN
+ gf180mcu_fd_sc_mcu7t5v0__oai22_1_0/B2 vdd vss gf180mcu_fd_sc_mcu7t5v0__oai22_1_0/ZN
+ gf180mcu_fd_sc_mcu7t5v0__inv_12_1/I vdd vss gf180mcu_fd_sc_mcu7t5v0__oai22_1
Xgf180mcu_fd_sc_mcu7t5v0__aoi22_1_80 gf180mcu_fd_sc_mcu7t5v0__nor2_4_9/ZN gf180mcu_fd_sc_mcu7t5v0__dffq_1_157/Q
+ vdd vss gf180mcu_fd_sc_mcu7t5v0__aoi22_1_80/ZN gf180mcu_fd_sc_mcu7t5v0__dffq_1_160/Q
+ gf180mcu_fd_sc_mcu7t5v0__nor2_4_8/ZN vdd vss gf180mcu_fd_sc_mcu7t5v0__aoi22_1
Xgf180mcu_fd_sc_mcu7t5v0__aoi22_1_91 gf180mcu_fd_sc_mcu7t5v0__nor2_4_11/ZN gf180mcu_fd_sc_mcu7t5v0__dffq_1_175/Q
+ vdd vss gf180mcu_fd_sc_mcu7t5v0__aoi22_1_91/ZN gf180mcu_fd_sc_mcu7t5v0__dffq_1_186/Q
+ gf180mcu_fd_sc_mcu7t5v0__nor2_4_10/ZN vdd vss gf180mcu_fd_sc_mcu7t5v0__aoi22_1
Xgf180mcu_fd_sc_mcu7t5v0__inv_1_0 vss gf180mcu_fd_sc_mcu7t5v0__inv_1_0/ZN gf180mcu_fd_sc_mcu7t5v0__inv_1_0/I
+ vdd vdd vss gf180mcu_fd_sc_mcu7t5v0__inv_1
Xgf180mcu_fd_sc_mcu7t5v0__nand3_2_20 gf180mcu_fd_sc_mcu7t5v0__xor2_1_85/Z vdd vss
+ gf180mcu_fd_sc_mcu7t5v0__or2_1_18/A1 gf180mcu_fd_sc_mcu7t5v0__nor2_4_45/ZN gf180mcu_fd_sc_mcu7t5v0__nor2_1_130/ZN
+ vdd vss gf180mcu_fd_sc_mcu7t5v0__nand3_2
Xgf180mcu_fd_sc_mcu7t5v0__nand3_2_31 gf180mcu_fd_sc_mcu7t5v0__or3_2_1/A1 vdd vss gf180mcu_fd_sc_mcu7t5v0__oai21_4_2/B
+ gf180mcu_fd_sc_mcu7t5v0__or2_4_0/A1 gf180mcu_fd_sc_mcu7t5v0__or2_4_0/A2 vdd vss
+ gf180mcu_fd_sc_mcu7t5v0__nand3_2
Xgf180mcu_fd_sc_mcu7t5v0__aoi222_2_6 gf180mcu_fd_sc_mcu7t5v0__nor2_4_12/ZN gf180mcu_fd_sc_mcu7t5v0__aoi222_2_6/B1
+ gf180mcu_fd_sc_mcu7t5v0__aoi222_2_6/A2 gf180mcu_fd_sc_mcu7t5v0__nor2_4_4/ZN gf180mcu_fd_sc_mcu7t5v0__nand3_1_43/A3
+ vss vdd gf180mcu_fd_sc_mcu7t5v0__nor2_4_5/ZN gf180mcu_fd_sc_mcu7t5v0__aoi222_2_6/C1
+ vdd vss gf180mcu_fd_sc_mcu7t5v0__aoi222_2
Xgf180mcu_fd_sc_mcu7t5v0__nor3_2_8 gf180mcu_fd_sc_mcu7t5v0__nor3_2_8/A3 vdd vss gf180mcu_fd_sc_mcu7t5v0__or2_1_37/A1
+ gf180mcu_fd_sc_mcu7t5v0__nor3_2_8/A1 gf180mcu_fd_sc_mcu7t5v0__nor3_2_8/A2 vdd vss
+ gf180mcu_fd_sc_mcu7t5v0__nor3_2
Xgf180mcu_fd_sc_mcu7t5v0__aoi21_4_9 gf180mcu_fd_sc_mcu7t5v0__or2_2_1/A1 gf180mcu_fd_sc_mcu7t5v0__inv_4_5/I
+ vdd vss gf180mcu_fd_sc_mcu7t5v0__aoi21_4_9/ZN gf180mcu_fd_sc_mcu7t5v0__aoi21_4_9/A1
+ vdd vss gf180mcu_fd_sc_mcu7t5v0__aoi21_4
Xgf180mcu_fd_sc_mcu7t5v0__nand2_1_706 vdd vss gf180mcu_fd_sc_mcu7t5v0__xor3_1_108/A3
+ gf180mcu_fd_sc_mcu7t5v0__inv_12_1/I gf180mcu_fd_sc_mcu7t5v0__mux4_2_1/Z vdd vss
+ gf180mcu_fd_sc_mcu7t5v0__nand2_1
Xgf180mcu_fd_sc_mcu7t5v0__nand2_1_717 vdd vss gf180mcu_fd_sc_mcu7t5v0__oai21_1_337/A2
+ gf180mcu_fd_sc_mcu7t5v0__dffq_4_37/Q gf180mcu_fd_sc_mcu7t5v0__mux4_4_4/Z vdd vss
+ gf180mcu_fd_sc_mcu7t5v0__nand2_1
Xgf180mcu_fd_sc_mcu7t5v0__nand2_1_728 vdd vss gf180mcu_fd_sc_mcu7t5v0__xor2_1_230/A1
+ gf180mcu_fd_sc_mcu7t5v0__inv_8_1/I gf180mcu_fd_sc_mcu7t5v0__inv_1_14/I vdd vss gf180mcu_fd_sc_mcu7t5v0__nand2_1
Xgf180mcu_fd_sc_mcu7t5v0__and2_1_14 vdd vss gf180mcu_fd_sc_mcu7t5v0__and2_1_14/Z gf180mcu_fd_sc_mcu7t5v0__dffq_4_0/Q
+ gf180mcu_fd_sc_mcu7t5v0__nor2_1_76/ZN vdd vss gf180mcu_fd_sc_mcu7t5v0__and2_1
Xgf180mcu_fd_sc_mcu7t5v0__and2_1_25 vdd vss gf180mcu_fd_sc_mcu7t5v0__or3_1_8/A1 gf180mcu_fd_sc_mcu7t5v0__dffq_1_13/Q
+ gf180mcu_fd_sc_mcu7t5v0__xor2_1_61/A2 vdd vss gf180mcu_fd_sc_mcu7t5v0__and2_1
Xgf180mcu_fd_sc_mcu7t5v0__and2_1_36 vdd vss gf180mcu_fd_sc_mcu7t5v0__and2_1_36/Z gf180mcu_fd_sc_mcu7t5v0__and2_1_36/A1
+ gf180mcu_fd_sc_mcu7t5v0__xor2_1_73/Z vdd vss gf180mcu_fd_sc_mcu7t5v0__and2_1
Xgf180mcu_fd_sc_mcu7t5v0__and2_1_47 vdd vss gf180mcu_fd_sc_mcu7t5v0__and2_1_47/Z gf180mcu_fd_sc_mcu7t5v0__nor4_4_0/A1
+ gf180mcu_fd_sc_mcu7t5v0__inv_2_7/ZN vdd vss gf180mcu_fd_sc_mcu7t5v0__and2_1
Xgf180mcu_fd_sc_mcu7t5v0__and2_1_58 vdd vss gf180mcu_fd_sc_mcu7t5v0__and2_1_58/Z gf180mcu_fd_sc_mcu7t5v0__nor4_1_1/A1
+ gf180mcu_fd_sc_mcu7t5v0__and2_1_54/Z vdd vss gf180mcu_fd_sc_mcu7t5v0__and2_1
Xgf180mcu_fd_sc_mcu7t5v0__and2_1_69 vdd vss gf180mcu_fd_sc_mcu7t5v0__and2_1_69/Z gf180mcu_fd_sc_mcu7t5v0__or4_1_2/A1
+ gf180mcu_fd_sc_mcu7t5v0__and2_1_62/Z vdd vss gf180mcu_fd_sc_mcu7t5v0__and2_1
Xgf180mcu_fd_sc_mcu7t5v0__oai21_1_190 vdd gf180mcu_fd_sc_mcu7t5v0__buf_8_7/Z gf180mcu_fd_sc_mcu7t5v0__dffq_1_399/Q
+ gf180mcu_fd_sc_mcu7t5v0__aoi21_1_187/B gf180mcu_fd_sc_mcu7t5v0__dffq_4_20/Q vss
+ vdd vss gf180mcu_fd_sc_mcu7t5v0__oai21_1
Xgf180mcu_fd_sc_mcu7t5v0__aoi211_1_15 gf180mcu_fd_sc_mcu7t5v0__nor2_1_53/ZN gf180mcu_fd_sc_mcu7t5v0__or2_1_23/A1
+ vdd vss gf180mcu_fd_sc_mcu7t5v0__dffq_1_10/D gf180mcu_fd_sc_mcu7t5v0__nor2_1_236/A1
+ gf180mcu_fd_sc_mcu7t5v0__nor2_4_15/ZN vdd vss gf180mcu_fd_sc_mcu7t5v0__aoi211_1
Xgf180mcu_fd_sc_mcu7t5v0__aoi211_1_26 gf180mcu_fd_sc_mcu7t5v0__nor2_1_113/ZN gf180mcu_fd_sc_mcu7t5v0__or2_1_23/A1
+ vdd vss gf180mcu_fd_sc_mcu7t5v0__dffq_1_243/D gf180mcu_fd_sc_mcu7t5v0__nor2_1_411/A1
+ gf180mcu_fd_sc_mcu7t5v0__nor2_4_19/ZN vdd vss gf180mcu_fd_sc_mcu7t5v0__aoi211_1
Xgf180mcu_fd_sc_mcu7t5v0__aoi211_1_37 gf180mcu_fd_sc_mcu7t5v0__nor2_1_142/ZN gf180mcu_fd_sc_mcu7t5v0__or2_1_23/A1
+ vdd vss gf180mcu_fd_sc_mcu7t5v0__dffq_1_449/D gf180mcu_fd_sc_mcu7t5v0__nor2_1_411/A1
+ gf180mcu_fd_sc_mcu7t5v0__nor2_4_22/ZN vdd vss gf180mcu_fd_sc_mcu7t5v0__aoi211_1
Xgf180mcu_fd_sc_mcu7t5v0__aoi211_1_48 gf180mcu_fd_sc_mcu7t5v0__nor2_1_171/ZN gf180mcu_fd_sc_mcu7t5v0__or2_1_23/A1
+ vdd vss gf180mcu_fd_sc_mcu7t5v0__dffq_1_309/D gf180mcu_fd_sc_mcu7t5v0__nor2_1_144/A1
+ gf180mcu_fd_sc_mcu7t5v0__nor2_4_28/ZN vdd vss gf180mcu_fd_sc_mcu7t5v0__aoi211_1
Xgf180mcu_fd_sc_mcu7t5v0__aoi211_1_59 gf180mcu_fd_sc_mcu7t5v0__nor2_1_297/ZN gf180mcu_fd_sc_mcu7t5v0__or2_1_23/A1
+ vdd vss gf180mcu_fd_sc_mcu7t5v0__dffq_1_416/D gf180mcu_fd_sc_mcu7t5v0__nor2_1_236/A1
+ gf180mcu_fd_sc_mcu7t5v0__nor2_4_18/ZN vdd vss gf180mcu_fd_sc_mcu7t5v0__aoi211_1
Xgf180mcu_fd_sc_mcu7t5v0__clkinv_1_50 vdd vss gf180mcu_fd_sc_mcu7t5v0__dffq_1_53/Q
+ gf180mcu_fd_sc_mcu7t5v0__oai22_1_35/A1 vdd vss gf180mcu_fd_sc_mcu7t5v0__clkinv_1
Xgf180mcu_fd_sc_mcu7t5v0__clkinv_1_61 vdd vss gf180mcu_fd_sc_mcu7t5v0__dffq_1_97/Q
+ gf180mcu_fd_sc_mcu7t5v0__oai22_1_73/B2 vdd vss gf180mcu_fd_sc_mcu7t5v0__clkinv_1
Xgf180mcu_fd_sc_mcu7t5v0__clkinv_1_72 vdd vss gf180mcu_fd_sc_mcu7t5v0__dffq_1_69/Q
+ gf180mcu_fd_sc_mcu7t5v0__oai22_1_60/B2 vdd vss gf180mcu_fd_sc_mcu7t5v0__clkinv_1
Xgf180mcu_fd_sc_mcu7t5v0__aoi21_1_203 gf180mcu_fd_sc_mcu7t5v0__aoi21_1_203/B vdd vss
+ gf180mcu_fd_sc_mcu7t5v0__dffq_1_394/D gf180mcu_fd_sc_mcu7t5v0__nor3_4_15/ZN gf180mcu_fd_sc_mcu7t5v0__aoi22_4_3/ZN
+ vdd vss gf180mcu_fd_sc_mcu7t5v0__aoi21_1
Xgf180mcu_fd_sc_mcu7t5v0__clkinv_1_83 vdd vss gf180mcu_fd_sc_mcu7t5v0__dffq_1_72/Q
+ gf180mcu_fd_sc_mcu7t5v0__oai22_1_69/B2 vdd vss gf180mcu_fd_sc_mcu7t5v0__clkinv_1
Xgf180mcu_fd_sc_mcu7t5v0__aoi21_1_214 gf180mcu_fd_sc_mcu7t5v0__aoi21_1_214/B vdd vss
+ gf180mcu_fd_sc_mcu7t5v0__dffq_2_40/D gf180mcu_fd_sc_mcu7t5v0__nor2_2_22/A1 gf180mcu_fd_sc_mcu7t5v0__buf_20_0/I
+ vdd vss gf180mcu_fd_sc_mcu7t5v0__aoi21_1
Xgf180mcu_fd_sc_mcu7t5v0__clkinv_1_94 vdd vss gf180mcu_fd_sc_mcu7t5v0__dffq_1_79/Q
+ gf180mcu_fd_sc_mcu7t5v0__oai22_1_79/B2 vdd vss gf180mcu_fd_sc_mcu7t5v0__clkinv_1
Xgf180mcu_fd_sc_mcu7t5v0__aoi21_1_225 gf180mcu_fd_sc_mcu7t5v0__nor2_2_26/ZN vdd vss
+ gf180mcu_fd_sc_mcu7t5v0__oai221_1_9/B1 gf180mcu_fd_sc_mcu7t5v0__mux2_1_8/I1 gf180mcu_fd_sc_mcu7t5v0__xor3_1_86/A1
+ vdd vss gf180mcu_fd_sc_mcu7t5v0__aoi21_1
Xgf180mcu_fd_sc_mcu7t5v0__aoi21_1_236 gf180mcu_fd_sc_mcu7t5v0__mux2_1_9/I1 vdd vss
+ gf180mcu_fd_sc_mcu7t5v0__oai32_1_7/A3 gf180mcu_fd_sc_mcu7t5v0__inv_4_6/I gf180mcu_fd_sc_mcu7t5v0__oai32_1_7/B1
+ vdd vss gf180mcu_fd_sc_mcu7t5v0__aoi21_1
Xgf180mcu_fd_sc_mcu7t5v0__aoi21_1_247 gf180mcu_fd_sc_mcu7t5v0__oai32_1_8/A1 vdd vss
+ gf180mcu_fd_sc_mcu7t5v0__oai22_1_269/B1 gf180mcu_fd_sc_mcu7t5v0__nor2_1_271/ZN gf180mcu_fd_sc_mcu7t5v0__or3_1_19/A1
+ vdd vss gf180mcu_fd_sc_mcu7t5v0__aoi21_1
Xgf180mcu_fd_sc_mcu7t5v0__aoi21_1_258 gf180mcu_fd_sc_mcu7t5v0__and2_1_113/Z vdd vss
+ gf180mcu_fd_sc_mcu7t5v0__xor3_1_104/A2 gf180mcu_fd_sc_mcu7t5v0__xor3_1_77/A2 gf180mcu_fd_sc_mcu7t5v0__or2_1_33/Z
+ vdd vss gf180mcu_fd_sc_mcu7t5v0__aoi21_1
Xgf180mcu_fd_sc_mcu7t5v0__aoi21_1_269 gf180mcu_fd_sc_mcu7t5v0__inv_1_16/I vdd vss
+ gf180mcu_fd_sc_mcu7t5v0__aoi221_2_6/C gf180mcu_fd_sc_mcu7t5v0__xor3_1_91/A1 gf180mcu_fd_sc_mcu7t5v0__mux4_4_9/S0
+ vdd vss gf180mcu_fd_sc_mcu7t5v0__aoi21_1
Xgf180mcu_fd_sc_mcu7t5v0__oai21_1_14 vdd gf180mcu_fd_sc_mcu7t5v0__oai21_1_14/B gf180mcu_fd_sc_mcu7t5v0__xor2_1_20/A1
+ gf180mcu_fd_sc_mcu7t5v0__nand4_1_0/A4 gf180mcu_fd_sc_mcu7t5v0__inv_4_6/I vss vdd
+ vss gf180mcu_fd_sc_mcu7t5v0__oai21_1
Xgf180mcu_fd_sc_mcu7t5v0__oai21_1_25 vdd gf180mcu_fd_sc_mcu7t5v0__oai21_1_25/B gf180mcu_fd_sc_mcu7t5v0__mux4_4_4/Z
+ gf180mcu_fd_sc_mcu7t5v0__oai21_1_25/ZN gf180mcu_fd_sc_mcu7t5v0__dffq_4_37/Q vss
+ vdd vss gf180mcu_fd_sc_mcu7t5v0__oai21_1
Xgf180mcu_fd_sc_mcu7t5v0__oai21_1_36 vdd gf180mcu_fd_sc_mcu7t5v0__and2_4_3/Z gf180mcu_fd_sc_mcu7t5v0__or2_1_34/A2
+ gf180mcu_fd_sc_mcu7t5v0__nor2_1_77/A2 gf180mcu_fd_sc_mcu7t5v0__dffq_2_23/Q vss vdd
+ vss gf180mcu_fd_sc_mcu7t5v0__oai21_1
Xgf180mcu_fd_sc_mcu7t5v0__oai21_1_47 vdd gf180mcu_fd_sc_mcu7t5v0__oai21_1_47/B gf180mcu_fd_sc_mcu7t5v0__nor2_1_65/ZN
+ gf180mcu_fd_sc_mcu7t5v0__xor3_1_42/A1 gf180mcu_fd_sc_mcu7t5v0__xnor3_1_11/A2 vss
+ vdd vss gf180mcu_fd_sc_mcu7t5v0__oai21_1
Xgf180mcu_fd_sc_mcu7t5v0__oai21_1_58 vdd gf180mcu_fd_sc_mcu7t5v0__and2_4_3/Z gf180mcu_fd_sc_mcu7t5v0__or2_1_34/A2
+ gf180mcu_fd_sc_mcu7t5v0__nor2_1_83/A2 gf180mcu_fd_sc_mcu7t5v0__dffq_1_14/Q vss vdd
+ vss gf180mcu_fd_sc_mcu7t5v0__oai21_1
Xgf180mcu_fd_sc_mcu7t5v0__oai21_1_69 vdd gf180mcu_fd_sc_mcu7t5v0__or3_1_7/A3 gf180mcu_fd_sc_mcu7t5v0__or3_1_7/A2
+ gf180mcu_fd_sc_mcu7t5v0__oai21_1_69/ZN gf180mcu_fd_sc_mcu7t5v0__or3_1_7/A1 vss vdd
+ vss gf180mcu_fd_sc_mcu7t5v0__oai21_1
Xgf180mcu_fd_sc_mcu7t5v0__aoi21_2_6 gf180mcu_fd_sc_mcu7t5v0__aoi21_2_6/B vdd vss gf180mcu_fd_sc_mcu7t5v0__aoi21_2_6/ZN
+ gf180mcu_fd_sc_mcu7t5v0__dffq_2_52/Q gf180mcu_fd_sc_mcu7t5v0__inv_2_8/ZN vdd vss
+ gf180mcu_fd_sc_mcu7t5v0__aoi21_2
Xgf180mcu_fd_sc_mcu7t5v0__nand2_1_503 vdd vss gf180mcu_fd_sc_mcu7t5v0__xor2_1_144/A1
+ gf180mcu_fd_sc_mcu7t5v0__nand2_1_504/ZN gf180mcu_fd_sc_mcu7t5v0__oai21_1_231/ZN
+ vdd vss gf180mcu_fd_sc_mcu7t5v0__nand2_1
Xgf180mcu_fd_sc_mcu7t5v0__nand2_1_514 vdd vss gf180mcu_fd_sc_mcu7t5v0__mux2_1_7/I0
+ gf180mcu_fd_sc_mcu7t5v0__inv_8_0/I gf180mcu_fd_sc_mcu7t5v0__mux4_4_7/Z vdd vss gf180mcu_fd_sc_mcu7t5v0__nand2_1
Xgf180mcu_fd_sc_mcu7t5v0__nand2_1_525 vdd vss gf180mcu_fd_sc_mcu7t5v0__oai211_1_37/B
+ gf180mcu_fd_sc_mcu7t5v0__inv_8_0/I gf180mcu_fd_sc_mcu7t5v0__nor2_2_42/ZN vdd vss
+ gf180mcu_fd_sc_mcu7t5v0__nand2_1
Xgf180mcu_fd_sc_mcu7t5v0__nand2_1_536 vdd vss gf180mcu_fd_sc_mcu7t5v0__nor2_2_44/A2
+ gf180mcu_fd_sc_mcu7t5v0__nor3_4_18/A2 gf180mcu_fd_sc_mcu7t5v0__inv_2_12/I vdd vss
+ gf180mcu_fd_sc_mcu7t5v0__nand2_1
Xgf180mcu_fd_sc_mcu7t5v0__nand2_1_547 vdd vss gf180mcu_fd_sc_mcu7t5v0__nand2_1_547/ZN
+ gf180mcu_fd_sc_mcu7t5v0__mux4_4_2/I3 gf180mcu_fd_sc_mcu7t5v0__clkinv_3_9/ZN vdd
+ vss gf180mcu_fd_sc_mcu7t5v0__nand2_1
Xgf180mcu_fd_sc_mcu7t5v0__nand2_1_558 vdd vss gf180mcu_fd_sc_mcu7t5v0__nand2_1_558/ZN
+ gf180mcu_fd_sc_mcu7t5v0__mux4_4_8/I0 gf180mcu_fd_sc_mcu7t5v0__or2_4_4/Z vdd vss
+ gf180mcu_fd_sc_mcu7t5v0__nand2_1
Xgf180mcu_fd_sc_mcu7t5v0__nand2_1_569 vdd vss gf180mcu_fd_sc_mcu7t5v0__or2_1_51/A1
+ gf180mcu_fd_sc_mcu7t5v0__nor3_2_5/A1 gf180mcu_fd_sc_mcu7t5v0__inv_1_23/I vdd vss
+ gf180mcu_fd_sc_mcu7t5v0__nand2_1
Xgf180mcu_fd_sc_mcu7t5v0__aoi21_2_16 gf180mcu_fd_sc_mcu7t5v0__dffq_4_35/Q vdd vss
+ gf180mcu_fd_sc_mcu7t5v0__aoi221_4_1/C gf180mcu_fd_sc_mcu7t5v0__inv_1_18/I gf180mcu_fd_sc_mcu7t5v0__inv_4_7/ZN
+ vdd vss gf180mcu_fd_sc_mcu7t5v0__aoi21_2
Xgf180mcu_fd_sc_mcu7t5v0__buf_12_0 gf180mcu_fd_sc_mcu7t5v0__buf_12_0/Z gf180mcu_fd_sc_mcu7t5v0__buf_8_4/Z
+ vdd vss vdd vss gf180mcu_fd_sc_mcu7t5v0__buf_12
Xgf180mcu_fd_sc_mcu7t5v0__oai211_2_6 gf180mcu_fd_sc_mcu7t5v0__oai211_2_6/A2 gf180mcu_fd_sc_mcu7t5v0__oai22_2_1/A2
+ gf180mcu_fd_sc_mcu7t5v0__and2_1_105/Z gf180mcu_fd_sc_mcu7t5v0__oai211_2_6/B gf180mcu_fd_sc_mcu7t5v0__inv_8_0/I
+ vdd vss vdd vss gf180mcu_fd_sc_mcu7t5v0__oai211_2
Xgf180mcu_fd_sc_mcu7t5v0__mux4_4_19 gf180mcu_fd_sc_mcu7t5v0__dffq_2_80/Q vss vdd gf180mcu_fd_sc_mcu7t5v0__inv_1_1/I
+ gf180mcu_fd_sc_mcu7t5v0__mux4_4_19/I1 gf180mcu_fd_sc_mcu7t5v0__mux4_4_9/S0 gf180mcu_fd_sc_mcu7t5v0__dffq_2_79/Q
+ gf180mcu_fd_sc_mcu7t5v0__inv_1_16/I gf180mcu_fd_sc_mcu7t5v0__mux4_4_19/Z vdd vss
+ gf180mcu_fd_sc_mcu7t5v0__mux4_4
Xgf180mcu_fd_sc_mcu7t5v0__oai21_2_9 gf180mcu_fd_sc_mcu7t5v0__oai22_4_3/A1 gf180mcu_fd_sc_mcu7t5v0__oai21_2_9/ZN
+ gf180mcu_fd_sc_mcu7t5v0__inv_2_10/I vss gf180mcu_fd_sc_mcu7t5v0__inv_4_4/ZN vdd
+ vdd vss gf180mcu_fd_sc_mcu7t5v0__oai21_2
Xgf180mcu_fd_sc_mcu7t5v0__or3_1_12 gf180mcu_fd_sc_mcu7t5v0__or3_1_12/A3 vdd vss gf180mcu_fd_sc_mcu7t5v0__or3_1_12/Z
+ gf180mcu_fd_sc_mcu7t5v0__inv_1_13/I gf180mcu_fd_sc_mcu7t5v0__or3_1_12/A2 vdd vss
+ gf180mcu_fd_sc_mcu7t5v0__or3_1
Xgf180mcu_fd_sc_mcu7t5v0__or3_1_23 gf180mcu_fd_sc_mcu7t5v0__or3_1_23/A3 vdd vss gf180mcu_fd_sc_mcu7t5v0__or3_1_23/Z
+ gf180mcu_fd_sc_mcu7t5v0__or3_1_23/A1 gf180mcu_fd_sc_mcu7t5v0__or3_1_23/A2 vdd vss
+ gf180mcu_fd_sc_mcu7t5v0__or3_1
Xgf180mcu_fd_sc_mcu7t5v0__nor3_4_12 gf180mcu_fd_sc_mcu7t5v0__or3_4_0/A3 vdd vss gf180mcu_fd_sc_mcu7t5v0__nor3_4_12/ZN
+ gf180mcu_fd_sc_mcu7t5v0__or3_4_0/A1 gf180mcu_fd_sc_mcu7t5v0__nor3_4_12/A2 vdd vss
+ gf180mcu_fd_sc_mcu7t5v0__nor3_4
Xgf180mcu_fd_sc_mcu7t5v0__nor3_4_23 gf180mcu_fd_sc_mcu7t5v0__nor4_4_4/A3 vdd vss gf180mcu_fd_sc_mcu7t5v0__and4_1_3/A3
+ gf180mcu_fd_sc_mcu7t5v0__nor4_4_4/A1 gf180mcu_fd_sc_mcu7t5v0__nor4_4_4/A2 vdd vss
+ gf180mcu_fd_sc_mcu7t5v0__nor3_4
Xgf180mcu_fd_sc_mcu7t5v0__tiel_7 uart_tx_PU vdd vss vdd vss gf180mcu_fd_sc_mcu7t5v0__tiel
Xgf180mcu_fd_sc_mcu7t5v0__nor2_1_107 vdd vss gf180mcu_fd_sc_mcu7t5v0__nor2_1_107/ZN
+ gf180mcu_fd_sc_mcu7t5v0__dffq_1_448/Q gf180mcu_fd_sc_mcu7t5v0__nor2_4_22/ZN vdd
+ vss gf180mcu_fd_sc_mcu7t5v0__nor2_1
Xgf180mcu_fd_sc_mcu7t5v0__nor2_1_118 vdd vss gf180mcu_fd_sc_mcu7t5v0__nor2_1_118/ZN
+ gf180mcu_fd_sc_mcu7t5v0__dffq_1_241/Q gf180mcu_fd_sc_mcu7t5v0__nor2_4_17/ZN vdd
+ vss gf180mcu_fd_sc_mcu7t5v0__nor2_1
Xgf180mcu_fd_sc_mcu7t5v0__nor2_1_129 vdd vss gf180mcu_fd_sc_mcu7t5v0__xnor2_1_27/A1
+ gf180mcu_fd_sc_mcu7t5v0__xor2_1_79/A1 gf180mcu_fd_sc_mcu7t5v0__xor2_1_79/A2 vdd
+ vss gf180mcu_fd_sc_mcu7t5v0__nor2_1
Xgf180mcu_fd_sc_mcu7t5v0__xor3_1_108 gf180mcu_fd_sc_mcu7t5v0__xor3_1_108/A3 vdd vss
+ gf180mcu_fd_sc_mcu7t5v0__xor3_1_108/Z gf180mcu_fd_sc_mcu7t5v0__xor3_1_108/A1 gf180mcu_fd_sc_mcu7t5v0__xor3_1_108/A2
+ vdd vss gf180mcu_fd_sc_mcu7t5v0__xor3_1
Xgf180mcu_fd_sc_mcu7t5v0__xor3_1_119 gf180mcu_fd_sc_mcu7t5v0__xor3_1_119/A3 vdd vss
+ gf180mcu_fd_sc_mcu7t5v0__xor3_1_119/Z gf180mcu_fd_sc_mcu7t5v0__or2_1_7/A1 gf180mcu_fd_sc_mcu7t5v0__xor3_1_119/A2
+ vdd vss gf180mcu_fd_sc_mcu7t5v0__xor3_1
Xgf180mcu_fd_sc_mcu7t5v0__nand2_1_300 vdd vss gf180mcu_fd_sc_mcu7t5v0__nand2_1_528/A2
+ gf180mcu_fd_sc_mcu7t5v0__nor2_1_312/A1 gf180mcu_fd_sc_mcu7t5v0__xor3_1_176/Z vdd
+ vss gf180mcu_fd_sc_mcu7t5v0__nand2_1
Xgf180mcu_fd_sc_mcu7t5v0__nand2_1_311 vdd vss gf180mcu_fd_sc_mcu7t5v0__nand2_1_311/ZN
+ gf180mcu_fd_sc_mcu7t5v0__nor4_4_0/A1 gf180mcu_fd_sc_mcu7t5v0__nor2_4_26/ZN vdd vss
+ gf180mcu_fd_sc_mcu7t5v0__nand2_1
Xgf180mcu_fd_sc_mcu7t5v0__nand2_1_322 vdd vss gf180mcu_fd_sc_mcu7t5v0__nand2_1_322/ZN
+ gf180mcu_fd_sc_mcu7t5v0__mux4_4_3/I3 gf180mcu_fd_sc_mcu7t5v0__clkinv_3_9/ZN vdd
+ vss gf180mcu_fd_sc_mcu7t5v0__nand2_1
Xgf180mcu_fd_sc_mcu7t5v0__nand2_1_333 vdd vss gf180mcu_fd_sc_mcu7t5v0__xnor3_1_20/A2
+ gf180mcu_fd_sc_mcu7t5v0__mux4_4_2/I0 gf180mcu_fd_sc_mcu7t5v0__xor2_1_89/A2 vdd vss
+ gf180mcu_fd_sc_mcu7t5v0__nand2_1
Xgf180mcu_fd_sc_mcu7t5v0__nand2_1_344 vdd vss gf180mcu_fd_sc_mcu7t5v0__or3_1_11/A3
+ gf180mcu_fd_sc_mcu7t5v0__dffq_1_337/Q gf180mcu_fd_sc_mcu7t5v0__nor2_1_179/ZN vdd
+ vss gf180mcu_fd_sc_mcu7t5v0__nand2_1
Xgf180mcu_fd_sc_mcu7t5v0__nand2_1_355 vdd vss gf180mcu_fd_sc_mcu7t5v0__xor2_1_95/A2
+ gf180mcu_fd_sc_mcu7t5v0__or4_1_2/A4 gf180mcu_fd_sc_mcu7t5v0__and2_1_65/Z vdd vss
+ gf180mcu_fd_sc_mcu7t5v0__nand2_1
Xgf180mcu_fd_sc_mcu7t5v0__nand2_1_366 vdd vss gf180mcu_fd_sc_mcu7t5v0__oai21_1_106/A2
+ gf180mcu_fd_sc_mcu7t5v0__buf_8_7/Z gf180mcu_fd_sc_mcu7t5v0__dffq_1_374/Q vdd vss
+ gf180mcu_fd_sc_mcu7t5v0__nand2_1
Xgf180mcu_fd_sc_mcu7t5v0__nand2_1_377 vdd vss gf180mcu_fd_sc_mcu7t5v0__xor2_1_226/A2
+ gf180mcu_fd_sc_mcu7t5v0__oai31_1_21/B gf180mcu_fd_sc_mcu7t5v0__oai21_1_293/A1 vdd
+ vss gf180mcu_fd_sc_mcu7t5v0__nand2_1
Xgf180mcu_fd_sc_mcu7t5v0__nand2_1_388 vdd vss gf180mcu_fd_sc_mcu7t5v0__oai21_1_179/A2
+ gf180mcu_fd_sc_mcu7t5v0__oai31_1_9/A3 gf180mcu_fd_sc_mcu7t5v0__nand2_1_388/A2 vdd
+ vss gf180mcu_fd_sc_mcu7t5v0__nand2_1
Xgf180mcu_fd_sc_mcu7t5v0__nand2_1_399 vdd vss gf180mcu_fd_sc_mcu7t5v0__xor2_2_2/A1
+ gf180mcu_fd_sc_mcu7t5v0__nand3_1_64/ZN gf180mcu_fd_sc_mcu7t5v0__and2_1_84/A2 vdd
+ vss gf180mcu_fd_sc_mcu7t5v0__nand2_1
Xgf180mcu_fd_sc_mcu7t5v0__dffq_1_430 vdd gf180mcu_fd_sc_mcu7t5v0__dffq_1_430/Q gf180mcu_fd_sc_mcu7t5v0__dffq_4_44/CLK
+ vss gf180mcu_fd_sc_mcu7t5v0__dffq_1_430/D vdd vss gf180mcu_fd_sc_mcu7t5v0__dffq_1
Xgf180mcu_fd_sc_mcu7t5v0__dffq_1_441 vdd gf180mcu_fd_sc_mcu7t5v0__dffq_1_441/Q gf180mcu_fd_sc_mcu7t5v0__dffq_4_44/CLK
+ vss gf180mcu_fd_sc_mcu7t5v0__dffq_1_441/D vdd vss gf180mcu_fd_sc_mcu7t5v0__dffq_1
Xgf180mcu_fd_sc_mcu7t5v0__dffq_1_452 vdd gf180mcu_fd_sc_mcu7t5v0__mux4_4_13/I0 gf180mcu_fd_sc_mcu7t5v0__dffq_4_9/CLK
+ vss gf180mcu_fd_sc_mcu7t5v0__dffq_1_452/D vdd vss gf180mcu_fd_sc_mcu7t5v0__dffq_1
Xgf180mcu_fd_sc_mcu7t5v0__clkinv_1_302 vdd vss gf180mcu_fd_sc_mcu7t5v0__dffq_1_327/Q
+ gf180mcu_fd_sc_mcu7t5v0__aoi21_1_175/A1 vdd vss gf180mcu_fd_sc_mcu7t5v0__clkinv_1
Xgf180mcu_fd_sc_mcu7t5v0__clkinv_1_313 vdd vss gf180mcu_fd_sc_mcu7t5v0__clkinv_1_313/I
+ gf180mcu_fd_sc_mcu7t5v0__aoi22_2_6/B1 vdd vss gf180mcu_fd_sc_mcu7t5v0__clkinv_1
Xgf180mcu_fd_sc_mcu7t5v0__clkinv_1_324 vdd vss gf180mcu_fd_sc_mcu7t5v0__nand2_1_441/ZN
+ gf180mcu_fd_sc_mcu7t5v0__xor3_1_83/A1 vdd vss gf180mcu_fd_sc_mcu7t5v0__clkinv_1
Xgf180mcu_fd_sc_mcu7t5v0__clkinv_1_335 vdd vss gf180mcu_fd_sc_mcu7t5v0__xor3_1_99/A1
+ gf180mcu_fd_sc_mcu7t5v0__aoi21_1_254/A1 vdd vss gf180mcu_fd_sc_mcu7t5v0__clkinv_1
Xgf180mcu_fd_sc_mcu7t5v0__clkinv_1_346 vdd vss gf180mcu_fd_sc_mcu7t5v0__dffq_2_74/Q
+ gf180mcu_fd_sc_mcu7t5v0__aoi21_1_304/A1 vdd vss gf180mcu_fd_sc_mcu7t5v0__clkinv_1
Xgf180mcu_fd_sc_mcu7t5v0__clkinv_1_357 vdd vss gf180mcu_fd_sc_mcu7t5v0__oai211_1_50/ZN
+ gf180mcu_fd_sc_mcu7t5v0__dffq_2_94/D vdd vss gf180mcu_fd_sc_mcu7t5v0__clkinv_1
Xgf180mcu_fd_sc_mcu7t5v0__nand2_4_0 vdd vss gf180mcu_fd_sc_mcu7t5v0__nor2_4_1/A2 gf180mcu_fd_sc_mcu7t5v0__inv_2_1/I
+ gf180mcu_fd_sc_mcu7t5v0__dffq_4_0/Q vdd vss gf180mcu_fd_sc_mcu7t5v0__nand2_4
Xgf180mcu_fd_sc_mcu7t5v0__nand2_4_10 vdd vss gf180mcu_fd_sc_mcu7t5v0__oai22_1_62/A2
+ gf180mcu_fd_sc_mcu7t5v0__nor3_4_10/ZN gf180mcu_fd_sc_mcu7t5v0__nor2_4_13/ZN vdd
+ vss gf180mcu_fd_sc_mcu7t5v0__nand2_4
Xgf180mcu_fd_sc_mcu7t5v0__nand2_4_21 vdd vss gf180mcu_fd_sc_mcu7t5v0__nand2_4_21/ZN
+ gf180mcu_fd_sc_mcu7t5v0__nor3_4_8/ZN gf180mcu_fd_sc_mcu7t5v0__nor2_4_12/ZN vdd vss
+ gf180mcu_fd_sc_mcu7t5v0__nand2_4
Xgf180mcu_fd_sc_mcu7t5v0__nand2_4_32 vdd vss gf180mcu_fd_sc_mcu7t5v0__nand2_4_32/ZN
+ gf180mcu_fd_sc_mcu7t5v0__nor2_4_6/ZN gf180mcu_fd_sc_mcu7t5v0__nor3_4_8/ZN vdd vss
+ gf180mcu_fd_sc_mcu7t5v0__nand2_4
Xgf180mcu_fd_sc_mcu7t5v0__nand2_4_43 vdd vss gf180mcu_fd_sc_mcu7t5v0__oai32_1_6/A3
+ gf180mcu_fd_sc_mcu7t5v0__dffq_4_40/Q gf180mcu_fd_sc_mcu7t5v0__dffq_2_61/Q vdd vss
+ gf180mcu_fd_sc_mcu7t5v0__nand2_4
Xgf180mcu_fd_sc_mcu7t5v0__clkinv_3_18 vdd gf180mcu_fd_sc_mcu7t5v0__nor3_1_35/A1 gf180mcu_fd_sc_mcu7t5v0__dffq_2_81/Q
+ vss vdd vss gf180mcu_fd_sc_mcu7t5v0__clkinv_3
Xgf180mcu_fd_sc_mcu7t5v0__nor4_1_0 gf180mcu_fd_sc_mcu7t5v0__nor4_1_0/A3 gf180mcu_fd_sc_mcu7t5v0__nor4_1_0/A4
+ vdd vss gf180mcu_fd_sc_mcu7t5v0__nor4_1_0/ZN gf180mcu_fd_sc_mcu7t5v0__nor4_1_0/A1
+ gf180mcu_fd_sc_mcu7t5v0__nor4_1_0/A2 vdd vss gf180mcu_fd_sc_mcu7t5v0__nor4_1
Xgf180mcu_fd_sc_mcu7t5v0__dffq_4_4 gf180mcu_fd_sc_mcu7t5v0__dffq_4_4/D gf180mcu_fd_sc_mcu7t5v0__dffq_4_4/Q
+ vdd vss gf180mcu_fd_sc_mcu7t5v0__dffq_4_6/CLK vdd vss gf180mcu_fd_sc_mcu7t5v0__dffq_4
Xgf180mcu_fd_sc_mcu7t5v0__nand2_1_130 vdd vss gf180mcu_fd_sc_mcu7t5v0__nand4_1_3/A3
+ gf180mcu_fd_sc_mcu7t5v0__and3_2_0/Z gf180mcu_fd_sc_mcu7t5v0__xor3_1_21/Z vdd vss
+ gf180mcu_fd_sc_mcu7t5v0__nand2_1
Xgf180mcu_fd_sc_mcu7t5v0__nand2_1_141 vdd vss gf180mcu_fd_sc_mcu7t5v0__xor3_1_45/A1
+ gf180mcu_fd_sc_mcu7t5v0__xnor3_1_13/ZN gf180mcu_fd_sc_mcu7t5v0__xor2_1_48/Z vdd
+ vss gf180mcu_fd_sc_mcu7t5v0__nand2_1
Xgf180mcu_fd_sc_mcu7t5v0__nand2_1_152 vdd vss gf180mcu_fd_sc_mcu7t5v0__and2_1_153/A1
+ gf180mcu_fd_sc_mcu7t5v0__inv_8_1/I gf180mcu_fd_sc_mcu7t5v0__xor2_1_117/Z vdd vss
+ gf180mcu_fd_sc_mcu7t5v0__nand2_1
Xgf180mcu_fd_sc_mcu7t5v0__nand2_1_163 vdd vss gf180mcu_fd_sc_mcu7t5v0__xor3_1_55/A3
+ gf180mcu_fd_sc_mcu7t5v0__inv_8_0/I gf180mcu_fd_sc_mcu7t5v0__xor2_1_58/A1 vdd vss
+ gf180mcu_fd_sc_mcu7t5v0__nand2_1
Xgf180mcu_fd_sc_mcu7t5v0__nand2_1_174 vdd vss gf180mcu_fd_sc_mcu7t5v0__oai211_1_14/B
+ gf180mcu_fd_sc_mcu7t5v0__nor2_2_10/ZN gf180mcu_fd_sc_mcu7t5v0__and2_1_23/Z vdd vss
+ gf180mcu_fd_sc_mcu7t5v0__nand2_1
Xgf180mcu_fd_sc_mcu7t5v0__nand2_1_185 vdd vss gf180mcu_fd_sc_mcu7t5v0__oai21_1_65/A1
+ gf180mcu_fd_sc_mcu7t5v0__nand2_1_188/ZN gf180mcu_fd_sc_mcu7t5v0__oai21_1_69/ZN vdd
+ vss gf180mcu_fd_sc_mcu7t5v0__nand2_1
Xgf180mcu_fd_sc_mcu7t5v0__nand2_1_196 vdd vss gf180mcu_fd_sc_mcu7t5v0__xor3_1_41/A3
+ gf180mcu_fd_sc_mcu7t5v0__inv_12_1/I gf180mcu_fd_sc_mcu7t5v0__oai22_1_8/A2 vdd vss
+ gf180mcu_fd_sc_mcu7t5v0__nand2_1
Xgf180mcu_fd_sc_mcu7t5v0__dffq_1_260 vdd gf180mcu_fd_sc_mcu7t5v0__dffq_1_260/Q gf180mcu_fd_sc_mcu7t5v0__dffq_1_99/CLK
+ vss gf180mcu_fd_sc_mcu7t5v0__dffq_1_260/D vdd vss gf180mcu_fd_sc_mcu7t5v0__dffq_1
Xgf180mcu_fd_sc_mcu7t5v0__dffq_1_271 vdd gf180mcu_fd_sc_mcu7t5v0__dffq_1_271/Q gf180mcu_fd_sc_mcu7t5v0__dffq_1_99/CLK
+ vss gf180mcu_fd_sc_mcu7t5v0__dffq_1_271/D vdd vss gf180mcu_fd_sc_mcu7t5v0__dffq_1
Xgf180mcu_fd_sc_mcu7t5v0__dffq_1_282 vdd gf180mcu_fd_sc_mcu7t5v0__dffq_1_282/Q gf180mcu_fd_sc_mcu7t5v0__dffq_4_9/CLK
+ vss gf180mcu_fd_sc_mcu7t5v0__dffq_1_282/D vdd vss gf180mcu_fd_sc_mcu7t5v0__dffq_1
Xgf180mcu_fd_sc_mcu7t5v0__clkinv_4_3 vdd vss gf180mcu_fd_sc_mcu7t5v0__oai22_4_0/A2
+ gf180mcu_fd_sc_mcu7t5v0__dffq_1_236/Q vdd vss gf180mcu_fd_sc_mcu7t5v0__clkinv_4
Xgf180mcu_fd_sc_mcu7t5v0__oai211_2_11 gf180mcu_fd_sc_mcu7t5v0__oai31_4_4/ZN gf180mcu_fd_sc_mcu7t5v0__or2_1_46/A1
+ gf180mcu_fd_sc_mcu7t5v0__aoi21_4_9/ZN gf180mcu_fd_sc_mcu7t5v0__oai21_4_12/B gf180mcu_fd_sc_mcu7t5v0__inv_12_1/I
+ vdd vss vdd vss gf180mcu_fd_sc_mcu7t5v0__oai211_2
Xgf180mcu_fd_sc_mcu7t5v0__dffq_1_293 vdd gf180mcu_fd_sc_mcu7t5v0__dffq_1_293/Q gf180mcu_fd_sc_mcu7t5v0__dffq_2_58/CLK
+ vss gf180mcu_fd_sc_mcu7t5v0__dffq_1_293/D vdd vss gf180mcu_fd_sc_mcu7t5v0__dffq_1
Xgf180mcu_fd_sc_mcu7t5v0__nand3_2_8 gf180mcu_fd_sc_mcu7t5v0__or3_2_2/A1 vdd vss gf180mcu_fd_sc_mcu7t5v0__oai21_4_7/B
+ gf180mcu_fd_sc_mcu7t5v0__or2_4_0/A1 gf180mcu_fd_sc_mcu7t5v0__or2_4_0/A2 vdd vss
+ gf180mcu_fd_sc_mcu7t5v0__nand3_2
Xgf180mcu_fd_sc_mcu7t5v0__xor2_1_107 vdd vss gf180mcu_fd_sc_mcu7t5v0__xor2_1_107/Z
+ gf180mcu_fd_sc_mcu7t5v0__xor2_1_107/A1 gf180mcu_fd_sc_mcu7t5v0__xor2_1_107/A2 vdd
+ vss gf180mcu_fd_sc_mcu7t5v0__xor2_1
Xgf180mcu_fd_sc_mcu7t5v0__xor2_1_118 vdd vss gf180mcu_fd_sc_mcu7t5v0__xor2_1_118/Z
+ gf180mcu_fd_sc_mcu7t5v0__mux4_4_18/Z gf180mcu_fd_sc_mcu7t5v0__xor2_1_118/A2 vdd
+ vss gf180mcu_fd_sc_mcu7t5v0__xor2_1
Xgf180mcu_fd_sc_mcu7t5v0__xor2_1_129 vdd vss gf180mcu_fd_sc_mcu7t5v0__xor2_1_129/Z
+ gf180mcu_fd_sc_mcu7t5v0__inv_4_6/I gf180mcu_fd_sc_mcu7t5v0__xor2_1_130/Z vdd vss
+ gf180mcu_fd_sc_mcu7t5v0__xor2_1
Xgf180mcu_fd_sc_mcu7t5v0__nor3_1_13 gf180mcu_fd_sc_mcu7t5v0__nor3_1_13/A3 vdd vss
+ gf180mcu_fd_sc_mcu7t5v0__and4_2_0/A4 gf180mcu_fd_sc_mcu7t5v0__nor3_1_13/A1 gf180mcu_fd_sc_mcu7t5v0__nor3_1_13/A2
+ vdd vss gf180mcu_fd_sc_mcu7t5v0__nor3_1
Xgf180mcu_fd_sc_mcu7t5v0__clkinv_1_110 vdd vss gf180mcu_fd_sc_mcu7t5v0__dffq_1_99/Q
+ gf180mcu_fd_sc_mcu7t5v0__oai22_1_258/B2 vdd vss gf180mcu_fd_sc_mcu7t5v0__clkinv_1
Xgf180mcu_fd_sc_mcu7t5v0__nor3_1_24 gf180mcu_fd_sc_mcu7t5v0__nor3_1_24/A3 vdd vss
+ gf180mcu_fd_sc_mcu7t5v0__nor3_1_24/ZN gf180mcu_fd_sc_mcu7t5v0__nor3_1_24/A1 gf180mcu_fd_sc_mcu7t5v0__nor3_1_24/A2
+ vdd vss gf180mcu_fd_sc_mcu7t5v0__nor3_1
Xgf180mcu_fd_sc_mcu7t5v0__clkinv_1_121 vdd vss gf180mcu_fd_sc_mcu7t5v0__dffq_1_104/Q
+ gf180mcu_fd_sc_mcu7t5v0__oai22_1_111/B2 vdd vss gf180mcu_fd_sc_mcu7t5v0__clkinv_1
Xgf180mcu_fd_sc_mcu7t5v0__nor3_1_35 gf180mcu_fd_sc_mcu7t5v0__nor3_1_35/A3 vdd vss
+ gf180mcu_fd_sc_mcu7t5v0__nor3_1_35/ZN gf180mcu_fd_sc_mcu7t5v0__nor3_1_35/A1 gf180mcu_fd_sc_mcu7t5v0__nor3_2_12/ZN
+ vdd vss gf180mcu_fd_sc_mcu7t5v0__nor3_1
Xgf180mcu_fd_sc_mcu7t5v0__clkinv_1_132 vdd vss gf180mcu_fd_sc_mcu7t5v0__dffq_1_115/Q
+ gf180mcu_fd_sc_mcu7t5v0__oai22_1_124/B2 vdd vss gf180mcu_fd_sc_mcu7t5v0__clkinv_1
Xgf180mcu_fd_sc_mcu7t5v0__clkinv_1_143 vdd vss gf180mcu_fd_sc_mcu7t5v0__dffq_1_120/Q
+ gf180mcu_fd_sc_mcu7t5v0__oai22_1_128/B2 vdd vss gf180mcu_fd_sc_mcu7t5v0__clkinv_1
Xgf180mcu_fd_sc_mcu7t5v0__dffq_1_70 vdd gf180mcu_fd_sc_mcu7t5v0__dffq_1_70/Q gf180mcu_fd_sc_mcu7t5v0__dffq_1_95/CLK
+ vss gf180mcu_fd_sc_mcu7t5v0__dffq_1_70/D vdd vss gf180mcu_fd_sc_mcu7t5v0__dffq_1
Xgf180mcu_fd_sc_mcu7t5v0__clkinv_1_154 vdd vss gf180mcu_fd_sc_mcu7t5v0__dffq_1_136/Q
+ gf180mcu_fd_sc_mcu7t5v0__oai22_1_263/B2 vdd vss gf180mcu_fd_sc_mcu7t5v0__clkinv_1
Xgf180mcu_fd_sc_mcu7t5v0__dffq_1_81 vdd gf180mcu_fd_sc_mcu7t5v0__dffq_1_81/Q gf180mcu_fd_sc_mcu7t5v0__dffq_1_99/CLK
+ vss gf180mcu_fd_sc_mcu7t5v0__dffq_1_81/D vdd vss gf180mcu_fd_sc_mcu7t5v0__dffq_1
Xgf180mcu_fd_sc_mcu7t5v0__clkinv_1_165 vdd vss gf180mcu_fd_sc_mcu7t5v0__dffq_1_148/Q
+ gf180mcu_fd_sc_mcu7t5v0__oai22_1_153/B2 vdd vss gf180mcu_fd_sc_mcu7t5v0__clkinv_1
Xgf180mcu_fd_sc_mcu7t5v0__dffq_1_92 vdd gf180mcu_fd_sc_mcu7t5v0__dffq_1_92/Q gf180mcu_fd_sc_mcu7t5v0__dffq_1_96/CLK
+ vss gf180mcu_fd_sc_mcu7t5v0__dffq_1_92/D vdd vss gf180mcu_fd_sc_mcu7t5v0__dffq_1
Xgf180mcu_fd_sc_mcu7t5v0__clkinv_1_176 vdd vss gf180mcu_fd_sc_mcu7t5v0__dffq_1_155/Q
+ gf180mcu_fd_sc_mcu7t5v0__oai22_1_161/B2 vdd vss gf180mcu_fd_sc_mcu7t5v0__clkinv_1
Xgf180mcu_fd_sc_mcu7t5v0__clkinv_1_187 vdd vss gf180mcu_fd_sc_mcu7t5v0__dffq_1_164/Q
+ gf180mcu_fd_sc_mcu7t5v0__oai22_1_173/B2 vdd vss gf180mcu_fd_sc_mcu7t5v0__clkinv_1
Xgf180mcu_fd_sc_mcu7t5v0__clkinv_1_198 vdd vss gf180mcu_fd_sc_mcu7t5v0__dffq_1_165/Q
+ gf180mcu_fd_sc_mcu7t5v0__oai22_1_178/B2 vdd vss gf180mcu_fd_sc_mcu7t5v0__clkinv_1
Xgf180mcu_fd_sc_mcu7t5v0__aoi211_1_1 gf180mcu_fd_sc_mcu7t5v0__aoi211_1_1/B gf180mcu_fd_sc_mcu7t5v0__or2_4_4/Z
+ vdd vss gf180mcu_fd_sc_mcu7t5v0__aoi21_1_6/B gf180mcu_fd_sc_mcu7t5v0__oai31_1_0/B
+ gf180mcu_fd_sc_mcu7t5v0__aoi221_1_2/ZN vdd vss gf180mcu_fd_sc_mcu7t5v0__aoi211_1
Xgf180mcu_fd_sc_mcu7t5v0__tiel_10 uart_tx_PD vdd vss vdd vss gf180mcu_fd_sc_mcu7t5v0__tiel
Xgf180mcu_fd_sc_mcu7t5v0__inv_3_4 vss gf180mcu_fd_sc_mcu7t5v0__inv_3_4/ZN gf180mcu_fd_sc_mcu7t5v0__inv_3_4/I
+ vdd vdd vss gf180mcu_fd_sc_mcu7t5v0__inv_3
Xgf180mcu_fd_sc_mcu7t5v0__dffq_2_1 gf180mcu_fd_sc_mcu7t5v0__dffq_2_1/D vdd vss gf180mcu_fd_sc_mcu7t5v0__dffq_4_6/CLK
+ gf180mcu_fd_sc_mcu7t5v0__or3_2_1/A1 vdd vss gf180mcu_fd_sc_mcu7t5v0__dffq_2
Xgf180mcu_fd_sc_mcu7t5v0__oai22_1_170 gf180mcu_fd_sc_mcu7t5v0__nand2_4_22/ZN gf180mcu_fd_sc_mcu7t5v0__nand2_2_29/ZN
+ gf180mcu_fd_sc_mcu7t5v0__oai22_1_170/B2 vdd vss gf180mcu_fd_sc_mcu7t5v0__dffq_1_188/D
+ gf180mcu_fd_sc_mcu7t5v0__oai22_1_88/A1 vdd vss gf180mcu_fd_sc_mcu7t5v0__oai22_1
Xgf180mcu_fd_sc_mcu7t5v0__oai22_1_181 gf180mcu_fd_sc_mcu7t5v0__nand2_4_24/ZN gf180mcu_fd_sc_mcu7t5v0__nand2_2_52/ZN
+ gf180mcu_fd_sc_mcu7t5v0__oai22_1_181/B2 vdd vss gf180mcu_fd_sc_mcu7t5v0__dffq_1_167/D
+ gf180mcu_fd_sc_mcu7t5v0__aoi21_4_3/ZN vdd vss gf180mcu_fd_sc_mcu7t5v0__oai22_1
Xgf180mcu_fd_sc_mcu7t5v0__oai22_1_192 gf180mcu_fd_sc_mcu7t5v0__nand2_4_15/ZN gf180mcu_fd_sc_mcu7t5v0__nand2_2_21/ZN
+ gf180mcu_fd_sc_mcu7t5v0__oai22_1_192/B2 vdd vss gf180mcu_fd_sc_mcu7t5v0__dffq_1_177/D
+ gf180mcu_fd_sc_mcu7t5v0__aoi21_4_4/ZN vdd vss gf180mcu_fd_sc_mcu7t5v0__oai22_1
Xgf180mcu_fd_sc_mcu7t5v0__xnor3_1_20 gf180mcu_fd_sc_mcu7t5v0__xnor3_1_20/A3 vdd vss
+ gf180mcu_fd_sc_mcu7t5v0__xnor3_1_20/ZN gf180mcu_fd_sc_mcu7t5v0__or3_2_3/A3 gf180mcu_fd_sc_mcu7t5v0__xnor3_1_20/A2
+ vdd vss gf180mcu_fd_sc_mcu7t5v0__xnor3_1
Xgf180mcu_fd_sc_mcu7t5v0__xnor3_1_31 gf180mcu_fd_sc_mcu7t5v0__xor3_1_156/A3 vdd vss
+ gf180mcu_fd_sc_mcu7t5v0__xnor3_1_31/ZN gf180mcu_fd_sc_mcu7t5v0__xor3_1_156/A1 gf180mcu_fd_sc_mcu7t5v0__xor3_1_99/Z
+ vdd vss gf180mcu_fd_sc_mcu7t5v0__xnor3_1
Xgf180mcu_fd_sc_mcu7t5v0__xnor3_1_42 gf180mcu_fd_sc_mcu7t5v0__xnor3_1_42/A3 vdd vss
+ gf180mcu_fd_sc_mcu7t5v0__nor3_1_40/A3 gf180mcu_fd_sc_mcu7t5v0__xor3_1_124/Z gf180mcu_fd_sc_mcu7t5v0__xnor3_1_42/A2
+ vdd vss gf180mcu_fd_sc_mcu7t5v0__xnor3_1
Xgf180mcu_fd_sc_mcu7t5v0__aoi221_1_17 gf180mcu_fd_sc_mcu7t5v0__nor4_4_2/ZN gf180mcu_fd_sc_mcu7t5v0__or2_1_23/A1
+ vdd vss gf180mcu_fd_sc_mcu7t5v0__dffq_2_34/D gf180mcu_fd_sc_mcu7t5v0__aoi221_1_17/A1
+ gf180mcu_fd_sc_mcu7t5v0__nor2_4_26/ZN gf180mcu_fd_sc_mcu7t5v0__nor2_1_152/ZN vdd
+ vss gf180mcu_fd_sc_mcu7t5v0__aoi221_1
Xgf180mcu_fd_sc_mcu7t5v0__aoi221_1_28 gf180mcu_fd_sc_mcu7t5v0__or2_1_21/Z gf180mcu_fd_sc_mcu7t5v0__aoi221_1_28/C
+ vdd vss gf180mcu_fd_sc_mcu7t5v0__dffq_2_105/D gf180mcu_fd_sc_mcu7t5v0__nand4_2_5/A2
+ gf180mcu_fd_sc_mcu7t5v0__nor3_1_44/A1 gf180mcu_fd_sc_mcu7t5v0__oai21_1_154/B vdd
+ vss gf180mcu_fd_sc_mcu7t5v0__aoi221_1
Xgf180mcu_fd_sc_mcu7t5v0__aoi221_1_39 gf180mcu_fd_sc_mcu7t5v0__oai21_1_207/A2 gf180mcu_fd_sc_mcu7t5v0__nor2_2_26/ZN
+ vdd vss gf180mcu_fd_sc_mcu7t5v0__oai21_1_207/B gf180mcu_fd_sc_mcu7t5v0__inv_8_2/I
+ gf180mcu_fd_sc_mcu7t5v0__nor2_2_27/ZN gf180mcu_fd_sc_mcu7t5v0__mux2_1_8/I1 vdd vss
+ gf180mcu_fd_sc_mcu7t5v0__aoi221_1
Xgf180mcu_fd_sc_mcu7t5v0__oai21_4_14 gf180mcu_fd_sc_mcu7t5v0__oai21_4_14/B vdd vss
+ gf180mcu_fd_sc_mcu7t5v0__oai21_4_14/A1 gf180mcu_fd_sc_mcu7t5v0__xor2_1_58/A1 gf180mcu_fd_sc_mcu7t5v0__or2_4_0/Z
+ vdd vss gf180mcu_fd_sc_mcu7t5v0__oai21_4
Xgf180mcu_fd_sc_mcu7t5v0__nor2_1_90 vdd vss gf180mcu_fd_sc_mcu7t5v0__or3_1_6/A1 gf180mcu_fd_sc_mcu7t5v0__inv_3_3/ZN
+ gf180mcu_fd_sc_mcu7t5v0__xor3_1_56/A2 vdd vss gf180mcu_fd_sc_mcu7t5v0__nor2_1
Xgf180mcu_fd_sc_mcu7t5v0__clkinv_2_0 vdd vss gf180mcu_fd_sc_mcu7t5v0__dffq_4_4/Q gf180mcu_fd_sc_mcu7t5v0__or3_2_2/A2
+ vdd vss gf180mcu_fd_sc_mcu7t5v0__clkinv_2
Xgf180mcu_fd_sc_mcu7t5v0__oai31_1_1 vdd gf180mcu_fd_sc_mcu7t5v0__xor2_1_25/A2 gf180mcu_fd_sc_mcu7t5v0__oai31_1_1/B
+ gf180mcu_fd_sc_mcu7t5v0__mux4_4_0/Z gf180mcu_fd_sc_mcu7t5v0__oai31_1_1/A2 vss gf180mcu_fd_sc_mcu7t5v0__mux4_4_4/Z
+ vdd vss gf180mcu_fd_sc_mcu7t5v0__oai31_1
Xgf180mcu_fd_sc_mcu7t5v0__nor2_1_290 vdd vss gf180mcu_fd_sc_mcu7t5v0__nor2_1_290/ZN
+ gf180mcu_fd_sc_mcu7t5v0__and2_1_109/Z gf180mcu_fd_sc_mcu7t5v0__xnor3_1_32/ZN vdd
+ vss gf180mcu_fd_sc_mcu7t5v0__nor2_1
Xgf180mcu_fd_sc_mcu7t5v0__nand2_1_11 vdd vss gf180mcu_fd_sc_mcu7t5v0__aoi21_1_7/A1
+ gf180mcu_fd_sc_mcu7t5v0__or3_2_0/A1 gf180mcu_fd_sc_mcu7t5v0__or2_4_4/Z vdd vss gf180mcu_fd_sc_mcu7t5v0__nand2_1
Xgf180mcu_fd_sc_mcu7t5v0__oai31_1_16 vdd gf180mcu_fd_sc_mcu7t5v0__xor2_1_133/A2 gf180mcu_fd_sc_mcu7t5v0__oai31_1_16/B
+ gf180mcu_fd_sc_mcu7t5v0__nor4_2_5/A1 gf180mcu_fd_sc_mcu7t5v0__and2_2_9/Z vss gf180mcu_fd_sc_mcu7t5v0__nor4_2_5/A3
+ vdd vss gf180mcu_fd_sc_mcu7t5v0__oai31_1
Xgf180mcu_fd_sc_mcu7t5v0__nand2_1_22 vdd vss gf180mcu_fd_sc_mcu7t5v0__oai21_1_8/A1
+ gf180mcu_fd_sc_mcu7t5v0__nor3_2_5/A1 gf180mcu_fd_sc_mcu7t5v0__and2_4_0/Z vdd vss
+ gf180mcu_fd_sc_mcu7t5v0__nand2_1
Xgf180mcu_fd_sc_mcu7t5v0__nand2_1_33 vdd vss gf180mcu_fd_sc_mcu7t5v0__nand2_1_33/ZN
+ gf180mcu_fd_sc_mcu7t5v0__dffq_2_7/Q gf180mcu_fd_sc_mcu7t5v0__or2_4_4/Z vdd vss gf180mcu_fd_sc_mcu7t5v0__nand2_1
Xgf180mcu_fd_sc_mcu7t5v0__nand2_1_44 vdd vss gf180mcu_fd_sc_mcu7t5v0__nand2_1_44/ZN
+ gf180mcu_fd_sc_mcu7t5v0__nand2_1_63/ZN gf180mcu_fd_sc_mcu7t5v0__nor2_1_26/ZN vdd
+ vss gf180mcu_fd_sc_mcu7t5v0__nand2_1
Xgf180mcu_fd_sc_mcu7t5v0__nand2_1_55 vdd vss gf180mcu_fd_sc_mcu7t5v0__xnor3_1_9/A2
+ gf180mcu_fd_sc_mcu7t5v0__inv_4_6/I gf180mcu_fd_sc_mcu7t5v0__and2_4_1/Z vdd vss gf180mcu_fd_sc_mcu7t5v0__nand2_1
Xgf180mcu_fd_sc_mcu7t5v0__nand2_1_66 vdd vss gf180mcu_fd_sc_mcu7t5v0__oai21_4_0/B
+ gf180mcu_fd_sc_mcu7t5v0__mux4_4_3/I3 gf180mcu_fd_sc_mcu7t5v0__dffq_4_4/Q vdd vss
+ gf180mcu_fd_sc_mcu7t5v0__nand2_1
Xgf180mcu_fd_sc_mcu7t5v0__nand2_1_77 vdd vss gf180mcu_fd_sc_mcu7t5v0__oai21_1_28/A2
+ gf180mcu_fd_sc_mcu7t5v0__inv_4_6/I gf180mcu_fd_sc_mcu7t5v0__mux4_4_1/Z vdd vss gf180mcu_fd_sc_mcu7t5v0__nand2_1
Xgf180mcu_fd_sc_mcu7t5v0__nand2_1_88 vdd vss gf180mcu_fd_sc_mcu7t5v0__xor3_1_20/A3
+ gf180mcu_fd_sc_mcu7t5v0__xor2_1_64/A2 gf180mcu_fd_sc_mcu7t5v0__nand2_1_88/A2 vdd
+ vss gf180mcu_fd_sc_mcu7t5v0__nand2_1
Xgf180mcu_fd_sc_mcu7t5v0__nand2_1_99 vdd vss gf180mcu_fd_sc_mcu7t5v0__xor3_1_38/A1
+ gf180mcu_fd_sc_mcu7t5v0__inv_8_0/I gf180mcu_fd_sc_mcu7t5v0__and4_1_0/A4 vdd vss
+ gf180mcu_fd_sc_mcu7t5v0__nand2_1
Xgf180mcu_fd_sc_mcu7t5v0__nor2_4_1 vdd vss gf180mcu_fd_sc_mcu7t5v0__nor2_4_1/ZN gf180mcu_fd_sc_mcu7t5v0__nor3_4_2/A1
+ gf180mcu_fd_sc_mcu7t5v0__nor2_4_1/A2 vdd vss gf180mcu_fd_sc_mcu7t5v0__nor2_4
Xgf180mcu_fd_sc_mcu7t5v0__oai22_1_1 gf180mcu_fd_sc_mcu7t5v0__and2_2_2/Z gf180mcu_fd_sc_mcu7t5v0__and2_1_10/Z
+ gf180mcu_fd_sc_mcu7t5v0__oai22_1_1/B2 vdd vss gf180mcu_fd_sc_mcu7t5v0__oai22_1_1/ZN
+ gf180mcu_fd_sc_mcu7t5v0__or4_1_0/A1 vdd vss gf180mcu_fd_sc_mcu7t5v0__oai22_1
Xgf180mcu_fd_sc_mcu7t5v0__aoi22_1_70 gf180mcu_fd_sc_mcu7t5v0__nor2_4_9/ZN gf180mcu_fd_sc_mcu7t5v0__dffq_1_117/Q
+ vdd vss gf180mcu_fd_sc_mcu7t5v0__aoi22_1_70/ZN gf180mcu_fd_sc_mcu7t5v0__dffq_1_115/Q
+ gf180mcu_fd_sc_mcu7t5v0__nor2_4_8/ZN vdd vss gf180mcu_fd_sc_mcu7t5v0__aoi22_1
Xgf180mcu_fd_sc_mcu7t5v0__aoi22_1_81 gf180mcu_fd_sc_mcu7t5v0__nor2_4_11/ZN gf180mcu_fd_sc_mcu7t5v0__dffq_1_128/Q
+ vdd vss gf180mcu_fd_sc_mcu7t5v0__aoi22_1_81/ZN gf180mcu_fd_sc_mcu7t5v0__dffq_1_131/Q
+ gf180mcu_fd_sc_mcu7t5v0__nor2_4_10/ZN vdd vss gf180mcu_fd_sc_mcu7t5v0__aoi22_1
Xgf180mcu_fd_sc_mcu7t5v0__aoi22_1_92 gf180mcu_fd_sc_mcu7t5v0__nor2_4_11/ZN gf180mcu_fd_sc_mcu7t5v0__dffq_1_191/Q
+ vdd vss gf180mcu_fd_sc_mcu7t5v0__aoi22_1_92/ZN gf180mcu_fd_sc_mcu7t5v0__dffq_1_187/Q
+ gf180mcu_fd_sc_mcu7t5v0__nor2_4_10/ZN vdd vss gf180mcu_fd_sc_mcu7t5v0__aoi22_1
Xgf180mcu_fd_sc_mcu7t5v0__inv_1_1 vss gf180mcu_fd_sc_mcu7t5v0__inv_1_1/ZN gf180mcu_fd_sc_mcu7t5v0__inv_1_1/I
+ vdd vdd vss gf180mcu_fd_sc_mcu7t5v0__inv_1
Xgf180mcu_fd_sc_mcu7t5v0__nand3_2_10 gf180mcu_fd_sc_mcu7t5v0__inv_1_0/I vdd vss gf180mcu_fd_sc_mcu7t5v0__oai21_4_5/B
+ gf180mcu_fd_sc_mcu7t5v0__or2_4_0/A1 gf180mcu_fd_sc_mcu7t5v0__or2_4_0/A2 vdd vss
+ gf180mcu_fd_sc_mcu7t5v0__nand3_2
Xgf180mcu_fd_sc_mcu7t5v0__nand3_2_21 gf180mcu_fd_sc_mcu7t5v0__or3_2_3/A2 vdd vss gf180mcu_fd_sc_mcu7t5v0__oai31_4_1/B
+ gf180mcu_fd_sc_mcu7t5v0__dffq_2_41/Q gf180mcu_fd_sc_mcu7t5v0__inv_1_6/I vdd vss
+ gf180mcu_fd_sc_mcu7t5v0__nand3_2
Xgf180mcu_fd_sc_mcu7t5v0__nand3_2_32 gf180mcu_fd_sc_mcu7t5v0__inv_1_1/I vdd vss gf180mcu_fd_sc_mcu7t5v0__oai21_4_15/B
+ gf180mcu_fd_sc_mcu7t5v0__or2_4_0/A1 gf180mcu_fd_sc_mcu7t5v0__or2_4_0/A2 vdd vss
+ gf180mcu_fd_sc_mcu7t5v0__nand3_2
Xgf180mcu_fd_sc_mcu7t5v0__aoi222_2_7 gf180mcu_fd_sc_mcu7t5v0__nor2_4_7/ZN gf180mcu_fd_sc_mcu7t5v0__aoi222_2_7/B1
+ gf180mcu_fd_sc_mcu7t5v0__aoi222_2_7/A2 gf180mcu_fd_sc_mcu7t5v0__nor2_4_6/ZN gf180mcu_fd_sc_mcu7t5v0__nand3_1_36/A2
+ vss vdd gf180mcu_fd_sc_mcu7t5v0__nor2_4_13/ZN gf180mcu_fd_sc_mcu7t5v0__aoi222_2_7/C1
+ vdd vss gf180mcu_fd_sc_mcu7t5v0__aoi222_2
Xgf180mcu_fd_sc_mcu7t5v0__nor3_2_9 gf180mcu_fd_sc_mcu7t5v0__nor3_2_9/A3 vdd vss gf180mcu_fd_sc_mcu7t5v0__nor3_2_9/ZN
+ gf180mcu_fd_sc_mcu7t5v0__nor3_2_9/A1 gf180mcu_fd_sc_mcu7t5v0__nor3_2_9/A2 vdd vss
+ gf180mcu_fd_sc_mcu7t5v0__nor3_2
Xgf180mcu_fd_sc_mcu7t5v0__nand2_1_707 vdd vss gf180mcu_fd_sc_mcu7t5v0__nand2_1_707/ZN
+ gf180mcu_fd_sc_mcu7t5v0__dffq_4_37/Q gf180mcu_fd_sc_mcu7t5v0__xor2_1_226/Z vdd vss
+ gf180mcu_fd_sc_mcu7t5v0__nand2_1
Xgf180mcu_fd_sc_mcu7t5v0__nand2_1_718 vdd vss gf180mcu_fd_sc_mcu7t5v0__nand4_1_25/A2
+ gf180mcu_fd_sc_mcu7t5v0__nor3_4_18/ZN gf180mcu_fd_sc_mcu7t5v0__xor2_1_82/Z vdd vss
+ gf180mcu_fd_sc_mcu7t5v0__nand2_1
Xgf180mcu_fd_sc_mcu7t5v0__and2_1_15 vdd vss gf180mcu_fd_sc_mcu7t5v0__and2_1_15/Z gf180mcu_fd_sc_mcu7t5v0__dffq_4_4/Q
+ gf180mcu_fd_sc_mcu7t5v0__inv_2_0/I vdd vss gf180mcu_fd_sc_mcu7t5v0__and2_1
Xgf180mcu_fd_sc_mcu7t5v0__and2_1_26 vdd vss gf180mcu_fd_sc_mcu7t5v0__and2_1_26/Z gf180mcu_fd_sc_mcu7t5v0__dffq_2_9/Q
+ gf180mcu_fd_sc_mcu7t5v0__and2_2_6/Z vdd vss gf180mcu_fd_sc_mcu7t5v0__and2_1
Xgf180mcu_fd_sc_mcu7t5v0__and2_1_37 vdd vss gf180mcu_fd_sc_mcu7t5v0__and2_1_37/Z gf180mcu_fd_sc_mcu7t5v0__inv_8_1/I
+ gf180mcu_fd_sc_mcu7t5v0__xor2_1_74/Z vdd vss gf180mcu_fd_sc_mcu7t5v0__and2_1
Xgf180mcu_fd_sc_mcu7t5v0__and2_1_48 vdd vss gf180mcu_fd_sc_mcu7t5v0__aoi21_4_5/B gf180mcu_fd_sc_mcu7t5v0__dffq_1_302/Q
+ gf180mcu_fd_sc_mcu7t5v0__nor3_2_3/ZN vdd vss gf180mcu_fd_sc_mcu7t5v0__and2_1
Xgf180mcu_fd_sc_mcu7t5v0__and2_1_59 vdd vss gf180mcu_fd_sc_mcu7t5v0__and2_1_59/Z gf180mcu_fd_sc_mcu7t5v0__nor4_1_0/A1
+ gf180mcu_fd_sc_mcu7t5v0__and2_1_52/Z vdd vss gf180mcu_fd_sc_mcu7t5v0__and2_1
Xgf180mcu_fd_sc_mcu7t5v0__oai21_1_180 vdd gf180mcu_fd_sc_mcu7t5v0__oai21_1_180/B gf180mcu_fd_sc_mcu7t5v0__mux4_4_16/Z
+ gf180mcu_fd_sc_mcu7t5v0__oai21_1_180/ZN gf180mcu_fd_sc_mcu7t5v0__dffq_4_37/Q vss
+ vdd vss gf180mcu_fd_sc_mcu7t5v0__oai21_1
Xgf180mcu_fd_sc_mcu7t5v0__oai21_1_191 vdd gf180mcu_fd_sc_mcu7t5v0__buf_8_7/Z gf180mcu_fd_sc_mcu7t5v0__dffq_1_396/Q
+ gf180mcu_fd_sc_mcu7t5v0__aoi21_1_208/B gf180mcu_fd_sc_mcu7t5v0__dffq_4_20/Q vss
+ vdd vss gf180mcu_fd_sc_mcu7t5v0__oai21_1
Xgf180mcu_fd_sc_mcu7t5v0__aoi211_1_16 gf180mcu_fd_sc_mcu7t5v0__nor3_4_3/ZN gf180mcu_fd_sc_mcu7t5v0__mux2_1_6/Z
+ vdd vss gf180mcu_fd_sc_mcu7t5v0__oai211_1_14/A2 gf180mcu_fd_sc_mcu7t5v0__inv_8_1/I
+ gf180mcu_fd_sc_mcu7t5v0__nor3_4_4/ZN vdd vss gf180mcu_fd_sc_mcu7t5v0__aoi211_1
Xgf180mcu_fd_sc_mcu7t5v0__aoi211_1_27 gf180mcu_fd_sc_mcu7t5v0__nor2_1_114/ZN gf180mcu_fd_sc_mcu7t5v0__or2_1_23/A1
+ vdd vss gf180mcu_fd_sc_mcu7t5v0__dffq_1_244/D gf180mcu_fd_sc_mcu7t5v0__nor2_1_236/A1
+ gf180mcu_fd_sc_mcu7t5v0__nor2_4_19/ZN vdd vss gf180mcu_fd_sc_mcu7t5v0__aoi211_1
Xgf180mcu_fd_sc_mcu7t5v0__aoi211_1_38 gf180mcu_fd_sc_mcu7t5v0__nor2_1_405/ZN gf180mcu_fd_sc_mcu7t5v0__or2_1_23/A1
+ vdd vss gf180mcu_fd_sc_mcu7t5v0__dffq_1_314/D gf180mcu_fd_sc_mcu7t5v0__nor2_1_411/A1
+ gf180mcu_fd_sc_mcu7t5v0__nor2_4_21/ZN vdd vss gf180mcu_fd_sc_mcu7t5v0__aoi211_1
Xgf180mcu_fd_sc_mcu7t5v0__aoi211_1_49 gf180mcu_fd_sc_mcu7t5v0__or3_4_0/A3 gf180mcu_fd_sc_mcu7t5v0__aoi211_1_49/C
+ vdd vss gf180mcu_fd_sc_mcu7t5v0__dffq_4_14/D gf180mcu_fd_sc_mcu7t5v0__or3_4_0/A1
+ gf180mcu_fd_sc_mcu7t5v0__or3_4_0/A2 vdd vss gf180mcu_fd_sc_mcu7t5v0__aoi211_1
Xgf180mcu_fd_sc_mcu7t5v0__clkinv_1_40 vdd vss gf180mcu_fd_sc_mcu7t5v0__dffq_1_30/Q
+ gf180mcu_fd_sc_mcu7t5v0__oai22_1_28/B2 vdd vss gf180mcu_fd_sc_mcu7t5v0__clkinv_1
Xgf180mcu_fd_sc_mcu7t5v0__clkinv_1_51 vdd vss gf180mcu_fd_sc_mcu7t5v0__dffq_1_40/Q
+ gf180mcu_fd_sc_mcu7t5v0__oai22_1_48/A1 vdd vss gf180mcu_fd_sc_mcu7t5v0__clkinv_1
Xgf180mcu_fd_sc_mcu7t5v0__clkinv_1_62 vdd vss gf180mcu_fd_sc_mcu7t5v0__dffq_1_77/Q
+ gf180mcu_fd_sc_mcu7t5v0__oai22_1_75/B2 vdd vss gf180mcu_fd_sc_mcu7t5v0__clkinv_1
Xgf180mcu_fd_sc_mcu7t5v0__clkinv_1_73 vdd vss gf180mcu_fd_sc_mcu7t5v0__dffq_1_64/Q
+ gf180mcu_fd_sc_mcu7t5v0__oai22_1_58/B2 vdd vss gf180mcu_fd_sc_mcu7t5v0__clkinv_1
Xgf180mcu_fd_sc_mcu7t5v0__aoi21_1_204 gf180mcu_fd_sc_mcu7t5v0__aoi21_1_204/B vdd vss
+ gf180mcu_fd_sc_mcu7t5v0__dffq_1_404/D gf180mcu_fd_sc_mcu7t5v0__nor3_4_15/ZN gf180mcu_fd_sc_mcu7t5v0__aoi22_4_7/ZN
+ vdd vss gf180mcu_fd_sc_mcu7t5v0__aoi21_1
Xgf180mcu_fd_sc_mcu7t5v0__clkinv_1_84 vdd vss gf180mcu_fd_sc_mcu7t5v0__dffq_1_75/Q
+ gf180mcu_fd_sc_mcu7t5v0__oai22_1_66/B2 vdd vss gf180mcu_fd_sc_mcu7t5v0__clkinv_1
Xgf180mcu_fd_sc_mcu7t5v0__aoi21_1_215 gf180mcu_fd_sc_mcu7t5v0__nor3_1_22/A3 vdd vss
+ gf180mcu_fd_sc_mcu7t5v0__nor4_1_4/A4 gf180mcu_fd_sc_mcu7t5v0__inv_1_11/I gf180mcu_fd_sc_mcu7t5v0__inv_1_12/ZN
+ vdd vss gf180mcu_fd_sc_mcu7t5v0__aoi21_1
Xgf180mcu_fd_sc_mcu7t5v0__clkinv_1_95 vdd vss gf180mcu_fd_sc_mcu7t5v0__dffq_1_262/Q
+ gf180mcu_fd_sc_mcu7t5v0__oai22_1_107/B2 vdd vss gf180mcu_fd_sc_mcu7t5v0__clkinv_1
Xgf180mcu_fd_sc_mcu7t5v0__aoi21_1_226 gf180mcu_fd_sc_mcu7t5v0__xnor2_1_44/A2 vdd vss
+ gf180mcu_fd_sc_mcu7t5v0__xor2_1_118/A2 gf180mcu_fd_sc_mcu7t5v0__oai31_1_15/B gf180mcu_fd_sc_mcu7t5v0__mux4_4_8/Z
+ vdd vss gf180mcu_fd_sc_mcu7t5v0__aoi21_1
Xgf180mcu_fd_sc_mcu7t5v0__aoi21_1_237 gf180mcu_fd_sc_mcu7t5v0__aoi21_1_237/B vdd vss
+ gf180mcu_fd_sc_mcu7t5v0__aoi211_1_77/C gf180mcu_fd_sc_mcu7t5v0__nor2_4_34/ZN gf180mcu_fd_sc_mcu7t5v0__xor3_1_91/Z
+ vdd vss gf180mcu_fd_sc_mcu7t5v0__aoi21_1
Xgf180mcu_fd_sc_mcu7t5v0__aoi21_1_248 gf180mcu_fd_sc_mcu7t5v0__nor2_1_280/ZN vdd vss
+ gf180mcu_fd_sc_mcu7t5v0__aoi221_1_43/C gf180mcu_fd_sc_mcu7t5v0__mux2_1_9/Z gf180mcu_fd_sc_mcu7t5v0__aoi21_1_249/ZN
+ vdd vss gf180mcu_fd_sc_mcu7t5v0__aoi21_1
Xgf180mcu_fd_sc_mcu7t5v0__aoi21_1_259 gf180mcu_fd_sc_mcu7t5v0__aoi21_1_259/B vdd vss
+ gf180mcu_fd_sc_mcu7t5v0__dffq_2_98/D gf180mcu_fd_sc_mcu7t5v0__nor2_2_31/A1 gf180mcu_fd_sc_mcu7t5v0__buf_20_0/Z
+ vdd vss gf180mcu_fd_sc_mcu7t5v0__aoi21_1
Xgf180mcu_fd_sc_mcu7t5v0__oai21_1_15 vdd gf180mcu_fd_sc_mcu7t5v0__or3_1_2/A3 gf180mcu_fd_sc_mcu7t5v0__or3_1_2/A2
+ gf180mcu_fd_sc_mcu7t5v0__nand3_1_9/A2 gf180mcu_fd_sc_mcu7t5v0__or3_1_2/A1 vss vdd
+ vss gf180mcu_fd_sc_mcu7t5v0__oai21_1
Xgf180mcu_fd_sc_mcu7t5v0__oai21_1_26 vdd gf180mcu_fd_sc_mcu7t5v0__oai21_1_26/B gf180mcu_fd_sc_mcu7t5v0__nor2_1_39/ZN
+ gf180mcu_fd_sc_mcu7t5v0__xor3_1_22/A2 gf180mcu_fd_sc_mcu7t5v0__xor3_1_23/A2 vss
+ vdd vss gf180mcu_fd_sc_mcu7t5v0__oai21_1
Xgf180mcu_fd_sc_mcu7t5v0__oai21_1_37 vdd gf180mcu_fd_sc_mcu7t5v0__buf_8_5/Z gf180mcu_fd_sc_mcu7t5v0__buf_20_0/Z
+ gf180mcu_fd_sc_mcu7t5v0__aoi21_1_76/B gf180mcu_fd_sc_mcu7t5v0__dffq_1_8/Q vss vdd
+ vss gf180mcu_fd_sc_mcu7t5v0__oai21_1
Xgf180mcu_fd_sc_mcu7t5v0__oai21_1_48 vdd gf180mcu_fd_sc_mcu7t5v0__oai21_1_48/B gf180mcu_fd_sc_mcu7t5v0__nor2_1_66/ZN
+ gf180mcu_fd_sc_mcu7t5v0__xor2_1_40/A1 gf180mcu_fd_sc_mcu7t5v0__xor3_1_58/A2 vss
+ vdd vss gf180mcu_fd_sc_mcu7t5v0__oai21_1
Xgf180mcu_fd_sc_mcu7t5v0__oai21_1_59 vdd gf180mcu_fd_sc_mcu7t5v0__nor4_2_0/A4 gf180mcu_fd_sc_mcu7t5v0__and2_1_28/Z
+ gf180mcu_fd_sc_mcu7t5v0__oai21_1_59/ZN gf180mcu_fd_sc_mcu7t5v0__or4_1_0/A3 vss vdd
+ vss gf180mcu_fd_sc_mcu7t5v0__oai21_1
Xgf180mcu_fd_sc_mcu7t5v0__and2_4_0 gf180mcu_fd_sc_mcu7t5v0__and2_4_0/A2 vdd vss gf180mcu_fd_sc_mcu7t5v0__and2_4_0/Z
+ gf180mcu_fd_sc_mcu7t5v0__and2_4_0/A1 vdd vss gf180mcu_fd_sc_mcu7t5v0__and2_4
Xgf180mcu_fd_sc_mcu7t5v0__aoi21_2_7 gf180mcu_fd_sc_mcu7t5v0__aoi21_2_7/B vdd vss gf180mcu_fd_sc_mcu7t5v0__xor3_1_82/A2
+ gf180mcu_fd_sc_mcu7t5v0__nor3_2_6/ZN gf180mcu_fd_sc_mcu7t5v0__aoi21_2_7/A2 vdd vss
+ gf180mcu_fd_sc_mcu7t5v0__aoi21_2
Xgf180mcu_fd_sc_mcu7t5v0__nand2_1_504 vdd vss gf180mcu_fd_sc_mcu7t5v0__nand2_1_504/ZN
+ gf180mcu_fd_sc_mcu7t5v0__xor2_2_3/A1 gf180mcu_fd_sc_mcu7t5v0__xor2_2_3/A2 vdd vss
+ gf180mcu_fd_sc_mcu7t5v0__nand2_1
Xgf180mcu_fd_sc_mcu7t5v0__nand2_1_515 vdd vss gf180mcu_fd_sc_mcu7t5v0__xor3_1_105/A2
+ gf180mcu_fd_sc_mcu7t5v0__inv_8_1/I gf180mcu_fd_sc_mcu7t5v0__mux4_4_7/Z vdd vss gf180mcu_fd_sc_mcu7t5v0__nand2_1
Xgf180mcu_fd_sc_mcu7t5v0__nand4_1_0 gf180mcu_fd_sc_mcu7t5v0__nand4_1_0/A3 gf180mcu_fd_sc_mcu7t5v0__nand4_1_0/A4
+ vdd vss gf180mcu_fd_sc_mcu7t5v0__oai211_1_0/B gf180mcu_fd_sc_mcu7t5v0__nor3_1_9/A1
+ gf180mcu_fd_sc_mcu7t5v0__nand4_1_0/A2 vdd vss gf180mcu_fd_sc_mcu7t5v0__nand4_1
Xgf180mcu_fd_sc_mcu7t5v0__nand2_1_526 vdd vss gf180mcu_fd_sc_mcu7t5v0__xnor2_1_54/A1
+ gf180mcu_fd_sc_mcu7t5v0__nand2_1_529/ZN gf180mcu_fd_sc_mcu7t5v0__nand2_1_528/A2
+ vdd vss gf180mcu_fd_sc_mcu7t5v0__nand2_1
Xgf180mcu_fd_sc_mcu7t5v0__nand2_1_537 vdd vss gf180mcu_fd_sc_mcu7t5v0__nand2_1_537/ZN
+ gf180mcu_fd_sc_mcu7t5v0__dffq_2_25/Q gf180mcu_fd_sc_mcu7t5v0__nor3_4_12/ZN vdd vss
+ gf180mcu_fd_sc_mcu7t5v0__nand2_1
Xgf180mcu_fd_sc_mcu7t5v0__nand2_1_548 vdd vss gf180mcu_fd_sc_mcu7t5v0__nand2_1_548/ZN
+ gf180mcu_fd_sc_mcu7t5v0__dffq_2_30/Q gf180mcu_fd_sc_mcu7t5v0__nor3_4_12/ZN vdd vss
+ gf180mcu_fd_sc_mcu7t5v0__nand2_1
Xgf180mcu_fd_sc_mcu7t5v0__nand2_1_559 vdd vss gf180mcu_fd_sc_mcu7t5v0__xnor2_1_56/A1
+ gf180mcu_fd_sc_mcu7t5v0__mux4_4_6/I0 gf180mcu_fd_sc_mcu7t5v0__nor2_2_52/ZN vdd vss
+ gf180mcu_fd_sc_mcu7t5v0__nand2_1
Xgf180mcu_fd_sc_mcu7t5v0__aoi21_2_17 gf180mcu_fd_sc_mcu7t5v0__dffq_4_35/Q vdd vss
+ gf180mcu_fd_sc_mcu7t5v0__aoi221_4_2/C gf180mcu_fd_sc_mcu7t5v0__inv_1_17/I gf180mcu_fd_sc_mcu7t5v0__inv_4_7/ZN
+ vdd vss gf180mcu_fd_sc_mcu7t5v0__aoi21_2
Xgf180mcu_fd_sc_mcu7t5v0__oai211_2_7 gf180mcu_fd_sc_mcu7t5v0__aoi21_4_6/ZN gf180mcu_fd_sc_mcu7t5v0__xnor3_1_33/A3
+ gf180mcu_fd_sc_mcu7t5v0__and2_1_111/Z gf180mcu_fd_sc_mcu7t5v0__or2_1_39/Z gf180mcu_fd_sc_mcu7t5v0__inv_8_0/I
+ vdd vss vdd vss gf180mcu_fd_sc_mcu7t5v0__oai211_2
Xgf180mcu_fd_sc_mcu7t5v0__or3_1_13 gf180mcu_fd_sc_mcu7t5v0__or3_1_13/A3 vdd vss gf180mcu_fd_sc_mcu7t5v0__or3_1_13/Z
+ gf180mcu_fd_sc_mcu7t5v0__inv_8_0/ZN gf180mcu_fd_sc_mcu7t5v0__inv_1_13/I vdd vss
+ gf180mcu_fd_sc_mcu7t5v0__or3_1
Xgf180mcu_fd_sc_mcu7t5v0__or3_1_24 gf180mcu_fd_sc_mcu7t5v0__or3_1_24/A3 vdd vss gf180mcu_fd_sc_mcu7t5v0__or3_1_24/Z
+ gf180mcu_fd_sc_mcu7t5v0__or3_1_24/A1 gf180mcu_fd_sc_mcu7t5v0__or3_1_24/A2 vdd vss
+ gf180mcu_fd_sc_mcu7t5v0__or3_1
Xgf180mcu_fd_sc_mcu7t5v0__nor3_4_13 gf180mcu_fd_sc_mcu7t5v0__nor4_4_1/A1 vdd vss gf180mcu_fd_sc_mcu7t5v0__nor3_4_13/ZN
+ gf180mcu_fd_sc_mcu7t5v0__dffq_2_34/Q gf180mcu_fd_sc_mcu7t5v0__inv_1_8/I vdd vss
+ gf180mcu_fd_sc_mcu7t5v0__nor3_4
Xgf180mcu_fd_sc_mcu7t5v0__tiel_8 uart_tx_PDRV1 vdd vss vdd vss gf180mcu_fd_sc_mcu7t5v0__tiel
Xgf180mcu_fd_sc_mcu7t5v0__nor2_1_108 vdd vss gf180mcu_fd_sc_mcu7t5v0__nor2_1_108/ZN
+ gf180mcu_fd_sc_mcu7t5v0__dffq_1_246/Q gf180mcu_fd_sc_mcu7t5v0__nor2_4_21/ZN vdd
+ vss gf180mcu_fd_sc_mcu7t5v0__nor2_1
Xgf180mcu_fd_sc_mcu7t5v0__nor2_1_119 vdd vss gf180mcu_fd_sc_mcu7t5v0__nor2_1_119/ZN
+ gf180mcu_fd_sc_mcu7t5v0__dffq_1_247/Q gf180mcu_fd_sc_mcu7t5v0__nor2_4_21/ZN vdd
+ vss gf180mcu_fd_sc_mcu7t5v0__nor2_1
Xgf180mcu_fd_sc_mcu7t5v0__xor3_1_109 gf180mcu_fd_sc_mcu7t5v0__xor3_2_1/Z vdd vss gf180mcu_fd_sc_mcu7t5v0__xor3_1_109/Z
+ gf180mcu_fd_sc_mcu7t5v0__inv_2_13/I gf180mcu_fd_sc_mcu7t5v0__and2_1_122/Z vdd vss
+ gf180mcu_fd_sc_mcu7t5v0__xor3_1
Xgf180mcu_fd_sc_mcu7t5v0__nand2_1_301 vdd vss gf180mcu_fd_sc_mcu7t5v0__oai31_1_8/A2
+ gf180mcu_fd_sc_mcu7t5v0__inv_8_0/I gf180mcu_fd_sc_mcu7t5v0__mux4_4_2/Z vdd vss gf180mcu_fd_sc_mcu7t5v0__nand2_1
Xgf180mcu_fd_sc_mcu7t5v0__nand2_1_312 vdd vss gf180mcu_fd_sc_mcu7t5v0__aoi21_1_213/B
+ gf180mcu_fd_sc_mcu7t5v0__aoi22_4_8/ZN gf180mcu_fd_sc_mcu7t5v0__nand2_1_313/ZN vdd
+ vss gf180mcu_fd_sc_mcu7t5v0__nand2_1
Xgf180mcu_fd_sc_mcu7t5v0__nand2_1_323 vdd vss gf180mcu_fd_sc_mcu7t5v0__nand2_1_323/ZN
+ gf180mcu_fd_sc_mcu7t5v0__dffq_2_111/Q gf180mcu_fd_sc_mcu7t5v0__nor3_4_12/ZN vdd
+ vss gf180mcu_fd_sc_mcu7t5v0__nand2_1
Xgf180mcu_fd_sc_mcu7t5v0__nand2_1_334 vdd vss gf180mcu_fd_sc_mcu7t5v0__oai21_4_9/B
+ gf180mcu_fd_sc_mcu7t5v0__nand2_1_334/A1 gf180mcu_fd_sc_mcu7t5v0__or3_4_0/Z vdd vss
+ gf180mcu_fd_sc_mcu7t5v0__nand2_1
Xgf180mcu_fd_sc_mcu7t5v0__nand2_1_345 vdd vss gf180mcu_fd_sc_mcu7t5v0__nand3_1_54/A3
+ gf180mcu_fd_sc_mcu7t5v0__or2_1_21/A1 gf180mcu_fd_sc_mcu7t5v0__and3_1_9/Z vdd vss
+ gf180mcu_fd_sc_mcu7t5v0__nand2_1
Xgf180mcu_fd_sc_mcu7t5v0__nand2_1_356 vdd vss gf180mcu_fd_sc_mcu7t5v0__nand2_1_356/ZN
+ gf180mcu_fd_sc_mcu7t5v0__dffq_2_33/Q gf180mcu_fd_sc_mcu7t5v0__inv_2_8/ZN vdd vss
+ gf180mcu_fd_sc_mcu7t5v0__nand2_1
Xgf180mcu_fd_sc_mcu7t5v0__nand2_1_367 vdd vss gf180mcu_fd_sc_mcu7t5v0__nor2_1_206/A1
+ gf180mcu_fd_sc_mcu7t5v0__buf_8_8/Z gf180mcu_fd_sc_mcu7t5v0__aoi22_4_8/B1 vdd vss
+ gf180mcu_fd_sc_mcu7t5v0__nand2_1
Xgf180mcu_fd_sc_mcu7t5v0__nand2_1_378 vdd vss gf180mcu_fd_sc_mcu7t5v0__nand2_1_387/A1
+ gf180mcu_fd_sc_mcu7t5v0__mux4_4_5/I0 gf180mcu_fd_sc_mcu7t5v0__xor2_1_97/A2 vdd vss
+ gf180mcu_fd_sc_mcu7t5v0__nand2_1
Xgf180mcu_fd_sc_mcu7t5v0__nand2_1_389 vdd vss gf180mcu_fd_sc_mcu7t5v0__xor3_1_73/A2
+ gf180mcu_fd_sc_mcu7t5v0__nor3_2_5/ZN gf180mcu_fd_sc_mcu7t5v0__xor3_1_72/Z vdd vss
+ gf180mcu_fd_sc_mcu7t5v0__nand2_1
Xgf180mcu_fd_sc_mcu7t5v0__dffq_1_420 vdd gf180mcu_fd_sc_mcu7t5v0__dffq_1_420/Q gf180mcu_fd_sc_mcu7t5v0__dffq_4_1/CLK
+ vss gf180mcu_fd_sc_mcu7t5v0__dffq_1_420/D vdd vss gf180mcu_fd_sc_mcu7t5v0__dffq_1
Xgf180mcu_fd_sc_mcu7t5v0__dffq_1_431 vdd gf180mcu_fd_sc_mcu7t5v0__dffq_1_431/Q gf180mcu_fd_sc_mcu7t5v0__dffq_4_44/CLK
+ vss gf180mcu_fd_sc_mcu7t5v0__dffq_1_431/D vdd vss gf180mcu_fd_sc_mcu7t5v0__dffq_1
Xgf180mcu_fd_sc_mcu7t5v0__dffq_1_442 vdd gf180mcu_fd_sc_mcu7t5v0__dffq_1_442/Q gf180mcu_fd_sc_mcu7t5v0__dffq_4_44/CLK
+ vss gf180mcu_fd_sc_mcu7t5v0__dffq_1_442/D vdd vss gf180mcu_fd_sc_mcu7t5v0__dffq_1
Xgf180mcu_fd_sc_mcu7t5v0__dffq_1_453 vdd gf180mcu_fd_sc_mcu7t5v0__xor2_1_92/A1 gf180mcu_fd_sc_mcu7t5v0__dffq_4_15/CLK
+ vss gf180mcu_fd_sc_mcu7t5v0__dffq_1_453/D vdd vss gf180mcu_fd_sc_mcu7t5v0__dffq_1
Xgf180mcu_fd_sc_mcu7t5v0__clkinv_1_303 vdd vss gf180mcu_fd_sc_mcu7t5v0__dffq_1_336/Q
+ gf180mcu_fd_sc_mcu7t5v0__aoi21_1_162/A1 vdd vss gf180mcu_fd_sc_mcu7t5v0__clkinv_1
Xgf180mcu_fd_sc_mcu7t5v0__clkinv_1_314 vdd vss gf180mcu_fd_sc_mcu7t5v0__dffq_1_366/Q
+ gf180mcu_fd_sc_mcu7t5v0__nand4_4_2/A1 vdd vss gf180mcu_fd_sc_mcu7t5v0__clkinv_1
Xgf180mcu_fd_sc_mcu7t5v0__clkinv_1_325 vdd vss gf180mcu_fd_sc_mcu7t5v0__xor2_1_216/A2
+ gf180mcu_fd_sc_mcu7t5v0__oai21_1_336/A2 vdd vss gf180mcu_fd_sc_mcu7t5v0__clkinv_1
Xgf180mcu_fd_sc_mcu7t5v0__clkinv_1_336 vdd vss gf180mcu_fd_sc_mcu7t5v0__xor3_1_156/A1
+ gf180mcu_fd_sc_mcu7t5v0__oai32_1_10/A1 vdd vss gf180mcu_fd_sc_mcu7t5v0__clkinv_1
Xgf180mcu_fd_sc_mcu7t5v0__clkinv_1_347 vdd vss gf180mcu_fd_sc_mcu7t5v0__mux4_4_6/I0
+ gf180mcu_fd_sc_mcu7t5v0__nor3_2_11/A1 vdd vss gf180mcu_fd_sc_mcu7t5v0__clkinv_1
Xgf180mcu_fd_sc_mcu7t5v0__clkinv_1_358 vdd vss gf180mcu_fd_sc_mcu7t5v0__dffq_2_93/Q
+ gf180mcu_fd_sc_mcu7t5v0__nand2_1_651/A2 vdd vss gf180mcu_fd_sc_mcu7t5v0__clkinv_1
Xgf180mcu_fd_sc_mcu7t5v0__nand2_4_1 vdd vss gf180mcu_fd_sc_mcu7t5v0__nand3_1_1/A3
+ gf180mcu_fd_sc_mcu7t5v0__nand2_4_1/A1 gf180mcu_fd_sc_mcu7t5v0__nand2_4_1/A2 vdd
+ vss gf180mcu_fd_sc_mcu7t5v0__nand2_4
Xgf180mcu_fd_sc_mcu7t5v0__nand2_4_11 vdd vss gf180mcu_fd_sc_mcu7t5v0__oai22_1_97/B1
+ gf180mcu_fd_sc_mcu7t5v0__buf_8_2/Z gf180mcu_fd_sc_mcu7t5v0__oai22_1_97/A2 vdd vss
+ gf180mcu_fd_sc_mcu7t5v0__nand2_4
Xgf180mcu_fd_sc_mcu7t5v0__nand2_4_22 vdd vss gf180mcu_fd_sc_mcu7t5v0__nand2_4_22/ZN
+ gf180mcu_fd_sc_mcu7t5v0__nor3_4_9/ZN gf180mcu_fd_sc_mcu7t5v0__nor2_4_5/ZN vdd vss
+ gf180mcu_fd_sc_mcu7t5v0__nand2_4
Xgf180mcu_fd_sc_mcu7t5v0__nand2_4_33 vdd vss gf180mcu_fd_sc_mcu7t5v0__oai22_1_43/A2
+ gf180mcu_fd_sc_mcu7t5v0__nor3_4_7/ZN gf180mcu_fd_sc_mcu7t5v0__nor2_4_6/ZN vdd vss
+ gf180mcu_fd_sc_mcu7t5v0__nand2_4
Xgf180mcu_fd_sc_mcu7t5v0__nand2_4_44 vdd vss gf180mcu_fd_sc_mcu7t5v0__aoi21_1_7/B
+ gf180mcu_fd_sc_mcu7t5v0__buf_8_4/Z gf180mcu_fd_sc_mcu7t5v0__buf_20_0/I vdd vss gf180mcu_fd_sc_mcu7t5v0__nand2_4
Xgf180mcu_fd_sc_mcu7t5v0__clkinv_3_19 vdd gf180mcu_fd_sc_mcu7t5v0__nor3_4_22/A3 gf180mcu_fd_sc_mcu7t5v0__dffq_2_87/Q
+ vss vdd vss gf180mcu_fd_sc_mcu7t5v0__clkinv_3
Xgf180mcu_fd_sc_mcu7t5v0__nor4_1_1 gf180mcu_fd_sc_mcu7t5v0__nor4_1_1/A3 gf180mcu_fd_sc_mcu7t5v0__nor4_1_1/A4
+ vdd vss gf180mcu_fd_sc_mcu7t5v0__nor4_1_1/ZN gf180mcu_fd_sc_mcu7t5v0__nor4_1_1/A1
+ gf180mcu_fd_sc_mcu7t5v0__nor4_1_1/A2 vdd vss gf180mcu_fd_sc_mcu7t5v0__nor4_1
Xgf180mcu_fd_sc_mcu7t5v0__dffq_4_5 gf180mcu_fd_sc_mcu7t5v0__dffq_4_5/D gf180mcu_fd_sc_mcu7t5v0__inv_2_0/I
+ vdd vss gf180mcu_fd_sc_mcu7t5v0__dffq_4_6/CLK vdd vss gf180mcu_fd_sc_mcu7t5v0__dffq_4
Xgf180mcu_fd_sc_mcu7t5v0__nand2_1_120 vdd vss gf180mcu_fd_sc_mcu7t5v0__xor3_1_42/A2
+ gf180mcu_fd_sc_mcu7t5v0__nand3_1_20/ZN gf180mcu_fd_sc_mcu7t5v0__nand3_1_19/ZN vdd
+ vss gf180mcu_fd_sc_mcu7t5v0__nand2_1
Xgf180mcu_fd_sc_mcu7t5v0__nand2_1_131 vdd vss gf180mcu_fd_sc_mcu7t5v0__oai21_1_9/B
+ gf180mcu_fd_sc_mcu7t5v0__mux2_1_2/Z gf180mcu_fd_sc_mcu7t5v0__aoi21_1_13/ZN vdd vss
+ gf180mcu_fd_sc_mcu7t5v0__nand2_1
Xgf180mcu_fd_sc_mcu7t5v0__nand2_1_142 vdd vss gf180mcu_fd_sc_mcu7t5v0__xor3_1_48/A2
+ gf180mcu_fd_sc_mcu7t5v0__inv_8_1/I gf180mcu_fd_sc_mcu7t5v0__nor4_2_2/A4 vdd vss
+ gf180mcu_fd_sc_mcu7t5v0__nand2_1
Xgf180mcu_fd_sc_mcu7t5v0__nand2_1_153 vdd vss gf180mcu_fd_sc_mcu7t5v0__or2_1_15/A1
+ gf180mcu_fd_sc_mcu7t5v0__nor3_2_5/A1 gf180mcu_fd_sc_mcu7t5v0__mux4_4_6/Z vdd vss
+ gf180mcu_fd_sc_mcu7t5v0__nand2_1
Xgf180mcu_fd_sc_mcu7t5v0__nand2_1_164 vdd vss gf180mcu_fd_sc_mcu7t5v0__xor3_1_55/A2
+ gf180mcu_fd_sc_mcu7t5v0__inv_4_6/I gf180mcu_fd_sc_mcu7t5v0__or4_1_1/A2 vdd vss gf180mcu_fd_sc_mcu7t5v0__nand2_1
Xgf180mcu_fd_sc_mcu7t5v0__nand2_1_175 vdd vss gf180mcu_fd_sc_mcu7t5v0__xor3_1_56/A3
+ gf180mcu_fd_sc_mcu7t5v0__nand2_1_175/A1 gf180mcu_fd_sc_mcu7t5v0__nand2_1_96/ZN vdd
+ vss gf180mcu_fd_sc_mcu7t5v0__nand2_1
Xgf180mcu_fd_sc_mcu7t5v0__nand2_1_186 vdd vss gf180mcu_fd_sc_mcu7t5v0__nand4_1_5/A1
+ gf180mcu_fd_sc_mcu7t5v0__nor2_2_10/ZN gf180mcu_fd_sc_mcu7t5v0__xor2_1_37/Z vdd vss
+ gf180mcu_fd_sc_mcu7t5v0__nand2_1
Xgf180mcu_fd_sc_mcu7t5v0__nand2_1_197 vdd vss gf180mcu_fd_sc_mcu7t5v0__aoi21_2_2/A2
+ gf180mcu_fd_sc_mcu7t5v0__nor2_1_57/A1 gf180mcu_fd_sc_mcu7t5v0__xor3_1_39/Z vdd vss
+ gf180mcu_fd_sc_mcu7t5v0__nand2_1
Xgf180mcu_fd_sc_mcu7t5v0__dffq_1_250 vdd gf180mcu_fd_sc_mcu7t5v0__dffq_1_250/Q gf180mcu_fd_sc_mcu7t5v0__dffq_4_8/CLK
+ vss gf180mcu_fd_sc_mcu7t5v0__dffq_1_250/D vdd vss gf180mcu_fd_sc_mcu7t5v0__dffq_1
Xgf180mcu_fd_sc_mcu7t5v0__dffq_1_261 vdd gf180mcu_fd_sc_mcu7t5v0__dffq_1_261/Q gf180mcu_fd_sc_mcu7t5v0__dffq_1_96/CLK
+ vss gf180mcu_fd_sc_mcu7t5v0__dffq_1_261/D vdd vss gf180mcu_fd_sc_mcu7t5v0__dffq_1
Xgf180mcu_fd_sc_mcu7t5v0__dffq_1_272 vdd gf180mcu_fd_sc_mcu7t5v0__dffq_1_272/Q gf180mcu_fd_sc_mcu7t5v0__dffq_1_99/CLK
+ vss gf180mcu_fd_sc_mcu7t5v0__dffq_1_272/D vdd vss gf180mcu_fd_sc_mcu7t5v0__dffq_1
Xgf180mcu_fd_sc_mcu7t5v0__dffq_1_283 vdd gf180mcu_fd_sc_mcu7t5v0__dffq_1_283/Q gf180mcu_fd_sc_mcu7t5v0__dffq_4_9/CLK
+ vss gf180mcu_fd_sc_mcu7t5v0__dffq_1_283/D vdd vss gf180mcu_fd_sc_mcu7t5v0__dffq_1
Xgf180mcu_fd_sc_mcu7t5v0__oai211_2_12 gf180mcu_fd_sc_mcu7t5v0__oai31_4_4/ZN gf180mcu_fd_sc_mcu7t5v0__xnor3_1_22/A2
+ gf180mcu_fd_sc_mcu7t5v0__aoi21_4_9/ZN gf180mcu_fd_sc_mcu7t5v0__oai21_4_12/B gf180mcu_fd_sc_mcu7t5v0__inv_8_1/I
+ vdd vss vdd vss gf180mcu_fd_sc_mcu7t5v0__oai211_2
Xgf180mcu_fd_sc_mcu7t5v0__dffq_1_294 vdd gf180mcu_fd_sc_mcu7t5v0__dffq_1_294/Q gf180mcu_fd_sc_mcu7t5v0__dffq_4_9/CLK
+ vss gf180mcu_fd_sc_mcu7t5v0__dffq_1_294/D vdd vss gf180mcu_fd_sc_mcu7t5v0__dffq_1
Xgf180mcu_fd_sc_mcu7t5v0__nand3_2_9 gf180mcu_fd_sc_mcu7t5v0__or3_2_0/A1 vdd vss gf180mcu_fd_sc_mcu7t5v0__oai21_4_3/B
+ gf180mcu_fd_sc_mcu7t5v0__or2_4_0/A1 gf180mcu_fd_sc_mcu7t5v0__or2_4_0/A2 vdd vss
+ gf180mcu_fd_sc_mcu7t5v0__nand3_2
Xgf180mcu_fd_sc_mcu7t5v0__xor2_1_108 vdd vss gf180mcu_fd_sc_mcu7t5v0__xor2_1_108/Z
+ gf180mcu_fd_sc_mcu7t5v0__xor2_1_108/A1 gf180mcu_fd_sc_mcu7t5v0__xor2_1_108/A2 vdd
+ vss gf180mcu_fd_sc_mcu7t5v0__xor2_1
Xgf180mcu_fd_sc_mcu7t5v0__xor2_1_119 vdd vss gf180mcu_fd_sc_mcu7t5v0__xor2_1_119/Z
+ gf180mcu_fd_sc_mcu7t5v0__mux4_4_9/Z gf180mcu_fd_sc_mcu7t5v0__xor2_1_119/A2 vdd vss
+ gf180mcu_fd_sc_mcu7t5v0__xor2_1
Xgf180mcu_fd_sc_mcu7t5v0__clkinv_1_100 vdd vss gf180mcu_fd_sc_mcu7t5v0__dffq_1_272/Q
+ gf180mcu_fd_sc_mcu7t5v0__oai22_1_86/B2 vdd vss gf180mcu_fd_sc_mcu7t5v0__clkinv_1
Xgf180mcu_fd_sc_mcu7t5v0__nor3_1_14 gf180mcu_fd_sc_mcu7t5v0__and2_1_60/Z vdd vss gf180mcu_fd_sc_mcu7t5v0__nor3_1_14/ZN
+ gf180mcu_fd_sc_mcu7t5v0__oai31_4_2/ZN gf180mcu_fd_sc_mcu7t5v0__nor3_1_14/A2 vdd
+ vss gf180mcu_fd_sc_mcu7t5v0__nor3_1
Xgf180mcu_fd_sc_mcu7t5v0__clkinv_1_111 vdd vss gf180mcu_fd_sc_mcu7t5v0__dffq_1_80/Q
+ gf180mcu_fd_sc_mcu7t5v0__oai22_1_102/B2 vdd vss gf180mcu_fd_sc_mcu7t5v0__clkinv_1
Xgf180mcu_fd_sc_mcu7t5v0__clkinv_1_122 vdd vss gf180mcu_fd_sc_mcu7t5v0__dffq_1_110/Q
+ gf180mcu_fd_sc_mcu7t5v0__oai22_1_116/B2 vdd vss gf180mcu_fd_sc_mcu7t5v0__clkinv_1
Xgf180mcu_fd_sc_mcu7t5v0__nor3_1_25 gf180mcu_fd_sc_mcu7t5v0__nor3_1_25/A3 vdd vss
+ gf180mcu_fd_sc_mcu7t5v0__or3_1_15/A2 gf180mcu_fd_sc_mcu7t5v0__xor3_1_73/A2 gf180mcu_fd_sc_mcu7t5v0__xor2_1_99/Z
+ vdd vss gf180mcu_fd_sc_mcu7t5v0__nor3_1
Xgf180mcu_fd_sc_mcu7t5v0__nor3_1_36 gf180mcu_fd_sc_mcu7t5v0__oai32_4_0/ZN vdd vss
+ gf180mcu_fd_sc_mcu7t5v0__nor3_1_36/ZN gf180mcu_fd_sc_mcu7t5v0__nor3_2_5/A1 gf180mcu_fd_sc_mcu7t5v0__nor3_1_36/A2
+ vdd vss gf180mcu_fd_sc_mcu7t5v0__nor3_1
Xgf180mcu_fd_sc_mcu7t5v0__dffq_1_60 vdd gf180mcu_fd_sc_mcu7t5v0__dffq_1_60/Q gf180mcu_fd_sc_mcu7t5v0__dffq_1_95/CLK
+ vss gf180mcu_fd_sc_mcu7t5v0__dffq_1_60/D vdd vss gf180mcu_fd_sc_mcu7t5v0__dffq_1
Xgf180mcu_fd_sc_mcu7t5v0__clkinv_1_133 vdd vss gf180mcu_fd_sc_mcu7t5v0__dffq_1_117/Q
+ gf180mcu_fd_sc_mcu7t5v0__oai22_1_126/B2 vdd vss gf180mcu_fd_sc_mcu7t5v0__clkinv_1
Xgf180mcu_fd_sc_mcu7t5v0__dffq_1_71 vdd gf180mcu_fd_sc_mcu7t5v0__dffq_1_71/Q gf180mcu_fd_sc_mcu7t5v0__dffq_1_95/CLK
+ vss gf180mcu_fd_sc_mcu7t5v0__dffq_1_71/D vdd vss gf180mcu_fd_sc_mcu7t5v0__dffq_1
Xgf180mcu_fd_sc_mcu7t5v0__clkinv_1_144 vdd vss gf180mcu_fd_sc_mcu7t5v0__dffq_1_126/Q
+ gf180mcu_fd_sc_mcu7t5v0__oai22_1_133/B2 vdd vss gf180mcu_fd_sc_mcu7t5v0__clkinv_1
Xgf180mcu_fd_sc_mcu7t5v0__clkinv_1_155 vdd vss gf180mcu_fd_sc_mcu7t5v0__dffq_1_119/Q
+ gf180mcu_fd_sc_mcu7t5v0__oai22_1_131/B2 vdd vss gf180mcu_fd_sc_mcu7t5v0__clkinv_1
Xgf180mcu_fd_sc_mcu7t5v0__clkinv_1_166 vdd vss gf180mcu_fd_sc_mcu7t5v0__dffq_1_150/Q
+ gf180mcu_fd_sc_mcu7t5v0__oai22_1_154/B2 vdd vss gf180mcu_fd_sc_mcu7t5v0__clkinv_1
Xgf180mcu_fd_sc_mcu7t5v0__dffq_1_82 vdd gf180mcu_fd_sc_mcu7t5v0__dffq_1_82/Q gf180mcu_fd_sc_mcu7t5v0__dffq_1_99/CLK
+ vss gf180mcu_fd_sc_mcu7t5v0__dffq_1_82/D vdd vss gf180mcu_fd_sc_mcu7t5v0__dffq_1
Xgf180mcu_fd_sc_mcu7t5v0__dffq_1_93 vdd gf180mcu_fd_sc_mcu7t5v0__dffq_1_93/Q gf180mcu_fd_sc_mcu7t5v0__dffq_1_99/CLK
+ vss gf180mcu_fd_sc_mcu7t5v0__dffq_1_93/D vdd vss gf180mcu_fd_sc_mcu7t5v0__dffq_1
Xgf180mcu_fd_sc_mcu7t5v0__clkinv_1_177 vdd vss gf180mcu_fd_sc_mcu7t5v0__dffq_1_160/Q
+ gf180mcu_fd_sc_mcu7t5v0__oai22_1_160/B2 vdd vss gf180mcu_fd_sc_mcu7t5v0__clkinv_1
Xgf180mcu_fd_sc_mcu7t5v0__clkinv_1_188 vdd vss gf180mcu_fd_sc_mcu7t5v0__dffq_1_166/Q
+ gf180mcu_fd_sc_mcu7t5v0__oai22_1_172/B2 vdd vss gf180mcu_fd_sc_mcu7t5v0__clkinv_1
Xgf180mcu_fd_sc_mcu7t5v0__clkinv_1_199 vdd vss gf180mcu_fd_sc_mcu7t5v0__dffq_1_173/Q
+ gf180mcu_fd_sc_mcu7t5v0__oai22_1_190/B2 vdd vss gf180mcu_fd_sc_mcu7t5v0__clkinv_1
Xgf180mcu_fd_sc_mcu7t5v0__aoi211_1_2 gf180mcu_fd_sc_mcu7t5v0__nor2_1_23/ZN gf180mcu_fd_sc_mcu7t5v0__or2_4_4/Z
+ vdd vss gf180mcu_fd_sc_mcu7t5v0__nor2_1_28/A1 gf180mcu_fd_sc_mcu7t5v0__nor3_1_9/A1
+ gf180mcu_fd_sc_mcu7t5v0__oai211_1_3/ZN vdd vss gf180mcu_fd_sc_mcu7t5v0__aoi211_1
Xgf180mcu_fd_sc_mcu7t5v0__tiel_11 uart_tx_IE vdd vss vdd vss gf180mcu_fd_sc_mcu7t5v0__tiel
Xgf180mcu_fd_sc_mcu7t5v0__dffq_2_2 gf180mcu_fd_sc_mcu7t5v0__dffq_2_2/D vdd vss gf180mcu_fd_sc_mcu7t5v0__dffq_4_6/CLK
+ gf180mcu_fd_sc_mcu7t5v0__inv_1_1/I vdd vss gf180mcu_fd_sc_mcu7t5v0__dffq_2
Xgf180mcu_fd_sc_mcu7t5v0__oai22_1_160 gf180mcu_fd_sc_mcu7t5v0__nand2_4_20/ZN gf180mcu_fd_sc_mcu7t5v0__nand2_2_27/ZN
+ gf180mcu_fd_sc_mcu7t5v0__oai22_1_160/B2 vdd vss gf180mcu_fd_sc_mcu7t5v0__dffq_1_160/D
+ gf180mcu_fd_sc_mcu7t5v0__aoi21_4_2/ZN vdd vss gf180mcu_fd_sc_mcu7t5v0__oai22_1
Xgf180mcu_fd_sc_mcu7t5v0__oai22_1_171 gf180mcu_fd_sc_mcu7t5v0__nand2_4_23/ZN gf180mcu_fd_sc_mcu7t5v0__nand2_2_30/ZN
+ gf180mcu_fd_sc_mcu7t5v0__oai22_1_171/B2 vdd vss gf180mcu_fd_sc_mcu7t5v0__dffq_1_191/D
+ gf180mcu_fd_sc_mcu7t5v0__aoi21_4_1/ZN vdd vss gf180mcu_fd_sc_mcu7t5v0__oai22_1
Xgf180mcu_fd_sc_mcu7t5v0__oai22_1_182 gf180mcu_fd_sc_mcu7t5v0__nand2_4_36/ZN gf180mcu_fd_sc_mcu7t5v0__nand2_2_31/ZN
+ gf180mcu_fd_sc_mcu7t5v0__oai22_1_182/B2 vdd vss gf180mcu_fd_sc_mcu7t5v0__dffq_1_456/D
+ gf180mcu_fd_sc_mcu7t5v0__oai22_1_98/A1 vdd vss gf180mcu_fd_sc_mcu7t5v0__oai22_1
Xgf180mcu_fd_sc_mcu7t5v0__oai22_1_193 gf180mcu_fd_sc_mcu7t5v0__nand2_4_15/ZN gf180mcu_fd_sc_mcu7t5v0__nand2_2_21/ZN
+ gf180mcu_fd_sc_mcu7t5v0__oai22_1_193/B2 vdd vss gf180mcu_fd_sc_mcu7t5v0__dffq_1_178/D
+ gf180mcu_fd_sc_mcu7t5v0__oai22_1_88/A1 vdd vss gf180mcu_fd_sc_mcu7t5v0__oai22_1
Xgf180mcu_fd_sc_mcu7t5v0__xnor3_1_10 gf180mcu_fd_sc_mcu7t5v0__xor2_1_32/Z vdd vss
+ gf180mcu_fd_sc_mcu7t5v0__nor2_1_9/A2 gf180mcu_fd_sc_mcu7t5v0__xnor2_1_7/A1 gf180mcu_fd_sc_mcu7t5v0__xor2_1_19/Z
+ vdd vss gf180mcu_fd_sc_mcu7t5v0__xnor3_1
Xgf180mcu_fd_sc_mcu7t5v0__xnor3_1_21 gf180mcu_fd_sc_mcu7t5v0__nor3_1_25/A3 vdd vss
+ gf180mcu_fd_sc_mcu7t5v0__xor2_1_98/A2 gf180mcu_fd_sc_mcu7t5v0__mux4_4_0/I0 gf180mcu_fd_sc_mcu7t5v0__xnor3_1_21/A2
+ vdd vss gf180mcu_fd_sc_mcu7t5v0__xnor3_1
Xgf180mcu_fd_sc_mcu7t5v0__xnor3_1_32 gf180mcu_fd_sc_mcu7t5v0__xor2_1_142/Z vdd vss
+ gf180mcu_fd_sc_mcu7t5v0__xnor3_1_32/ZN gf180mcu_fd_sc_mcu7t5v0__xnor3_1_32/A1 gf180mcu_fd_sc_mcu7t5v0__xnor3_1_32/A2
+ vdd vss gf180mcu_fd_sc_mcu7t5v0__xnor3_1
Xgf180mcu_fd_sc_mcu7t5v0__xnor3_1_43 gf180mcu_fd_sc_mcu7t5v0__xnor3_1_43/A3 vdd vss
+ gf180mcu_fd_sc_mcu7t5v0__xnor3_1_43/ZN gf180mcu_fd_sc_mcu7t5v0__xnor3_1_43/A1 gf180mcu_fd_sc_mcu7t5v0__xnor3_1_43/A2
+ vdd vss gf180mcu_fd_sc_mcu7t5v0__xnor3_1
Xgf180mcu_fd_sc_mcu7t5v0__aoi221_1_18 gf180mcu_fd_sc_mcu7t5v0__dffq_2_33/Q gf180mcu_fd_sc_mcu7t5v0__nor2_1_154/ZN
+ vdd vss gf180mcu_fd_sc_mcu7t5v0__nor2_1_157/A2 gf180mcu_fd_sc_mcu7t5v0__dffq_1_299/Q
+ gf180mcu_fd_sc_mcu7t5v0__or2_4_3/Z gf180mcu_fd_sc_mcu7t5v0__nor2_4_32/ZN vdd vss
+ gf180mcu_fd_sc_mcu7t5v0__aoi221_1
Xgf180mcu_fd_sc_mcu7t5v0__aoi221_1_29 gf180mcu_fd_sc_mcu7t5v0__nor2_2_22/ZN gf180mcu_fd_sc_mcu7t5v0__nor2_4_30/ZN
+ vdd vss gf180mcu_fd_sc_mcu7t5v0__oai211_1_23/C gf180mcu_fd_sc_mcu7t5v0__inv_8_1/I
+ gf180mcu_fd_sc_mcu7t5v0__nor2_2_23/ZN gf180mcu_fd_sc_mcu7t5v0__xnor3_1_20/A3 vdd
+ vss gf180mcu_fd_sc_mcu7t5v0__aoi221_1
Xgf180mcu_fd_sc_mcu7t5v0__oai21_4_15 gf180mcu_fd_sc_mcu7t5v0__oai21_4_15/B vdd vss
+ gf180mcu_fd_sc_mcu7t5v0__xor2_1_157/A1 gf180mcu_fd_sc_mcu7t5v0__or4_1_1/A2 gf180mcu_fd_sc_mcu7t5v0__or2_4_0/Z
+ vdd vss gf180mcu_fd_sc_mcu7t5v0__oai21_4
Xgf180mcu_fd_sc_mcu7t5v0__nor2_1_80 vdd vss gf180mcu_fd_sc_mcu7t5v0__nor2_1_80/ZN
+ gf180mcu_fd_sc_mcu7t5v0__and3_1_5/Z gf180mcu_fd_sc_mcu7t5v0__nor2_1_80/A2 vdd vss
+ gf180mcu_fd_sc_mcu7t5v0__nor2_1
Xgf180mcu_fd_sc_mcu7t5v0__nor2_1_91 vdd vss gf180mcu_fd_sc_mcu7t5v0__nor2_1_91/ZN
+ gf180mcu_fd_sc_mcu7t5v0__nor3_4_4/A1 gf180mcu_fd_sc_mcu7t5v0__inv_2_4/I vdd vss
+ gf180mcu_fd_sc_mcu7t5v0__nor2_1
Xgf180mcu_fd_sc_mcu7t5v0__clkinv_2_1 vdd vss gf180mcu_fd_sc_mcu7t5v0__mux4_4_2/I2
+ gf180mcu_fd_sc_mcu7t5v0__oai22_4_1/A2 vdd vss gf180mcu_fd_sc_mcu7t5v0__clkinv_2
Xgf180mcu_fd_sc_mcu7t5v0__oai31_1_2 vdd gf180mcu_fd_sc_mcu7t5v0__xor2_1_52/A2 gf180mcu_fd_sc_mcu7t5v0__oai31_1_2/B
+ gf180mcu_fd_sc_mcu7t5v0__or4_1_1/A1 gf180mcu_fd_sc_mcu7t5v0__or4_1_1/A2 vss gf180mcu_fd_sc_mcu7t5v0__or4_1_1/A3
+ vdd vss gf180mcu_fd_sc_mcu7t5v0__oai31_1
Xgf180mcu_fd_sc_mcu7t5v0__nor2_1_280 vdd vss gf180mcu_fd_sc_mcu7t5v0__nor2_1_280/ZN
+ gf180mcu_fd_sc_mcu7t5v0__or2_1_7/A1 gf180mcu_fd_sc_mcu7t5v0__xor3_1_90/A2 vdd vss
+ gf180mcu_fd_sc_mcu7t5v0__nor2_1
Xgf180mcu_fd_sc_mcu7t5v0__nor2_1_291 vdd vss gf180mcu_fd_sc_mcu7t5v0__oai32_1_10/A2
+ gf180mcu_fd_sc_mcu7t5v0__xor3_1_99/Z gf180mcu_fd_sc_mcu7t5v0__xor3_1_156/A3 vdd
+ vss gf180mcu_fd_sc_mcu7t5v0__nor2_1
Xgf180mcu_fd_sc_mcu7t5v0__nand2_1_12 vdd vss gf180mcu_fd_sc_mcu7t5v0__xnor2_1_8/A2
+ gf180mcu_fd_sc_mcu7t5v0__inv_12_1/I gf180mcu_fd_sc_mcu7t5v0__nand3_1_1/A3 vdd vss
+ gf180mcu_fd_sc_mcu7t5v0__nand2_1
Xgf180mcu_fd_sc_mcu7t5v0__oai31_1_17 vdd gf180mcu_fd_sc_mcu7t5v0__xor3_1_95/A2 gf180mcu_fd_sc_mcu7t5v0__oai31_1_17/B
+ gf180mcu_fd_sc_mcu7t5v0__inv_8_0/I gf180mcu_fd_sc_mcu7t5v0__xnor2_1_48/A2 vss gf180mcu_fd_sc_mcu7t5v0__xor2_1_139/A1
+ vdd vss gf180mcu_fd_sc_mcu7t5v0__oai31_1
Xgf180mcu_fd_sc_mcu7t5v0__nand2_1_23 vdd vss gf180mcu_fd_sc_mcu7t5v0__nand2_1_9/A1
+ gf180mcu_fd_sc_mcu7t5v0__nand3_1_4/ZN gf180mcu_fd_sc_mcu7t5v0__nor2_1_22/ZN vdd
+ vss gf180mcu_fd_sc_mcu7t5v0__nand2_1
Xgf180mcu_fd_sc_mcu7t5v0__aoi221_4_0 gf180mcu_fd_sc_mcu7t5v0__xor2_1_147/A1 gf180mcu_fd_sc_mcu7t5v0__nor2_2_38/ZN
+ gf180mcu_fd_sc_mcu7t5v0__xor2_1_61/A1 gf180mcu_fd_sc_mcu7t5v0__aoi221_4_0/C vdd
+ vss gf180mcu_fd_sc_mcu7t5v0__xnor2_1_47/A1 gf180mcu_fd_sc_mcu7t5v0__inv_4_4/I vdd
+ vss gf180mcu_fd_sc_mcu7t5v0__aoi221_4
Xgf180mcu_fd_sc_mcu7t5v0__nand2_1_34 vdd vss gf180mcu_fd_sc_mcu7t5v0__xnor2_1_5/A2
+ gf180mcu_fd_sc_mcu7t5v0__xor2_1_20/A2 gf180mcu_fd_sc_mcu7t5v0__nand2_1_35/ZN vdd
+ vss gf180mcu_fd_sc_mcu7t5v0__nand2_1
Xgf180mcu_fd_sc_mcu7t5v0__nand2_1_45 vdd vss gf180mcu_fd_sc_mcu7t5v0__xnor2_1_5/A1
+ gf180mcu_fd_sc_mcu7t5v0__nand3_2_12/ZN gf180mcu_fd_sc_mcu7t5v0__oai22_1_2/A2 vdd
+ vss gf180mcu_fd_sc_mcu7t5v0__nand2_1
Xgf180mcu_fd_sc_mcu7t5v0__and4_1_0 gf180mcu_fd_sc_mcu7t5v0__or4_1_1/A2 gf180mcu_fd_sc_mcu7t5v0__and4_1_0/A4
+ vdd vss gf180mcu_fd_sc_mcu7t5v0__or3_1_3/A1 gf180mcu_fd_sc_mcu7t5v0__or4_1_0/A1
+ gf180mcu_fd_sc_mcu7t5v0__inv_12_1/I vdd vss gf180mcu_fd_sc_mcu7t5v0__and4_1
Xgf180mcu_fd_sc_mcu7t5v0__nand2_1_56 vdd vss gf180mcu_fd_sc_mcu7t5v0__xor2_1_31/A2
+ gf180mcu_fd_sc_mcu7t5v0__inv_12_1/I gf180mcu_fd_sc_mcu7t5v0__nand2_1_89/ZN vdd vss
+ gf180mcu_fd_sc_mcu7t5v0__nand2_1
Xgf180mcu_fd_sc_mcu7t5v0__nand2_1_67 vdd vss gf180mcu_fd_sc_mcu7t5v0__oai21_4_1/B
+ gf180mcu_fd_sc_mcu7t5v0__mux4_4_2/I3 gf180mcu_fd_sc_mcu7t5v0__dffq_4_4/Q vdd vss
+ gf180mcu_fd_sc_mcu7t5v0__nand2_1
Xgf180mcu_fd_sc_mcu7t5v0__nand2_1_78 vdd vss gf180mcu_fd_sc_mcu7t5v0__nand4_1_1/A2
+ gf180mcu_fd_sc_mcu7t5v0__nor3_4_18/ZN gf180mcu_fd_sc_mcu7t5v0__xor2_2_1/Z vdd vss
+ gf180mcu_fd_sc_mcu7t5v0__nand2_1
Xgf180mcu_fd_sc_mcu7t5v0__nand2_1_89 vdd vss gf180mcu_fd_sc_mcu7t5v0__nand2_1_89/ZN
+ gf180mcu_fd_sc_mcu7t5v0__nand3_2_12/A2 gf180mcu_fd_sc_mcu7t5v0__aoi22_2_1/ZN vdd
+ vss gf180mcu_fd_sc_mcu7t5v0__nand2_1
Xgf180mcu_fd_sc_mcu7t5v0__nor2_4_2 vdd vss gf180mcu_fd_sc_mcu7t5v0__nor2_4_2/ZN gf180mcu_fd_sc_mcu7t5v0__inv_3_0/I
+ gf180mcu_fd_sc_mcu7t5v0__inv_4_1/I vdd vss gf180mcu_fd_sc_mcu7t5v0__nor2_4
Xgf180mcu_fd_sc_mcu7t5v0__oai21_1_340 vdd gf180mcu_fd_sc_mcu7t5v0__oai21_1_340/B gf180mcu_fd_sc_mcu7t5v0__or2_1_25/A2
+ gf180mcu_fd_sc_mcu7t5v0__xor2_1_227/A1 gf180mcu_fd_sc_mcu7t5v0__or2_1_25/A1 vss
+ vdd vss gf180mcu_fd_sc_mcu7t5v0__oai21_1
Xgf180mcu_fd_sc_mcu7t5v0__xnor2_1_0 vdd vss gf180mcu_fd_sc_mcu7t5v0__nor3_1_0/A3 gf180mcu_fd_sc_mcu7t5v0__nor2_2_0/A1
+ gf180mcu_fd_sc_mcu7t5v0__or2_1_14/A1 vdd vss gf180mcu_fd_sc_mcu7t5v0__xnor2_1
Xgf180mcu_fd_sc_mcu7t5v0__oai22_1_2 gf180mcu_fd_sc_mcu7t5v0__oai22_1_2/A2 gf180mcu_fd_sc_mcu7t5v0__xnor2_1_5/A1
+ gf180mcu_fd_sc_mcu7t5v0__oai22_1_2/B2 vdd vss gf180mcu_fd_sc_mcu7t5v0__oai22_1_2/ZN
+ gf180mcu_fd_sc_mcu7t5v0__oai32_1_3/B2 vdd vss gf180mcu_fd_sc_mcu7t5v0__oai22_1
Xgf180mcu_fd_sc_mcu7t5v0__aoi22_1_60 gf180mcu_fd_sc_mcu7t5v0__nor2_4_11/ZN gf180mcu_fd_sc_mcu7t5v0__dffq_1_100/Q
+ vdd vss gf180mcu_fd_sc_mcu7t5v0__aoi22_1_60/ZN gf180mcu_fd_sc_mcu7t5v0__dffq_1_261/Q
+ gf180mcu_fd_sc_mcu7t5v0__nor2_4_10/ZN vdd vss gf180mcu_fd_sc_mcu7t5v0__aoi22_1
Xgf180mcu_fd_sc_mcu7t5v0__aoi22_1_71 gf180mcu_fd_sc_mcu7t5v0__nor2_4_9/ZN gf180mcu_fd_sc_mcu7t5v0__dffq_1_120/Q
+ vdd vss gf180mcu_fd_sc_mcu7t5v0__aoi22_1_71/ZN gf180mcu_fd_sc_mcu7t5v0__dffq_1_121/Q
+ gf180mcu_fd_sc_mcu7t5v0__nor2_4_8/ZN vdd vss gf180mcu_fd_sc_mcu7t5v0__aoi22_1
Xgf180mcu_fd_sc_mcu7t5v0__aoi22_1_82 gf180mcu_fd_sc_mcu7t5v0__nor2_4_11/ZN gf180mcu_fd_sc_mcu7t5v0__dffq_1_145/Q
+ vdd vss gf180mcu_fd_sc_mcu7t5v0__aoi22_1_82/ZN gf180mcu_fd_sc_mcu7t5v0__dffq_1_143/Q
+ gf180mcu_fd_sc_mcu7t5v0__nor2_4_10/ZN vdd vss gf180mcu_fd_sc_mcu7t5v0__aoi22_1
Xgf180mcu_fd_sc_mcu7t5v0__aoi22_1_93 gf180mcu_fd_sc_mcu7t5v0__nor2_4_11/ZN gf180mcu_fd_sc_mcu7t5v0__dffq_1_166/Q
+ vdd vss gf180mcu_fd_sc_mcu7t5v0__aoi22_1_93/ZN gf180mcu_fd_sc_mcu7t5v0__dffq_1_173/Q
+ gf180mcu_fd_sc_mcu7t5v0__nor2_4_10/ZN vdd vss gf180mcu_fd_sc_mcu7t5v0__aoi22_1
Xgf180mcu_fd_sc_mcu7t5v0__inv_1_2 vss gf180mcu_fd_sc_mcu7t5v0__inv_1_2/ZN gf180mcu_fd_sc_mcu7t5v0__inv_1_2/I
+ vdd vdd vss gf180mcu_fd_sc_mcu7t5v0__inv_1
Xgf180mcu_fd_sc_mcu7t5v0__nand3_2_11 gf180mcu_fd_sc_mcu7t5v0__dffq_4_0/Q vdd vss gf180mcu_fd_sc_mcu7t5v0__oai221_1_1/B2
+ gf180mcu_fd_sc_mcu7t5v0__dffq_4_3/Q gf180mcu_fd_sc_mcu7t5v0__inv_2_1/ZN vdd vss
+ gf180mcu_fd_sc_mcu7t5v0__nand3_2
Xgf180mcu_fd_sc_mcu7t5v0__nand3_2_22 gf180mcu_fd_sc_mcu7t5v0__nor3_1_44/A1 vdd vss
+ gf180mcu_fd_sc_mcu7t5v0__xor2_1_92/A2 gf180mcu_fd_sc_mcu7t5v0__dffq_1_337/Q gf180mcu_fd_sc_mcu7t5v0__nand4_2_5/A2
+ vdd vss gf180mcu_fd_sc_mcu7t5v0__nand3_2
Xgf180mcu_fd_sc_mcu7t5v0__aoi222_2_8 gf180mcu_fd_sc_mcu7t5v0__nor2_4_13/ZN gf180mcu_fd_sc_mcu7t5v0__aoi222_2_8/B1
+ gf180mcu_fd_sc_mcu7t5v0__aoi222_2_8/A2 gf180mcu_fd_sc_mcu7t5v0__nor2_4_7/ZN gf180mcu_fd_sc_mcu7t5v0__nand3_1_45/A3
+ vss vdd gf180mcu_fd_sc_mcu7t5v0__nor2_4_6/ZN gf180mcu_fd_sc_mcu7t5v0__aoi222_2_8/C1
+ vdd vss gf180mcu_fd_sc_mcu7t5v0__aoi222_2
Xgf180mcu_fd_sc_mcu7t5v0__oai32_4_0 gf180mcu_fd_sc_mcu7t5v0__oai32_4_0/A3 gf180mcu_fd_sc_mcu7t5v0__or2_2_1/Z
+ gf180mcu_fd_sc_mcu7t5v0__inv_1_19/I vdd vss gf180mcu_fd_sc_mcu7t5v0__oai32_4_0/ZN
+ gf180mcu_fd_sc_mcu7t5v0__and3_1_17/Z gf180mcu_fd_sc_mcu7t5v0__oai32_4_0/A2 vdd vss
+ gf180mcu_fd_sc_mcu7t5v0__oai32_4
Xgf180mcu_fd_sc_mcu7t5v0__nand2_1_708 vdd vss gf180mcu_fd_sc_mcu7t5v0__oai21_1_336/B
+ gf180mcu_fd_sc_mcu7t5v0__xor2_1_216/A1 gf180mcu_fd_sc_mcu7t5v0__xor2_1_216/A2 vdd
+ vss gf180mcu_fd_sc_mcu7t5v0__nand2_1
Xgf180mcu_fd_sc_mcu7t5v0__nand2_1_719 vdd vss gf180mcu_fd_sc_mcu7t5v0__nand2_1_719/ZN
+ gf180mcu_fd_sc_mcu7t5v0__or2_1_55/A1 gf180mcu_fd_sc_mcu7t5v0__or2_4_4/Z vdd vss
+ gf180mcu_fd_sc_mcu7t5v0__nand2_1
Xgf180mcu_fd_sc_mcu7t5v0__and2_1_16 vdd vss gf180mcu_fd_sc_mcu7t5v0__and2_1_16/Z gf180mcu_fd_sc_mcu7t5v0__xor3_1_38/A2
+ gf180mcu_fd_sc_mcu7t5v0__xor3_1_38/A3 vdd vss gf180mcu_fd_sc_mcu7t5v0__and2_1
Xgf180mcu_fd_sc_mcu7t5v0__and2_1_27 vdd vss gf180mcu_fd_sc_mcu7t5v0__and2_1_27/Z gf180mcu_fd_sc_mcu7t5v0__dffq_4_37/Q
+ gf180mcu_fd_sc_mcu7t5v0__xor2_1_28/A2 vdd vss gf180mcu_fd_sc_mcu7t5v0__and2_1
Xgf180mcu_fd_sc_mcu7t5v0__and2_1_38 vdd vss gf180mcu_fd_sc_mcu7t5v0__and2_1_38/Z gf180mcu_fd_sc_mcu7t5v0__dffq_4_7/Q
+ gf180mcu_fd_sc_mcu7t5v0__and2_1_38/A2 vdd vss gf180mcu_fd_sc_mcu7t5v0__and2_1
Xgf180mcu_fd_sc_mcu7t5v0__and2_1_49 vdd vss gf180mcu_fd_sc_mcu7t5v0__and2_1_49/Z gf180mcu_fd_sc_mcu7t5v0__dffq_1_279/Q
+ gf180mcu_fd_sc_mcu7t5v0__nor2_4_14/A2 vdd vss gf180mcu_fd_sc_mcu7t5v0__and2_1
Xgf180mcu_fd_sc_mcu7t5v0__oai21_1_170 vdd gf180mcu_fd_sc_mcu7t5v0__oai21_1_170/B gf180mcu_fd_sc_mcu7t5v0__or3_1_12/A2
+ gf180mcu_fd_sc_mcu7t5v0__oai211_1_23/B gf180mcu_fd_sc_mcu7t5v0__inv_8_1/I vss vdd
+ vss gf180mcu_fd_sc_mcu7t5v0__oai21_1
Xgf180mcu_fd_sc_mcu7t5v0__oai21_1_181 vdd gf180mcu_fd_sc_mcu7t5v0__buf_8_7/Z gf180mcu_fd_sc_mcu7t5v0__dffq_1_395/Q
+ gf180mcu_fd_sc_mcu7t5v0__aoi21_1_197/B gf180mcu_fd_sc_mcu7t5v0__dffq_4_20/Q vss
+ vdd vss gf180mcu_fd_sc_mcu7t5v0__oai21_1
Xgf180mcu_fd_sc_mcu7t5v0__oai21_1_192 vdd gf180mcu_fd_sc_mcu7t5v0__buf_8_7/Z gf180mcu_fd_sc_mcu7t5v0__nor3_4_15/ZN
+ gf180mcu_fd_sc_mcu7t5v0__aoi21_1_206/B gf180mcu_fd_sc_mcu7t5v0__dffq_1_405/Q vss
+ vdd vss gf180mcu_fd_sc_mcu7t5v0__oai21_1
Xgf180mcu_fd_sc_mcu7t5v0__aoi211_1_17 gf180mcu_fd_sc_mcu7t5v0__aoi211_1_17/B gf180mcu_fd_sc_mcu7t5v0__or2_4_4/Z
+ vdd vss gf180mcu_fd_sc_mcu7t5v0__aoi21_1_64/B gf180mcu_fd_sc_mcu7t5v0__nor2_4_3/ZN
+ gf180mcu_fd_sc_mcu7t5v0__nand2_1_171/ZN vdd vss gf180mcu_fd_sc_mcu7t5v0__aoi211_1
Xgf180mcu_fd_sc_mcu7t5v0__aoi211_1_28 gf180mcu_fd_sc_mcu7t5v0__nor2_1_108/ZN gf180mcu_fd_sc_mcu7t5v0__or2_1_23/A1
+ vdd vss gf180mcu_fd_sc_mcu7t5v0__dffq_1_246/D gf180mcu_fd_sc_mcu7t5v0__inv_4_3/ZN
+ gf180mcu_fd_sc_mcu7t5v0__nor2_4_21/ZN vdd vss gf180mcu_fd_sc_mcu7t5v0__aoi211_1
Xgf180mcu_fd_sc_mcu7t5v0__aoi211_1_39 gf180mcu_fd_sc_mcu7t5v0__nor2_1_141/ZN gf180mcu_fd_sc_mcu7t5v0__or2_1_23/A1
+ vdd vss gf180mcu_fd_sc_mcu7t5v0__dffq_1_284/D gf180mcu_fd_sc_mcu7t5v0__inv_4_2/ZN
+ gf180mcu_fd_sc_mcu7t5v0__nor2_4_22/ZN vdd vss gf180mcu_fd_sc_mcu7t5v0__aoi211_1
Xgf180mcu_fd_sc_mcu7t5v0__clkinv_1_30 vdd vss gf180mcu_fd_sc_mcu7t5v0__dffq_1_22/Q
+ gf180mcu_fd_sc_mcu7t5v0__oai22_1_17/B2 vdd vss gf180mcu_fd_sc_mcu7t5v0__clkinv_1
Xgf180mcu_fd_sc_mcu7t5v0__clkinv_1_41 vdd vss gf180mcu_fd_sc_mcu7t5v0__dffq_1_35/Q
+ gf180mcu_fd_sc_mcu7t5v0__oai22_1_29/B2 vdd vss gf180mcu_fd_sc_mcu7t5v0__clkinv_1
Xgf180mcu_fd_sc_mcu7t5v0__clkinv_1_52 vdd vss gf180mcu_fd_sc_mcu7t5v0__dffq_1_45/Q
+ gf180mcu_fd_sc_mcu7t5v0__oai22_1_43/B2 vdd vss gf180mcu_fd_sc_mcu7t5v0__clkinv_1
Xgf180mcu_fd_sc_mcu7t5v0__clkinv_1_63 vdd vss gf180mcu_fd_sc_mcu7t5v0__dffq_1_91/Q
+ gf180mcu_fd_sc_mcu7t5v0__oai22_1_93/B2 vdd vss gf180mcu_fd_sc_mcu7t5v0__clkinv_1
Xgf180mcu_fd_sc_mcu7t5v0__clkinv_1_74 vdd vss gf180mcu_fd_sc_mcu7t5v0__dffq_1_63/Q
+ gf180mcu_fd_sc_mcu7t5v0__oai22_1_59/B2 vdd vss gf180mcu_fd_sc_mcu7t5v0__clkinv_1
Xgf180mcu_fd_sc_mcu7t5v0__aoi21_1_205 gf180mcu_fd_sc_mcu7t5v0__aoi21_1_205/B vdd vss
+ gf180mcu_fd_sc_mcu7t5v0__dffq_1_398/D gf180mcu_fd_sc_mcu7t5v0__nor3_4_15/ZN gf180mcu_fd_sc_mcu7t5v0__aoi22_4_5/ZN
+ vdd vss gf180mcu_fd_sc_mcu7t5v0__aoi21_1
Xgf180mcu_fd_sc_mcu7t5v0__clkinv_1_85 vdd vss gf180mcu_fd_sc_mcu7t5v0__dffq_1_98/Q
+ gf180mcu_fd_sc_mcu7t5v0__oai22_1_65/B2 vdd vss gf180mcu_fd_sc_mcu7t5v0__clkinv_1
Xgf180mcu_fd_sc_mcu7t5v0__aoi21_1_216 gf180mcu_fd_sc_mcu7t5v0__aoi21_1_7/B vdd vss
+ gf180mcu_fd_sc_mcu7t5v0__dffq_2_60/D gf180mcu_fd_sc_mcu7t5v0__nand2_1_418/ZN gf180mcu_fd_sc_mcu7t5v0__oai211_1_25/ZN
+ vdd vss gf180mcu_fd_sc_mcu7t5v0__aoi21_1
Xgf180mcu_fd_sc_mcu7t5v0__clkinv_1_96 vdd vss gf180mcu_fd_sc_mcu7t5v0__dffq_1_96/Q
+ gf180mcu_fd_sc_mcu7t5v0__oai22_1_78/B2 vdd vss gf180mcu_fd_sc_mcu7t5v0__clkinv_1
Xgf180mcu_fd_sc_mcu7t5v0__aoi21_1_227 gf180mcu_fd_sc_mcu7t5v0__xor2_1_121/Z vdd vss
+ gf180mcu_fd_sc_mcu7t5v0__or3_1_16/A2 gf180mcu_fd_sc_mcu7t5v0__nand3_1_66/A1 gf180mcu_fd_sc_mcu7t5v0__nand3_1_66/A2
+ vdd vss gf180mcu_fd_sc_mcu7t5v0__aoi21_1
Xgf180mcu_fd_sc_mcu7t5v0__aoi21_1_238 gf180mcu_fd_sc_mcu7t5v0__inv_4_6/ZN vdd vss
+ gf180mcu_fd_sc_mcu7t5v0__oai32_1_7/A2 gf180mcu_fd_sc_mcu7t5v0__oai32_1_6/A3 gf180mcu_fd_sc_mcu7t5v0__nand2_1_480/ZN
+ vdd vss gf180mcu_fd_sc_mcu7t5v0__aoi21_1
Xgf180mcu_fd_sc_mcu7t5v0__aoi21_1_249 gf180mcu_fd_sc_mcu7t5v0__oai32_1_8/A1 vdd vss
+ gf180mcu_fd_sc_mcu7t5v0__aoi21_1_249/ZN gf180mcu_fd_sc_mcu7t5v0__or2_1_7/A1 gf180mcu_fd_sc_mcu7t5v0__nor2_2_37/ZN
+ vdd vss gf180mcu_fd_sc_mcu7t5v0__aoi21_1
Xgf180mcu_fd_sc_mcu7t5v0__oai21_1_16 vdd gf180mcu_fd_sc_mcu7t5v0__oai21_1_16/B gf180mcu_fd_sc_mcu7t5v0__xor2_1_75/Z
+ gf180mcu_fd_sc_mcu7t5v0__oai221_1_2/B2 gf180mcu_fd_sc_mcu7t5v0__oai21_1_16/A1 vss
+ vdd vss gf180mcu_fd_sc_mcu7t5v0__oai21_1
Xgf180mcu_fd_sc_mcu7t5v0__oai21_1_27 vdd gf180mcu_fd_sc_mcu7t5v0__oai21_1_27/B gf180mcu_fd_sc_mcu7t5v0__mux4_4_1/Z
+ gf180mcu_fd_sc_mcu7t5v0__nand4_1_1/A4 gf180mcu_fd_sc_mcu7t5v0__inv_4_6/I vss vdd
+ vss gf180mcu_fd_sc_mcu7t5v0__oai21_1
Xgf180mcu_fd_sc_mcu7t5v0__oai21_1_38 vdd gf180mcu_fd_sc_mcu7t5v0__buf_8_5/Z gf180mcu_fd_sc_mcu7t5v0__buf_20_0/Z
+ gf180mcu_fd_sc_mcu7t5v0__aoi21_1_43/B gf180mcu_fd_sc_mcu7t5v0__dffq_1_7/Q vss vdd
+ vss gf180mcu_fd_sc_mcu7t5v0__oai21_1
Xgf180mcu_fd_sc_mcu7t5v0__oai21_1_49 vdd gf180mcu_fd_sc_mcu7t5v0__or3_1_5/A3 gf180mcu_fd_sc_mcu7t5v0__or3_1_5/A2
+ gf180mcu_fd_sc_mcu7t5v0__and3_1_4/A3 gf180mcu_fd_sc_mcu7t5v0__or3_1_5/A1 vss vdd
+ vss gf180mcu_fd_sc_mcu7t5v0__oai21_1
Xgf180mcu_fd_sc_mcu7t5v0__and2_4_1 gf180mcu_fd_sc_mcu7t5v0__and2_4_1/A2 vdd vss gf180mcu_fd_sc_mcu7t5v0__and2_4_1/Z
+ gf180mcu_fd_sc_mcu7t5v0__and2_4_1/A1 vdd vss gf180mcu_fd_sc_mcu7t5v0__and2_4
Xgf180mcu_fd_sc_mcu7t5v0__aoi21_2_8 gf180mcu_fd_sc_mcu7t5v0__aoi21_2_8/B vdd vss gf180mcu_fd_sc_mcu7t5v0__xor3_1_83/A3
+ gf180mcu_fd_sc_mcu7t5v0__and2_1_89/Z gf180mcu_fd_sc_mcu7t5v0__aoi21_2_8/A2 vdd vss
+ gf180mcu_fd_sc_mcu7t5v0__aoi21_2
Xgf180mcu_fd_sc_mcu7t5v0__nand2_1_505 vdd vss gf180mcu_fd_sc_mcu7t5v0__oai21_1_229/B
+ gf180mcu_fd_sc_mcu7t5v0__and2_1_109/Z gf180mcu_fd_sc_mcu7t5v0__xnor3_1_32/ZN vdd
+ vss gf180mcu_fd_sc_mcu7t5v0__nand2_1
Xgf180mcu_fd_sc_mcu7t5v0__nand4_1_1 gf180mcu_fd_sc_mcu7t5v0__nand4_1_1/A3 gf180mcu_fd_sc_mcu7t5v0__nand4_1_1/A4
+ vdd vss gf180mcu_fd_sc_mcu7t5v0__nand4_1_1/ZN gf180mcu_fd_sc_mcu7t5v0__nand4_1_1/A1
+ gf180mcu_fd_sc_mcu7t5v0__nand4_1_1/A2 vdd vss gf180mcu_fd_sc_mcu7t5v0__nand4_1
Xgf180mcu_fd_sc_mcu7t5v0__nand2_1_516 vdd vss gf180mcu_fd_sc_mcu7t5v0__nand4_1_12/A2
+ gf180mcu_fd_sc_mcu7t5v0__nor2_4_33/ZN gf180mcu_fd_sc_mcu7t5v0__xor2_1_108/Z vdd
+ vss gf180mcu_fd_sc_mcu7t5v0__nand2_1
Xgf180mcu_fd_sc_mcu7t5v0__nand2_1_527 vdd vss gf180mcu_fd_sc_mcu7t5v0__xnor2_1_55/A1
+ gf180mcu_fd_sc_mcu7t5v0__inv_8_1/I gf180mcu_fd_sc_mcu7t5v0__mux4_4_2/Z vdd vss gf180mcu_fd_sc_mcu7t5v0__nand2_1
Xgf180mcu_fd_sc_mcu7t5v0__nand2_1_538 vdd vss gf180mcu_fd_sc_mcu7t5v0__nand2_1_538/ZN
+ gf180mcu_fd_sc_mcu7t5v0__nor2_4_38/ZN gf180mcu_fd_sc_mcu7t5v0__xor2_1_153/Z vdd
+ vss gf180mcu_fd_sc_mcu7t5v0__nand2_1
Xgf180mcu_fd_sc_mcu7t5v0__nand2_1_549 vdd vss gf180mcu_fd_sc_mcu7t5v0__xor3_1_108/A1
+ gf180mcu_fd_sc_mcu7t5v0__inv_8_0/I gf180mcu_fd_sc_mcu7t5v0__mux4_4_16/Z vdd vss
+ gf180mcu_fd_sc_mcu7t5v0__nand2_1
Xgf180mcu_fd_sc_mcu7t5v0__aoi21_2_18 gf180mcu_fd_sc_mcu7t5v0__dffq_4_32/Q vdd vss
+ gf180mcu_fd_sc_mcu7t5v0__oai32_4_2/A3 gf180mcu_fd_sc_mcu7t5v0__oai31_4_1/A1 gf180mcu_fd_sc_mcu7t5v0__inv_1_20/I
+ vdd vss gf180mcu_fd_sc_mcu7t5v0__aoi21_2
Xgf180mcu_fd_sc_mcu7t5v0__oai211_2_8 gf180mcu_fd_sc_mcu7t5v0__oai31_4_3/ZN gf180mcu_fd_sc_mcu7t5v0__or2_1_46/A2
+ gf180mcu_fd_sc_mcu7t5v0__aoi21_4_8/ZN gf180mcu_fd_sc_mcu7t5v0__oai21_4_13/B gf180mcu_fd_sc_mcu7t5v0__inv_8_1/I
+ vdd vss vdd vss gf180mcu_fd_sc_mcu7t5v0__oai211_2
Xgf180mcu_fd_sc_mcu7t5v0__nand3_1_100 gf180mcu_fd_sc_mcu7t5v0__nand3_1_90/A3 vdd vss
+ gf180mcu_fd_sc_mcu7t5v0__nand3_1_100/ZN gf180mcu_fd_sc_mcu7t5v0__dffq_2_80/Q gf180mcu_fd_sc_mcu7t5v0__nand3_1_91/ZN
+ vdd vss gf180mcu_fd_sc_mcu7t5v0__nand3_1
Xgf180mcu_fd_sc_mcu7t5v0__or3_1_14 gf180mcu_fd_sc_mcu7t5v0__or3_1_14/A3 vdd vss gf180mcu_fd_sc_mcu7t5v0__or3_1_14/Z
+ gf180mcu_fd_sc_mcu7t5v0__or3_1_24/A1 gf180mcu_fd_sc_mcu7t5v0__inv_1_13/I vdd vss
+ gf180mcu_fd_sc_mcu7t5v0__or3_1
Xgf180mcu_fd_sc_mcu7t5v0__or3_1_25 gf180mcu_fd_sc_mcu7t5v0__or3_1_25/A3 vdd vss gf180mcu_fd_sc_mcu7t5v0__or3_1_25/Z
+ gf180mcu_fd_sc_mcu7t5v0__or3_1_25/A1 gf180mcu_fd_sc_mcu7t5v0__or3_1_25/A2 vdd vss
+ gf180mcu_fd_sc_mcu7t5v0__or3_1
Xgf180mcu_fd_sc_mcu7t5v0__nor3_4_14 gf180mcu_fd_sc_mcu7t5v0__inv_1_12/ZN vdd vss gf180mcu_fd_sc_mcu7t5v0__nor3_4_14/ZN
+ gf180mcu_fd_sc_mcu7t5v0__inv_1_11/I gf180mcu_fd_sc_mcu7t5v0__nor3_4_15/A2 vdd vss
+ gf180mcu_fd_sc_mcu7t5v0__nor3_4
Xgf180mcu_fd_sc_mcu7t5v0__tiel_9 uart_tx_PDRV0 vdd vss vdd vss gf180mcu_fd_sc_mcu7t5v0__tiel
Xgf180mcu_fd_sc_mcu7t5v0__nor2_1_109 vdd vss gf180mcu_fd_sc_mcu7t5v0__xor2_1_77/A1
+ gf180mcu_fd_sc_mcu7t5v0__or3_1_9/A1 gf180mcu_fd_sc_mcu7t5v0__or3_1_9/A2 vdd vss
+ gf180mcu_fd_sc_mcu7t5v0__nor2_1
Xgf180mcu_fd_sc_mcu7t5v0__nand2_1_302 vdd vss gf180mcu_fd_sc_mcu7t5v0__and3_1_8/A2
+ gf180mcu_fd_sc_mcu7t5v0__xor2_1_87/A1 gf180mcu_fd_sc_mcu7t5v0__xnor2_1_85/ZN vdd
+ vss gf180mcu_fd_sc_mcu7t5v0__nand2_1
Xgf180mcu_fd_sc_mcu7t5v0__nand2_1_313 vdd vss gf180mcu_fd_sc_mcu7t5v0__nand2_1_313/ZN
+ gf180mcu_fd_sc_mcu7t5v0__dffq_1_408/Q gf180mcu_fd_sc_mcu7t5v0__inv_2_8/I vdd vss
+ gf180mcu_fd_sc_mcu7t5v0__nand2_1
Xgf180mcu_fd_sc_mcu7t5v0__nand2_1_324 vdd vss gf180mcu_fd_sc_mcu7t5v0__oai211_1_19/B
+ gf180mcu_fd_sc_mcu7t5v0__nor2_4_30/ZN gf180mcu_fd_sc_mcu7t5v0__xor3_1_70/Z vdd vss
+ gf180mcu_fd_sc_mcu7t5v0__nand2_1
Xgf180mcu_fd_sc_mcu7t5v0__nand2_1_335 vdd vss gf180mcu_fd_sc_mcu7t5v0__nor3_1_10/A3
+ gf180mcu_fd_sc_mcu7t5v0__nor3_4_12/A2 gf180mcu_fd_sc_mcu7t5v0__or3_4_0/A3 vdd vss
+ gf180mcu_fd_sc_mcu7t5v0__nand2_1
Xgf180mcu_fd_sc_mcu7t5v0__nand2_1_346 vdd vss gf180mcu_fd_sc_mcu7t5v0__aoi211_1_51/C
+ gf180mcu_fd_sc_mcu7t5v0__buf_8_8/I gf180mcu_fd_sc_mcu7t5v0__xor2_1_92/A2 vdd vss
+ gf180mcu_fd_sc_mcu7t5v0__nand2_1
Xgf180mcu_fd_sc_mcu7t5v0__nand2_1_357 vdd vss gf180mcu_fd_sc_mcu7t5v0__oai211_1_21/B
+ gf180mcu_fd_sc_mcu7t5v0__dffq_2_50/Q gf180mcu_fd_sc_mcu7t5v0__and4_2_0/Z vdd vss
+ gf180mcu_fd_sc_mcu7t5v0__nand2_1
Xgf180mcu_fd_sc_mcu7t5v0__nand2_1_368 vdd vss gf180mcu_fd_sc_mcu7t5v0__dffq_2_49/D
+ gf180mcu_fd_sc_mcu7t5v0__oai31_1_10/A2 gf180mcu_fd_sc_mcu7t5v0__nand2_1_368/A2 vdd
+ vss gf180mcu_fd_sc_mcu7t5v0__nand2_1
Xgf180mcu_fd_sc_mcu7t5v0__nand2_1_379 vdd vss gf180mcu_fd_sc_mcu7t5v0__oai21_1_174/B
+ gf180mcu_fd_sc_mcu7t5v0__mux4_4_4/I0 gf180mcu_fd_sc_mcu7t5v0__and2_1_84/Z vdd vss
+ gf180mcu_fd_sc_mcu7t5v0__nand2_1
Xgf180mcu_fd_sc_mcu7t5v0__dffq_1_410 vdd gf180mcu_fd_sc_mcu7t5v0__dffq_1_410/Q gf180mcu_fd_sc_mcu7t5v0__dffq_2_58/CLK
+ vss gf180mcu_fd_sc_mcu7t5v0__dffq_1_410/D vdd vss gf180mcu_fd_sc_mcu7t5v0__dffq_1
Xgf180mcu_fd_sc_mcu7t5v0__dffq_1_421 vdd gf180mcu_fd_sc_mcu7t5v0__mux4_4_19/I1 gf180mcu_fd_sc_mcu7t5v0__dffq_4_1/CLK
+ vss gf180mcu_fd_sc_mcu7t5v0__dffq_1_421/D vdd vss gf180mcu_fd_sc_mcu7t5v0__dffq_1
Xgf180mcu_fd_sc_mcu7t5v0__dffq_1_432 vdd gf180mcu_fd_sc_mcu7t5v0__dffq_1_432/Q gf180mcu_fd_sc_mcu7t5v0__dffq_4_1/CLK
+ vss gf180mcu_fd_sc_mcu7t5v0__dffq_1_432/D vdd vss gf180mcu_fd_sc_mcu7t5v0__dffq_1
Xgf180mcu_fd_sc_mcu7t5v0__dffq_1_443 vdd gf180mcu_fd_sc_mcu7t5v0__dffq_1_443/Q gf180mcu_fd_sc_mcu7t5v0__dffq_4_44/CLK
+ vss gf180mcu_fd_sc_mcu7t5v0__dffq_1_443/D vdd vss gf180mcu_fd_sc_mcu7t5v0__dffq_1
Xgf180mcu_fd_sc_mcu7t5v0__dffq_1_454 vdd gf180mcu_fd_sc_mcu7t5v0__nand4_2_5/A1 gf180mcu_fd_sc_mcu7t5v0__dffq_4_15/CLK
+ vss gf180mcu_fd_sc_mcu7t5v0__nor3_1_44/ZN vdd vss gf180mcu_fd_sc_mcu7t5v0__dffq_1
Xgf180mcu_fd_sc_mcu7t5v0__clkinv_1_304 vdd vss gf180mcu_fd_sc_mcu7t5v0__dffq_1_333/Q
+ gf180mcu_fd_sc_mcu7t5v0__aoi21_1_156/A1 vdd vss gf180mcu_fd_sc_mcu7t5v0__clkinv_1
Xgf180mcu_fd_sc_mcu7t5v0__clkinv_1_315 vdd vss gf180mcu_fd_sc_mcu7t5v0__dffq_1_380/Q
+ gf180mcu_fd_sc_mcu7t5v0__nor3_1_13/A2 vdd vss gf180mcu_fd_sc_mcu7t5v0__clkinv_1
Xgf180mcu_fd_sc_mcu7t5v0__clkinv_1_326 vdd vss gf180mcu_fd_sc_mcu7t5v0__xor2_1_116/A1
+ gf180mcu_fd_sc_mcu7t5v0__nor2_1_244/A1 vdd vss gf180mcu_fd_sc_mcu7t5v0__clkinv_1
Xgf180mcu_fd_sc_mcu7t5v0__clkinv_1_337 vdd vss gf180mcu_fd_sc_mcu7t5v0__dffq_4_40/Q
+ gf180mcu_fd_sc_mcu7t5v0__nand2_2_66/A2 vdd vss gf180mcu_fd_sc_mcu7t5v0__clkinv_1
Xgf180mcu_fd_sc_mcu7t5v0__clkinv_1_348 vdd vss gf180mcu_fd_sc_mcu7t5v0__oai211_1_38/ZN
+ gf180mcu_fd_sc_mcu7t5v0__dffq_2_75/D vdd vss gf180mcu_fd_sc_mcu7t5v0__clkinv_1
Xgf180mcu_fd_sc_mcu7t5v0__clkinv_1_359 vdd vss gf180mcu_fd_sc_mcu7t5v0__nand2_1_658/ZN
+ gf180mcu_fd_sc_mcu7t5v0__or3_1_25/A1 vdd vss gf180mcu_fd_sc_mcu7t5v0__clkinv_1
Xgf180mcu_fd_sc_mcu7t5v0__nand2_4_2 vdd vss gf180mcu_fd_sc_mcu7t5v0__nand2_4_2/ZN
+ gf180mcu_fd_sc_mcu7t5v0__nor3_4_11/ZN gf180mcu_fd_sc_mcu7t5v0__nor3_4_9/ZN vdd vss
+ gf180mcu_fd_sc_mcu7t5v0__nand2_4
Xgf180mcu_fd_sc_mcu7t5v0__nand2_4_12 vdd vss gf180mcu_fd_sc_mcu7t5v0__oai22_1_97/A2
+ gf180mcu_fd_sc_mcu7t5v0__nor3_4_7/ZN gf180mcu_fd_sc_mcu7t5v0__nor3_4_6/ZN vdd vss
+ gf180mcu_fd_sc_mcu7t5v0__nand2_4
Xgf180mcu_fd_sc_mcu7t5v0__nand2_4_23 vdd vss gf180mcu_fd_sc_mcu7t5v0__nand2_4_23/ZN
+ gf180mcu_fd_sc_mcu7t5v0__nor2_4_5/ZN gf180mcu_fd_sc_mcu7t5v0__nor3_4_10/ZN vdd vss
+ gf180mcu_fd_sc_mcu7t5v0__nand2_4
Xgf180mcu_fd_sc_mcu7t5v0__nand2_4_34 vdd vss gf180mcu_fd_sc_mcu7t5v0__oai22_1_28/A2
+ gf180mcu_fd_sc_mcu7t5v0__nor2_4_6/ZN gf180mcu_fd_sc_mcu7t5v0__nor3_4_10/ZN vdd vss
+ gf180mcu_fd_sc_mcu7t5v0__nand2_4
Xgf180mcu_fd_sc_mcu7t5v0__nand2_4_45 vdd vss gf180mcu_fd_sc_mcu7t5v0__and3_1_23/A2
+ gf180mcu_fd_sc_mcu7t5v0__nand3_2_29/ZN gf180mcu_fd_sc_mcu7t5v0__aoi22_2_9/ZN vdd
+ vss gf180mcu_fd_sc_mcu7t5v0__nand2_4
Xgf180mcu_fd_sc_mcu7t5v0__nor4_1_2 gf180mcu_fd_sc_mcu7t5v0__nor4_1_2/A3 gf180mcu_fd_sc_mcu7t5v0__nor4_1_2/A4
+ vdd vss gf180mcu_fd_sc_mcu7t5v0__nor4_1_2/ZN gf180mcu_fd_sc_mcu7t5v0__nor4_1_2/A1
+ gf180mcu_fd_sc_mcu7t5v0__nor4_1_2/A2 vdd vss gf180mcu_fd_sc_mcu7t5v0__nor4_1
Xgf180mcu_fd_sc_mcu7t5v0__dffq_4_6 gf180mcu_fd_sc_mcu7t5v0__dffq_4_6/D gf180mcu_fd_sc_mcu7t5v0__inv_4_1/I
+ vdd vss gf180mcu_fd_sc_mcu7t5v0__dffq_4_6/CLK vdd vss gf180mcu_fd_sc_mcu7t5v0__dffq_4
Xgf180mcu_fd_sc_mcu7t5v0__nand2_1_110 vdd vss gf180mcu_fd_sc_mcu7t5v0__xor3_1_34/A3
+ gf180mcu_fd_sc_mcu7t5v0__inv_12_1/I gf180mcu_fd_sc_mcu7t5v0__xor2_1_58/A1 vdd vss
+ gf180mcu_fd_sc_mcu7t5v0__nand2_1
Xgf180mcu_fd_sc_mcu7t5v0__nand2_1_121 vdd vss gf180mcu_fd_sc_mcu7t5v0__aoi21_1_58/A1
+ gf180mcu_fd_sc_mcu7t5v0__dffq_1_16/Q gf180mcu_fd_sc_mcu7t5v0__or2_4_4/Z vdd vss
+ gf180mcu_fd_sc_mcu7t5v0__nand2_1
Xgf180mcu_fd_sc_mcu7t5v0__nand2_1_132 vdd vss gf180mcu_fd_sc_mcu7t5v0__nand2_1_198/A1
+ gf180mcu_fd_sc_mcu7t5v0__inv_2_5/I gf180mcu_fd_sc_mcu7t5v0__and2_1_23/Z vdd vss
+ gf180mcu_fd_sc_mcu7t5v0__nand2_1
Xgf180mcu_fd_sc_mcu7t5v0__nand2_1_143 vdd vss gf180mcu_fd_sc_mcu7t5v0__xnor2_1_20/A1
+ gf180mcu_fd_sc_mcu7t5v0__dffq_4_37/Q gf180mcu_fd_sc_mcu7t5v0__and2_2_0/Z vdd vss
+ gf180mcu_fd_sc_mcu7t5v0__nand2_1
Xgf180mcu_fd_sc_mcu7t5v0__nand2_1_154 vdd vss gf180mcu_fd_sc_mcu7t5v0__oai21_4_6/B
+ gf180mcu_fd_sc_mcu7t5v0__dffq_1_16/Q gf180mcu_fd_sc_mcu7t5v0__and2_2_7/Z vdd vss
+ gf180mcu_fd_sc_mcu7t5v0__nand2_1
Xgf180mcu_fd_sc_mcu7t5v0__nand2_1_165 vdd vss gf180mcu_fd_sc_mcu7t5v0__xor2_1_59/A1
+ gf180mcu_fd_sc_mcu7t5v0__inv_8_1/I gf180mcu_fd_sc_mcu7t5v0__oai22_1_8/A2 vdd vss
+ gf180mcu_fd_sc_mcu7t5v0__nand2_1
Xgf180mcu_fd_sc_mcu7t5v0__nand2_1_176 vdd vss gf180mcu_fd_sc_mcu7t5v0__and2_2_8/A1
+ gf180mcu_fd_sc_mcu7t5v0__nor3_4_3/A1 gf180mcu_fd_sc_mcu7t5v0__inv_2_4/ZN vdd vss
+ gf180mcu_fd_sc_mcu7t5v0__nand2_1
Xgf180mcu_fd_sc_mcu7t5v0__nand2_1_187 vdd vss gf180mcu_fd_sc_mcu7t5v0__xnor2_1_83/A2
+ gf180mcu_fd_sc_mcu7t5v0__or4_1_0/A1 gf180mcu_fd_sc_mcu7t5v0__mux4_4_6/Z vdd vss
+ gf180mcu_fd_sc_mcu7t5v0__nand2_1
Xgf180mcu_fd_sc_mcu7t5v0__nand2_1_198 vdd vss gf180mcu_fd_sc_mcu7t5v0__xnor2_1_14/A1
+ gf180mcu_fd_sc_mcu7t5v0__nand2_1_198/A1 gf180mcu_fd_sc_mcu7t5v0__nand3_1_25/ZN vdd
+ vss gf180mcu_fd_sc_mcu7t5v0__nand2_1
Xgf180mcu_fd_sc_mcu7t5v0__dffq_1_240 vdd gf180mcu_fd_sc_mcu7t5v0__dffq_1_240/Q gf180mcu_fd_sc_mcu7t5v0__dffq_4_8/CLK
+ vss gf180mcu_fd_sc_mcu7t5v0__dffq_1_240/D vdd vss gf180mcu_fd_sc_mcu7t5v0__dffq_1
Xgf180mcu_fd_sc_mcu7t5v0__dffq_1_251 vdd gf180mcu_fd_sc_mcu7t5v0__dffq_1_251/Q gf180mcu_fd_sc_mcu7t5v0__dffq_4_8/CLK
+ vss gf180mcu_fd_sc_mcu7t5v0__dffq_1_251/D vdd vss gf180mcu_fd_sc_mcu7t5v0__dffq_1
Xgf180mcu_fd_sc_mcu7t5v0__dffq_1_262 vdd gf180mcu_fd_sc_mcu7t5v0__dffq_1_262/Q gf180mcu_fd_sc_mcu7t5v0__dffq_1_96/CLK
+ vss gf180mcu_fd_sc_mcu7t5v0__dffq_1_262/D vdd vss gf180mcu_fd_sc_mcu7t5v0__dffq_1
Xgf180mcu_fd_sc_mcu7t5v0__dffq_1_273 vdd gf180mcu_fd_sc_mcu7t5v0__dffq_1_273/Q gf180mcu_fd_sc_mcu7t5v0__dffq_2_58/CLK
+ vss gf180mcu_fd_sc_mcu7t5v0__dffq_1_273/D vdd vss gf180mcu_fd_sc_mcu7t5v0__dffq_1
Xgf180mcu_fd_sc_mcu7t5v0__dffq_1_284 vdd gf180mcu_fd_sc_mcu7t5v0__dffq_1_284/Q gf180mcu_fd_sc_mcu7t5v0__dffq_2_58/CLK
+ vss gf180mcu_fd_sc_mcu7t5v0__dffq_1_284/D vdd vss gf180mcu_fd_sc_mcu7t5v0__dffq_1
Xgf180mcu_fd_sc_mcu7t5v0__dffq_1_295 vdd gf180mcu_fd_sc_mcu7t5v0__dffq_1_295/Q gf180mcu_fd_sc_mcu7t5v0__dffq_4_21/CLK
+ vss gf180mcu_fd_sc_mcu7t5v0__dffq_1_295/D vdd vss gf180mcu_fd_sc_mcu7t5v0__dffq_1
Xgf180mcu_fd_sc_mcu7t5v0__xor2_1_109 vdd vss gf180mcu_fd_sc_mcu7t5v0__xor2_1_109/Z
+ gf180mcu_fd_sc_mcu7t5v0__xor2_1_109/A1 gf180mcu_fd_sc_mcu7t5v0__xor2_1_109/A2 vdd
+ vss gf180mcu_fd_sc_mcu7t5v0__xor2_1
Xgf180mcu_fd_sc_mcu7t5v0__clkinv_1_101 vdd vss gf180mcu_fd_sc_mcu7t5v0__dffq_1_84/Q
+ gf180mcu_fd_sc_mcu7t5v0__oai22_1_77/B2 vdd vss gf180mcu_fd_sc_mcu7t5v0__clkinv_1
Xgf180mcu_fd_sc_mcu7t5v0__nor3_1_15 gf180mcu_fd_sc_mcu7t5v0__and2_1_61/Z vdd vss gf180mcu_fd_sc_mcu7t5v0__nor3_1_15/ZN
+ gf180mcu_fd_sc_mcu7t5v0__oai31_4_2/ZN gf180mcu_fd_sc_mcu7t5v0__nor3_1_15/A2 vdd
+ vss gf180mcu_fd_sc_mcu7t5v0__nor3_1
Xgf180mcu_fd_sc_mcu7t5v0__clkinv_1_112 vdd vss gf180mcu_fd_sc_mcu7t5v0__dffq_1_102/Q
+ gf180mcu_fd_sc_mcu7t5v0__oai22_1_104/B2 vdd vss gf180mcu_fd_sc_mcu7t5v0__clkinv_1
Xgf180mcu_fd_sc_mcu7t5v0__nor3_1_26 gf180mcu_fd_sc_mcu7t5v0__nor3_1_26/A3 vdd vss
+ gf180mcu_fd_sc_mcu7t5v0__nor3_1_26/ZN gf180mcu_fd_sc_mcu7t5v0__xor3_1_86/Z gf180mcu_fd_sc_mcu7t5v0__mux2_1_7/S
+ vdd vss gf180mcu_fd_sc_mcu7t5v0__nor3_1
Xgf180mcu_fd_sc_mcu7t5v0__dffq_1_50 vdd gf180mcu_fd_sc_mcu7t5v0__dffq_1_50/Q gf180mcu_fd_sc_mcu7t5v0__dffq_1_99/CLK
+ vss gf180mcu_fd_sc_mcu7t5v0__dffq_1_50/D vdd vss gf180mcu_fd_sc_mcu7t5v0__dffq_1
Xgf180mcu_fd_sc_mcu7t5v0__clkinv_1_123 vdd vss gf180mcu_fd_sc_mcu7t5v0__dffq_1_111/Q
+ gf180mcu_fd_sc_mcu7t5v0__oai22_1_98/B2 vdd vss gf180mcu_fd_sc_mcu7t5v0__clkinv_1
Xgf180mcu_fd_sc_mcu7t5v0__nor3_1_37 gf180mcu_fd_sc_mcu7t5v0__nor3_1_37/A3 vdd vss
+ gf180mcu_fd_sc_mcu7t5v0__nor3_1_37/ZN gf180mcu_fd_sc_mcu7t5v0__xor3_1_124/Z gf180mcu_fd_sc_mcu7t5v0__mux2_1_12/S
+ vdd vss gf180mcu_fd_sc_mcu7t5v0__nor3_1
Xgf180mcu_fd_sc_mcu7t5v0__clkinv_1_134 vdd vss gf180mcu_fd_sc_mcu7t5v0__dffq_1_130/Q
+ gf180mcu_fd_sc_mcu7t5v0__oai22_1_121/B2 vdd vss gf180mcu_fd_sc_mcu7t5v0__clkinv_1
Xgf180mcu_fd_sc_mcu7t5v0__dffq_1_61 vdd gf180mcu_fd_sc_mcu7t5v0__dffq_1_61/Q gf180mcu_fd_sc_mcu7t5v0__dffq_1_95/CLK
+ vss gf180mcu_fd_sc_mcu7t5v0__dffq_1_61/D vdd vss gf180mcu_fd_sc_mcu7t5v0__dffq_1
Xgf180mcu_fd_sc_mcu7t5v0__clkinv_1_145 vdd vss gf180mcu_fd_sc_mcu7t5v0__dffq_1_124/Q
+ gf180mcu_fd_sc_mcu7t5v0__oai22_1_132/B2 vdd vss gf180mcu_fd_sc_mcu7t5v0__clkinv_1
Xgf180mcu_fd_sc_mcu7t5v0__dffq_1_72 vdd gf180mcu_fd_sc_mcu7t5v0__dffq_1_72/Q gf180mcu_fd_sc_mcu7t5v0__dffq_1_99/CLK
+ vss gf180mcu_fd_sc_mcu7t5v0__dffq_1_72/D vdd vss gf180mcu_fd_sc_mcu7t5v0__dffq_1
Xgf180mcu_fd_sc_mcu7t5v0__dffq_1_83 vdd gf180mcu_fd_sc_mcu7t5v0__dffq_1_83/Q gf180mcu_fd_sc_mcu7t5v0__dffq_1_99/CLK
+ vss gf180mcu_fd_sc_mcu7t5v0__dffq_1_83/D vdd vss gf180mcu_fd_sc_mcu7t5v0__dffq_1
Xgf180mcu_fd_sc_mcu7t5v0__clkinv_1_156 vdd vss gf180mcu_fd_sc_mcu7t5v0__dffq_1_138/Q
+ gf180mcu_fd_sc_mcu7t5v0__oai22_1_141/B2 vdd vss gf180mcu_fd_sc_mcu7t5v0__clkinv_1
Xgf180mcu_fd_sc_mcu7t5v0__dffq_1_94 vdd gf180mcu_fd_sc_mcu7t5v0__dffq_1_94/Q gf180mcu_fd_sc_mcu7t5v0__dffq_1_95/CLK
+ vss gf180mcu_fd_sc_mcu7t5v0__dffq_1_94/D vdd vss gf180mcu_fd_sc_mcu7t5v0__dffq_1
Xgf180mcu_fd_sc_mcu7t5v0__clkinv_1_167 vdd vss gf180mcu_fd_sc_mcu7t5v0__dffq_1_147/Q
+ gf180mcu_fd_sc_mcu7t5v0__oai22_1_152/B2 vdd vss gf180mcu_fd_sc_mcu7t5v0__clkinv_1
Xgf180mcu_fd_sc_mcu7t5v0__clkinv_1_178 vdd vss gf180mcu_fd_sc_mcu7t5v0__dffq_1_157/Q
+ gf180mcu_fd_sc_mcu7t5v0__oai22_1_148/B2 vdd vss gf180mcu_fd_sc_mcu7t5v0__clkinv_1
Xgf180mcu_fd_sc_mcu7t5v0__clkinv_1_189 vdd vss gf180mcu_fd_sc_mcu7t5v0__dffq_1_188/Q
+ gf180mcu_fd_sc_mcu7t5v0__oai22_1_170/B2 vdd vss gf180mcu_fd_sc_mcu7t5v0__clkinv_1
Xgf180mcu_fd_sc_mcu7t5v0__aoi211_1_3 gf180mcu_fd_sc_mcu7t5v0__nor2_1_29/ZN gf180mcu_fd_sc_mcu7t5v0__or2_1_23/A1
+ vdd vss gf180mcu_fd_sc_mcu7t5v0__dffq_1_0/D gf180mcu_fd_sc_mcu7t5v0__inv_4_3/ZN
+ gf180mcu_fd_sc_mcu7t5v0__nor2_4_19/ZN vdd vss gf180mcu_fd_sc_mcu7t5v0__aoi211_1
Xgf180mcu_fd_sc_mcu7t5v0__tiel_12 uart_tx_CS vdd vss vdd vss gf180mcu_fd_sc_mcu7t5v0__tiel
Xgf180mcu_fd_sc_mcu7t5v0__dffq_2_3 gf180mcu_fd_sc_mcu7t5v0__dffq_2_3/D vdd vss gf180mcu_fd_sc_mcu7t5v0__dffq_4_6/CLK
+ gf180mcu_fd_sc_mcu7t5v0__or3_2_2/A1 vdd vss gf180mcu_fd_sc_mcu7t5v0__dffq_2
Xgf180mcu_fd_sc_mcu7t5v0__aoi22_1_0 gf180mcu_fd_sc_mcu7t5v0__and2_2_0/Z gf180mcu_fd_sc_mcu7t5v0__inv_8_0/I
+ vdd vss gf180mcu_fd_sc_mcu7t5v0__nor3_1_0/A2 gf180mcu_fd_sc_mcu7t5v0__or4_1_0/A1
+ gf180mcu_fd_sc_mcu7t5v0__and2_4_0/Z vdd vss gf180mcu_fd_sc_mcu7t5v0__aoi22_1
Xgf180mcu_fd_sc_mcu7t5v0__oai22_1_150 gf180mcu_fd_sc_mcu7t5v0__nand2_4_20/ZN gf180mcu_fd_sc_mcu7t5v0__nand2_2_27/ZN
+ gf180mcu_fd_sc_mcu7t5v0__oai22_1_150/B2 vdd vss gf180mcu_fd_sc_mcu7t5v0__dffq_1_144/D
+ gf180mcu_fd_sc_mcu7t5v0__aoi21_4_1/ZN vdd vss gf180mcu_fd_sc_mcu7t5v0__oai22_1
Xgf180mcu_fd_sc_mcu7t5v0__oai22_1_161 gf180mcu_fd_sc_mcu7t5v0__nand2_4_19/ZN gf180mcu_fd_sc_mcu7t5v0__nand2_2_26/ZN
+ gf180mcu_fd_sc_mcu7t5v0__oai22_1_161/B2 vdd vss gf180mcu_fd_sc_mcu7t5v0__dffq_1_155/D
+ gf180mcu_fd_sc_mcu7t5v0__oai22_1_88/A1 vdd vss gf180mcu_fd_sc_mcu7t5v0__oai22_1
Xgf180mcu_fd_sc_mcu7t5v0__oai221_1_0 gf180mcu_fd_sc_mcu7t5v0__nor3_1_3/ZN gf180mcu_fd_sc_mcu7t5v0__oai221_1_0/C
+ vdd vss gf180mcu_fd_sc_mcu7t5v0__oai21_1_6/A2 gf180mcu_fd_sc_mcu7t5v0__oai221_1_1/B2
+ gf180mcu_fd_sc_mcu7t5v0__or2_1_0/Z gf180mcu_fd_sc_mcu7t5v0__oai221_1_0/B2 vdd vss
+ gf180mcu_fd_sc_mcu7t5v0__oai221_1
Xgf180mcu_fd_sc_mcu7t5v0__oai22_1_172 gf180mcu_fd_sc_mcu7t5v0__nand2_4_23/ZN gf180mcu_fd_sc_mcu7t5v0__nand2_2_30/ZN
+ gf180mcu_fd_sc_mcu7t5v0__oai22_1_172/B2 vdd vss gf180mcu_fd_sc_mcu7t5v0__dffq_1_166/D
+ gf180mcu_fd_sc_mcu7t5v0__aoi21_4_5/ZN vdd vss gf180mcu_fd_sc_mcu7t5v0__oai22_1
Xgf180mcu_fd_sc_mcu7t5v0__oai22_1_183 gf180mcu_fd_sc_mcu7t5v0__nand2_4_24/ZN gf180mcu_fd_sc_mcu7t5v0__nand2_2_52/ZN
+ gf180mcu_fd_sc_mcu7t5v0__oai22_1_183/B2 vdd vss gf180mcu_fd_sc_mcu7t5v0__dffq_1_168/D
+ gf180mcu_fd_sc_mcu7t5v0__aoi21_4_2/ZN vdd vss gf180mcu_fd_sc_mcu7t5v0__oai22_1
Xgf180mcu_fd_sc_mcu7t5v0__oai22_1_194 gf180mcu_fd_sc_mcu7t5v0__nand2_4_15/ZN gf180mcu_fd_sc_mcu7t5v0__nand2_2_21/ZN
+ gf180mcu_fd_sc_mcu7t5v0__oai22_1_194/B2 vdd vss gf180mcu_fd_sc_mcu7t5v0__dffq_1_179/D
+ gf180mcu_fd_sc_mcu7t5v0__aoi21_4_2/ZN vdd vss gf180mcu_fd_sc_mcu7t5v0__oai22_1
Xgf180mcu_fd_sc_mcu7t5v0__xnor3_1_11 gf180mcu_fd_sc_mcu7t5v0__nor2_1_65/A2 vdd vss
+ gf180mcu_fd_sc_mcu7t5v0__xor2_1_38/A2 gf180mcu_fd_sc_mcu7t5v0__and2_1_21/Z gf180mcu_fd_sc_mcu7t5v0__xnor3_1_11/A2
+ vdd vss gf180mcu_fd_sc_mcu7t5v0__xnor3_1
Xgf180mcu_fd_sc_mcu7t5v0__xnor3_1_22 gf180mcu_fd_sc_mcu7t5v0__xnor3_1_22/A3 vdd vss
+ gf180mcu_fd_sc_mcu7t5v0__xor2_1_107/A2 gf180mcu_fd_sc_mcu7t5v0__xnor3_1_22/A1 gf180mcu_fd_sc_mcu7t5v0__xnor3_1_22/A2
+ vdd vss gf180mcu_fd_sc_mcu7t5v0__xnor3_1
Xgf180mcu_fd_sc_mcu7t5v0__xnor3_1_33 gf180mcu_fd_sc_mcu7t5v0__xnor3_1_33/A3 vdd vss
+ gf180mcu_fd_sc_mcu7t5v0__xnor3_1_33/ZN gf180mcu_fd_sc_mcu7t5v0__or2_1_38/A2 gf180mcu_fd_sc_mcu7t5v0__oai22_2_1/B2
+ vdd vss gf180mcu_fd_sc_mcu7t5v0__xnor3_1
Xgf180mcu_fd_sc_mcu7t5v0__xnor3_1_44 gf180mcu_fd_sc_mcu7t5v0__xnor3_1_44/A3 vdd vss
+ gf180mcu_fd_sc_mcu7t5v0__xor2_1_206/A2 gf180mcu_fd_sc_mcu7t5v0__xnor3_1_44/A1 gf180mcu_fd_sc_mcu7t5v0__or3_1_26/A1
+ vdd vss gf180mcu_fd_sc_mcu7t5v0__xnor3_1
Xgf180mcu_fd_sc_mcu7t5v0__aoi221_1_19 gf180mcu_fd_sc_mcu7t5v0__dffq_1_302/Q gf180mcu_fd_sc_mcu7t5v0__nor2_1_156/ZN
+ vdd vss gf180mcu_fd_sc_mcu7t5v0__nor2_1_155/A2 gf180mcu_fd_sc_mcu7t5v0__dffq_1_304/Q
+ gf180mcu_fd_sc_mcu7t5v0__or2_4_3/Z gf180mcu_fd_sc_mcu7t5v0__nor2_4_32/ZN vdd vss
+ gf180mcu_fd_sc_mcu7t5v0__aoi221_1
Xgf180mcu_fd_sc_mcu7t5v0__nor2_1_70 vdd vss gf180mcu_fd_sc_mcu7t5v0__nor2_1_70/ZN
+ gf180mcu_fd_sc_mcu7t5v0__inv_8_0/I gf180mcu_fd_sc_mcu7t5v0__and2_2_4/Z vdd vss gf180mcu_fd_sc_mcu7t5v0__nor2_1
Xgf180mcu_fd_sc_mcu7t5v0__nor2_1_81 vdd vss gf180mcu_fd_sc_mcu7t5v0__nor2_1_81/ZN
+ gf180mcu_fd_sc_mcu7t5v0__inv_8_1/I gf180mcu_fd_sc_mcu7t5v0__mux4_4_19/Z vdd vss
+ gf180mcu_fd_sc_mcu7t5v0__nor2_1
Xgf180mcu_fd_sc_mcu7t5v0__nor2_1_92 vdd vss gf180mcu_fd_sc_mcu7t5v0__oai32_1_2/A2
+ gf180mcu_fd_sc_mcu7t5v0__inv_8_2/ZN gf180mcu_fd_sc_mcu7t5v0__nor2_1_92/A2 vdd vss
+ gf180mcu_fd_sc_mcu7t5v0__nor2_1
Xgf180mcu_fd_sc_mcu7t5v0__clkinv_2_2 vdd vss gf180mcu_fd_sc_mcu7t5v0__dffq_1_13/Q
+ gf180mcu_fd_sc_mcu7t5v0__xor2_1_61/A1 vdd vss gf180mcu_fd_sc_mcu7t5v0__clkinv_2
Xgf180mcu_fd_sc_mcu7t5v0__nor2_1_270 vdd vss gf180mcu_fd_sc_mcu7t5v0__nor2_1_270/ZN
+ gf180mcu_fd_sc_mcu7t5v0__dffq_2_97/Q gf180mcu_fd_sc_mcu7t5v0__nor2_4_34/A2 vdd vss
+ gf180mcu_fd_sc_mcu7t5v0__nor2_1
Xgf180mcu_fd_sc_mcu7t5v0__oai31_1_3 vdd gf180mcu_fd_sc_mcu7t5v0__oai31_1_3/ZN gf180mcu_fd_sc_mcu7t5v0__oai31_1_3/B
+ gf180mcu_fd_sc_mcu7t5v0__oai31_1_3/A1 gf180mcu_fd_sc_mcu7t5v0__mux2_1_6/I1 vss gf180mcu_fd_sc_mcu7t5v0__and2_2_8/Z
+ vdd vss gf180mcu_fd_sc_mcu7t5v0__oai31_1
Xgf180mcu_fd_sc_mcu7t5v0__nor2_1_281 vdd vss gf180mcu_fd_sc_mcu7t5v0__nor2_1_281/ZN
+ gf180mcu_fd_sc_mcu7t5v0__inv_8_0/I gf180mcu_fd_sc_mcu7t5v0__nor4_2_5/A3 vdd vss
+ gf180mcu_fd_sc_mcu7t5v0__nor2_1
Xgf180mcu_fd_sc_mcu7t5v0__nor2_1_292 vdd vss gf180mcu_fd_sc_mcu7t5v0__or3_1_19/A3
+ gf180mcu_fd_sc_mcu7t5v0__or2_1_38/A1 gf180mcu_fd_sc_mcu7t5v0__or2_1_38/A2 vdd vss
+ gf180mcu_fd_sc_mcu7t5v0__nor2_1
Xgf180mcu_fd_sc_mcu7t5v0__nand2_1_13 vdd vss gf180mcu_fd_sc_mcu7t5v0__and2_1_5/A1
+ gf180mcu_fd_sc_mcu7t5v0__or3_2_1/A1 gf180mcu_fd_sc_mcu7t5v0__xor2_1_11/Z vdd vss
+ gf180mcu_fd_sc_mcu7t5v0__nand2_1
Xgf180mcu_fd_sc_mcu7t5v0__oai31_1_18 vdd gf180mcu_fd_sc_mcu7t5v0__oai31_1_18/ZN gf180mcu_fd_sc_mcu7t5v0__oai31_1_18/B
+ gf180mcu_fd_sc_mcu7t5v0__nor2_2_56/A1 gf180mcu_fd_sc_mcu7t5v0__nor2_2_56/A2 vss
+ gf180mcu_fd_sc_mcu7t5v0__xor2_1_196/Z vdd vss gf180mcu_fd_sc_mcu7t5v0__oai31_1
Xgf180mcu_fd_sc_mcu7t5v0__aoi221_4_1 gf180mcu_fd_sc_mcu7t5v0__aoi21_4_9/A1 gf180mcu_fd_sc_mcu7t5v0__nor2_4_40/ZN
+ gf180mcu_fd_sc_mcu7t5v0__inv_2_13/ZN gf180mcu_fd_sc_mcu7t5v0__aoi221_4_1/C vdd vss
+ gf180mcu_fd_sc_mcu7t5v0__xor2_1_192/A1 gf180mcu_fd_sc_mcu7t5v0__inv_4_7/I vdd vss
+ gf180mcu_fd_sc_mcu7t5v0__aoi221_4
Xgf180mcu_fd_sc_mcu7t5v0__nand2_1_24 vdd vss gf180mcu_fd_sc_mcu7t5v0__aoi22_1_3/A2
+ gf180mcu_fd_sc_mcu7t5v0__mux2_1_2/I0 gf180mcu_fd_sc_mcu7t5v0__oai221_1_1/B2 vdd
+ vss gf180mcu_fd_sc_mcu7t5v0__nand2_1
Xgf180mcu_fd_sc_mcu7t5v0__nand2_1_35 vdd vss gf180mcu_fd_sc_mcu7t5v0__nand2_1_35/ZN
+ gf180mcu_fd_sc_mcu7t5v0__oai31_1_5/B gf180mcu_fd_sc_mcu7t5v0__xor2_1_20/A1 vdd vss
+ gf180mcu_fd_sc_mcu7t5v0__nand2_1
Xgf180mcu_fd_sc_mcu7t5v0__nand2_1_46 vdd vss gf180mcu_fd_sc_mcu7t5v0__nor3_4_1/A2
+ gf180mcu_fd_sc_mcu7t5v0__and2_4_1/A1 gf180mcu_fd_sc_mcu7t5v0__and2_4_1/A2 vdd vss
+ gf180mcu_fd_sc_mcu7t5v0__nand2_1
Xgf180mcu_fd_sc_mcu7t5v0__and4_1_1 gf180mcu_fd_sc_mcu7t5v0__and4_1_1/A3 gf180mcu_fd_sc_mcu7t5v0__mux4_4_13/Z
+ vdd vss gf180mcu_fd_sc_mcu7t5v0__and4_1_1/Z gf180mcu_fd_sc_mcu7t5v0__inv_12_1/I
+ gf180mcu_fd_sc_mcu7t5v0__or3_1_21/Z vdd vss gf180mcu_fd_sc_mcu7t5v0__and4_1
Xgf180mcu_fd_sc_mcu7t5v0__nand2_1_57 vdd vss gf180mcu_fd_sc_mcu7t5v0__xor2_1_31/A1
+ gf180mcu_fd_sc_mcu7t5v0__inv_8_1/I gf180mcu_fd_sc_mcu7t5v0__xor2_1_20/A1 vdd vss
+ gf180mcu_fd_sc_mcu7t5v0__nand2_1
Xgf180mcu_fd_sc_mcu7t5v0__nand2_1_68 vdd vss gf180mcu_fd_sc_mcu7t5v0__nand2_1_68/ZN
+ gf180mcu_fd_sc_mcu7t5v0__mux4_4_3/I2 gf180mcu_fd_sc_mcu7t5v0__or2_4_4/Z vdd vss
+ gf180mcu_fd_sc_mcu7t5v0__nand2_1
Xgf180mcu_fd_sc_mcu7t5v0__nand2_1_79 vdd vss gf180mcu_fd_sc_mcu7t5v0__oai21_1_26/B
+ gf180mcu_fd_sc_mcu7t5v0__dffq_2_14/Q gf180mcu_fd_sc_mcu7t5v0__xor2_2_1/Z vdd vss
+ gf180mcu_fd_sc_mcu7t5v0__nand2_1
Xgf180mcu_fd_sc_mcu7t5v0__nor2_4_3 vdd vss gf180mcu_fd_sc_mcu7t5v0__nor2_4_3/ZN gf180mcu_fd_sc_mcu7t5v0__nor3_4_4/A1
+ gf180mcu_fd_sc_mcu7t5v0__nor2_4_3/A2 vdd vss gf180mcu_fd_sc_mcu7t5v0__nor2_4
Xgf180mcu_fd_sc_mcu7t5v0__oai21_1_330 vdd gf180mcu_fd_sc_mcu7t5v0__nor2_4_34/ZN gf180mcu_fd_sc_mcu7t5v0__nor2_2_32/ZN
+ gf180mcu_fd_sc_mcu7t5v0__aoi21_1_300/B gf180mcu_fd_sc_mcu7t5v0__inv_1_24/I vss vdd
+ vss gf180mcu_fd_sc_mcu7t5v0__oai21_1
Xgf180mcu_fd_sc_mcu7t5v0__xnor2_1_1 vdd vss gf180mcu_fd_sc_mcu7t5v0__nor3_2_0/A2 gf180mcu_fd_sc_mcu7t5v0__xor3_2_0/A1
+ gf180mcu_fd_sc_mcu7t5v0__xor2_1_4/Z vdd vss gf180mcu_fd_sc_mcu7t5v0__xnor2_1
Xgf180mcu_fd_sc_mcu7t5v0__oai22_1_3 gf180mcu_fd_sc_mcu7t5v0__xor3_1_15/A1 gf180mcu_fd_sc_mcu7t5v0__and2_1_11/Z
+ gf180mcu_fd_sc_mcu7t5v0__oai22_1_3/B2 vdd vss gf180mcu_fd_sc_mcu7t5v0__xnor3_1_9/A3
+ gf180mcu_fd_sc_mcu7t5v0__xnor3_1_7/A3 vdd vss gf180mcu_fd_sc_mcu7t5v0__oai22_1
Xgf180mcu_fd_sc_mcu7t5v0__aoi22_1_50 gf180mcu_fd_sc_mcu7t5v0__nor2_4_9/ZN gf180mcu_fd_sc_mcu7t5v0__dffq_1_93/Q
+ vdd vss gf180mcu_fd_sc_mcu7t5v0__aoi22_1_50/ZN gf180mcu_fd_sc_mcu7t5v0__dffq_1_87/Q
+ gf180mcu_fd_sc_mcu7t5v0__nor2_4_8/ZN vdd vss gf180mcu_fd_sc_mcu7t5v0__aoi22_1
Xgf180mcu_fd_sc_mcu7t5v0__aoi22_1_61 gf180mcu_fd_sc_mcu7t5v0__nor2_4_11/ZN gf180mcu_fd_sc_mcu7t5v0__dffq_1_179/Q
+ vdd vss gf180mcu_fd_sc_mcu7t5v0__aoi22_1_61/ZN gf180mcu_fd_sc_mcu7t5v0__dffq_1_262/Q
+ gf180mcu_fd_sc_mcu7t5v0__nor2_4_10/ZN vdd vss gf180mcu_fd_sc_mcu7t5v0__aoi22_1
Xgf180mcu_fd_sc_mcu7t5v0__aoi22_1_72 gf180mcu_fd_sc_mcu7t5v0__nor2_4_11/ZN gf180mcu_fd_sc_mcu7t5v0__dffq_1_124/Q
+ vdd vss gf180mcu_fd_sc_mcu7t5v0__aoi22_1_72/ZN gf180mcu_fd_sc_mcu7t5v0__dffq_1_126/Q
+ gf180mcu_fd_sc_mcu7t5v0__nor2_4_10/ZN vdd vss gf180mcu_fd_sc_mcu7t5v0__aoi22_1
Xgf180mcu_fd_sc_mcu7t5v0__aoi22_1_83 gf180mcu_fd_sc_mcu7t5v0__nor2_4_9/ZN gf180mcu_fd_sc_mcu7t5v0__dffq_1_146/Q
+ vdd vss gf180mcu_fd_sc_mcu7t5v0__aoi22_1_83/ZN gf180mcu_fd_sc_mcu7t5v0__dffq_1_144/Q
+ gf180mcu_fd_sc_mcu7t5v0__nor2_4_8/ZN vdd vss gf180mcu_fd_sc_mcu7t5v0__aoi22_1
Xgf180mcu_fd_sc_mcu7t5v0__aoi22_1_94 gf180mcu_fd_sc_mcu7t5v0__nor2_4_9/ZN gf180mcu_fd_sc_mcu7t5v0__dffq_1_323/Q
+ vdd vss gf180mcu_fd_sc_mcu7t5v0__aoi22_1_94/ZN gf180mcu_fd_sc_mcu7t5v0__dffq_1_457/Q
+ gf180mcu_fd_sc_mcu7t5v0__nor2_4_8/ZN vdd vss gf180mcu_fd_sc_mcu7t5v0__aoi22_1
Xgf180mcu_fd_sc_mcu7t5v0__inv_1_3 vss gf180mcu_fd_sc_mcu7t5v0__inv_1_3/ZN gf180mcu_fd_sc_mcu7t5v0__inv_1_3/I
+ vdd vdd vss gf180mcu_fd_sc_mcu7t5v0__inv_1
Xgf180mcu_fd_sc_mcu7t5v0__nand3_2_12 gf180mcu_fd_sc_mcu7t5v0__aoi22_2_1/ZN vdd vss
+ gf180mcu_fd_sc_mcu7t5v0__nand3_2_12/ZN gf180mcu_fd_sc_mcu7t5v0__xor3_1_159/A1 gf180mcu_fd_sc_mcu7t5v0__nand3_2_12/A2
+ vdd vss gf180mcu_fd_sc_mcu7t5v0__nand3_2
Xgf180mcu_fd_sc_mcu7t5v0__nand3_2_23 gf180mcu_fd_sc_mcu7t5v0__oai32_1_4/B2 vdd vss
+ gf180mcu_fd_sc_mcu7t5v0__clkinv_2_7/I gf180mcu_fd_sc_mcu7t5v0__oai32_1_5/B1 gf180mcu_fd_sc_mcu7t5v0__oai32_1_5/A2
+ vdd vss gf180mcu_fd_sc_mcu7t5v0__nand3_2
Xgf180mcu_fd_sc_mcu7t5v0__nand2_1_709 vdd vss gf180mcu_fd_sc_mcu7t5v0__nand4_1_11/A2
+ gf180mcu_fd_sc_mcu7t5v0__nor2_4_33/ZN gf180mcu_fd_sc_mcu7t5v0__xor2_1_219/Z vdd
+ vss gf180mcu_fd_sc_mcu7t5v0__nand2_1
Xgf180mcu_fd_sc_mcu7t5v0__oai32_4_1 gf180mcu_fd_sc_mcu7t5v0__oai32_4_1/A3 gf180mcu_fd_sc_mcu7t5v0__or2_2_1/Z
+ gf180mcu_fd_sc_mcu7t5v0__dffq_2_70/Q vdd vss gf180mcu_fd_sc_mcu7t5v0__inv_1_13/I
+ gf180mcu_fd_sc_mcu7t5v0__oai32_4_1/A1 gf180mcu_fd_sc_mcu7t5v0__oai32_4_1/A2 vdd
+ vss gf180mcu_fd_sc_mcu7t5v0__oai32_4
Xgf180mcu_fd_sc_mcu7t5v0__and2_1_17 vdd vss gf180mcu_fd_sc_mcu7t5v0__and2_1_17/Z gf180mcu_fd_sc_mcu7t5v0__inv_12_1/I
+ gf180mcu_fd_sc_mcu7t5v0__or4_1_1/A3 vdd vss gf180mcu_fd_sc_mcu7t5v0__and2_1
Xgf180mcu_fd_sc_mcu7t5v0__and2_1_28 vdd vss gf180mcu_fd_sc_mcu7t5v0__and2_1_28/Z gf180mcu_fd_sc_mcu7t5v0__inv_4_0/I
+ gf180mcu_fd_sc_mcu7t5v0__nor2_1_84/ZN vdd vss gf180mcu_fd_sc_mcu7t5v0__and2_1
Xgf180mcu_fd_sc_mcu7t5v0__and2_1_39 vdd vss gf180mcu_fd_sc_mcu7t5v0__dffq_2_26/D gf180mcu_fd_sc_mcu7t5v0__buf_8_5/I
+ gf180mcu_fd_sc_mcu7t5v0__and2_1_39/A2 vdd vss gf180mcu_fd_sc_mcu7t5v0__and2_1
Xgf180mcu_fd_sc_mcu7t5v0__nor2_2_0 vdd vss gf180mcu_fd_sc_mcu7t5v0__xor2_1_1/A2 gf180mcu_fd_sc_mcu7t5v0__nor2_2_0/A1
+ gf180mcu_fd_sc_mcu7t5v0__or2_1_14/A1 vdd vss gf180mcu_fd_sc_mcu7t5v0__nor2_2
Xgf180mcu_fd_sc_mcu7t5v0__oai21_1_160 vdd gf180mcu_fd_sc_mcu7t5v0__oai21_1_163/B gf180mcu_fd_sc_mcu7t5v0__and2_1_66/Z
+ gf180mcu_fd_sc_mcu7t5v0__nor2_1_200/A2 gf180mcu_fd_sc_mcu7t5v0__nor3_1_17/A2 vss
+ vdd vss gf180mcu_fd_sc_mcu7t5v0__oai21_1
Xgf180mcu_fd_sc_mcu7t5v0__oai21_1_171 vdd gf180mcu_fd_sc_mcu7t5v0__oai21_1_171/B gf180mcu_fd_sc_mcu7t5v0__or3_1_13/A3
+ gf180mcu_fd_sc_mcu7t5v0__oai21_1_170/B gf180mcu_fd_sc_mcu7t5v0__oai32_1_4/B2 vss
+ vdd vss gf180mcu_fd_sc_mcu7t5v0__oai21_1
Xgf180mcu_fd_sc_mcu7t5v0__oai21_1_182 vdd gf180mcu_fd_sc_mcu7t5v0__buf_8_7/Z gf180mcu_fd_sc_mcu7t5v0__dffq_1_392/Q
+ gf180mcu_fd_sc_mcu7t5v0__aoi21_1_207/B gf180mcu_fd_sc_mcu7t5v0__dffq_4_20/Q vss
+ vdd vss gf180mcu_fd_sc_mcu7t5v0__oai21_1
Xgf180mcu_fd_sc_mcu7t5v0__oai21_1_193 vdd gf180mcu_fd_sc_mcu7t5v0__oai21_1_193/B gf180mcu_fd_sc_mcu7t5v0__nor2_1_232/ZN
+ gf180mcu_fd_sc_mcu7t5v0__xor2_1_105/A1 gf180mcu_fd_sc_mcu7t5v0__xor2_1_104/A1 vss
+ vdd vss gf180mcu_fd_sc_mcu7t5v0__oai21_1
Xgf180mcu_fd_sc_mcu7t5v0__aoi211_1_18 gf180mcu_fd_sc_mcu7t5v0__aoi211_1_18/B gf180mcu_fd_sc_mcu7t5v0__nor2_1_88/ZN
+ vdd vss gf180mcu_fd_sc_mcu7t5v0__aoi211_1_17/B gf180mcu_fd_sc_mcu7t5v0__and2_2_8/Z
+ gf180mcu_fd_sc_mcu7t5v0__xor2_1_60/Z vdd vss gf180mcu_fd_sc_mcu7t5v0__aoi211_1
Xgf180mcu_fd_sc_mcu7t5v0__aoi211_1_29 gf180mcu_fd_sc_mcu7t5v0__nor2_1_119/ZN gf180mcu_fd_sc_mcu7t5v0__or2_1_23/A1
+ vdd vss gf180mcu_fd_sc_mcu7t5v0__dffq_1_247/D gf180mcu_fd_sc_mcu7t5v0__nor2_1_144/A1
+ gf180mcu_fd_sc_mcu7t5v0__nor2_4_21/ZN vdd vss gf180mcu_fd_sc_mcu7t5v0__aoi211_1
Xgf180mcu_fd_sc_mcu7t5v0__clkinv_1_20 vdd vss gf180mcu_fd_sc_mcu7t5v0__xor3_1_4/A1
+ gf180mcu_fd_sc_mcu7t5v0__aoi21_1_1/A1 vdd vss gf180mcu_fd_sc_mcu7t5v0__clkinv_1
Xgf180mcu_fd_sc_mcu7t5v0__clkinv_1_31 vdd vss gf180mcu_fd_sc_mcu7t5v0__dffq_1_20/Q
+ gf180mcu_fd_sc_mcu7t5v0__oai22_1_18/B2 vdd vss gf180mcu_fd_sc_mcu7t5v0__clkinv_1
Xgf180mcu_fd_sc_mcu7t5v0__clkinv_1_42 vdd vss gf180mcu_fd_sc_mcu7t5v0__dffq_1_29/Q
+ gf180mcu_fd_sc_mcu7t5v0__oai22_1_34/B2 vdd vss gf180mcu_fd_sc_mcu7t5v0__clkinv_1
Xgf180mcu_fd_sc_mcu7t5v0__clkinv_1_53 vdd vss gf180mcu_fd_sc_mcu7t5v0__dffq_1_42/Q
+ gf180mcu_fd_sc_mcu7t5v0__oai22_1_41/A1 vdd vss gf180mcu_fd_sc_mcu7t5v0__clkinv_1
Xgf180mcu_fd_sc_mcu7t5v0__clkinv_1_64 vdd vss gf180mcu_fd_sc_mcu7t5v0__dffq_1_70/Q
+ gf180mcu_fd_sc_mcu7t5v0__oai22_1_63/B2 vdd vss gf180mcu_fd_sc_mcu7t5v0__clkinv_1
Xgf180mcu_fd_sc_mcu7t5v0__clkinv_1_75 vdd vss gf180mcu_fd_sc_mcu7t5v0__dffq_1_65/Q
+ gf180mcu_fd_sc_mcu7t5v0__oai22_1_57/B2 vdd vss gf180mcu_fd_sc_mcu7t5v0__clkinv_1
Xgf180mcu_fd_sc_mcu7t5v0__aoi21_1_206 gf180mcu_fd_sc_mcu7t5v0__aoi21_1_206/B vdd vss
+ gf180mcu_fd_sc_mcu7t5v0__dffq_1_405/D gf180mcu_fd_sc_mcu7t5v0__nor3_4_15/ZN gf180mcu_fd_sc_mcu7t5v0__aoi22_4_4/ZN
+ vdd vss gf180mcu_fd_sc_mcu7t5v0__aoi21_1
Xgf180mcu_fd_sc_mcu7t5v0__clkinv_1_86 vdd vss gf180mcu_fd_sc_mcu7t5v0__dffq_1_94/Q
+ gf180mcu_fd_sc_mcu7t5v0__oai22_1_70/B2 vdd vss gf180mcu_fd_sc_mcu7t5v0__clkinv_1
Xgf180mcu_fd_sc_mcu7t5v0__aoi21_1_217 gf180mcu_fd_sc_mcu7t5v0__and2_1_90/Z vdd vss
+ gf180mcu_fd_sc_mcu7t5v0__xor2_1_146/A1 gf180mcu_fd_sc_mcu7t5v0__xor3_1_106/A2 gf180mcu_fd_sc_mcu7t5v0__or2_1_40/Z
+ vdd vss gf180mcu_fd_sc_mcu7t5v0__aoi21_1
Xgf180mcu_fd_sc_mcu7t5v0__clkinv_1_97 vdd vss gf180mcu_fd_sc_mcu7t5v0__dffq_1_92/Q
+ gf180mcu_fd_sc_mcu7t5v0__oai22_1_80/B2 vdd vss gf180mcu_fd_sc_mcu7t5v0__clkinv_1
Xgf180mcu_fd_sc_mcu7t5v0__aoi21_1_228 gf180mcu_fd_sc_mcu7t5v0__oai31_1_13/ZN vdd vss
+ gf180mcu_fd_sc_mcu7t5v0__oai31_1_14/A2 gf180mcu_fd_sc_mcu7t5v0__or2_1_31/Z gf180mcu_fd_sc_mcu7t5v0__xor3_1_159/Z
+ vdd vss gf180mcu_fd_sc_mcu7t5v0__aoi21_1
Xgf180mcu_fd_sc_mcu7t5v0__aoi21_1_239 gf180mcu_fd_sc_mcu7t5v0__mux2_1_9/I1 vdd vss
+ gf180mcu_fd_sc_mcu7t5v0__oai32_1_8/A3 gf180mcu_fd_sc_mcu7t5v0__inv_8_2/I gf180mcu_fd_sc_mcu7t5v0__oai32_1_8/B1
+ vdd vss gf180mcu_fd_sc_mcu7t5v0__aoi21_1
Xgf180mcu_fd_sc_mcu7t5v0__oai21_1_17 vdd gf180mcu_fd_sc_mcu7t5v0__oai21_1_17/B gf180mcu_fd_sc_mcu7t5v0__nor2_1_35/ZN
+ gf180mcu_fd_sc_mcu7t5v0__xor3_1_17/A2 gf180mcu_fd_sc_mcu7t5v0__xor3_1_26/A2 vss
+ vdd vss gf180mcu_fd_sc_mcu7t5v0__oai21_1
Xgf180mcu_fd_sc_mcu7t5v0__oai21_1_28 vdd gf180mcu_fd_sc_mcu7t5v0__oai21_1_28/B gf180mcu_fd_sc_mcu7t5v0__oai21_1_28/A2
+ gf180mcu_fd_sc_mcu7t5v0__oai21_1_27/B gf180mcu_fd_sc_mcu7t5v0__oai21_1_28/A1 vss
+ vdd vss gf180mcu_fd_sc_mcu7t5v0__oai21_1
Xgf180mcu_fd_sc_mcu7t5v0__oai21_1_39 vdd gf180mcu_fd_sc_mcu7t5v0__and2_4_3/Z gf180mcu_fd_sc_mcu7t5v0__or2_1_34/A2
+ gf180mcu_fd_sc_mcu7t5v0__nor2_1_54/A2 gf180mcu_fd_sc_mcu7t5v0__or3_2_2/A1 vss vdd
+ vss gf180mcu_fd_sc_mcu7t5v0__oai21_1
Xgf180mcu_fd_sc_mcu7t5v0__and2_4_2 gf180mcu_fd_sc_mcu7t5v0__and2_4_2/A2 vdd vss gf180mcu_fd_sc_mcu7t5v0__and2_4_2/Z
+ gf180mcu_fd_sc_mcu7t5v0__or3_2_2/Z vdd vss gf180mcu_fd_sc_mcu7t5v0__and2_4
Xgf180mcu_fd_sc_mcu7t5v0__aoi21_2_9 gf180mcu_fd_sc_mcu7t5v0__aoi21_2_9/B vdd vss gf180mcu_fd_sc_mcu7t5v0__aoi21_2_9/ZN
+ gf180mcu_fd_sc_mcu7t5v0__aoi21_2_9/A1 gf180mcu_fd_sc_mcu7t5v0__aoi21_2_9/A2 vdd
+ vss gf180mcu_fd_sc_mcu7t5v0__aoi21_2
Xgf180mcu_fd_sc_mcu7t5v0__nand2_1_506 vdd vss gf180mcu_fd_sc_mcu7t5v0__xnor2_1_51/A1
+ gf180mcu_fd_sc_mcu7t5v0__dffq_4_37/Q gf180mcu_fd_sc_mcu7t5v0__and2_2_9/Z vdd vss
+ gf180mcu_fd_sc_mcu7t5v0__nand2_1
Xgf180mcu_fd_sc_mcu7t5v0__nand2_1_517 vdd vss gf180mcu_fd_sc_mcu7t5v0__nand4_1_16/A2
+ gf180mcu_fd_sc_mcu7t5v0__nor2_4_33/ZN gf180mcu_fd_sc_mcu7t5v0__or2_1_40/A2 vdd vss
+ gf180mcu_fd_sc_mcu7t5v0__nand2_1
Xgf180mcu_fd_sc_mcu7t5v0__nand4_1_2 gf180mcu_fd_sc_mcu7t5v0__or4_1_1/A2 gf180mcu_fd_sc_mcu7t5v0__xor2_1_58/A1
+ vdd vss gf180mcu_fd_sc_mcu7t5v0__oai21_1_42/B gf180mcu_fd_sc_mcu7t5v0__inv_8_2/I
+ gf180mcu_fd_sc_mcu7t5v0__inv_12_1/I vdd vss gf180mcu_fd_sc_mcu7t5v0__nand4_1
Xgf180mcu_fd_sc_mcu7t5v0__nand2_1_528 vdd vss gf180mcu_fd_sc_mcu7t5v0__oai21_1_246/A2
+ gf180mcu_fd_sc_mcu7t5v0__nor2_1_315/A2 gf180mcu_fd_sc_mcu7t5v0__nand2_1_528/A2 vdd
+ vss gf180mcu_fd_sc_mcu7t5v0__nand2_1
Xgf180mcu_fd_sc_mcu7t5v0__nand2_1_539 vdd vss gf180mcu_fd_sc_mcu7t5v0__nand2_1_539/ZN
+ gf180mcu_fd_sc_mcu7t5v0__mux4_4_0/I3 gf180mcu_fd_sc_mcu7t5v0__clkinv_3_9/ZN vdd
+ vss gf180mcu_fd_sc_mcu7t5v0__nand2_1
Xgf180mcu_fd_sc_mcu7t5v0__aoi21_2_19 gf180mcu_fd_sc_mcu7t5v0__inv_1_20/I vdd vss gf180mcu_fd_sc_mcu7t5v0__nor3_2_9/A3
+ gf180mcu_fd_sc_mcu7t5v0__xor3_1_151/A1 gf180mcu_fd_sc_mcu7t5v0__dffq_4_32/Q vdd
+ vss gf180mcu_fd_sc_mcu7t5v0__aoi21_2
Xgf180mcu_fd_sc_mcu7t5v0__oai211_2_9 gf180mcu_fd_sc_mcu7t5v0__oai31_4_3/ZN gf180mcu_fd_sc_mcu7t5v0__xnor3_1_22/A3
+ gf180mcu_fd_sc_mcu7t5v0__aoi21_4_8/ZN gf180mcu_fd_sc_mcu7t5v0__oai21_4_13/B gf180mcu_fd_sc_mcu7t5v0__inv_12_1/I
+ vdd vss vdd vss gf180mcu_fd_sc_mcu7t5v0__oai211_2
Xgf180mcu_fd_sc_mcu7t5v0__nand3_1_101 gf180mcu_fd_sc_mcu7t5v0__and2_1_91/Z vdd vss
+ gf180mcu_fd_sc_mcu7t5v0__nand3_1_101/ZN gf180mcu_fd_sc_mcu7t5v0__inv_8_0/I gf180mcu_fd_sc_mcu7t5v0__mux4_4_6/Z
+ vdd vss gf180mcu_fd_sc_mcu7t5v0__nand3_1
Xgf180mcu_fd_sc_mcu7t5v0__or3_1_15 gf180mcu_fd_sc_mcu7t5v0__xor3_1_76/Z vdd vss gf180mcu_fd_sc_mcu7t5v0__or3_1_15/Z
+ gf180mcu_fd_sc_mcu7t5v0__or3_1_15/A1 gf180mcu_fd_sc_mcu7t5v0__or3_1_15/A2 vdd vss
+ gf180mcu_fd_sc_mcu7t5v0__or3_1
Xgf180mcu_fd_sc_mcu7t5v0__or3_1_26 gf180mcu_fd_sc_mcu7t5v0__or3_1_26/A3 vdd vss gf180mcu_fd_sc_mcu7t5v0__or3_1_26/Z
+ gf180mcu_fd_sc_mcu7t5v0__or3_1_26/A1 gf180mcu_fd_sc_mcu7t5v0__and4_1_3/Z vdd vss
+ gf180mcu_fd_sc_mcu7t5v0__or3_1
Xgf180mcu_fd_sc_mcu7t5v0__nor3_4_15 gf180mcu_fd_sc_mcu7t5v0__inv_1_12/I vdd vss gf180mcu_fd_sc_mcu7t5v0__nor3_4_15/ZN
+ gf180mcu_fd_sc_mcu7t5v0__inv_1_11/I gf180mcu_fd_sc_mcu7t5v0__nor3_4_15/A2 vdd vss
+ gf180mcu_fd_sc_mcu7t5v0__nor3_4
Xgf180mcu_fd_sc_mcu7t5v0__nand2_1_303 vdd vss gf180mcu_fd_sc_mcu7t5v0__xnor2_1_31/A1
+ gf180mcu_fd_sc_mcu7t5v0__xor2_1_88/Z gf180mcu_fd_sc_mcu7t5v0__xor2_1_83/Z vdd vss
+ gf180mcu_fd_sc_mcu7t5v0__nand2_1
Xgf180mcu_fd_sc_mcu7t5v0__nand2_1_314 vdd vss gf180mcu_fd_sc_mcu7t5v0__oai21_1_106/B
+ gf180mcu_fd_sc_mcu7t5v0__dffq_4_20/Q gf180mcu_fd_sc_mcu7t5v0__buf_8_7/Z vdd vss
+ gf180mcu_fd_sc_mcu7t5v0__nand2_1
Xgf180mcu_fd_sc_mcu7t5v0__nand2_1_325 vdd vss gf180mcu_fd_sc_mcu7t5v0__nand2_1_325/ZN
+ gf180mcu_fd_sc_mcu7t5v0__dffq_2_41/Q gf180mcu_fd_sc_mcu7t5v0__clkinv_3_9/ZN vdd
+ vss gf180mcu_fd_sc_mcu7t5v0__nand2_1
Xgf180mcu_fd_sc_mcu7t5v0__nand2_1_336 vdd vss gf180mcu_fd_sc_mcu7t5v0__oai211_1_20/B
+ gf180mcu_fd_sc_mcu7t5v0__inv_4_2/I gf180mcu_fd_sc_mcu7t5v0__nor2_4_21/ZN vdd vss
+ gf180mcu_fd_sc_mcu7t5v0__nand2_1
Xgf180mcu_fd_sc_mcu7t5v0__nand2_1_347 vdd vss gf180mcu_fd_sc_mcu7t5v0__oai21_1_154/B
+ gf180mcu_fd_sc_mcu7t5v0__oai31_2_0/A2 gf180mcu_fd_sc_mcu7t5v0__or3_1_11/Z vdd vss
+ gf180mcu_fd_sc_mcu7t5v0__nand2_1
Xgf180mcu_fd_sc_mcu7t5v0__nand2_1_358 vdd vss gf180mcu_fd_sc_mcu7t5v0__aoi21_1_169/B
+ gf180mcu_fd_sc_mcu7t5v0__aoi22_4_8/ZN gf180mcu_fd_sc_mcu7t5v0__nand2_1_360/ZN vdd
+ vss gf180mcu_fd_sc_mcu7t5v0__nand2_1
Xgf180mcu_fd_sc_mcu7t5v0__nand2_1_369 vdd vss gf180mcu_fd_sc_mcu7t5v0__nor3_1_24/A3
+ gf180mcu_fd_sc_mcu7t5v0__buf_8_8/Z gf180mcu_fd_sc_mcu7t5v0__nand4_1_8/A2 vdd vss
+ gf180mcu_fd_sc_mcu7t5v0__nand2_1
Xgf180mcu_fd_sc_mcu7t5v0__dffq_1_400 vdd gf180mcu_fd_sc_mcu7t5v0__dffq_1_400/Q gf180mcu_fd_sc_mcu7t5v0__dffq_4_21/CLK
+ vss gf180mcu_fd_sc_mcu7t5v0__dffq_1_400/D vdd vss gf180mcu_fd_sc_mcu7t5v0__dffq_1
Xgf180mcu_fd_sc_mcu7t5v0__dffq_1_411 vdd gf180mcu_fd_sc_mcu7t5v0__dffq_1_411/Q gf180mcu_fd_sc_mcu7t5v0__dffq_2_58/CLK
+ vss gf180mcu_fd_sc_mcu7t5v0__dffq_1_411/D vdd vss gf180mcu_fd_sc_mcu7t5v0__dffq_1
Xgf180mcu_fd_sc_mcu7t5v0__dffq_1_422 vdd gf180mcu_fd_sc_mcu7t5v0__dffq_1_422/Q gf180mcu_fd_sc_mcu7t5v0__dffq_4_1/CLK
+ vss gf180mcu_fd_sc_mcu7t5v0__dffq_1_422/D vdd vss gf180mcu_fd_sc_mcu7t5v0__dffq_1
Xgf180mcu_fd_sc_mcu7t5v0__dffq_1_433 vdd gf180mcu_fd_sc_mcu7t5v0__dffq_1_433/Q gf180mcu_fd_sc_mcu7t5v0__dffq_4_44/CLK
+ vss gf180mcu_fd_sc_mcu7t5v0__dffq_1_433/D vdd vss gf180mcu_fd_sc_mcu7t5v0__dffq_1
Xgf180mcu_fd_sc_mcu7t5v0__dffq_1_444 vdd gf180mcu_fd_sc_mcu7t5v0__oai31_2_1/A2 gf180mcu_fd_sc_mcu7t5v0__dffq_4_1/CLK
+ vss gf180mcu_fd_sc_mcu7t5v0__dffq_1_444/D vdd vss gf180mcu_fd_sc_mcu7t5v0__dffq_1
Xgf180mcu_fd_sc_mcu7t5v0__dffq_1_455 vdd gf180mcu_fd_sc_mcu7t5v0__mux4_4_2/I2 gf180mcu_fd_sc_mcu7t5v0__dffq_4_6/CLK
+ vss gf180mcu_fd_sc_mcu7t5v0__dffq_1_455/D vdd vss gf180mcu_fd_sc_mcu7t5v0__dffq_1
Xgf180mcu_fd_sc_mcu7t5v0__clkinv_1_305 vdd vss gf180mcu_fd_sc_mcu7t5v0__dffq_1_329/Q
+ gf180mcu_fd_sc_mcu7t5v0__aoi21_1_154/A1 vdd vss gf180mcu_fd_sc_mcu7t5v0__clkinv_1
Xgf180mcu_fd_sc_mcu7t5v0__clkinv_1_316 vdd vss gf180mcu_fd_sc_mcu7t5v0__dffq_2_52/Q
+ gf180mcu_fd_sc_mcu7t5v0__oai31_1_10/A2 vdd vss gf180mcu_fd_sc_mcu7t5v0__clkinv_1
Xgf180mcu_fd_sc_mcu7t5v0__clkinv_1_327 vdd vss gf180mcu_fd_sc_mcu7t5v0__xor3_1_79/Z
+ gf180mcu_fd_sc_mcu7t5v0__xor3_1_82/A3 vdd vss gf180mcu_fd_sc_mcu7t5v0__clkinv_1
Xgf180mcu_fd_sc_mcu7t5v0__clkinv_1_338 vdd vss gf180mcu_fd_sc_mcu7t5v0__mux4_4_9/S0
+ gf180mcu_fd_sc_mcu7t5v0__nor2_1_300/A1 vdd vss gf180mcu_fd_sc_mcu7t5v0__clkinv_1
Xgf180mcu_fd_sc_mcu7t5v0__clkinv_1_349 vdd vss gf180mcu_fd_sc_mcu7t5v0__xor3_2_2/A2
+ gf180mcu_fd_sc_mcu7t5v0__aoi21_1_319/A1 vdd vss gf180mcu_fd_sc_mcu7t5v0__clkinv_1
Xgf180mcu_fd_sc_mcu7t5v0__nand2_4_3 vdd vss gf180mcu_fd_sc_mcu7t5v0__nand2_4_3/ZN
+ gf180mcu_fd_sc_mcu7t5v0__nor3_4_11/ZN gf180mcu_fd_sc_mcu7t5v0__nor3_4_8/ZN vdd vss
+ gf180mcu_fd_sc_mcu7t5v0__nand2_4
Xgf180mcu_fd_sc_mcu7t5v0__nand2_4_13 vdd vss gf180mcu_fd_sc_mcu7t5v0__oai22_1_99/A2
+ gf180mcu_fd_sc_mcu7t5v0__nor3_4_8/ZN gf180mcu_fd_sc_mcu7t5v0__nor3_4_6/ZN vdd vss
+ gf180mcu_fd_sc_mcu7t5v0__nand2_4
Xgf180mcu_fd_sc_mcu7t5v0__nand2_4_24 vdd vss gf180mcu_fd_sc_mcu7t5v0__nand2_4_24/ZN
+ gf180mcu_fd_sc_mcu7t5v0__nor2_4_5/ZN gf180mcu_fd_sc_mcu7t5v0__nor3_4_8/ZN vdd vss
+ gf180mcu_fd_sc_mcu7t5v0__nand2_4
Xgf180mcu_fd_sc_mcu7t5v0__nand2_4_35 vdd vss gf180mcu_fd_sc_mcu7t5v0__oai22_1_90/A2
+ gf180mcu_fd_sc_mcu7t5v0__nor3_4_9/ZN gf180mcu_fd_sc_mcu7t5v0__nor2_4_7/ZN vdd vss
+ gf180mcu_fd_sc_mcu7t5v0__nand2_4
Xgf180mcu_fd_sc_mcu7t5v0__nand2_4_46 vdd vss gf180mcu_fd_sc_mcu7t5v0__oai211_1_43/C
+ gf180mcu_fd_sc_mcu7t5v0__inv_3_4/I gf180mcu_fd_sc_mcu7t5v0__nor2_2_47/ZN vdd vss
+ gf180mcu_fd_sc_mcu7t5v0__nand2_4
Xgf180mcu_fd_sc_mcu7t5v0__nor4_1_3 gf180mcu_fd_sc_mcu7t5v0__or3_2_4/A1 gf180mcu_fd_sc_mcu7t5v0__nor4_4_2/A2
+ vdd vss gf180mcu_fd_sc_mcu7t5v0__nor4_1_3/ZN gf180mcu_fd_sc_mcu7t5v0__nor4_1_3/A1
+ gf180mcu_fd_sc_mcu7t5v0__nor4_4_2/A1 vdd vss gf180mcu_fd_sc_mcu7t5v0__nor4_1
Xgf180mcu_fd_sc_mcu7t5v0__dffq_4_7 gf180mcu_fd_sc_mcu7t5v0__dffq_4_7/D gf180mcu_fd_sc_mcu7t5v0__dffq_4_7/Q
+ vdd vss gf180mcu_fd_sc_mcu7t5v0__dffq_4_8/CLK vdd vss gf180mcu_fd_sc_mcu7t5v0__dffq_4
Xgf180mcu_fd_sc_mcu7t5v0__nand2_1_100 vdd vss gf180mcu_fd_sc_mcu7t5v0__xor3_1_31/A2
+ gf180mcu_fd_sc_mcu7t5v0__inv_12_1/I gf180mcu_fd_sc_mcu7t5v0__and4_1_0/A4 vdd vss
+ gf180mcu_fd_sc_mcu7t5v0__nand2_1
Xgf180mcu_fd_sc_mcu7t5v0__nand2_1_111 vdd vss gf180mcu_fd_sc_mcu7t5v0__xor3_1_34/A2
+ gf180mcu_fd_sc_mcu7t5v0__inv_8_2/I gf180mcu_fd_sc_mcu7t5v0__or4_1_1/A2 vdd vss gf180mcu_fd_sc_mcu7t5v0__nand2_1
Xgf180mcu_fd_sc_mcu7t5v0__nand2_1_122 vdd vss gf180mcu_fd_sc_mcu7t5v0__xor3_1_48/A3
+ gf180mcu_fd_sc_mcu7t5v0__inv_12_1/I gf180mcu_fd_sc_mcu7t5v0__aoi22_4_1/ZN vdd vss
+ gf180mcu_fd_sc_mcu7t5v0__nand2_1
Xgf180mcu_fd_sc_mcu7t5v0__nand2_1_133 vdd vss gf180mcu_fd_sc_mcu7t5v0__xnor2_1_18/A2
+ gf180mcu_fd_sc_mcu7t5v0__inv_12_1/I gf180mcu_fd_sc_mcu7t5v0__xnor2_1_25/A1 vdd vss
+ gf180mcu_fd_sc_mcu7t5v0__nand2_1
Xgf180mcu_fd_sc_mcu7t5v0__nand2_1_144 vdd vss gf180mcu_fd_sc_mcu7t5v0__xnor3_1_12/A1
+ gf180mcu_fd_sc_mcu7t5v0__inv_4_6/I gf180mcu_fd_sc_mcu7t5v0__and2_4_0/Z vdd vss gf180mcu_fd_sc_mcu7t5v0__nand2_1
Xgf180mcu_fd_sc_mcu7t5v0__nand2_1_155 vdd vss gf180mcu_fd_sc_mcu7t5v0__aoi21_1_74/A1
+ gf180mcu_fd_sc_mcu7t5v0__mux4_4_5/I1 gf180mcu_fd_sc_mcu7t5v0__or2_4_4/Z vdd vss
+ gf180mcu_fd_sc_mcu7t5v0__nand2_1
Xgf180mcu_fd_sc_mcu7t5v0__nand2_1_166 vdd vss gf180mcu_fd_sc_mcu7t5v0__xor3_1_53/A3
+ gf180mcu_fd_sc_mcu7t5v0__or4_1_1/A1 gf180mcu_fd_sc_mcu7t5v0__oai31_1_2/B vdd vss
+ gf180mcu_fd_sc_mcu7t5v0__nand2_1
Xgf180mcu_fd_sc_mcu7t5v0__nand2_1_177 vdd vss gf180mcu_fd_sc_mcu7t5v0__aoi21_1_83/A1
+ gf180mcu_fd_sc_mcu7t5v0__dffq_2_21/Q gf180mcu_fd_sc_mcu7t5v0__or2_4_4/Z vdd vss
+ gf180mcu_fd_sc_mcu7t5v0__nand2_1
Xgf180mcu_fd_sc_mcu7t5v0__nand2_1_188 vdd vss gf180mcu_fd_sc_mcu7t5v0__nand2_1_188/ZN
+ gf180mcu_fd_sc_mcu7t5v0__dffq_4_37/Q gf180mcu_fd_sc_mcu7t5v0__xor2_1_58/Z vdd vss
+ gf180mcu_fd_sc_mcu7t5v0__nand2_1
Xgf180mcu_fd_sc_mcu7t5v0__nand2_1_199 vdd vss gf180mcu_fd_sc_mcu7t5v0__oai211_1_11/A2
+ gf180mcu_fd_sc_mcu7t5v0__nor2_4_3/ZN gf180mcu_fd_sc_mcu7t5v0__xnor2_1_24/A1 vdd
+ vss gf180mcu_fd_sc_mcu7t5v0__nand2_1
Xgf180mcu_fd_sc_mcu7t5v0__dffq_1_230 vdd gf180mcu_fd_sc_mcu7t5v0__mux2_4_0/I1 gf180mcu_fd_sc_mcu7t5v0__dffq_2_58/CLK
+ vss gf180mcu_fd_sc_mcu7t5v0__dffq_1_230/D vdd vss gf180mcu_fd_sc_mcu7t5v0__dffq_1
Xgf180mcu_fd_sc_mcu7t5v0__dffq_1_241 vdd gf180mcu_fd_sc_mcu7t5v0__dffq_1_241/Q gf180mcu_fd_sc_mcu7t5v0__dffq_2_58/CLK
+ vss gf180mcu_fd_sc_mcu7t5v0__dffq_1_241/D vdd vss gf180mcu_fd_sc_mcu7t5v0__dffq_1
Xgf180mcu_fd_sc_mcu7t5v0__dffq_1_252 vdd gf180mcu_fd_sc_mcu7t5v0__dffq_1_252/Q gf180mcu_fd_sc_mcu7t5v0__dffq_2_58/CLK
+ vss gf180mcu_fd_sc_mcu7t5v0__dffq_1_252/D vdd vss gf180mcu_fd_sc_mcu7t5v0__dffq_1
Xgf180mcu_fd_sc_mcu7t5v0__dffq_1_263 vdd gf180mcu_fd_sc_mcu7t5v0__dffq_1_263/Q gf180mcu_fd_sc_mcu7t5v0__dffq_1_96/CLK
+ vss gf180mcu_fd_sc_mcu7t5v0__dffq_1_263/D vdd vss gf180mcu_fd_sc_mcu7t5v0__dffq_1
Xgf180mcu_fd_sc_mcu7t5v0__dffq_1_274 vdd gf180mcu_fd_sc_mcu7t5v0__dffq_1_274/Q gf180mcu_fd_sc_mcu7t5v0__dffq_2_26/CLK
+ vss gf180mcu_fd_sc_mcu7t5v0__dffq_1_274/D vdd vss gf180mcu_fd_sc_mcu7t5v0__dffq_1
Xgf180mcu_fd_sc_mcu7t5v0__dffq_1_285 vdd gf180mcu_fd_sc_mcu7t5v0__dffq_1_285/Q gf180mcu_fd_sc_mcu7t5v0__dffq_2_58/CLK
+ vss gf180mcu_fd_sc_mcu7t5v0__dffq_1_285/D vdd vss gf180mcu_fd_sc_mcu7t5v0__dffq_1
Xgf180mcu_fd_sc_mcu7t5v0__dffq_1_296 vdd gf180mcu_fd_sc_mcu7t5v0__dffq_1_296/Q gf180mcu_fd_sc_mcu7t5v0__dffq_4_9/CLK
+ vss gf180mcu_fd_sc_mcu7t5v0__dffq_1_296/D vdd vss gf180mcu_fd_sc_mcu7t5v0__dffq_1
Xgf180mcu_fd_sc_mcu7t5v0__clkinv_1_102 vdd vss gf180mcu_fd_sc_mcu7t5v0__dffq_1_81/Q
+ gf180mcu_fd_sc_mcu7t5v0__oai22_1_84/B2 vdd vss gf180mcu_fd_sc_mcu7t5v0__clkinv_1
Xgf180mcu_fd_sc_mcu7t5v0__clkinv_1_113 vdd vss gf180mcu_fd_sc_mcu7t5v0__dffq_1_179/Q
+ gf180mcu_fd_sc_mcu7t5v0__oai22_1_194/B2 vdd vss gf180mcu_fd_sc_mcu7t5v0__clkinv_1
Xgf180mcu_fd_sc_mcu7t5v0__nor3_1_16 gf180mcu_fd_sc_mcu7t5v0__and2_1_63/Z vdd vss gf180mcu_fd_sc_mcu7t5v0__nor3_1_16/ZN
+ gf180mcu_fd_sc_mcu7t5v0__oai31_4_2/ZN gf180mcu_fd_sc_mcu7t5v0__nor3_1_16/A2 vdd
+ vss gf180mcu_fd_sc_mcu7t5v0__nor3_1
Xgf180mcu_fd_sc_mcu7t5v0__dffq_1_40 vdd gf180mcu_fd_sc_mcu7t5v0__dffq_1_40/Q gf180mcu_fd_sc_mcu7t5v0__dffq_4_8/CLK
+ vss gf180mcu_fd_sc_mcu7t5v0__dffq_1_40/D vdd vss gf180mcu_fd_sc_mcu7t5v0__dffq_1
Xgf180mcu_fd_sc_mcu7t5v0__nor3_1_27 gf180mcu_fd_sc_mcu7t5v0__and2_1_89/Z vdd vss gf180mcu_fd_sc_mcu7t5v0__nor3_1_27/ZN
+ gf180mcu_fd_sc_mcu7t5v0__inv_2_9/I gf180mcu_fd_sc_mcu7t5v0__and3_2_3/A3 vdd vss
+ gf180mcu_fd_sc_mcu7t5v0__nor3_1
Xgf180mcu_fd_sc_mcu7t5v0__dffq_1_51 vdd gf180mcu_fd_sc_mcu7t5v0__dffq_1_51/Q gf180mcu_fd_sc_mcu7t5v0__dffq_4_8/CLK
+ vss gf180mcu_fd_sc_mcu7t5v0__dffq_1_51/D vdd vss gf180mcu_fd_sc_mcu7t5v0__dffq_1
Xgf180mcu_fd_sc_mcu7t5v0__clkinv_1_124 vdd vss gf180mcu_fd_sc_mcu7t5v0__dffq_1_106/Q
+ gf180mcu_fd_sc_mcu7t5v0__oai22_1_117/B2 vdd vss gf180mcu_fd_sc_mcu7t5v0__clkinv_1
Xgf180mcu_fd_sc_mcu7t5v0__nor3_1_38 gf180mcu_fd_sc_mcu7t5v0__nor3_1_38/A3 vdd vss
+ gf180mcu_fd_sc_mcu7t5v0__nor3_1_38/ZN gf180mcu_fd_sc_mcu7t5v0__inv_8_2/ZN gf180mcu_fd_sc_mcu7t5v0__or3_1_24/A2
+ vdd vss gf180mcu_fd_sc_mcu7t5v0__nor3_1
Xgf180mcu_fd_sc_mcu7t5v0__dffq_1_62 vdd gf180mcu_fd_sc_mcu7t5v0__dffq_1_62/Q gf180mcu_fd_sc_mcu7t5v0__dffq_1_95/CLK
+ vss gf180mcu_fd_sc_mcu7t5v0__dffq_1_62/D vdd vss gf180mcu_fd_sc_mcu7t5v0__dffq_1
Xgf180mcu_fd_sc_mcu7t5v0__clkinv_1_135 vdd vss gf180mcu_fd_sc_mcu7t5v0__dffq_1_270/Q
+ gf180mcu_fd_sc_mcu7t5v0__oai22_1_122/B2 vdd vss gf180mcu_fd_sc_mcu7t5v0__clkinv_1
Xgf180mcu_fd_sc_mcu7t5v0__clkinv_1_146 vdd vss gf180mcu_fd_sc_mcu7t5v0__dffq_1_123/Q
+ gf180mcu_fd_sc_mcu7t5v0__oai22_1_135/B2 vdd vss gf180mcu_fd_sc_mcu7t5v0__clkinv_1
Xgf180mcu_fd_sc_mcu7t5v0__dffq_1_73 vdd gf180mcu_fd_sc_mcu7t5v0__dffq_1_73/Q gf180mcu_fd_sc_mcu7t5v0__dffq_1_99/CLK
+ vss gf180mcu_fd_sc_mcu7t5v0__dffq_1_73/D vdd vss gf180mcu_fd_sc_mcu7t5v0__dffq_1
Xgf180mcu_fd_sc_mcu7t5v0__clkinv_1_157 vdd vss gf180mcu_fd_sc_mcu7t5v0__dffq_1_137/Q
+ gf180mcu_fd_sc_mcu7t5v0__oai22_1_130/B2 vdd vss gf180mcu_fd_sc_mcu7t5v0__clkinv_1
Xgf180mcu_fd_sc_mcu7t5v0__dffq_1_84 vdd gf180mcu_fd_sc_mcu7t5v0__dffq_1_84/Q gf180mcu_fd_sc_mcu7t5v0__dffq_1_99/CLK
+ vss gf180mcu_fd_sc_mcu7t5v0__dffq_1_84/D vdd vss gf180mcu_fd_sc_mcu7t5v0__dffq_1
Xgf180mcu_fd_sc_mcu7t5v0__clkinv_1_168 vdd vss gf180mcu_fd_sc_mcu7t5v0__dffq_1_149/Q
+ gf180mcu_fd_sc_mcu7t5v0__oai22_1_162/B2 vdd vss gf180mcu_fd_sc_mcu7t5v0__clkinv_1
Xgf180mcu_fd_sc_mcu7t5v0__dffq_1_95 vdd gf180mcu_fd_sc_mcu7t5v0__dffq_1_95/Q gf180mcu_fd_sc_mcu7t5v0__dffq_1_95/CLK
+ vss gf180mcu_fd_sc_mcu7t5v0__dffq_1_95/D vdd vss gf180mcu_fd_sc_mcu7t5v0__dffq_1
Xgf180mcu_fd_sc_mcu7t5v0__clkinv_1_179 vdd vss gf180mcu_fd_sc_mcu7t5v0__dffq_1_163/Q
+ gf180mcu_fd_sc_mcu7t5v0__oai22_1_165/B2 vdd vss gf180mcu_fd_sc_mcu7t5v0__clkinv_1
Xgf180mcu_fd_sc_mcu7t5v0__nand2_2_0 vdd vss gf180mcu_fd_sc_mcu7t5v0__nor3_4_0/A2 gf180mcu_fd_sc_mcu7t5v0__and2_2_0/A1
+ gf180mcu_fd_sc_mcu7t5v0__and2_2_0/A2 vdd vss gf180mcu_fd_sc_mcu7t5v0__nand2_2
Xgf180mcu_fd_sc_mcu7t5v0__aoi211_1_4 gf180mcu_fd_sc_mcu7t5v0__nor2_1_32/ZN gf180mcu_fd_sc_mcu7t5v0__or2_1_23/A1
+ vdd vss gf180mcu_fd_sc_mcu7t5v0__dffq_1_1/D gf180mcu_fd_sc_mcu7t5v0__inv_4_2/ZN
+ gf180mcu_fd_sc_mcu7t5v0__nor2_4_19/ZN vdd vss gf180mcu_fd_sc_mcu7t5v0__aoi211_1
Xgf180mcu_fd_sc_mcu7t5v0__dffq_2_4 gf180mcu_fd_sc_mcu7t5v0__dffq_2_4/D vdd vss gf180mcu_fd_sc_mcu7t5v0__dffq_4_6/CLK
+ gf180mcu_fd_sc_mcu7t5v0__dffq_2_4/Q vdd vss gf180mcu_fd_sc_mcu7t5v0__dffq_2
Xgf180mcu_fd_sc_mcu7t5v0__aoi22_1_1 gf180mcu_fd_sc_mcu7t5v0__and2_4_1/Z gf180mcu_fd_sc_mcu7t5v0__inv_8_0/I
+ vdd vss gf180mcu_fd_sc_mcu7t5v0__nor3_1_1/A2 gf180mcu_fd_sc_mcu7t5v0__or4_1_0/A1
+ gf180mcu_fd_sc_mcu7t5v0__and2_4_2/Z vdd vss gf180mcu_fd_sc_mcu7t5v0__aoi22_1
Xgf180mcu_fd_sc_mcu7t5v0__oai22_1_140 gf180mcu_fd_sc_mcu7t5v0__nand2_4_18/ZN gf180mcu_fd_sc_mcu7t5v0__nand2_2_25/ZN
+ gf180mcu_fd_sc_mcu7t5v0__oai22_1_140/B2 vdd vss gf180mcu_fd_sc_mcu7t5v0__dffq_1_183/D
+ gf180mcu_fd_sc_mcu7t5v0__oai22_1_88/A1 vdd vss gf180mcu_fd_sc_mcu7t5v0__oai22_1
Xgf180mcu_fd_sc_mcu7t5v0__oai22_1_151 gf180mcu_fd_sc_mcu7t5v0__nand2_4_19/ZN gf180mcu_fd_sc_mcu7t5v0__nand2_2_26/ZN
+ gf180mcu_fd_sc_mcu7t5v0__oai22_1_151/B2 vdd vss gf180mcu_fd_sc_mcu7t5v0__dffq_1_145/D
+ gf180mcu_fd_sc_mcu7t5v0__aoi21_4_3/ZN vdd vss gf180mcu_fd_sc_mcu7t5v0__oai22_1
Xgf180mcu_fd_sc_mcu7t5v0__oai22_1_162 gf180mcu_fd_sc_mcu7t5v0__nand2_4_21/ZN gf180mcu_fd_sc_mcu7t5v0__nand2_2_28/ZN
+ gf180mcu_fd_sc_mcu7t5v0__oai22_1_162/B2 vdd vss gf180mcu_fd_sc_mcu7t5v0__dffq_1_149/D
+ gf180mcu_fd_sc_mcu7t5v0__oai22_1_98/A1 vdd vss gf180mcu_fd_sc_mcu7t5v0__oai22_1
Xgf180mcu_fd_sc_mcu7t5v0__oai221_1_1 gf180mcu_fd_sc_mcu7t5v0__xor2_1_13/A2 gf180mcu_fd_sc_mcu7t5v0__oai221_1_1/C
+ vdd vss gf180mcu_fd_sc_mcu7t5v0__oai31_1_0/A3 gf180mcu_fd_sc_mcu7t5v0__mux2_1_2/I0
+ gf180mcu_fd_sc_mcu7t5v0__and2_1_3/A1 gf180mcu_fd_sc_mcu7t5v0__oai221_1_1/B2 vdd
+ vss gf180mcu_fd_sc_mcu7t5v0__oai221_1
Xgf180mcu_fd_sc_mcu7t5v0__oai22_1_173 gf180mcu_fd_sc_mcu7t5v0__nand2_4_23/ZN gf180mcu_fd_sc_mcu7t5v0__nand2_2_30/ZN
+ gf180mcu_fd_sc_mcu7t5v0__oai22_1_173/B2 vdd vss gf180mcu_fd_sc_mcu7t5v0__dffq_1_164/D
+ gf180mcu_fd_sc_mcu7t5v0__oai21_4_9/ZN vdd vss gf180mcu_fd_sc_mcu7t5v0__oai22_1
Xgf180mcu_fd_sc_mcu7t5v0__oai22_1_184 gf180mcu_fd_sc_mcu7t5v0__nand2_4_36/ZN gf180mcu_fd_sc_mcu7t5v0__nand2_2_31/ZN
+ gf180mcu_fd_sc_mcu7t5v0__oai22_1_184/B2 vdd vss gf180mcu_fd_sc_mcu7t5v0__dffq_1_273/D
+ gf180mcu_fd_sc_mcu7t5v0__aoi21_4_3/ZN vdd vss gf180mcu_fd_sc_mcu7t5v0__oai22_1
Xgf180mcu_fd_sc_mcu7t5v0__oai22_1_195 gf180mcu_fd_sc_mcu7t5v0__nand2_4_19/ZN gf180mcu_fd_sc_mcu7t5v0__nand2_2_26/ZN
+ gf180mcu_fd_sc_mcu7t5v0__oai22_1_195/B2 vdd vss gf180mcu_fd_sc_mcu7t5v0__dffq_1_128/D
+ gf180mcu_fd_sc_mcu7t5v0__oai21_4_9/ZN vdd vss gf180mcu_fd_sc_mcu7t5v0__oai22_1
Xgf180mcu_fd_sc_mcu7t5v0__xnor3_1_12 gf180mcu_fd_sc_mcu7t5v0__xor2_1_44/Z vdd vss
+ gf180mcu_fd_sc_mcu7t5v0__nor2_1_65/A2 gf180mcu_fd_sc_mcu7t5v0__xnor3_1_12/A1 gf180mcu_fd_sc_mcu7t5v0__xnor3_1_12/A2
+ vdd vss gf180mcu_fd_sc_mcu7t5v0__xnor3_1
Xgf180mcu_fd_sc_mcu7t5v0__xnor3_1_23 gf180mcu_fd_sc_mcu7t5v0__xor2_1_107/Z vdd vss
+ gf180mcu_fd_sc_mcu7t5v0__xor2_1_106/A2 gf180mcu_fd_sc_mcu7t5v0__xnor3_1_23/A1 gf180mcu_fd_sc_mcu7t5v0__xor2_1_104/A1
+ vdd vss gf180mcu_fd_sc_mcu7t5v0__xnor3_1
Xgf180mcu_fd_sc_mcu7t5v0__xnor3_1_34 gf180mcu_fd_sc_mcu7t5v0__xor3_1_96/Z vdd vss
+ gf180mcu_fd_sc_mcu7t5v0__aoi21_2_10/B gf180mcu_fd_sc_mcu7t5v0__nor3_4_16/ZN gf180mcu_fd_sc_mcu7t5v0__oai33_2_3/A1
+ vdd vss gf180mcu_fd_sc_mcu7t5v0__xnor3_1
Xgf180mcu_fd_sc_mcu7t5v0__xnor3_1_45 gf180mcu_fd_sc_mcu7t5v0__xnor3_1_45/A3 vdd vss
+ gf180mcu_fd_sc_mcu7t5v0__xor2_1_200/A2 gf180mcu_fd_sc_mcu7t5v0__xnor3_1_45/A1 gf180mcu_fd_sc_mcu7t5v0__xnor3_1_45/A2
+ vdd vss gf180mcu_fd_sc_mcu7t5v0__xnor3_1
Xgf180mcu_fd_sc_mcu7t5v0__nor2_1_60 vdd vss gf180mcu_fd_sc_mcu7t5v0__nor2_1_60/ZN
+ gf180mcu_fd_sc_mcu7t5v0__xor3_1_57/A1 gf180mcu_fd_sc_mcu7t5v0__xor3_1_57/A3 vdd
+ vss gf180mcu_fd_sc_mcu7t5v0__nor2_1
Xgf180mcu_fd_sc_mcu7t5v0__nor2_1_71 vdd vss gf180mcu_fd_sc_mcu7t5v0__nor2_1_71/ZN
+ gf180mcu_fd_sc_mcu7t5v0__xor2_1_44/A1 gf180mcu_fd_sc_mcu7t5v0__xor2_1_44/A2 vdd
+ vss gf180mcu_fd_sc_mcu7t5v0__nor2_1
Xgf180mcu_fd_sc_mcu7t5v0__nor2_1_82 vdd vss gf180mcu_fd_sc_mcu7t5v0__dffq_2_20/D gf180mcu_fd_sc_mcu7t5v0__aoi21_1_7/B
+ gf180mcu_fd_sc_mcu7t5v0__nor2_1_82/A2 vdd vss gf180mcu_fd_sc_mcu7t5v0__nor2_1
Xgf180mcu_fd_sc_mcu7t5v0__nor2_1_93 vdd vss gf180mcu_fd_sc_mcu7t5v0__mux2_1_6/I1 gf180mcu_fd_sc_mcu7t5v0__inv_4_0/I
+ gf180mcu_fd_sc_mcu7t5v0__and2_2_8/A1 vdd vss gf180mcu_fd_sc_mcu7t5v0__nor2_1
Xgf180mcu_fd_sc_mcu7t5v0__clkinv_2_3 vdd vss gf180mcu_fd_sc_mcu7t5v0__or3_4_0/A2 gf180mcu_fd_sc_mcu7t5v0__nor3_4_12/A2
+ vdd vss gf180mcu_fd_sc_mcu7t5v0__clkinv_2
Xgf180mcu_fd_sc_mcu7t5v0__nor2_1_260 vdd vss gf180mcu_fd_sc_mcu7t5v0__nor2_1_260/ZN
+ gf180mcu_fd_sc_mcu7t5v0__inv_8_0/I gf180mcu_fd_sc_mcu7t5v0__xor2_1_119/Z vdd vss
+ gf180mcu_fd_sc_mcu7t5v0__nor2_1
Xgf180mcu_fd_sc_mcu7t5v0__nor2_1_271 vdd vss gf180mcu_fd_sc_mcu7t5v0__nor2_1_271/ZN
+ gf180mcu_fd_sc_mcu7t5v0__dffq_2_61/Q gf180mcu_fd_sc_mcu7t5v0__nor2_2_33/A2 vdd vss
+ gf180mcu_fd_sc_mcu7t5v0__nor2_1
Xgf180mcu_fd_sc_mcu7t5v0__xor3_1_0 gf180mcu_fd_sc_mcu7t5v0__xor3_1_48/Z vdd vss gf180mcu_fd_sc_mcu7t5v0__xor3_1_0/Z
+ gf180mcu_fd_sc_mcu7t5v0__xor3_1_0/A1 gf180mcu_fd_sc_mcu7t5v0__xor3_1_0/A2 vdd vss
+ gf180mcu_fd_sc_mcu7t5v0__xor3_1
Xgf180mcu_fd_sc_mcu7t5v0__nor2_1_282 vdd vss gf180mcu_fd_sc_mcu7t5v0__nor2_1_282/ZN
+ gf180mcu_fd_sc_mcu7t5v0__dffq_2_97/Q gf180mcu_fd_sc_mcu7t5v0__dffq_4_40/Q vdd vss
+ gf180mcu_fd_sc_mcu7t5v0__nor2_1
Xgf180mcu_fd_sc_mcu7t5v0__oai31_1_4 vdd gf180mcu_fd_sc_mcu7t5v0__xor2_1_41/A2 gf180mcu_fd_sc_mcu7t5v0__oai31_1_4/B
+ gf180mcu_fd_sc_mcu7t5v0__and2_4_0/Z gf180mcu_fd_sc_mcu7t5v0__and2_2_0/Z vss gf180mcu_fd_sc_mcu7t5v0__and2_2_4/Z
+ vdd vss gf180mcu_fd_sc_mcu7t5v0__oai31_1
Xgf180mcu_fd_sc_mcu7t5v0__nor2_1_293 vdd vss gf180mcu_fd_sc_mcu7t5v0__oai21_2_11/A2
+ gf180mcu_fd_sc_mcu7t5v0__or2_1_36/A2 gf180mcu_fd_sc_mcu7t5v0__dffq_2_96/Q vdd vss
+ gf180mcu_fd_sc_mcu7t5v0__nor2_1
Xgf180mcu_fd_sc_mcu7t5v0__nand2_1_14 vdd vss gf180mcu_fd_sc_mcu7t5v0__and2_1_6/A1
+ gf180mcu_fd_sc_mcu7t5v0__inv_8_1/I gf180mcu_fd_sc_mcu7t5v0__nand3_1_1/A3 vdd vss
+ gf180mcu_fd_sc_mcu7t5v0__nand2_1
Xgf180mcu_fd_sc_mcu7t5v0__oai31_1_19 vdd gf180mcu_fd_sc_mcu7t5v0__xor2_1_192/A2 gf180mcu_fd_sc_mcu7t5v0__oai31_1_19/B
+ gf180mcu_fd_sc_mcu7t5v0__and4_1_3/A3 gf180mcu_fd_sc_mcu7t5v0__and4_1_3/A4 vss gf180mcu_fd_sc_mcu7t5v0__xor3_1_162/A2
+ vdd vss gf180mcu_fd_sc_mcu7t5v0__oai31_1
Xgf180mcu_fd_sc_mcu7t5v0__nand2_1_25 vdd vss gf180mcu_fd_sc_mcu7t5v0__oai221_1_0/B2
+ gf180mcu_fd_sc_mcu7t5v0__and3_2_0/Z gf180mcu_fd_sc_mcu7t5v0__oai21_1_10/ZN vdd vss
+ gf180mcu_fd_sc_mcu7t5v0__nand2_1
Xgf180mcu_fd_sc_mcu7t5v0__aoi221_4_2 gf180mcu_fd_sc_mcu7t5v0__nor3_1_35/A1 gf180mcu_fd_sc_mcu7t5v0__nor2_4_40/ZN
+ gf180mcu_fd_sc_mcu7t5v0__oai21_4_5/A1 gf180mcu_fd_sc_mcu7t5v0__aoi221_4_2/C vdd
+ vss gf180mcu_fd_sc_mcu7t5v0__xnor2_1_66/A1 gf180mcu_fd_sc_mcu7t5v0__inv_4_7/I vdd
+ vss gf180mcu_fd_sc_mcu7t5v0__aoi221_4
Xgf180mcu_fd_sc_mcu7t5v0__nand2_1_36 vdd vss gf180mcu_fd_sc_mcu7t5v0__oai211_1_3/C
+ gf180mcu_fd_sc_mcu7t5v0__nor2_2_14/ZN gf180mcu_fd_sc_mcu7t5v0__xor3_1_61/Z vdd vss
+ gf180mcu_fd_sc_mcu7t5v0__nand2_1
Xgf180mcu_fd_sc_mcu7t5v0__nand2_1_47 vdd vss gf180mcu_fd_sc_mcu7t5v0__oai21_1_17/B
+ gf180mcu_fd_sc_mcu7t5v0__mux4_4_3/I2 gf180mcu_fd_sc_mcu7t5v0__xor3_2_0/Z vdd vss
+ gf180mcu_fd_sc_mcu7t5v0__nand2_1
Xgf180mcu_fd_sc_mcu7t5v0__and4_1_2 gf180mcu_fd_sc_mcu7t5v0__and4_1_2/A3 gf180mcu_fd_sc_mcu7t5v0__or2_1_46/Z
+ vdd vss gf180mcu_fd_sc_mcu7t5v0__and4_1_2/Z gf180mcu_fd_sc_mcu7t5v0__inv_8_0/I gf180mcu_fd_sc_mcu7t5v0__inv_1_14/I
+ vdd vss gf180mcu_fd_sc_mcu7t5v0__and4_1
Xgf180mcu_fd_sc_mcu7t5v0__nand2_1_58 vdd vss gf180mcu_fd_sc_mcu7t5v0__xor3_1_15/A1
+ gf180mcu_fd_sc_mcu7t5v0__or4_1_0/A1 gf180mcu_fd_sc_mcu7t5v0__and2_2_3/Z vdd vss
+ gf180mcu_fd_sc_mcu7t5v0__nand2_1
Xgf180mcu_fd_sc_mcu7t5v0__nand2_1_69 vdd vss gf180mcu_fd_sc_mcu7t5v0__xor3_1_19/A3
+ gf180mcu_fd_sc_mcu7t5v0__xor2_1_25/A2 gf180mcu_fd_sc_mcu7t5v0__nand2_1_70/ZN vdd
+ vss gf180mcu_fd_sc_mcu7t5v0__nand2_1
Xgf180mcu_fd_sc_mcu7t5v0__oai21_1_320 vdd gf180mcu_fd_sc_mcu7t5v0__oai21_1_320/B gf180mcu_fd_sc_mcu7t5v0__nor2_1_399/ZN
+ gf180mcu_fd_sc_mcu7t5v0__xor3_1_149/A2 gf180mcu_fd_sc_mcu7t5v0__xor3_1_151/A2 vss
+ vdd vss gf180mcu_fd_sc_mcu7t5v0__oai21_1
Xgf180mcu_fd_sc_mcu7t5v0__oai21_1_331 vdd gf180mcu_fd_sc_mcu7t5v0__oai21_1_331/B gf180mcu_fd_sc_mcu7t5v0__xnor2_1_56/ZN
+ gf180mcu_fd_sc_mcu7t5v0__oai21_1_331/ZN gf180mcu_fd_sc_mcu7t5v0__oai211_1_43/C vss
+ vdd vss gf180mcu_fd_sc_mcu7t5v0__oai21_1
Xgf180mcu_fd_sc_mcu7t5v0__nor2_4_4 vdd vss gf180mcu_fd_sc_mcu7t5v0__nor2_4_4/ZN gf180mcu_fd_sc_mcu7t5v0__nor2_4_7/A1
+ gf180mcu_fd_sc_mcu7t5v0__or2_2_0/Z vdd vss gf180mcu_fd_sc_mcu7t5v0__nor2_4
Xgf180mcu_fd_sc_mcu7t5v0__xnor2_1_2 vdd vss gf180mcu_fd_sc_mcu7t5v0__nor3_1_1/A3 gf180mcu_fd_sc_mcu7t5v0__nor2_2_1/A1
+ gf180mcu_fd_sc_mcu7t5v0__or2_1_2/A1 vdd vss gf180mcu_fd_sc_mcu7t5v0__xnor2_1
Xgf180mcu_fd_sc_mcu7t5v0__oai22_1_4 gf180mcu_fd_sc_mcu7t5v0__oai22_1_4/A2 gf180mcu_fd_sc_mcu7t5v0__xor3_1_38/A1
+ gf180mcu_fd_sc_mcu7t5v0__and2_1_16/Z vdd vss gf180mcu_fd_sc_mcu7t5v0__xor3_1_40/A1
+ gf180mcu_fd_sc_mcu7t5v0__mux2_1_6/S vdd vss gf180mcu_fd_sc_mcu7t5v0__oai22_1
Xgf180mcu_fd_sc_mcu7t5v0__aoi22_1_40 gf180mcu_fd_sc_mcu7t5v0__nor2_4_11/ZN gf180mcu_fd_sc_mcu7t5v0__dffq_1_66/Q
+ vdd vss gf180mcu_fd_sc_mcu7t5v0__aoi22_1_40/ZN gf180mcu_fd_sc_mcu7t5v0__dffq_1_58/Q
+ gf180mcu_fd_sc_mcu7t5v0__nor2_4_10/ZN vdd vss gf180mcu_fd_sc_mcu7t5v0__aoi22_1
Xgf180mcu_fd_sc_mcu7t5v0__aoi22_1_51 gf180mcu_fd_sc_mcu7t5v0__nor2_4_9/ZN gf180mcu_fd_sc_mcu7t5v0__dffq_1_77/Q
+ vdd vss gf180mcu_fd_sc_mcu7t5v0__aoi22_1_51/ZN gf180mcu_fd_sc_mcu7t5v0__dffq_1_97/Q
+ gf180mcu_fd_sc_mcu7t5v0__nor2_4_8/ZN vdd vss gf180mcu_fd_sc_mcu7t5v0__aoi22_1
Xgf180mcu_fd_sc_mcu7t5v0__aoi22_1_62 gf180mcu_fd_sc_mcu7t5v0__nor2_4_11/ZN gf180mcu_fd_sc_mcu7t5v0__dffq_1_176/Q
+ vdd vss gf180mcu_fd_sc_mcu7t5v0__aoi22_1_62/ZN gf180mcu_fd_sc_mcu7t5v0__dffq_1_180/Q
+ gf180mcu_fd_sc_mcu7t5v0__nor2_4_10/ZN vdd vss gf180mcu_fd_sc_mcu7t5v0__aoi22_1
Xgf180mcu_fd_sc_mcu7t5v0__aoi22_1_73 gf180mcu_fd_sc_mcu7t5v0__nor2_4_11/ZN gf180mcu_fd_sc_mcu7t5v0__dffq_1_125/Q
+ vdd vss gf180mcu_fd_sc_mcu7t5v0__aoi22_1_73/ZN gf180mcu_fd_sc_mcu7t5v0__dffq_1_123/Q
+ gf180mcu_fd_sc_mcu7t5v0__nor2_4_10/ZN vdd vss gf180mcu_fd_sc_mcu7t5v0__aoi22_1
Xgf180mcu_fd_sc_mcu7t5v0__aoi22_1_84 gf180mcu_fd_sc_mcu7t5v0__nor2_4_9/ZN gf180mcu_fd_sc_mcu7t5v0__dffq_1_149/Q
+ vdd vss gf180mcu_fd_sc_mcu7t5v0__aoi22_1_84/ZN gf180mcu_fd_sc_mcu7t5v0__dffq_1_147/Q
+ gf180mcu_fd_sc_mcu7t5v0__nor2_4_8/ZN vdd vss gf180mcu_fd_sc_mcu7t5v0__aoi22_1
Xgf180mcu_fd_sc_mcu7t5v0__aoi22_1_95 gf180mcu_fd_sc_mcu7t5v0__nor2_4_9/ZN gf180mcu_fd_sc_mcu7t5v0__dffq_1_189/Q
+ vdd vss gf180mcu_fd_sc_mcu7t5v0__aoi22_1_95/ZN gf180mcu_fd_sc_mcu7t5v0__dffq_1_184/Q
+ gf180mcu_fd_sc_mcu7t5v0__nor2_4_8/ZN vdd vss gf180mcu_fd_sc_mcu7t5v0__aoi22_1
Xgf180mcu_fd_sc_mcu7t5v0__or3_1_0 gf180mcu_fd_sc_mcu7t5v0__xor2_1_8/Z vdd vss gf180mcu_fd_sc_mcu7t5v0__or3_1_0/Z
+ gf180mcu_fd_sc_mcu7t5v0__or3_1_0/A1 gf180mcu_fd_sc_mcu7t5v0__or3_1_0/A2 vdd vss
+ gf180mcu_fd_sc_mcu7t5v0__or3_1
Xgf180mcu_fd_sc_mcu7t5v0__inv_1_4 vss gf180mcu_fd_sc_mcu7t5v0__inv_1_4/ZN gf180mcu_fd_sc_mcu7t5v0__inv_1_4/I
+ vdd vdd vss gf180mcu_fd_sc_mcu7t5v0__inv_1
Xgf180mcu_fd_sc_mcu7t5v0__nand3_2_13 gf180mcu_fd_sc_mcu7t5v0__inv_2_0/ZN vdd vss gf180mcu_fd_sc_mcu7t5v0__nand2_4_1/A1
+ gf180mcu_fd_sc_mcu7t5v0__dffq_2_4/Q gf180mcu_fd_sc_mcu7t5v0__dffq_4_4/Q vdd vss
+ gf180mcu_fd_sc_mcu7t5v0__nand3_2
Xgf180mcu_fd_sc_mcu7t5v0__nand3_2_24 gf180mcu_fd_sc_mcu7t5v0__and2_2_11/A2 vdd vss
+ gf180mcu_fd_sc_mcu7t5v0__nor3_2_7/A3 gf180mcu_fd_sc_mcu7t5v0__inv_12_1/I gf180mcu_fd_sc_mcu7t5v0__and2_2_11/A1
+ vdd vss gf180mcu_fd_sc_mcu7t5v0__nand3_2
Xgf180mcu_fd_sc_mcu7t5v0__oai32_4_2 gf180mcu_fd_sc_mcu7t5v0__oai32_4_2/A3 gf180mcu_fd_sc_mcu7t5v0__oai32_4_2/B1
+ gf180mcu_fd_sc_mcu7t5v0__dffq_2_74/Q vdd vss gf180mcu_fd_sc_mcu7t5v0__or3_1_24/A2
+ gf180mcu_fd_sc_mcu7t5v0__oai32_4_2/A1 gf180mcu_fd_sc_mcu7t5v0__oai32_4_2/A2 vdd
+ vss gf180mcu_fd_sc_mcu7t5v0__oai32_4
Xgf180mcu_fd_sc_mcu7t5v0__and2_1_18 vdd vss gf180mcu_fd_sc_mcu7t5v0__and2_1_18/Z gf180mcu_fd_sc_mcu7t5v0__mux2_1_6/I1
+ gf180mcu_fd_sc_mcu7t5v0__or2_1_9/A1 vdd vss gf180mcu_fd_sc_mcu7t5v0__and2_1
Xgf180mcu_fd_sc_mcu7t5v0__and2_1_29 vdd vss gf180mcu_fd_sc_mcu7t5v0__and2_1_29/Z gf180mcu_fd_sc_mcu7t5v0__or3_1_8/Z
+ gf180mcu_fd_sc_mcu7t5v0__and2_1_29/A2 vdd vss gf180mcu_fd_sc_mcu7t5v0__and2_1
Xgf180mcu_fd_sc_mcu7t5v0__nor2_2_1 vdd vss gf180mcu_fd_sc_mcu7t5v0__xor2_1_5/A2 gf180mcu_fd_sc_mcu7t5v0__nor2_2_1/A1
+ gf180mcu_fd_sc_mcu7t5v0__or2_1_2/A1 vdd vss gf180mcu_fd_sc_mcu7t5v0__nor2_2
Xgf180mcu_fd_sc_mcu7t5v0__oai21_1_150 vdd gf180mcu_fd_sc_mcu7t5v0__oai21_1_157/B gf180mcu_fd_sc_mcu7t5v0__and2_1_56/Z
+ gf180mcu_fd_sc_mcu7t5v0__nor2_1_185/A2 gf180mcu_fd_sc_mcu7t5v0__nor4_1_0/A3 vss
+ vdd vss gf180mcu_fd_sc_mcu7t5v0__oai21_1
Xgf180mcu_fd_sc_mcu7t5v0__oai21_1_161 vdd gf180mcu_fd_sc_mcu7t5v0__oai21_1_163/B gf180mcu_fd_sc_mcu7t5v0__and2_1_64/Z
+ gf180mcu_fd_sc_mcu7t5v0__nor2_1_199/A2 gf180mcu_fd_sc_mcu7t5v0__or4_1_2/A2 vss vdd
+ vss gf180mcu_fd_sc_mcu7t5v0__oai21_1
Xgf180mcu_fd_sc_mcu7t5v0__oai21_1_172 vdd gf180mcu_fd_sc_mcu7t5v0__oai31_1_9/A3 gf180mcu_fd_sc_mcu7t5v0__xor3_1_74/Z
+ gf180mcu_fd_sc_mcu7t5v0__oai21_1_172/ZN gf180mcu_fd_sc_mcu7t5v0__and2_1_78/A1 vss
+ vdd vss gf180mcu_fd_sc_mcu7t5v0__oai21_1
Xgf180mcu_fd_sc_mcu7t5v0__oai21_1_183 vdd gf180mcu_fd_sc_mcu7t5v0__buf_8_7/Z gf180mcu_fd_sc_mcu7t5v0__nor2_4_31/ZN
+ gf180mcu_fd_sc_mcu7t5v0__aoi21_1_198/B gf180mcu_fd_sc_mcu7t5v0__dffq_1_393/Q vss
+ vdd vss gf180mcu_fd_sc_mcu7t5v0__oai21_1
Xgf180mcu_fd_sc_mcu7t5v0__oai21_1_194 vdd gf180mcu_fd_sc_mcu7t5v0__or3_1_14/A3 gf180mcu_fd_sc_mcu7t5v0__inv_1_13/I
+ gf180mcu_fd_sc_mcu7t5v0__nand3_1_63/A2 gf180mcu_fd_sc_mcu7t5v0__or3_1_24/A1 vss
+ vdd vss gf180mcu_fd_sc_mcu7t5v0__oai21_1
Xgf180mcu_fd_sc_mcu7t5v0__aoi211_1_19 gf180mcu_fd_sc_mcu7t5v0__and2_1_32/Z gf180mcu_fd_sc_mcu7t5v0__or3_1_6/A1
+ vdd vss gf180mcu_fd_sc_mcu7t5v0__or3_1_6/A2 gf180mcu_fd_sc_mcu7t5v0__nand2_1_175/A1
+ gf180mcu_fd_sc_mcu7t5v0__nand2_1_96/ZN vdd vss gf180mcu_fd_sc_mcu7t5v0__aoi211_1
Xgf180mcu_fd_sc_mcu7t5v0__clkinv_1_10 vdd vss gf180mcu_fd_sc_mcu7t5v0__xor3_1_39/A2
+ gf180mcu_fd_sc_mcu7t5v0__aoi21_1_49/A1 vdd vss gf180mcu_fd_sc_mcu7t5v0__clkinv_1
Xgf180mcu_fd_sc_mcu7t5v0__clkinv_1_21 vdd vss gf180mcu_fd_sc_mcu7t5v0__dffq_1_52/Q
+ gf180mcu_fd_sc_mcu7t5v0__oai22_1_12/B2 vdd vss gf180mcu_fd_sc_mcu7t5v0__clkinv_1
Xgf180mcu_fd_sc_mcu7t5v0__clkinv_1_32 vdd vss gf180mcu_fd_sc_mcu7t5v0__dffq_1_268/Q
+ gf180mcu_fd_sc_mcu7t5v0__oai22_1_262/B2 vdd vss gf180mcu_fd_sc_mcu7t5v0__clkinv_1
Xgf180mcu_fd_sc_mcu7t5v0__clkinv_1_43 vdd vss gf180mcu_fd_sc_mcu7t5v0__dffq_1_19/Q
+ gf180mcu_fd_sc_mcu7t5v0__oai22_1_27/B2 vdd vss gf180mcu_fd_sc_mcu7t5v0__clkinv_1
Xgf180mcu_fd_sc_mcu7t5v0__clkinv_1_54 vdd vss gf180mcu_fd_sc_mcu7t5v0__dffq_1_46/Q
+ gf180mcu_fd_sc_mcu7t5v0__oai22_1_44/B2 vdd vss gf180mcu_fd_sc_mcu7t5v0__clkinv_1
Xgf180mcu_fd_sc_mcu7t5v0__clkinv_1_65 vdd vss gf180mcu_fd_sc_mcu7t5v0__dffq_1_56/Q
+ gf180mcu_fd_sc_mcu7t5v0__oai22_1_96/B2 vdd vss gf180mcu_fd_sc_mcu7t5v0__clkinv_1
Xgf180mcu_fd_sc_mcu7t5v0__clkinv_1_76 vdd vss gf180mcu_fd_sc_mcu7t5v0__dffq_1_67/Q
+ gf180mcu_fd_sc_mcu7t5v0__oai22_1_62/B2 vdd vss gf180mcu_fd_sc_mcu7t5v0__clkinv_1
Xgf180mcu_fd_sc_mcu7t5v0__aoi21_1_207 gf180mcu_fd_sc_mcu7t5v0__aoi21_1_207/B vdd vss
+ gf180mcu_fd_sc_mcu7t5v0__dffq_1_392/D gf180mcu_fd_sc_mcu7t5v0__dffq_4_20/Q gf180mcu_fd_sc_mcu7t5v0__aoi22_4_5/ZN
+ vdd vss gf180mcu_fd_sc_mcu7t5v0__aoi21_1
Xgf180mcu_fd_sc_mcu7t5v0__clkinv_1_87 vdd vss gf180mcu_fd_sc_mcu7t5v0__dffq_1_90/Q
+ gf180mcu_fd_sc_mcu7t5v0__oai22_1_92/B2 vdd vss gf180mcu_fd_sc_mcu7t5v0__clkinv_1
Xgf180mcu_fd_sc_mcu7t5v0__aoi21_1_218 gf180mcu_fd_sc_mcu7t5v0__aoi21_1_7/B vdd vss
+ gf180mcu_fd_sc_mcu7t5v0__dffq_4_22/D gf180mcu_fd_sc_mcu7t5v0__nand2_1_427/ZN gf180mcu_fd_sc_mcu7t5v0__oai211_1_26/ZN
+ vdd vss gf180mcu_fd_sc_mcu7t5v0__aoi21_1
Xgf180mcu_fd_sc_mcu7t5v0__clkinv_1_98 vdd vss gf180mcu_fd_sc_mcu7t5v0__dffq_1_260/Q
+ gf180mcu_fd_sc_mcu7t5v0__oai22_1_87/B2 vdd vss gf180mcu_fd_sc_mcu7t5v0__clkinv_1
Xgf180mcu_fd_sc_mcu7t5v0__aoi21_1_229 gf180mcu_fd_sc_mcu7t5v0__aoi21_1_229/B vdd vss
+ gf180mcu_fd_sc_mcu7t5v0__xor2_1_123/A2 gf180mcu_fd_sc_mcu7t5v0__oai31_1_15/B gf180mcu_fd_sc_mcu7t5v0__mux4_4_7/Z
+ vdd vss gf180mcu_fd_sc_mcu7t5v0__aoi21_1
Xgf180mcu_fd_sc_mcu7t5v0__oai21_1_18 vdd gf180mcu_fd_sc_mcu7t5v0__oai21_1_18/B gf180mcu_fd_sc_mcu7t5v0__oai21_1_18/A2
+ gf180mcu_fd_sc_mcu7t5v0__oai21_1_21/B gf180mcu_fd_sc_mcu7t5v0__oai32_1_3/B2 vss
+ vdd vss gf180mcu_fd_sc_mcu7t5v0__oai21_1
Xgf180mcu_fd_sc_mcu7t5v0__oai21_1_29 vdd gf180mcu_fd_sc_mcu7t5v0__oai21_1_29/B gf180mcu_fd_sc_mcu7t5v0__nor2_1_75/ZN
+ gf180mcu_fd_sc_mcu7t5v0__xor2_1_29/A1 gf180mcu_fd_sc_mcu7t5v0__xor3_1_21/A2 vss
+ vdd vss gf180mcu_fd_sc_mcu7t5v0__oai21_1
Xgf180mcu_fd_sc_mcu7t5v0__and2_4_3 gf180mcu_fd_sc_mcu7t5v0__buf_20_0/Z vdd vss gf180mcu_fd_sc_mcu7t5v0__and2_4_3/Z
+ gf180mcu_fd_sc_mcu7t5v0__buf_12_0/Z vdd vss gf180mcu_fd_sc_mcu7t5v0__and2_4
Xgf180mcu_fd_sc_mcu7t5v0__nand2_1_507 vdd vss gf180mcu_fd_sc_mcu7t5v0__xor3_1_99/A2
+ gf180mcu_fd_sc_mcu7t5v0__inv_8_2/I gf180mcu_fd_sc_mcu7t5v0__and2_2_9/Z vdd vss gf180mcu_fd_sc_mcu7t5v0__nand2_1
Xgf180mcu_fd_sc_mcu7t5v0__nand2_1_518 vdd vss gf180mcu_fd_sc_mcu7t5v0__nand2_1_518/ZN
+ gf180mcu_fd_sc_mcu7t5v0__or2_1_41/A1 gf180mcu_fd_sc_mcu7t5v0__or2_4_4/Z vdd vss
+ gf180mcu_fd_sc_mcu7t5v0__nand2_1
Xgf180mcu_fd_sc_mcu7t5v0__nand4_1_3 gf180mcu_fd_sc_mcu7t5v0__nand4_1_3/A3 gf180mcu_fd_sc_mcu7t5v0__nand4_1_3/A4
+ vdd vss gf180mcu_fd_sc_mcu7t5v0__oai211_1_9/B gf180mcu_fd_sc_mcu7t5v0__oai31_1_0/B
+ gf180mcu_fd_sc_mcu7t5v0__nand4_1_3/A2 vdd vss gf180mcu_fd_sc_mcu7t5v0__nand4_1
Xgf180mcu_fd_sc_mcu7t5v0__nand2_1_529 vdd vss gf180mcu_fd_sc_mcu7t5v0__nand2_1_529/ZN
+ gf180mcu_fd_sc_mcu7t5v0__inv_8_1/I gf180mcu_fd_sc_mcu7t5v0__xor2_1_150/Z vdd vss
+ gf180mcu_fd_sc_mcu7t5v0__nand2_1
Xgf180mcu_fd_sc_mcu7t5v0__nand3_1_102 gf180mcu_fd_sc_mcu7t5v0__and3_1_3/A2 vdd vss
+ gf180mcu_fd_sc_mcu7t5v0__nand4_1_25/A3 gf180mcu_fd_sc_mcu7t5v0__nor2_1_315/A2 gf180mcu_fd_sc_mcu7t5v0__or3_1_28/Z
+ vdd vss gf180mcu_fd_sc_mcu7t5v0__nand3_1
Xgf180mcu_fd_sc_mcu7t5v0__or3_1_16 gf180mcu_fd_sc_mcu7t5v0__or3_1_16/A3 vdd vss gf180mcu_fd_sc_mcu7t5v0__or3_1_16/Z
+ gf180mcu_fd_sc_mcu7t5v0__or3_1_16/A1 gf180mcu_fd_sc_mcu7t5v0__or3_1_16/A2 vdd vss
+ gf180mcu_fd_sc_mcu7t5v0__or3_1
Xgf180mcu_fd_sc_mcu7t5v0__or3_1_27 gf180mcu_fd_sc_mcu7t5v0__or3_1_27/A3 vdd vss gf180mcu_fd_sc_mcu7t5v0__or3_1_27/Z
+ gf180mcu_fd_sc_mcu7t5v0__or3_1_27/A1 gf180mcu_fd_sc_mcu7t5v0__or3_1_27/A2 vdd vss
+ gf180mcu_fd_sc_mcu7t5v0__or3_1
Xgf180mcu_fd_sc_mcu7t5v0__nor3_4_16 gf180mcu_fd_sc_mcu7t5v0__nor3_4_16/A3 vdd vss
+ gf180mcu_fd_sc_mcu7t5v0__nor3_4_16/ZN gf180mcu_fd_sc_mcu7t5v0__or3_1_24/A1 gf180mcu_fd_sc_mcu7t5v0__xor3_1_88/A2
+ vdd vss gf180mcu_fd_sc_mcu7t5v0__nor3_4
Xgf180mcu_fd_sc_mcu7t5v0__dffq_4_40 gf180mcu_fd_sc_mcu7t5v0__dffq_4_40/D gf180mcu_fd_sc_mcu7t5v0__dffq_4_40/Q
+ vdd vss gf180mcu_fd_sc_mcu7t5v0__dffq_4_1/CLK vdd vss gf180mcu_fd_sc_mcu7t5v0__dffq_4
Xgf180mcu_fd_sc_mcu7t5v0__and2_2_0 vdd vss gf180mcu_fd_sc_mcu7t5v0__and2_2_0/Z gf180mcu_fd_sc_mcu7t5v0__and2_2_0/A1
+ gf180mcu_fd_sc_mcu7t5v0__and2_2_0/A2 vdd vss gf180mcu_fd_sc_mcu7t5v0__and2_2
Xgf180mcu_fd_sc_mcu7t5v0__nand2_1_304 vdd vss gf180mcu_fd_sc_mcu7t5v0__nand2_1_304/ZN
+ gf180mcu_fd_sc_mcu7t5v0__xor3_1_68/A1 gf180mcu_fd_sc_mcu7t5v0__or2_1_56/Z vdd vss
+ gf180mcu_fd_sc_mcu7t5v0__nand2_1
Xgf180mcu_fd_sc_mcu7t5v0__nand2_1_315 vdd vss gf180mcu_fd_sc_mcu7t5v0__nor2_1_154/A2
+ gf180mcu_fd_sc_mcu7t5v0__dffq_1_298/Q gf180mcu_fd_sc_mcu7t5v0__nor4_4_2/A3 vdd vss
+ gf180mcu_fd_sc_mcu7t5v0__nand2_1
Xgf180mcu_fd_sc_mcu7t5v0__nand2_1_326 vdd vss gf180mcu_fd_sc_mcu7t5v0__oai21_4_10/B
+ gf180mcu_fd_sc_mcu7t5v0__nor2_1_161/A1 gf180mcu_fd_sc_mcu7t5v0__or3_4_0/Z vdd vss
+ gf180mcu_fd_sc_mcu7t5v0__nand2_1
Xgf180mcu_fd_sc_mcu7t5v0__nand2_1_337 vdd vss gf180mcu_fd_sc_mcu7t5v0__aoi211_1_49/C
+ gf180mcu_fd_sc_mcu7t5v0__buf_8_5/I gf180mcu_fd_sc_mcu7t5v0__oai21_1_101/ZN vdd vss
+ gf180mcu_fd_sc_mcu7t5v0__nand2_1
Xgf180mcu_fd_sc_mcu7t5v0__nand2_1_348 vdd vss gf180mcu_fd_sc_mcu7t5v0__oai21_1_148/A2
+ gf180mcu_fd_sc_mcu7t5v0__buf_8_8/I gf180mcu_fd_sc_mcu7t5v0__oai31_2_0/A2 vdd vss
+ gf180mcu_fd_sc_mcu7t5v0__nand2_1
Xgf180mcu_fd_sc_mcu7t5v0__nand2_1_359 vdd vss gf180mcu_fd_sc_mcu7t5v0__nand3_1_59/A2
+ gf180mcu_fd_sc_mcu7t5v0__dffq_2_52/Q gf180mcu_fd_sc_mcu7t5v0__nand4_4_2/ZN vdd vss
+ gf180mcu_fd_sc_mcu7t5v0__nand2_1
Xgf180mcu_fd_sc_mcu7t5v0__dffq_1_401 vdd gf180mcu_fd_sc_mcu7t5v0__dffq_1_401/Q gf180mcu_fd_sc_mcu7t5v0__dffq_4_21/CLK
+ vss gf180mcu_fd_sc_mcu7t5v0__dffq_1_401/D vdd vss gf180mcu_fd_sc_mcu7t5v0__dffq_1
Xgf180mcu_fd_sc_mcu7t5v0__dffq_1_412 vdd gf180mcu_fd_sc_mcu7t5v0__or3_2_4/A1 gf180mcu_fd_sc_mcu7t5v0__dffq_4_21/CLK
+ vss gf180mcu_fd_sc_mcu7t5v0__dffq_1_412/D vdd vss gf180mcu_fd_sc_mcu7t5v0__dffq_1
Xgf180mcu_fd_sc_mcu7t5v0__dffq_1_423 vdd gf180mcu_fd_sc_mcu7t5v0__dffq_1_423/Q gf180mcu_fd_sc_mcu7t5v0__dffq_4_1/CLK
+ vss gf180mcu_fd_sc_mcu7t5v0__dffq_1_423/D vdd vss gf180mcu_fd_sc_mcu7t5v0__dffq_1
Xgf180mcu_fd_sc_mcu7t5v0__dffq_1_434 vdd gf180mcu_fd_sc_mcu7t5v0__mux4_4_18/I1 gf180mcu_fd_sc_mcu7t5v0__dffq_4_44/CLK
+ vss gf180mcu_fd_sc_mcu7t5v0__dffq_1_434/D vdd vss gf180mcu_fd_sc_mcu7t5v0__dffq_1
Xgf180mcu_fd_sc_mcu7t5v0__dffq_1_445 vdd gf180mcu_fd_sc_mcu7t5v0__dffq_1_445/Q gf180mcu_fd_sc_mcu7t5v0__dffq_4_9/CLK
+ vss gf180mcu_fd_sc_mcu7t5v0__dffq_1_445/D vdd vss gf180mcu_fd_sc_mcu7t5v0__dffq_1
Xgf180mcu_fd_sc_mcu7t5v0__dffq_1_456 vdd gf180mcu_fd_sc_mcu7t5v0__dffq_1_456/Q gf180mcu_fd_sc_mcu7t5v0__dffq_2_58/CLK
+ vss gf180mcu_fd_sc_mcu7t5v0__dffq_1_456/D vdd vss gf180mcu_fd_sc_mcu7t5v0__dffq_1
Xgf180mcu_fd_sc_mcu7t5v0__clkinv_1_306 vdd vss gf180mcu_fd_sc_mcu7t5v0__dffq_1_322/Q
+ gf180mcu_fd_sc_mcu7t5v0__aoi21_1_158/A1 vdd vss gf180mcu_fd_sc_mcu7t5v0__clkinv_1
Xgf180mcu_fd_sc_mcu7t5v0__clkinv_1_317 vdd vss gf180mcu_fd_sc_mcu7t5v0__and3_1_9/A3
+ gf180mcu_fd_sc_mcu7t5v0__aoi211_1_50/A1 vdd vss gf180mcu_fd_sc_mcu7t5v0__clkinv_1
Xgf180mcu_fd_sc_mcu7t5v0__clkinv_1_328 vdd vss gf180mcu_fd_sc_mcu7t5v0__nand2_1_436/ZN
+ gf180mcu_fd_sc_mcu7t5v0__xor3_1_78/A1 vdd vss gf180mcu_fd_sc_mcu7t5v0__clkinv_1
Xgf180mcu_fd_sc_mcu7t5v0__clkinv_1_339 vdd vss gf180mcu_fd_sc_mcu7t5v0__mux4_4_6/I3
+ gf180mcu_fd_sc_mcu7t5v0__nor3_2_10/A1 vdd vss gf180mcu_fd_sc_mcu7t5v0__clkinv_1
Xgf180mcu_fd_sc_mcu7t5v0__nand2_4_4 vdd vss gf180mcu_fd_sc_mcu7t5v0__nand2_4_4/ZN
+ gf180mcu_fd_sc_mcu7t5v0__nor3_4_11/ZN gf180mcu_fd_sc_mcu7t5v0__nor3_4_10/ZN vdd
+ vss gf180mcu_fd_sc_mcu7t5v0__nand2_4
Xgf180mcu_fd_sc_mcu7t5v0__nand2_4_14 vdd vss gf180mcu_fd_sc_mcu7t5v0__nand2_4_14/ZN
+ gf180mcu_fd_sc_mcu7t5v0__nor3_4_9/ZN gf180mcu_fd_sc_mcu7t5v0__nor3_4_6/ZN vdd vss
+ gf180mcu_fd_sc_mcu7t5v0__nand2_4
Xgf180mcu_fd_sc_mcu7t5v0__nand2_4_25 vdd vss gf180mcu_fd_sc_mcu7t5v0__oai32_1_3/A3
+ gf180mcu_fd_sc_mcu7t5v0__inv_2_6/I gf180mcu_fd_sc_mcu7t5v0__dffq_4_7/Q vdd vss gf180mcu_fd_sc_mcu7t5v0__nand2_4
Xgf180mcu_fd_sc_mcu7t5v0__nand2_4_36 vdd vss gf180mcu_fd_sc_mcu7t5v0__nand2_4_36/ZN
+ gf180mcu_fd_sc_mcu7t5v0__nor3_4_7/ZN gf180mcu_fd_sc_mcu7t5v0__nor2_4_5/ZN vdd vss
+ gf180mcu_fd_sc_mcu7t5v0__nand2_4
Xgf180mcu_fd_sc_mcu7t5v0__nor4_1_4 gf180mcu_fd_sc_mcu7t5v0__nor4_1_4/A3 gf180mcu_fd_sc_mcu7t5v0__nor4_1_4/A4
+ vdd vss gf180mcu_fd_sc_mcu7t5v0__nor4_1_4/ZN gf180mcu_fd_sc_mcu7t5v0__nor4_1_4/A1
+ gf180mcu_fd_sc_mcu7t5v0__nor4_1_4/A2 vdd vss gf180mcu_fd_sc_mcu7t5v0__nor4_1
Xgf180mcu_fd_sc_mcu7t5v0__dffq_4_8 gf180mcu_fd_sc_mcu7t5v0__dffq_4_8/D gf180mcu_fd_sc_mcu7t5v0__dffq_4_8/Q
+ vdd vss gf180mcu_fd_sc_mcu7t5v0__dffq_4_8/CLK vdd vss gf180mcu_fd_sc_mcu7t5v0__dffq_4
Xgf180mcu_fd_sc_mcu7t5v0__nand2_1_101 vdd vss gf180mcu_fd_sc_mcu7t5v0__xor3_1_32/A1
+ gf180mcu_fd_sc_mcu7t5v0__or4_1_0/A1 gf180mcu_fd_sc_mcu7t5v0__or4_1_1/A4 vdd vss
+ gf180mcu_fd_sc_mcu7t5v0__nand2_1
Xgf180mcu_fd_sc_mcu7t5v0__nand2_1_112 vdd vss gf180mcu_fd_sc_mcu7t5v0__xor3_1_34/A1
+ gf180mcu_fd_sc_mcu7t5v0__inv_8_1/I gf180mcu_fd_sc_mcu7t5v0__and4_1_0/A4 vdd vss
+ gf180mcu_fd_sc_mcu7t5v0__nand2_1
Xgf180mcu_fd_sc_mcu7t5v0__nand2_1_123 vdd vss gf180mcu_fd_sc_mcu7t5v0__xor3_1_47/A1
+ gf180mcu_fd_sc_mcu7t5v0__dffq_4_37/Q gf180mcu_fd_sc_mcu7t5v0__and2_4_0/Z vdd vss
+ gf180mcu_fd_sc_mcu7t5v0__nand2_1
Xgf180mcu_fd_sc_mcu7t5v0__nand2_1_134 vdd vss gf180mcu_fd_sc_mcu7t5v0__xor3_1_46/A1
+ gf180mcu_fd_sc_mcu7t5v0__or4_1_0/A1 gf180mcu_fd_sc_mcu7t5v0__aoi22_4_1/ZN vdd vss
+ gf180mcu_fd_sc_mcu7t5v0__nand2_1
Xgf180mcu_fd_sc_mcu7t5v0__nand2_1_145 vdd vss gf180mcu_fd_sc_mcu7t5v0__xor2_1_63/A2
+ gf180mcu_fd_sc_mcu7t5v0__inv_8_1/I gf180mcu_fd_sc_mcu7t5v0__or4_1_1/A3 vdd vss gf180mcu_fd_sc_mcu7t5v0__nand2_1
Xgf180mcu_fd_sc_mcu7t5v0__nand2_1_156 vdd vss gf180mcu_fd_sc_mcu7t5v0__nand2_1_156/ZN
+ gf180mcu_fd_sc_mcu7t5v0__oai31_1_14/B gf180mcu_fd_sc_mcu7t5v0__oai211_1_56/ZN vdd
+ vss gf180mcu_fd_sc_mcu7t5v0__nand2_1
Xgf180mcu_fd_sc_mcu7t5v0__nand2_1_167 vdd vss gf180mcu_fd_sc_mcu7t5v0__xor3_1_55/A1
+ gf180mcu_fd_sc_mcu7t5v0__or4_1_0/A1 gf180mcu_fd_sc_mcu7t5v0__and4_1_0/A4 vdd vss
+ gf180mcu_fd_sc_mcu7t5v0__nand2_1
Xgf180mcu_fd_sc_mcu7t5v0__nand2_1_178 vdd vss gf180mcu_fd_sc_mcu7t5v0__or3_1_27/A3
+ gf180mcu_fd_sc_mcu7t5v0__inv_12_1/I gf180mcu_fd_sc_mcu7t5v0__mux4_4_9/Z vdd vss
+ gf180mcu_fd_sc_mcu7t5v0__nand2_1
Xgf180mcu_fd_sc_mcu7t5v0__nand2_1_189 vdd vss gf180mcu_fd_sc_mcu7t5v0__xor3_1_54/A1
+ gf180mcu_fd_sc_mcu7t5v0__or2_1_16/Z gf180mcu_fd_sc_mcu7t5v0__nand2_1_190/ZN vdd
+ vss gf180mcu_fd_sc_mcu7t5v0__nand2_1
Xgf180mcu_fd_sc_mcu7t5v0__dffq_1_220 vdd gf180mcu_fd_sc_mcu7t5v0__dffq_1_220/Q gf180mcu_fd_sc_mcu7t5v0__dffq_4_8/CLK
+ vss gf180mcu_fd_sc_mcu7t5v0__dffq_1_220/D vdd vss gf180mcu_fd_sc_mcu7t5v0__dffq_1
Xgf180mcu_fd_sc_mcu7t5v0__dffq_1_231 vdd gf180mcu_fd_sc_mcu7t5v0__dffq_1_231/Q gf180mcu_fd_sc_mcu7t5v0__dffq_2_26/CLK
+ vss gf180mcu_fd_sc_mcu7t5v0__dffq_1_231/D vdd vss gf180mcu_fd_sc_mcu7t5v0__dffq_1
Xgf180mcu_fd_sc_mcu7t5v0__dffq_1_242 vdd gf180mcu_fd_sc_mcu7t5v0__dffq_1_242/Q gf180mcu_fd_sc_mcu7t5v0__dffq_4_8/CLK
+ vss gf180mcu_fd_sc_mcu7t5v0__dffq_1_242/D vdd vss gf180mcu_fd_sc_mcu7t5v0__dffq_1
Xgf180mcu_fd_sc_mcu7t5v0__dffq_1_253 vdd gf180mcu_fd_sc_mcu7t5v0__dffq_1_253/Q gf180mcu_fd_sc_mcu7t5v0__dffq_4_8/CLK
+ vss gf180mcu_fd_sc_mcu7t5v0__dffq_1_253/D vdd vss gf180mcu_fd_sc_mcu7t5v0__dffq_1
Xgf180mcu_fd_sc_mcu7t5v0__dffq_1_264 vdd gf180mcu_fd_sc_mcu7t5v0__dffq_1_264/Q gf180mcu_fd_sc_mcu7t5v0__dffq_2_26/CLK
+ vss gf180mcu_fd_sc_mcu7t5v0__dffq_1_264/D vdd vss gf180mcu_fd_sc_mcu7t5v0__dffq_1
Xgf180mcu_fd_sc_mcu7t5v0__dffq_1_275 vdd gf180mcu_fd_sc_mcu7t5v0__dffq_1_275/Q gf180mcu_fd_sc_mcu7t5v0__dffq_2_26/CLK
+ vss gf180mcu_fd_sc_mcu7t5v0__dffq_1_275/D vdd vss gf180mcu_fd_sc_mcu7t5v0__dffq_1
Xgf180mcu_fd_sc_mcu7t5v0__dffq_1_286 vdd gf180mcu_fd_sc_mcu7t5v0__dffq_1_286/Q gf180mcu_fd_sc_mcu7t5v0__dffq_2_58/CLK
+ vss gf180mcu_fd_sc_mcu7t5v0__dffq_1_286/D vdd vss gf180mcu_fd_sc_mcu7t5v0__dffq_1
Xgf180mcu_fd_sc_mcu7t5v0__dffq_1_297 vdd gf180mcu_fd_sc_mcu7t5v0__dffq_1_297/Q gf180mcu_fd_sc_mcu7t5v0__dffq_4_9/CLK
+ vss gf180mcu_fd_sc_mcu7t5v0__dffq_1_297/D vdd vss gf180mcu_fd_sc_mcu7t5v0__dffq_1
Xgf180mcu_fd_sc_mcu7t5v0__nand2_1_690 vdd vss gf180mcu_fd_sc_mcu7t5v0__oai21_1_325/B
+ gf180mcu_fd_sc_mcu7t5v0__inv_4_6/I gf180mcu_fd_sc_mcu7t5v0__xor3_1_150/A3 vdd vss
+ gf180mcu_fd_sc_mcu7t5v0__nand2_1
Xgf180mcu_fd_sc_mcu7t5v0__clkinv_1_103 vdd vss gf180mcu_fd_sc_mcu7t5v0__dffq_1_82/Q
+ gf180mcu_fd_sc_mcu7t5v0__oai22_1_83/B2 vdd vss gf180mcu_fd_sc_mcu7t5v0__clkinv_1
Xgf180mcu_fd_sc_mcu7t5v0__dffq_1_30 vdd gf180mcu_fd_sc_mcu7t5v0__dffq_1_30/Q gf180mcu_fd_sc_mcu7t5v0__dffq_1_99/CLK
+ vss gf180mcu_fd_sc_mcu7t5v0__dffq_1_30/D vdd vss gf180mcu_fd_sc_mcu7t5v0__dffq_1
Xgf180mcu_fd_sc_mcu7t5v0__nor3_1_17 gf180mcu_fd_sc_mcu7t5v0__or4_1_2/Z vdd vss gf180mcu_fd_sc_mcu7t5v0__and4_2_0/A2
+ gf180mcu_fd_sc_mcu7t5v0__nor3_1_17/A1 gf180mcu_fd_sc_mcu7t5v0__nor3_1_17/A2 vdd
+ vss gf180mcu_fd_sc_mcu7t5v0__nor3_1
Xgf180mcu_fd_sc_mcu7t5v0__clkinv_1_114 vdd vss gf180mcu_fd_sc_mcu7t5v0__dffq_1_100/Q
+ gf180mcu_fd_sc_mcu7t5v0__oai22_1_103/B2 vdd vss gf180mcu_fd_sc_mcu7t5v0__clkinv_1
Xgf180mcu_fd_sc_mcu7t5v0__nor3_1_28 gf180mcu_fd_sc_mcu7t5v0__oai22_2_1/A1 vdd vss
+ gf180mcu_fd_sc_mcu7t5v0__nor3_1_28/ZN gf180mcu_fd_sc_mcu7t5v0__nor3_2_7/A3 gf180mcu_fd_sc_mcu7t5v0__xor3_1_97/A1
+ vdd vss gf180mcu_fd_sc_mcu7t5v0__nor3_1
Xgf180mcu_fd_sc_mcu7t5v0__dffq_1_41 vdd gf180mcu_fd_sc_mcu7t5v0__dffq_1_41/Q gf180mcu_fd_sc_mcu7t5v0__dffq_1_99/CLK
+ vss gf180mcu_fd_sc_mcu7t5v0__dffq_1_41/D vdd vss gf180mcu_fd_sc_mcu7t5v0__dffq_1
Xgf180mcu_fd_sc_mcu7t5v0__clkinv_1_125 vdd vss gf180mcu_fd_sc_mcu7t5v0__dffq_1_109/Q
+ gf180mcu_fd_sc_mcu7t5v0__oai22_1_115/B2 vdd vss gf180mcu_fd_sc_mcu7t5v0__clkinv_1
Xgf180mcu_fd_sc_mcu7t5v0__dffq_1_52 vdd gf180mcu_fd_sc_mcu7t5v0__dffq_1_52/Q gf180mcu_fd_sc_mcu7t5v0__dffq_1_99/CLK
+ vss gf180mcu_fd_sc_mcu7t5v0__dffq_1_52/D vdd vss gf180mcu_fd_sc_mcu7t5v0__dffq_1
Xgf180mcu_fd_sc_mcu7t5v0__clkinv_1_136 vdd vss gf180mcu_fd_sc_mcu7t5v0__dffq_1_118/Q
+ gf180mcu_fd_sc_mcu7t5v0__oai22_1_125/B2 vdd vss gf180mcu_fd_sc_mcu7t5v0__clkinv_1
Xgf180mcu_fd_sc_mcu7t5v0__nor3_1_39 gf180mcu_fd_sc_mcu7t5v0__or3_1_24/A3 vdd vss gf180mcu_fd_sc_mcu7t5v0__nor3_1_39/ZN
+ gf180mcu_fd_sc_mcu7t5v0__or3_1_24/A1 gf180mcu_fd_sc_mcu7t5v0__or3_1_24/A2 vdd vss
+ gf180mcu_fd_sc_mcu7t5v0__nor3_1
Xgf180mcu_fd_sc_mcu7t5v0__dffq_1_63 vdd gf180mcu_fd_sc_mcu7t5v0__dffq_1_63/Q gf180mcu_fd_sc_mcu7t5v0__dffq_1_95/CLK
+ vss gf180mcu_fd_sc_mcu7t5v0__dffq_1_63/D vdd vss gf180mcu_fd_sc_mcu7t5v0__dffq_1
Xgf180mcu_fd_sc_mcu7t5v0__dffq_1_74 vdd gf180mcu_fd_sc_mcu7t5v0__dffq_1_74/Q gf180mcu_fd_sc_mcu7t5v0__dffq_1_99/CLK
+ vss gf180mcu_fd_sc_mcu7t5v0__dffq_1_74/D vdd vss gf180mcu_fd_sc_mcu7t5v0__dffq_1
Xgf180mcu_fd_sc_mcu7t5v0__clkinv_1_147 vdd vss gf180mcu_fd_sc_mcu7t5v0__dffq_1_125/Q
+ gf180mcu_fd_sc_mcu7t5v0__oai22_1_196/B2 vdd vss gf180mcu_fd_sc_mcu7t5v0__clkinv_1
Xgf180mcu_fd_sc_mcu7t5v0__dffq_1_85 vdd gf180mcu_fd_sc_mcu7t5v0__dffq_1_85/Q gf180mcu_fd_sc_mcu7t5v0__dffq_1_99/CLK
+ vss gf180mcu_fd_sc_mcu7t5v0__dffq_1_85/D vdd vss gf180mcu_fd_sc_mcu7t5v0__dffq_1
Xgf180mcu_fd_sc_mcu7t5v0__clkinv_1_158 vdd vss gf180mcu_fd_sc_mcu7t5v0__dffq_1_140/Q
+ gf180mcu_fd_sc_mcu7t5v0__oai22_1_144/B2 vdd vss gf180mcu_fd_sc_mcu7t5v0__clkinv_1
Xgf180mcu_fd_sc_mcu7t5v0__clkinv_1_169 vdd vss gf180mcu_fd_sc_mcu7t5v0__dffq_1_154/Q
+ gf180mcu_fd_sc_mcu7t5v0__oai22_1_157/B2 vdd vss gf180mcu_fd_sc_mcu7t5v0__clkinv_1
Xgf180mcu_fd_sc_mcu7t5v0__dffq_1_96 vdd gf180mcu_fd_sc_mcu7t5v0__dffq_1_96/Q gf180mcu_fd_sc_mcu7t5v0__dffq_1_96/CLK
+ vss gf180mcu_fd_sc_mcu7t5v0__dffq_1_96/D vdd vss gf180mcu_fd_sc_mcu7t5v0__dffq_1
Xgf180mcu_fd_sc_mcu7t5v0__nand2_2_1 vdd vss gf180mcu_fd_sc_mcu7t5v0__xor3_1_62/A1
+ gf180mcu_fd_sc_mcu7t5v0__inv_8_0/I gf180mcu_fd_sc_mcu7t5v0__and2_2_1/Z vdd vss gf180mcu_fd_sc_mcu7t5v0__nand2_2
Xgf180mcu_fd_sc_mcu7t5v0__aoi211_1_5 gf180mcu_fd_sc_mcu7t5v0__aoi21_1_7/B gf180mcu_fd_sc_mcu7t5v0__aoi211_1_5/C
+ vdd vss gf180mcu_fd_sc_mcu7t5v0__dffq_1_455/D gf180mcu_fd_sc_mcu7t5v0__oai22_4_1/A2
+ gf180mcu_fd_sc_mcu7t5v0__or2_4_4/Z vdd vss gf180mcu_fd_sc_mcu7t5v0__aoi211_1
Xgf180mcu_fd_sc_mcu7t5v0__dffq_2_5 gf180mcu_fd_sc_mcu7t5v0__dffq_2_5/D vdd vss gf180mcu_fd_sc_mcu7t5v0__dffq_4_6/CLK
+ gf180mcu_fd_sc_mcu7t5v0__or3_2_0/A1 vdd vss gf180mcu_fd_sc_mcu7t5v0__dffq_2
Xgf180mcu_fd_sc_mcu7t5v0__aoi22_1_2 gf180mcu_fd_sc_mcu7t5v0__nand2_1_8/ZN gf180mcu_fd_sc_mcu7t5v0__aoi22_1_2/B2
+ vdd vss gf180mcu_fd_sc_mcu7t5v0__nor2_1_15/A2 gf180mcu_fd_sc_mcu7t5v0__dffq_2_4/Q
+ gf180mcu_fd_sc_mcu7t5v0__or2_4_4/Z vdd vss gf180mcu_fd_sc_mcu7t5v0__aoi22_1
Xgf180mcu_fd_sc_mcu7t5v0__oai22_1_130 gf180mcu_fd_sc_mcu7t5v0__nand2_4_17/ZN gf180mcu_fd_sc_mcu7t5v0__nand2_2_23/ZN
+ gf180mcu_fd_sc_mcu7t5v0__oai22_1_130/B2 vdd vss gf180mcu_fd_sc_mcu7t5v0__dffq_1_137/D
+ gf180mcu_fd_sc_mcu7t5v0__aoi21_4_2/ZN vdd vss gf180mcu_fd_sc_mcu7t5v0__oai22_1
Xgf180mcu_fd_sc_mcu7t5v0__oai22_1_141 gf180mcu_fd_sc_mcu7t5v0__nand2_4_18/ZN gf180mcu_fd_sc_mcu7t5v0__nand2_2_25/ZN
+ gf180mcu_fd_sc_mcu7t5v0__oai22_1_141/B2 vdd vss gf180mcu_fd_sc_mcu7t5v0__dffq_1_138/D
+ gf180mcu_fd_sc_mcu7t5v0__aoi21_4_2/ZN vdd vss gf180mcu_fd_sc_mcu7t5v0__oai22_1
Xgf180mcu_fd_sc_mcu7t5v0__oai22_1_152 gf180mcu_fd_sc_mcu7t5v0__nand2_4_20/ZN gf180mcu_fd_sc_mcu7t5v0__nand2_2_27/ZN
+ gf180mcu_fd_sc_mcu7t5v0__oai22_1_152/B2 vdd vss gf180mcu_fd_sc_mcu7t5v0__dffq_1_147/D
+ gf180mcu_fd_sc_mcu7t5v0__oai22_1_98/A1 vdd vss gf180mcu_fd_sc_mcu7t5v0__oai22_1
Xgf180mcu_fd_sc_mcu7t5v0__oai22_1_163 gf180mcu_fd_sc_mcu7t5v0__nand2_4_21/ZN gf180mcu_fd_sc_mcu7t5v0__nand2_2_28/ZN
+ gf180mcu_fd_sc_mcu7t5v0__oai22_1_163/B2 vdd vss gf180mcu_fd_sc_mcu7t5v0__dffq_1_156/D
+ gf180mcu_fd_sc_mcu7t5v0__oai22_1_88/A1 vdd vss gf180mcu_fd_sc_mcu7t5v0__oai22_1
Xgf180mcu_fd_sc_mcu7t5v0__oai221_1_2 gf180mcu_fd_sc_mcu7t5v0__oai221_1_2/B1 gf180mcu_fd_sc_mcu7t5v0__or2_1_34/A2
+ vdd vss gf180mcu_fd_sc_mcu7t5v0__oai221_1_2/ZN gf180mcu_fd_sc_mcu7t5v0__nor3_1_9/A1
+ gf180mcu_fd_sc_mcu7t5v0__xor3_1_27/Z gf180mcu_fd_sc_mcu7t5v0__oai221_1_2/B2 vdd
+ vss gf180mcu_fd_sc_mcu7t5v0__oai221_1
Xgf180mcu_fd_sc_mcu7t5v0__oai22_1_174 gf180mcu_fd_sc_mcu7t5v0__nand2_4_22/ZN gf180mcu_fd_sc_mcu7t5v0__nand2_2_29/ZN
+ gf180mcu_fd_sc_mcu7t5v0__oai22_1_174/B2 vdd vss gf180mcu_fd_sc_mcu7t5v0__dffq_1_172/D
+ gf180mcu_fd_sc_mcu7t5v0__oai21_4_9/ZN vdd vss gf180mcu_fd_sc_mcu7t5v0__oai22_1
Xgf180mcu_fd_sc_mcu7t5v0__oai22_1_185 gf180mcu_fd_sc_mcu7t5v0__nand2_4_36/ZN gf180mcu_fd_sc_mcu7t5v0__nand2_2_31/ZN
+ gf180mcu_fd_sc_mcu7t5v0__oai22_1_185/B2 vdd vss gf180mcu_fd_sc_mcu7t5v0__dffq_1_171/D
+ gf180mcu_fd_sc_mcu7t5v0__aoi21_4_4/ZN vdd vss gf180mcu_fd_sc_mcu7t5v0__oai22_1
Xgf180mcu_fd_sc_mcu7t5v0__oai22_1_196 gf180mcu_fd_sc_mcu7t5v0__nand2_4_19/ZN gf180mcu_fd_sc_mcu7t5v0__nand2_2_26/ZN
+ gf180mcu_fd_sc_mcu7t5v0__oai22_1_196/B2 vdd vss gf180mcu_fd_sc_mcu7t5v0__dffq_1_125/D
+ gf180mcu_fd_sc_mcu7t5v0__aoi21_4_1/ZN vdd vss gf180mcu_fd_sc_mcu7t5v0__oai22_1
Xgf180mcu_fd_sc_mcu7t5v0__xnor3_1_13 gf180mcu_fd_sc_mcu7t5v0__oai22_1_5/B2 vdd vss
+ gf180mcu_fd_sc_mcu7t5v0__xnor3_1_13/ZN gf180mcu_fd_sc_mcu7t5v0__and2_1_22/A1 gf180mcu_fd_sc_mcu7t5v0__oai22_1_6/A2
+ vdd vss gf180mcu_fd_sc_mcu7t5v0__xnor3_1
Xgf180mcu_fd_sc_mcu7t5v0__xnor3_1_24 gf180mcu_fd_sc_mcu7t5v0__xor2_1_106/A2 vdd vss
+ gf180mcu_fd_sc_mcu7t5v0__nor3_1_25/A3 gf180mcu_fd_sc_mcu7t5v0__or3_1_14/Z gf180mcu_fd_sc_mcu7t5v0__and2_1_85/A1
+ vdd vss gf180mcu_fd_sc_mcu7t5v0__xnor3_1
Xgf180mcu_fd_sc_mcu7t5v0__xnor3_1_35 gf180mcu_fd_sc_mcu7t5v0__or2_1_42/A2 vdd vss
+ gf180mcu_fd_sc_mcu7t5v0__xnor3_1_35/ZN gf180mcu_fd_sc_mcu7t5v0__or2_1_42/A1 gf180mcu_fd_sc_mcu7t5v0__xnor3_1_35/A2
+ vdd vss gf180mcu_fd_sc_mcu7t5v0__xnor3_1
Xgf180mcu_fd_sc_mcu7t5v0__xnor3_1_46 gf180mcu_fd_sc_mcu7t5v0__xnor3_1_46/A3 vdd vss
+ gf180mcu_fd_sc_mcu7t5v0__xnor3_1_46/ZN gf180mcu_fd_sc_mcu7t5v0__nor3_1_41/A3 gf180mcu_fd_sc_mcu7t5v0__and2_1_150/Z
+ vdd vss gf180mcu_fd_sc_mcu7t5v0__xnor3_1
Xgf180mcu_fd_sc_mcu7t5v0__nor2_1_50 vdd vss gf180mcu_fd_sc_mcu7t5v0__nor2_1_50/ZN
+ gf180mcu_fd_sc_mcu7t5v0__dffq_1_8/Q gf180mcu_fd_sc_mcu7t5v0__nor2_4_16/ZN vdd vss
+ gf180mcu_fd_sc_mcu7t5v0__nor2_1
Xgf180mcu_fd_sc_mcu7t5v0__nor2_1_61 vdd vss gf180mcu_fd_sc_mcu7t5v0__dffq_1_11/D gf180mcu_fd_sc_mcu7t5v0__aoi21_1_7/B
+ gf180mcu_fd_sc_mcu7t5v0__nor2_1_61/A2 vdd vss gf180mcu_fd_sc_mcu7t5v0__nor2_1
Xgf180mcu_fd_sc_mcu7t5v0__nor2_1_72 vdd vss gf180mcu_fd_sc_mcu7t5v0__nor2_1_72/ZN
+ gf180mcu_fd_sc_mcu7t5v0__inv_2_3/I gf180mcu_fd_sc_mcu7t5v0__oai31_1_3/A1 vdd vss
+ gf180mcu_fd_sc_mcu7t5v0__nor2_1
Xgf180mcu_fd_sc_mcu7t5v0__nor2_1_83 vdd vss gf180mcu_fd_sc_mcu7t5v0__dffq_1_14/D gf180mcu_fd_sc_mcu7t5v0__nor2_1_83/A1
+ gf180mcu_fd_sc_mcu7t5v0__nor2_1_83/A2 vdd vss gf180mcu_fd_sc_mcu7t5v0__nor2_1
Xgf180mcu_fd_sc_mcu7t5v0__nor2_1_94 vdd vss gf180mcu_fd_sc_mcu7t5v0__nor2_1_94/ZN
+ gf180mcu_fd_sc_mcu7t5v0__nor2_1_94/A1 gf180mcu_fd_sc_mcu7t5v0__xor3_1_29/Z vdd vss
+ gf180mcu_fd_sc_mcu7t5v0__nor2_1
Xgf180mcu_fd_sc_mcu7t5v0__nor2_1_250 vdd vss gf180mcu_fd_sc_mcu7t5v0__xor3_1_105/A3
+ gf180mcu_fd_sc_mcu7t5v0__nor3_2_5/A1 gf180mcu_fd_sc_mcu7t5v0__oai32_2_2/ZN vdd vss
+ gf180mcu_fd_sc_mcu7t5v0__nor2_1
Xgf180mcu_fd_sc_mcu7t5v0__clkinv_2_4 vdd vss gf180mcu_fd_sc_mcu7t5v0__or2_4_2/A2 gf180mcu_fd_sc_mcu7t5v0__or2_4_1/A2
+ vdd vss gf180mcu_fd_sc_mcu7t5v0__clkinv_2
Xgf180mcu_fd_sc_mcu7t5v0__nor2_1_261 vdd vss gf180mcu_fd_sc_mcu7t5v0__and2_1_94/A2
+ gf180mcu_fd_sc_mcu7t5v0__dffq_2_98/Q gf180mcu_fd_sc_mcu7t5v0__oai31_2_1/A2 vdd vss
+ gf180mcu_fd_sc_mcu7t5v0__nor2_1
Xgf180mcu_fd_sc_mcu7t5v0__nor2_1_272 vdd vss gf180mcu_fd_sc_mcu7t5v0__nor2_1_272/ZN
+ gf180mcu_fd_sc_mcu7t5v0__oai32_1_6/A2 gf180mcu_fd_sc_mcu7t5v0__dffq_4_40/Q vdd vss
+ gf180mcu_fd_sc_mcu7t5v0__nor2_1
Xgf180mcu_fd_sc_mcu7t5v0__xor3_1_1 gf180mcu_fd_sc_mcu7t5v0__xor3_1_1/A3 vdd vss gf180mcu_fd_sc_mcu7t5v0__xor3_1_1/Z
+ gf180mcu_fd_sc_mcu7t5v0__xor3_1_1/A1 gf180mcu_fd_sc_mcu7t5v0__xor3_1_47/Z vdd vss
+ gf180mcu_fd_sc_mcu7t5v0__xor3_1
Xgf180mcu_fd_sc_mcu7t5v0__oai31_1_5 vdd gf180mcu_fd_sc_mcu7t5v0__xor2_1_70/A2 gf180mcu_fd_sc_mcu7t5v0__oai31_1_5/B
+ gf180mcu_fd_sc_mcu7t5v0__and2_4_2/Z gf180mcu_fd_sc_mcu7t5v0__and2_4_1/Z vss gf180mcu_fd_sc_mcu7t5v0__and2_2_1/Z
+ vdd vss gf180mcu_fd_sc_mcu7t5v0__oai31_1
Xgf180mcu_fd_sc_mcu7t5v0__nor2_1_283 vdd vss gf180mcu_fd_sc_mcu7t5v0__nor2_1_283/ZN
+ gf180mcu_fd_sc_mcu7t5v0__xor2_1_142/A1 gf180mcu_fd_sc_mcu7t5v0__xor2_1_142/A2 vdd
+ vss gf180mcu_fd_sc_mcu7t5v0__nor2_1
Xgf180mcu_fd_sc_mcu7t5v0__nor2_1_294 vdd vss gf180mcu_fd_sc_mcu7t5v0__nor2_1_294/ZN
+ gf180mcu_fd_sc_mcu7t5v0__inv_1_2/I gf180mcu_fd_sc_mcu7t5v0__xor3_1_87/A3 vdd vss
+ gf180mcu_fd_sc_mcu7t5v0__nor2_1
Xgf180mcu_fd_sc_mcu7t5v0__nand2_1_15 vdd vss gf180mcu_fd_sc_mcu7t5v0__oai221_1_1/C
+ gf180mcu_fd_sc_mcu7t5v0__inv_8_1/I gf180mcu_fd_sc_mcu7t5v0__nor2_4_1/ZN vdd vss
+ gf180mcu_fd_sc_mcu7t5v0__nand2_1
Xgf180mcu_fd_sc_mcu7t5v0__nand2_1_26 vdd vss gf180mcu_fd_sc_mcu7t5v0__nand2_1_26/ZN
+ gf180mcu_fd_sc_mcu7t5v0__inv_8_2/I gf180mcu_fd_sc_mcu7t5v0__xor2_1_66/Z vdd vss
+ gf180mcu_fd_sc_mcu7t5v0__nand2_1
Xgf180mcu_fd_sc_mcu7t5v0__nand2_1_37 vdd vss gf180mcu_fd_sc_mcu7t5v0__oai211_1_3/A2
+ gf180mcu_fd_sc_mcu7t5v0__and3_1_24/Z gf180mcu_fd_sc_mcu7t5v0__nand3_1_9/ZN vdd vss
+ gf180mcu_fd_sc_mcu7t5v0__nand2_1
Xgf180mcu_fd_sc_mcu7t5v0__nand2_1_48 vdd vss gf180mcu_fd_sc_mcu7t5v0__oai211_1_5/B
+ gf180mcu_fd_sc_mcu7t5v0__inv_8_0/I gf180mcu_fd_sc_mcu7t5v0__nor2_4_44/ZN vdd vss
+ gf180mcu_fd_sc_mcu7t5v0__nand2_1
Xgf180mcu_fd_sc_mcu7t5v0__and4_1_3 gf180mcu_fd_sc_mcu7t5v0__and4_1_3/A3 gf180mcu_fd_sc_mcu7t5v0__and4_1_3/A4
+ vdd vss gf180mcu_fd_sc_mcu7t5v0__and4_1_3/Z gf180mcu_fd_sc_mcu7t5v0__or4_1_0/A1
+ gf180mcu_fd_sc_mcu7t5v0__inv_8_0/I vdd vss gf180mcu_fd_sc_mcu7t5v0__and4_1
Xgf180mcu_fd_sc_mcu7t5v0__nand2_1_59 vdd vss gf180mcu_fd_sc_mcu7t5v0__oai22_1_3/B2
+ gf180mcu_fd_sc_mcu7t5v0__inv_8_2/I gf180mcu_fd_sc_mcu7t5v0__and2_2_1/Z vdd vss gf180mcu_fd_sc_mcu7t5v0__nand2_1
Xgf180mcu_fd_sc_mcu7t5v0__oai21_1_310 vdd gf180mcu_fd_sc_mcu7t5v0__oai21_1_310/B gf180mcu_fd_sc_mcu7t5v0__nor2_1_385/ZN
+ gf180mcu_fd_sc_mcu7t5v0__xor3_1_152/A2 gf180mcu_fd_sc_mcu7t5v0__xor3_1_154/A2 vss
+ vdd vss gf180mcu_fd_sc_mcu7t5v0__oai21_1
Xgf180mcu_fd_sc_mcu7t5v0__oai21_1_321 vdd gf180mcu_fd_sc_mcu7t5v0__oai21_1_321/B gf180mcu_fd_sc_mcu7t5v0__oai31_4_5/ZN
+ gf180mcu_fd_sc_mcu7t5v0__nand4_1_23/A4 gf180mcu_fd_sc_mcu7t5v0__inv_4_6/I vss vdd
+ vss gf180mcu_fd_sc_mcu7t5v0__oai21_1
Xgf180mcu_fd_sc_mcu7t5v0__nor2_4_5 vdd vss gf180mcu_fd_sc_mcu7t5v0__nor2_4_5/ZN gf180mcu_fd_sc_mcu7t5v0__mux2_4_3/Z
+ gf180mcu_fd_sc_mcu7t5v0__nor2_4_7/A2 vdd vss gf180mcu_fd_sc_mcu7t5v0__nor2_4
Xgf180mcu_fd_sc_mcu7t5v0__oai21_1_332 vdd gf180mcu_fd_sc_mcu7t5v0__buf_8_5/Z gf180mcu_fd_sc_mcu7t5v0__oai21_1_94/A2
+ gf180mcu_fd_sc_mcu7t5v0__aoi21_1_370/B gf180mcu_fd_sc_mcu7t5v0__mux2_4_0/I1 vss
+ vdd vss gf180mcu_fd_sc_mcu7t5v0__oai21_1
Xgf180mcu_fd_sc_mcu7t5v0__xnor2_1_3 vdd vss gf180mcu_fd_sc_mcu7t5v0__nor3_2_2/A2 gf180mcu_fd_sc_mcu7t5v0__xor3_1_7/A1
+ gf180mcu_fd_sc_mcu7t5v0__xor3_1_7/A3 vdd vss gf180mcu_fd_sc_mcu7t5v0__xnor2_1
Xgf180mcu_fd_sc_mcu7t5v0__oai22_1_5 gf180mcu_fd_sc_mcu7t5v0__xor3_1_46/A1 gf180mcu_fd_sc_mcu7t5v0__and2_1_22/Z
+ gf180mcu_fd_sc_mcu7t5v0__oai22_1_5/B2 vdd vss gf180mcu_fd_sc_mcu7t5v0__xor3_1_45/A2
+ gf180mcu_fd_sc_mcu7t5v0__oai22_1_5/A1 vdd vss gf180mcu_fd_sc_mcu7t5v0__oai22_1
Xgf180mcu_fd_sc_mcu7t5v0__aoi22_1_30 gf180mcu_fd_sc_mcu7t5v0__nor2_4_9/ZN gf180mcu_fd_sc_mcu7t5v0__dffq_1_51/Q
+ vdd vss gf180mcu_fd_sc_mcu7t5v0__aoi22_1_30/ZN gf180mcu_fd_sc_mcu7t5v0__dffq_1_40/Q
+ gf180mcu_fd_sc_mcu7t5v0__nor2_4_8/ZN vdd vss gf180mcu_fd_sc_mcu7t5v0__aoi22_1
Xgf180mcu_fd_sc_mcu7t5v0__aoi22_1_41 gf180mcu_fd_sc_mcu7t5v0__nor2_4_11/ZN gf180mcu_fd_sc_mcu7t5v0__dffq_1_67/Q
+ vdd vss gf180mcu_fd_sc_mcu7t5v0__aoi22_1_41/ZN gf180mcu_fd_sc_mcu7t5v0__dffq_1_70/Q
+ gf180mcu_fd_sc_mcu7t5v0__nor2_4_10/ZN vdd vss gf180mcu_fd_sc_mcu7t5v0__aoi22_1
Xgf180mcu_fd_sc_mcu7t5v0__aoi22_1_52 gf180mcu_fd_sc_mcu7t5v0__nor2_4_9/ZN gf180mcu_fd_sc_mcu7t5v0__dffq_1_78/Q
+ vdd vss gf180mcu_fd_sc_mcu7t5v0__aoi22_1_52/ZN gf180mcu_fd_sc_mcu7t5v0__dffq_1_86/Q
+ gf180mcu_fd_sc_mcu7t5v0__nor2_4_8/ZN vdd vss gf180mcu_fd_sc_mcu7t5v0__aoi22_1
Xgf180mcu_fd_sc_mcu7t5v0__aoi22_1_63 gf180mcu_fd_sc_mcu7t5v0__nor2_4_11/ZN gf180mcu_fd_sc_mcu7t5v0__dffq_1_102/Q
+ vdd vss gf180mcu_fd_sc_mcu7t5v0__aoi22_1_63/ZN gf180mcu_fd_sc_mcu7t5v0__dffq_1_80/Q
+ gf180mcu_fd_sc_mcu7t5v0__nor2_4_10/ZN vdd vss gf180mcu_fd_sc_mcu7t5v0__aoi22_1
Xgf180mcu_fd_sc_mcu7t5v0__aoi22_1_74 gf180mcu_fd_sc_mcu7t5v0__nor2_4_9/ZN gf180mcu_fd_sc_mcu7t5v0__dffq_1_119/Q
+ vdd vss gf180mcu_fd_sc_mcu7t5v0__aoi22_1_74/ZN gf180mcu_fd_sc_mcu7t5v0__dffq_1_135/Q
+ gf180mcu_fd_sc_mcu7t5v0__nor2_4_8/ZN vdd vss gf180mcu_fd_sc_mcu7t5v0__aoi22_1
Xgf180mcu_fd_sc_mcu7t5v0__aoi22_1_85 gf180mcu_fd_sc_mcu7t5v0__nor2_4_9/ZN gf180mcu_fd_sc_mcu7t5v0__dffq_1_150/Q
+ vdd vss gf180mcu_fd_sc_mcu7t5v0__aoi22_1_85/ZN gf180mcu_fd_sc_mcu7t5v0__dffq_1_148/Q
+ gf180mcu_fd_sc_mcu7t5v0__nor2_4_8/ZN vdd vss gf180mcu_fd_sc_mcu7t5v0__aoi22_1
Xgf180mcu_fd_sc_mcu7t5v0__aoi22_1_96 gf180mcu_fd_sc_mcu7t5v0__nor2_4_11/ZN gf180mcu_fd_sc_mcu7t5v0__dffq_1_192/Q
+ vdd vss gf180mcu_fd_sc_mcu7t5v0__aoi22_1_96/ZN gf180mcu_fd_sc_mcu7t5v0__dffq_1_188/Q
+ gf180mcu_fd_sc_mcu7t5v0__nor2_4_10/ZN vdd vss gf180mcu_fd_sc_mcu7t5v0__aoi22_1
Xgf180mcu_fd_sc_mcu7t5v0__or3_1_1 gf180mcu_fd_sc_mcu7t5v0__or3_1_1/A3 vdd vss gf180mcu_fd_sc_mcu7t5v0__or3_1_1/Z
+ gf180mcu_fd_sc_mcu7t5v0__or3_1_1/A1 gf180mcu_fd_sc_mcu7t5v0__or3_1_1/A2 vdd vss
+ gf180mcu_fd_sc_mcu7t5v0__or3_1
Xgf180mcu_fd_sc_mcu7t5v0__inv_1_5 vss gf180mcu_fd_sc_mcu7t5v0__inv_1_5/ZN gf180mcu_fd_sc_mcu7t5v0__inv_1_5/I
+ vdd vdd vss gf180mcu_fd_sc_mcu7t5v0__inv_1
Xgf180mcu_fd_sc_mcu7t5v0__nand3_2_14 gf180mcu_fd_sc_mcu7t5v0__inv_2_0/ZN vdd vss gf180mcu_fd_sc_mcu7t5v0__and2_2_3/A1
+ gf180mcu_fd_sc_mcu7t5v0__inv_1_0/ZN gf180mcu_fd_sc_mcu7t5v0__dffq_4_4/Q vdd vss
+ gf180mcu_fd_sc_mcu7t5v0__nand3_2
Xgf180mcu_fd_sc_mcu7t5v0__nand3_2_25 gf180mcu_fd_sc_mcu7t5v0__or2_1_36/A2 vdd vss
+ gf180mcu_fd_sc_mcu7t5v0__and2_2_11/A1 gf180mcu_fd_sc_mcu7t5v0__inv_2_2/ZN gf180mcu_fd_sc_mcu7t5v0__inv_4_4/ZN
+ vdd vss gf180mcu_fd_sc_mcu7t5v0__nand3_2
Xgf180mcu_fd_sc_mcu7t5v0__mux4_4_0 gf180mcu_fd_sc_mcu7t5v0__mux4_4_0/I0 vss vdd gf180mcu_fd_sc_mcu7t5v0__dffq_2_9/Q
+ gf180mcu_fd_sc_mcu7t5v0__inv_1_3/I gf180mcu_fd_sc_mcu7t5v0__inv_1_6/I gf180mcu_fd_sc_mcu7t5v0__mux4_4_0/I3
+ gf180mcu_fd_sc_mcu7t5v0__or3_2_3/A2 gf180mcu_fd_sc_mcu7t5v0__mux4_4_0/Z vdd vss
+ gf180mcu_fd_sc_mcu7t5v0__mux4_4
Xgf180mcu_fd_sc_mcu7t5v0__and2_1_19 vdd vss gf180mcu_fd_sc_mcu7t5v0__and2_1_19/Z gf180mcu_fd_sc_mcu7t5v0__xor3_1_34/Z
+ gf180mcu_fd_sc_mcu7t5v0__nor2_2_7/A2 vdd vss gf180mcu_fd_sc_mcu7t5v0__and2_1
Xgf180mcu_fd_sc_mcu7t5v0__aoi221_2_0 gf180mcu_fd_sc_mcu7t5v0__oai22_1_1/B2 gf180mcu_fd_sc_mcu7t5v0__nand3_2_12/ZN
+ vdd vss gf180mcu_fd_sc_mcu7t5v0__oai211_1_3/B gf180mcu_fd_sc_mcu7t5v0__or2_1_7/A1
+ gf180mcu_fd_sc_mcu7t5v0__nor2_4_44/ZN gf180mcu_fd_sc_mcu7t5v0__oai22_1_2/ZN vdd
+ vss gf180mcu_fd_sc_mcu7t5v0__aoi221_2
Xgf180mcu_fd_sc_mcu7t5v0__nor2_2_2 vdd vss gf180mcu_fd_sc_mcu7t5v0__nor2_2_2/ZN gf180mcu_fd_sc_mcu7t5v0__dffq_4_0/Q
+ gf180mcu_fd_sc_mcu7t5v0__nor2_2_6/A2 vdd vss gf180mcu_fd_sc_mcu7t5v0__nor2_2
Xgf180mcu_fd_sc_mcu7t5v0__oai21_1_140 vdd gf180mcu_fd_sc_mcu7t5v0__buf_8_6/Z gf180mcu_fd_sc_mcu7t5v0__nand2_4_40/ZN
+ gf180mcu_fd_sc_mcu7t5v0__aoi21_1_162/B gf180mcu_fd_sc_mcu7t5v0__dffq_1_335/Q vss
+ vdd vss gf180mcu_fd_sc_mcu7t5v0__oai21_1
Xgf180mcu_fd_sc_mcu7t5v0__oai21_1_151 vdd gf180mcu_fd_sc_mcu7t5v0__oai21_1_157/B gf180mcu_fd_sc_mcu7t5v0__and2_1_59/Z
+ gf180mcu_fd_sc_mcu7t5v0__nor2_1_186/A2 gf180mcu_fd_sc_mcu7t5v0__nor4_1_0/A4 vss
+ vdd vss gf180mcu_fd_sc_mcu7t5v0__oai21_1
Xgf180mcu_fd_sc_mcu7t5v0__oai21_1_162 vdd gf180mcu_fd_sc_mcu7t5v0__oai21_1_163/B gf180mcu_fd_sc_mcu7t5v0__and2_1_65/Z
+ gf180mcu_fd_sc_mcu7t5v0__aoi21_1_166/B gf180mcu_fd_sc_mcu7t5v0__or4_1_2/A4 vss vdd
+ vss gf180mcu_fd_sc_mcu7t5v0__oai21_1
Xgf180mcu_fd_sc_mcu7t5v0__oai21_1_173 vdd gf180mcu_fd_sc_mcu7t5v0__oai32_1_5/B1 gf180mcu_fd_sc_mcu7t5v0__or2_1_24/A2
+ gf180mcu_fd_sc_mcu7t5v0__oai21_1_173/ZN gf180mcu_fd_sc_mcu7t5v0__oai32_1_4/B2 vss
+ vdd vss gf180mcu_fd_sc_mcu7t5v0__oai21_1
Xgf180mcu_fd_sc_mcu7t5v0__oai21_1_184 vdd gf180mcu_fd_sc_mcu7t5v0__buf_8_7/Z gf180mcu_fd_sc_mcu7t5v0__nor2_4_31/ZN
+ gf180mcu_fd_sc_mcu7t5v0__aoi21_1_199/B gf180mcu_fd_sc_mcu7t5v0__dffq_1_400/Q vss
+ vdd vss gf180mcu_fd_sc_mcu7t5v0__oai21_1
Xgf180mcu_fd_sc_mcu7t5v0__oai21_1_195 vdd gf180mcu_fd_sc_mcu7t5v0__xor3_1_76/Z gf180mcu_fd_sc_mcu7t5v0__or3_1_15/A2
+ gf180mcu_fd_sc_mcu7t5v0__and2_1_84/A2 gf180mcu_fd_sc_mcu7t5v0__or3_1_15/A1 vss vdd
+ vss gf180mcu_fd_sc_mcu7t5v0__oai21_1
Xgf180mcu_fd_sc_mcu7t5v0__clkinv_1_11 vdd vss gf180mcu_fd_sc_mcu7t5v0__xor3_1_57/Z
+ gf180mcu_fd_sc_mcu7t5v0__nand2_1_172/A2 vdd vss gf180mcu_fd_sc_mcu7t5v0__clkinv_1
Xgf180mcu_fd_sc_mcu7t5v0__clkinv_1_22 vdd vss gf180mcu_fd_sc_mcu7t5v0__dffq_1_17/Q
+ gf180mcu_fd_sc_mcu7t5v0__oai22_1_14/B2 vdd vss gf180mcu_fd_sc_mcu7t5v0__clkinv_1
Xgf180mcu_fd_sc_mcu7t5v0__clkinv_1_33 vdd vss gf180mcu_fd_sc_mcu7t5v0__dffq_1_25/Q
+ gf180mcu_fd_sc_mcu7t5v0__oai22_1_21/B2 vdd vss gf180mcu_fd_sc_mcu7t5v0__clkinv_1
Xgf180mcu_fd_sc_mcu7t5v0__clkinv_1_44 vdd vss gf180mcu_fd_sc_mcu7t5v0__dffq_1_33/Q
+ gf180mcu_fd_sc_mcu7t5v0__oai22_1_33/B2 vdd vss gf180mcu_fd_sc_mcu7t5v0__clkinv_1
Xgf180mcu_fd_sc_mcu7t5v0__clkinv_1_55 vdd vss gf180mcu_fd_sc_mcu7t5v0__dffq_1_43/Q
+ gf180mcu_fd_sc_mcu7t5v0__oai22_1_46/A1 vdd vss gf180mcu_fd_sc_mcu7t5v0__clkinv_1
Xgf180mcu_fd_sc_mcu7t5v0__clkinv_1_66 vdd vss gf180mcu_fd_sc_mcu7t5v0__dffq_1_58/Q
+ gf180mcu_fd_sc_mcu7t5v0__oai22_1_50/B2 vdd vss gf180mcu_fd_sc_mcu7t5v0__clkinv_1
Xgf180mcu_fd_sc_mcu7t5v0__clkinv_1_77 vdd vss gf180mcu_fd_sc_mcu7t5v0__dffq_1_57/Q
+ gf180mcu_fd_sc_mcu7t5v0__oai22_1_49/B2 vdd vss gf180mcu_fd_sc_mcu7t5v0__clkinv_1
Xgf180mcu_fd_sc_mcu7t5v0__aoi21_1_208 gf180mcu_fd_sc_mcu7t5v0__aoi21_1_208/B vdd vss
+ gf180mcu_fd_sc_mcu7t5v0__dffq_1_396/D gf180mcu_fd_sc_mcu7t5v0__dffq_4_20/Q gf180mcu_fd_sc_mcu7t5v0__nor2_1_203/A1
+ vdd vss gf180mcu_fd_sc_mcu7t5v0__aoi21_1
Xgf180mcu_fd_sc_mcu7t5v0__clkinv_1_88 vdd vss gf180mcu_fd_sc_mcu7t5v0__dffq_1_85/Q
+ gf180mcu_fd_sc_mcu7t5v0__oai22_1_71/B2 vdd vss gf180mcu_fd_sc_mcu7t5v0__clkinv_1
Xgf180mcu_fd_sc_mcu7t5v0__aoi21_1_219 gf180mcu_fd_sc_mcu7t5v0__aoi21_1_7/B vdd vss
+ gf180mcu_fd_sc_mcu7t5v0__dffq_2_64/D gf180mcu_fd_sc_mcu7t5v0__nand2_1_462/ZN gf180mcu_fd_sc_mcu7t5v0__oai211_1_34/ZN
+ vdd vss gf180mcu_fd_sc_mcu7t5v0__aoi21_1
Xgf180mcu_fd_sc_mcu7t5v0__clkinv_1_99 vdd vss gf180mcu_fd_sc_mcu7t5v0__dffq_1_257/Q
+ gf180mcu_fd_sc_mcu7t5v0__oai22_1_82/B2 vdd vss gf180mcu_fd_sc_mcu7t5v0__clkinv_1
Xgf180mcu_fd_sc_mcu7t5v0__oai21_1_19 vdd gf180mcu_fd_sc_mcu7t5v0__oai21_1_19/B gf180mcu_fd_sc_mcu7t5v0__oai21_1_19/A2
+ gf180mcu_fd_sc_mcu7t5v0__oai21_1_14/B gf180mcu_fd_sc_mcu7t5v0__oai32_1_3/B2 vss
+ vdd vss gf180mcu_fd_sc_mcu7t5v0__oai21_1
Xgf180mcu_fd_sc_mcu7t5v0__nand2_1_508 vdd vss gf180mcu_fd_sc_mcu7t5v0__xor3_1_99/A1
+ gf180mcu_fd_sc_mcu7t5v0__dffq_4_37/Q gf180mcu_fd_sc_mcu7t5v0__nor4_2_5/A1 vdd vss
+ gf180mcu_fd_sc_mcu7t5v0__nand2_1
Xgf180mcu_fd_sc_mcu7t5v0__oai32_2_0 gf180mcu_fd_sc_mcu7t5v0__xor3_1_30/Z gf180mcu_fd_sc_mcu7t5v0__oai32_2_0/B1
+ gf180mcu_fd_sc_mcu7t5v0__xor3_1_30/A2 vdd vss gf180mcu_fd_sc_mcu7t5v0__xor2_1_37/A1
+ gf180mcu_fd_sc_mcu7t5v0__or2_1_13/Z gf180mcu_fd_sc_mcu7t5v0__xor2_1_35/Z vdd vss
+ gf180mcu_fd_sc_mcu7t5v0__oai32_2
Xgf180mcu_fd_sc_mcu7t5v0__nand2_1_519 vdd vss gf180mcu_fd_sc_mcu7t5v0__oai21_1_242/A2
+ gf180mcu_fd_sc_mcu7t5v0__inv_8_2/I gf180mcu_fd_sc_mcu7t5v0__mux4_4_0/Z vdd vss gf180mcu_fd_sc_mcu7t5v0__nand2_1
Xgf180mcu_fd_sc_mcu7t5v0__nand4_1_4 gf180mcu_fd_sc_mcu7t5v0__oai22_1_9/ZN gf180mcu_fd_sc_mcu7t5v0__nand4_1_4/A4
+ vdd vss gf180mcu_fd_sc_mcu7t5v0__nand4_1_4/ZN gf180mcu_fd_sc_mcu7t5v0__nand4_1_4/A1
+ gf180mcu_fd_sc_mcu7t5v0__nand4_1_4/A2 vdd vss gf180mcu_fd_sc_mcu7t5v0__nand4_1
Xgf180mcu_fd_sc_mcu7t5v0__nand3_1_103 gf180mcu_fd_sc_mcu7t5v0__inv_1_5/ZN vdd vss
+ gf180mcu_fd_sc_mcu7t5v0__nand3_1_103/ZN gf180mcu_fd_sc_mcu7t5v0__nor2_4_45/A2 gf180mcu_fd_sc_mcu7t5v0__or3_1_9/A2
+ vdd vss gf180mcu_fd_sc_mcu7t5v0__nand3_1
Xgf180mcu_fd_sc_mcu7t5v0__or3_1_17 gf180mcu_fd_sc_mcu7t5v0__xor3_1_89/Z vdd vss gf180mcu_fd_sc_mcu7t5v0__or3_1_17/Z
+ gf180mcu_fd_sc_mcu7t5v0__or3_1_17/A1 gf180mcu_fd_sc_mcu7t5v0__or3_1_17/A2 vdd vss
+ gf180mcu_fd_sc_mcu7t5v0__or3_1
Xgf180mcu_fd_sc_mcu7t5v0__or3_1_28 gf180mcu_fd_sc_mcu7t5v0__xor2_1_26/Z vdd vss gf180mcu_fd_sc_mcu7t5v0__or3_1_28/Z
+ gf180mcu_fd_sc_mcu7t5v0__or3_1_28/A1 gf180mcu_fd_sc_mcu7t5v0__or3_1_28/A2 vdd vss
+ gf180mcu_fd_sc_mcu7t5v0__or3_1
Xgf180mcu_fd_sc_mcu7t5v0__dffq_4_30 gf180mcu_fd_sc_mcu7t5v0__dffq_4_30/D gf180mcu_fd_sc_mcu7t5v0__inv_4_5/I
+ vdd vss gf180mcu_fd_sc_mcu7t5v0__dffq_4_9/CLK vdd vss gf180mcu_fd_sc_mcu7t5v0__dffq_4
Xgf180mcu_fd_sc_mcu7t5v0__dffq_4_41 gf180mcu_fd_sc_mcu7t5v0__dffq_4_41/D gf180mcu_fd_sc_mcu7t5v0__inv_1_24/I
+ vdd vss gf180mcu_fd_sc_mcu7t5v0__dffq_4_1/CLK vdd vss gf180mcu_fd_sc_mcu7t5v0__dffq_4
Xgf180mcu_fd_sc_mcu7t5v0__nor3_4_17 gf180mcu_fd_sc_mcu7t5v0__inv_2_12/I vdd vss gf180mcu_fd_sc_mcu7t5v0__nor3_4_17/ZN
+ gf180mcu_fd_sc_mcu7t5v0__nor3_4_18/A1 gf180mcu_fd_sc_mcu7t5v0__nor3_4_18/A2 vdd
+ vss gf180mcu_fd_sc_mcu7t5v0__nor3_4
Xgf180mcu_fd_sc_mcu7t5v0__and2_2_1 vdd vss gf180mcu_fd_sc_mcu7t5v0__and2_2_1/Z gf180mcu_fd_sc_mcu7t5v0__or3_2_1/Z
+ gf180mcu_fd_sc_mcu7t5v0__and3_1_1/A3 vdd vss gf180mcu_fd_sc_mcu7t5v0__and2_2
Xgf180mcu_fd_sc_mcu7t5v0__nand2_1_305 vdd vss gf180mcu_fd_sc_mcu7t5v0__xnor2_1_29/A1
+ gf180mcu_fd_sc_mcu7t5v0__nor2_4_45/ZN gf180mcu_fd_sc_mcu7t5v0__nor2_1_130/ZN vdd
+ vss gf180mcu_fd_sc_mcu7t5v0__nand2_1
Xgf180mcu_fd_sc_mcu7t5v0__nand2_1_316 vdd vss gf180mcu_fd_sc_mcu7t5v0__nor2_1_174/A2
+ gf180mcu_fd_sc_mcu7t5v0__dffq_1_316/Q gf180mcu_fd_sc_mcu7t5v0__nor4_4_2/A3 vdd vss
+ gf180mcu_fd_sc_mcu7t5v0__nand2_1
Xgf180mcu_fd_sc_mcu7t5v0__nand2_1_327 vdd vss gf180mcu_fd_sc_mcu7t5v0__nand2_1_327/ZN
+ gf180mcu_fd_sc_mcu7t5v0__nor2_1_161/A1 gf180mcu_fd_sc_mcu7t5v0__xor2_2_2/Z vdd vss
+ gf180mcu_fd_sc_mcu7t5v0__nand2_1
Xgf180mcu_fd_sc_mcu7t5v0__nand2_1_338 vdd vss gf180mcu_fd_sc_mcu7t5v0__xor2_1_90/A2
+ gf180mcu_fd_sc_mcu7t5v0__and3_1_9/A3 gf180mcu_fd_sc_mcu7t5v0__oai21_1_167/ZN vdd
+ vss gf180mcu_fd_sc_mcu7t5v0__nand2_1
Xgf180mcu_fd_sc_mcu7t5v0__nand2_1_349 vdd vss gf180mcu_fd_sc_mcu7t5v0__and3_1_11/A2
+ gf180mcu_fd_sc_mcu7t5v0__oai21_1_154/B gf180mcu_fd_sc_mcu7t5v0__or2_1_21/A2 vdd
+ vss gf180mcu_fd_sc_mcu7t5v0__nand2_1
Xgf180mcu_fd_sc_mcu7t5v0__dffq_1_402 vdd gf180mcu_fd_sc_mcu7t5v0__nor4_2_4/A1 gf180mcu_fd_sc_mcu7t5v0__dffq_4_21/CLK
+ vss gf180mcu_fd_sc_mcu7t5v0__dffq_1_402/D vdd vss gf180mcu_fd_sc_mcu7t5v0__dffq_1
Xgf180mcu_fd_sc_mcu7t5v0__dffq_1_413 vdd gf180mcu_fd_sc_mcu7t5v0__or3_2_4/A2 gf180mcu_fd_sc_mcu7t5v0__dffq_4_21/CLK
+ vss gf180mcu_fd_sc_mcu7t5v0__nor3_1_24/ZN vdd vss gf180mcu_fd_sc_mcu7t5v0__dffq_1
Xgf180mcu_fd_sc_mcu7t5v0__dffq_1_424 vdd gf180mcu_fd_sc_mcu7t5v0__inv_1_17/I gf180mcu_fd_sc_mcu7t5v0__dffq_4_44/CLK
+ vss gf180mcu_fd_sc_mcu7t5v0__dffq_1_424/D vdd vss gf180mcu_fd_sc_mcu7t5v0__dffq_1
Xgf180mcu_fd_sc_mcu7t5v0__dffq_1_435 vdd gf180mcu_fd_sc_mcu7t5v0__inv_2_11/I gf180mcu_fd_sc_mcu7t5v0__dffq_4_44/CLK
+ vss gf180mcu_fd_sc_mcu7t5v0__dffq_1_435/D vdd vss gf180mcu_fd_sc_mcu7t5v0__dffq_1
Xgf180mcu_fd_sc_mcu7t5v0__dffq_1_446 vdd gf180mcu_fd_sc_mcu7t5v0__dffq_1_446/Q gf180mcu_fd_sc_mcu7t5v0__dffq_4_1/CLK
+ vss gf180mcu_fd_sc_mcu7t5v0__dffq_1_446/D vdd vss gf180mcu_fd_sc_mcu7t5v0__dffq_1
Xgf180mcu_fd_sc_mcu7t5v0__dffq_1_457 vdd gf180mcu_fd_sc_mcu7t5v0__dffq_1_457/Q gf180mcu_fd_sc_mcu7t5v0__dffq_2_58/CLK
+ vss gf180mcu_fd_sc_mcu7t5v0__dffq_1_457/D vdd vss gf180mcu_fd_sc_mcu7t5v0__dffq_1
Xgf180mcu_fd_sc_mcu7t5v0__or2_1_50 vdd vss gf180mcu_fd_sc_mcu7t5v0__or2_1_50/Z gf180mcu_fd_sc_mcu7t5v0__or2_1_50/A1
+ gf180mcu_fd_sc_mcu7t5v0__or2_1_50/A2 vdd vss gf180mcu_fd_sc_mcu7t5v0__or2_1
Xgf180mcu_fd_sc_mcu7t5v0__clkinv_1_307 vdd vss gf180mcu_fd_sc_mcu7t5v0__dffq_1_332/Q
+ gf180mcu_fd_sc_mcu7t5v0__aoi21_1_149/A1 vdd vss gf180mcu_fd_sc_mcu7t5v0__clkinv_1
Xgf180mcu_fd_sc_mcu7t5v0__clkinv_1_318 vdd vss gf180mcu_fd_sc_mcu7t5v0__dffq_1_382/Q
+ gf180mcu_fd_sc_mcu7t5v0__aoi21_1_151/A1 vdd vss gf180mcu_fd_sc_mcu7t5v0__clkinv_1
Xgf180mcu_fd_sc_mcu7t5v0__clkinv_1_329 vdd vss gf180mcu_fd_sc_mcu7t5v0__xor3_1_79/A1
+ gf180mcu_fd_sc_mcu7t5v0__nor2_1_253/A1 vdd vss gf180mcu_fd_sc_mcu7t5v0__clkinv_1
Xgf180mcu_fd_sc_mcu7t5v0__nand2_4_5 vdd vss gf180mcu_fd_sc_mcu7t5v0__nand2_4_5/ZN
+ gf180mcu_fd_sc_mcu7t5v0__nor3_4_11/ZN gf180mcu_fd_sc_mcu7t5v0__nor3_4_7/ZN vdd vss
+ gf180mcu_fd_sc_mcu7t5v0__nand2_4
Xgf180mcu_fd_sc_mcu7t5v0__nand2_4_15 vdd vss gf180mcu_fd_sc_mcu7t5v0__nand2_4_15/ZN
+ gf180mcu_fd_sc_mcu7t5v0__nor3_4_10/ZN gf180mcu_fd_sc_mcu7t5v0__nor3_4_6/ZN vdd vss
+ gf180mcu_fd_sc_mcu7t5v0__nand2_4
Xgf180mcu_fd_sc_mcu7t5v0__nand2_4_26 vdd vss gf180mcu_fd_sc_mcu7t5v0__nand2_4_26/ZN
+ gf180mcu_fd_sc_mcu7t5v0__nor2_4_6/ZN gf180mcu_fd_sc_mcu7t5v0__nor3_4_9/ZN vdd vss
+ gf180mcu_fd_sc_mcu7t5v0__nand2_4
Xgf180mcu_fd_sc_mcu7t5v0__nand2_4_37 vdd vss gf180mcu_fd_sc_mcu7t5v0__nor2_4_22/A1
+ gf180mcu_fd_sc_mcu7t5v0__or2_4_2/A1 gf180mcu_fd_sc_mcu7t5v0__or2_4_1/A2 vdd vss
+ gf180mcu_fd_sc_mcu7t5v0__nand2_4
Xgf180mcu_fd_sc_mcu7t5v0__dffq_4_9 gf180mcu_fd_sc_mcu7t5v0__dffq_4_9/D gf180mcu_fd_sc_mcu7t5v0__inv_1_6/I
+ vdd vss gf180mcu_fd_sc_mcu7t5v0__dffq_4_9/CLK vdd vss gf180mcu_fd_sc_mcu7t5v0__dffq_4
Xgf180mcu_fd_sc_mcu7t5v0__aoi21_1_380 gf180mcu_fd_sc_mcu7t5v0__xor2_1_151/Z vdd vss
+ gf180mcu_fd_sc_mcu7t5v0__or3_1_28/A2 gf180mcu_fd_sc_mcu7t5v0__and3_1_16/A1 gf180mcu_fd_sc_mcu7t5v0__and3_1_16/A2
+ vdd vss gf180mcu_fd_sc_mcu7t5v0__aoi21_1
Xgf180mcu_fd_sc_mcu7t5v0__nand2_1_102 vdd vss gf180mcu_fd_sc_mcu7t5v0__or2_1_11/A1
+ gf180mcu_fd_sc_mcu7t5v0__inv_8_0/I gf180mcu_fd_sc_mcu7t5v0__or4_1_1/A1 vdd vss gf180mcu_fd_sc_mcu7t5v0__nand2_1
Xgf180mcu_fd_sc_mcu7t5v0__nand2_1_113 vdd vss gf180mcu_fd_sc_mcu7t5v0__oai21_1_44/B
+ gf180mcu_fd_sc_mcu7t5v0__nor2_2_7/ZN gf180mcu_fd_sc_mcu7t5v0__xor3_1_41/Z vdd vss
+ gf180mcu_fd_sc_mcu7t5v0__nand2_1
Xgf180mcu_fd_sc_mcu7t5v0__nand2_1_124 vdd vss gf180mcu_fd_sc_mcu7t5v0__xor3_1_47/A2
+ gf180mcu_fd_sc_mcu7t5v0__inv_8_2/I gf180mcu_fd_sc_mcu7t5v0__and2_2_0/Z vdd vss gf180mcu_fd_sc_mcu7t5v0__nand2_1
Xgf180mcu_fd_sc_mcu7t5v0__nand2_1_135 vdd vss gf180mcu_fd_sc_mcu7t5v0__or4_1_0/A4
+ gf180mcu_fd_sc_mcu7t5v0__inv_8_0/I gf180mcu_fd_sc_mcu7t5v0__or4_1_1/A2 vdd vss gf180mcu_fd_sc_mcu7t5v0__nand2_1
Xgf180mcu_fd_sc_mcu7t5v0__nand2_1_146 vdd vss gf180mcu_fd_sc_mcu7t5v0__mux2_1_4/S
+ gf180mcu_fd_sc_mcu7t5v0__xor2_1_48/A1 gf180mcu_fd_sc_mcu7t5v0__xor2_1_48/A2 vdd
+ vss gf180mcu_fd_sc_mcu7t5v0__nand2_1
Xgf180mcu_fd_sc_mcu7t5v0__nand2_1_157 vdd vss gf180mcu_fd_sc_mcu7t5v0__and3_1_5/A1
+ gf180mcu_fd_sc_mcu7t5v0__nor2_2_8/A2 gf180mcu_fd_sc_mcu7t5v0__xor2_1_47/A2 vdd vss
+ gf180mcu_fd_sc_mcu7t5v0__nand2_1
Xgf180mcu_fd_sc_mcu7t5v0__nand2_1_168 vdd vss gf180mcu_fd_sc_mcu7t5v0__oai211_1_17/B
+ gf180mcu_fd_sc_mcu7t5v0__oai31_1_3/ZN gf180mcu_fd_sc_mcu7t5v0__aoi21_1_80/ZN vdd
+ vss gf180mcu_fd_sc_mcu7t5v0__nand2_1
Xgf180mcu_fd_sc_mcu7t5v0__nand2_1_179 vdd vss gf180mcu_fd_sc_mcu7t5v0__aoi21_1_84/B
+ gf180mcu_fd_sc_mcu7t5v0__and2_2_8/A1 gf180mcu_fd_sc_mcu7t5v0__and2_2_8/A2 vdd vss
+ gf180mcu_fd_sc_mcu7t5v0__nand2_1
Xgf180mcu_fd_sc_mcu7t5v0__xor3_1_90 gf180mcu_fd_sc_mcu7t5v0__xor3_1_90/A3 vdd vss
+ gf180mcu_fd_sc_mcu7t5v0__xor3_1_90/Z gf180mcu_fd_sc_mcu7t5v0__or2_1_7/A1 gf180mcu_fd_sc_mcu7t5v0__xor3_1_90/A2
+ vdd vss gf180mcu_fd_sc_mcu7t5v0__xor3_1
Xgf180mcu_fd_sc_mcu7t5v0__dffq_1_210 vdd gf180mcu_fd_sc_mcu7t5v0__dffq_1_210/Q gf180mcu_fd_sc_mcu7t5v0__dffq_2_26/CLK
+ vss gf180mcu_fd_sc_mcu7t5v0__dffq_1_210/D vdd vss gf180mcu_fd_sc_mcu7t5v0__dffq_1
Xgf180mcu_fd_sc_mcu7t5v0__dffq_1_221 vdd gf180mcu_fd_sc_mcu7t5v0__dffq_1_221/Q gf180mcu_fd_sc_mcu7t5v0__dffq_4_8/CLK
+ vss gf180mcu_fd_sc_mcu7t5v0__dffq_1_221/D vdd vss gf180mcu_fd_sc_mcu7t5v0__dffq_1
Xgf180mcu_fd_sc_mcu7t5v0__dffq_1_232 vdd gf180mcu_fd_sc_mcu7t5v0__dffq_1_232/Q gf180mcu_fd_sc_mcu7t5v0__dffq_2_26/CLK
+ vss gf180mcu_fd_sc_mcu7t5v0__dffq_1_232/D vdd vss gf180mcu_fd_sc_mcu7t5v0__dffq_1
Xgf180mcu_fd_sc_mcu7t5v0__nor2_1_410 vdd vss gf180mcu_fd_sc_mcu7t5v0__xor3_1_178/A2
+ gf180mcu_fd_sc_mcu7t5v0__or3_1_24/A1 gf180mcu_fd_sc_mcu7t5v0__inv_1_14/ZN vdd vss
+ gf180mcu_fd_sc_mcu7t5v0__nor2_1
Xgf180mcu_fd_sc_mcu7t5v0__dffq_1_243 vdd gf180mcu_fd_sc_mcu7t5v0__dffq_1_243/Q gf180mcu_fd_sc_mcu7t5v0__dffq_4_8/CLK
+ vss gf180mcu_fd_sc_mcu7t5v0__dffq_1_243/D vdd vss gf180mcu_fd_sc_mcu7t5v0__dffq_1
Xgf180mcu_fd_sc_mcu7t5v0__dffq_1_254 vdd gf180mcu_fd_sc_mcu7t5v0__dffq_1_254/Q gf180mcu_fd_sc_mcu7t5v0__dffq_4_8/CLK
+ vss gf180mcu_fd_sc_mcu7t5v0__dffq_1_254/D vdd vss gf180mcu_fd_sc_mcu7t5v0__dffq_1
Xgf180mcu_fd_sc_mcu7t5v0__dffq_1_265 vdd gf180mcu_fd_sc_mcu7t5v0__dffq_1_265/Q gf180mcu_fd_sc_mcu7t5v0__dffq_1_99/CLK
+ vss gf180mcu_fd_sc_mcu7t5v0__dffq_1_265/D vdd vss gf180mcu_fd_sc_mcu7t5v0__dffq_1
Xgf180mcu_fd_sc_mcu7t5v0__dffq_1_276 vdd gf180mcu_fd_sc_mcu7t5v0__dffq_1_276/Q gf180mcu_fd_sc_mcu7t5v0__dffq_1_99/CLK
+ vss gf180mcu_fd_sc_mcu7t5v0__dffq_1_276/D vdd vss gf180mcu_fd_sc_mcu7t5v0__dffq_1
Xgf180mcu_fd_sc_mcu7t5v0__dffq_1_287 vdd gf180mcu_fd_sc_mcu7t5v0__dffq_1_287/Q gf180mcu_fd_sc_mcu7t5v0__dffq_4_9/CLK
+ vss gf180mcu_fd_sc_mcu7t5v0__dffq_1_287/D vdd vss gf180mcu_fd_sc_mcu7t5v0__dffq_1
Xgf180mcu_fd_sc_mcu7t5v0__dffq_1_298 vdd gf180mcu_fd_sc_mcu7t5v0__dffq_1_298/Q gf180mcu_fd_sc_mcu7t5v0__dffq_4_21/CLK
+ vss gf180mcu_fd_sc_mcu7t5v0__dffq_1_298/D vdd vss gf180mcu_fd_sc_mcu7t5v0__dffq_1
Xgf180mcu_fd_sc_mcu7t5v0__nand2_1_680 vdd vss gf180mcu_fd_sc_mcu7t5v0__nand2_1_692/A1
+ gf180mcu_fd_sc_mcu7t5v0__xor2_1_200/A1 gf180mcu_fd_sc_mcu7t5v0__xor2_1_200/A2 vdd
+ vss gf180mcu_fd_sc_mcu7t5v0__nand2_1
Xgf180mcu_fd_sc_mcu7t5v0__nand2_1_691 vdd vss gf180mcu_fd_sc_mcu7t5v0__xnor2_1_71/A2
+ gf180mcu_fd_sc_mcu7t5v0__xor2_1_203/A2 gf180mcu_fd_sc_mcu7t5v0__nand2_1_691/A2 vdd
+ vss gf180mcu_fd_sc_mcu7t5v0__nand2_1
Xgf180mcu_fd_sc_mcu7t5v0__clkinv_1_104 vdd vss gf180mcu_fd_sc_mcu7t5v0__dffq_1_89/Q
+ gf180mcu_fd_sc_mcu7t5v0__oai22_1_91/B2 vdd vss gf180mcu_fd_sc_mcu7t5v0__clkinv_1
Xgf180mcu_fd_sc_mcu7t5v0__dffq_1_20 vdd gf180mcu_fd_sc_mcu7t5v0__dffq_1_20/Q gf180mcu_fd_sc_mcu7t5v0__dffq_1_99/CLK
+ vss gf180mcu_fd_sc_mcu7t5v0__dffq_1_20/D vdd vss gf180mcu_fd_sc_mcu7t5v0__dffq_1
Xgf180mcu_fd_sc_mcu7t5v0__dffq_1_31 vdd gf180mcu_fd_sc_mcu7t5v0__dffq_1_31/Q gf180mcu_fd_sc_mcu7t5v0__dffq_1_99/CLK
+ vss gf180mcu_fd_sc_mcu7t5v0__dffq_1_31/D vdd vss gf180mcu_fd_sc_mcu7t5v0__dffq_1
Xgf180mcu_fd_sc_mcu7t5v0__nor3_1_18 gf180mcu_fd_sc_mcu7t5v0__nor3_1_18/A3 vdd vss
+ gf180mcu_fd_sc_mcu7t5v0__nor3_1_18/ZN gf180mcu_fd_sc_mcu7t5v0__oai31_4_2/ZN gf180mcu_fd_sc_mcu7t5v0__and2_1_69/Z
+ vdd vss gf180mcu_fd_sc_mcu7t5v0__nor3_1
Xgf180mcu_fd_sc_mcu7t5v0__dffq_1_42 vdd gf180mcu_fd_sc_mcu7t5v0__dffq_1_42/Q gf180mcu_fd_sc_mcu7t5v0__dffq_4_8/CLK
+ vss gf180mcu_fd_sc_mcu7t5v0__dffq_1_42/D vdd vss gf180mcu_fd_sc_mcu7t5v0__dffq_1
Xgf180mcu_fd_sc_mcu7t5v0__clkinv_1_115 vdd vss gf180mcu_fd_sc_mcu7t5v0__dffq_1_180/Q
+ gf180mcu_fd_sc_mcu7t5v0__oai22_1_106/B2 vdd vss gf180mcu_fd_sc_mcu7t5v0__clkinv_1
Xgf180mcu_fd_sc_mcu7t5v0__nor3_1_29 gf180mcu_fd_sc_mcu7t5v0__nor3_1_29/A3 vdd vss
+ gf180mcu_fd_sc_mcu7t5v0__xor3_1_96/A1 gf180mcu_fd_sc_mcu7t5v0__nor3_4_16/ZN gf180mcu_fd_sc_mcu7t5v0__nor3_1_29/A2
+ vdd vss gf180mcu_fd_sc_mcu7t5v0__nor3_1
Xgf180mcu_fd_sc_mcu7t5v0__dffq_1_53 vdd gf180mcu_fd_sc_mcu7t5v0__dffq_1_53/Q gf180mcu_fd_sc_mcu7t5v0__dffq_1_99/CLK
+ vss gf180mcu_fd_sc_mcu7t5v0__dffq_1_53/D vdd vss gf180mcu_fd_sc_mcu7t5v0__dffq_1
Xgf180mcu_fd_sc_mcu7t5v0__clkinv_1_126 vdd vss gf180mcu_fd_sc_mcu7t5v0__dffq_1_107/Q
+ gf180mcu_fd_sc_mcu7t5v0__oai22_1_112/B2 vdd vss gf180mcu_fd_sc_mcu7t5v0__clkinv_1
Xgf180mcu_fd_sc_mcu7t5v0__clkinv_1_137 vdd vss gf180mcu_fd_sc_mcu7t5v0__dffq_1_176/Q
+ gf180mcu_fd_sc_mcu7t5v0__oai22_1_191/B2 vdd vss gf180mcu_fd_sc_mcu7t5v0__clkinv_1
Xgf180mcu_fd_sc_mcu7t5v0__dffq_1_64 vdd gf180mcu_fd_sc_mcu7t5v0__dffq_1_64/Q gf180mcu_fd_sc_mcu7t5v0__dffq_1_95/CLK
+ vss gf180mcu_fd_sc_mcu7t5v0__dffq_1_64/D vdd vss gf180mcu_fd_sc_mcu7t5v0__dffq_1
Xgf180mcu_fd_sc_mcu7t5v0__clkinv_1_148 vdd vss gf180mcu_fd_sc_mcu7t5v0__dffq_1_134/Q
+ gf180mcu_fd_sc_mcu7t5v0__oai22_1_134/B2 vdd vss gf180mcu_fd_sc_mcu7t5v0__clkinv_1
Xgf180mcu_fd_sc_mcu7t5v0__dffq_1_75 vdd gf180mcu_fd_sc_mcu7t5v0__dffq_1_75/Q gf180mcu_fd_sc_mcu7t5v0__dffq_1_99/CLK
+ vss gf180mcu_fd_sc_mcu7t5v0__dffq_1_75/D vdd vss gf180mcu_fd_sc_mcu7t5v0__dffq_1
Xgf180mcu_fd_sc_mcu7t5v0__clkinv_1_159 vdd vss gf180mcu_fd_sc_mcu7t5v0__dffq_1_139/Q
+ gf180mcu_fd_sc_mcu7t5v0__oai22_1_146/B2 vdd vss gf180mcu_fd_sc_mcu7t5v0__clkinv_1
Xgf180mcu_fd_sc_mcu7t5v0__dffq_1_86 vdd gf180mcu_fd_sc_mcu7t5v0__dffq_1_86/Q gf180mcu_fd_sc_mcu7t5v0__dffq_1_99/CLK
+ vss gf180mcu_fd_sc_mcu7t5v0__dffq_1_86/D vdd vss gf180mcu_fd_sc_mcu7t5v0__dffq_1
Xgf180mcu_fd_sc_mcu7t5v0__dffq_1_97 vdd gf180mcu_fd_sc_mcu7t5v0__dffq_1_97/Q gf180mcu_fd_sc_mcu7t5v0__dffq_1_99/CLK
+ vss gf180mcu_fd_sc_mcu7t5v0__dffq_1_97/D vdd vss gf180mcu_fd_sc_mcu7t5v0__dffq_1
Xgf180mcu_fd_sc_mcu7t5v0__nand2_2_2 vdd vss gf180mcu_fd_sc_mcu7t5v0__oai31_1_4/B gf180mcu_fd_sc_mcu7t5v0__dffq_4_0/Q
+ gf180mcu_fd_sc_mcu7t5v0__nor2_1_76/ZN vdd vss gf180mcu_fd_sc_mcu7t5v0__nand2_2
Xgf180mcu_fd_sc_mcu7t5v0__aoi211_1_6 gf180mcu_fd_sc_mcu7t5v0__aoi211_1_6/B gf180mcu_fd_sc_mcu7t5v0__or2_4_4/Z
+ vdd vss gf180mcu_fd_sc_mcu7t5v0__aoi211_1_5/C gf180mcu_fd_sc_mcu7t5v0__nor3_1_9/A1
+ gf180mcu_fd_sc_mcu7t5v0__nand2_1_49/ZN vdd vss gf180mcu_fd_sc_mcu7t5v0__aoi211_1
Xgf180mcu_fd_sc_mcu7t5v0__dffq_2_6 gf180mcu_fd_sc_mcu7t5v0__dffq_2_6/D vdd vss gf180mcu_fd_sc_mcu7t5v0__dffq_4_6/CLK
+ gf180mcu_fd_sc_mcu7t5v0__dffq_2_6/Q vdd vss gf180mcu_fd_sc_mcu7t5v0__dffq_2
Xgf180mcu_fd_sc_mcu7t5v0__aoi22_1_3 gf180mcu_fd_sc_mcu7t5v0__nor2_4_1/ZN gf180mcu_fd_sc_mcu7t5v0__inv_12_1/I
+ vdd vss gf180mcu_fd_sc_mcu7t5v0__aoi22_1_3/ZN gf180mcu_fd_sc_mcu7t5v0__and2_1_8/Z
+ gf180mcu_fd_sc_mcu7t5v0__aoi22_1_3/A2 vdd vss gf180mcu_fd_sc_mcu7t5v0__aoi22_1
Xgf180mcu_fd_sc_mcu7t5v0__oai22_1_120 gf180mcu_fd_sc_mcu7t5v0__nand2_4_14/ZN gf180mcu_fd_sc_mcu7t5v0__nand2_2_32/ZN
+ gf180mcu_fd_sc_mcu7t5v0__oai22_1_120/B2 vdd vss gf180mcu_fd_sc_mcu7t5v0__dffq_1_105/D
+ gf180mcu_fd_sc_mcu7t5v0__oai22_1_98/A1 vdd vss gf180mcu_fd_sc_mcu7t5v0__oai22_1
Xgf180mcu_fd_sc_mcu7t5v0__oai22_1_131 gf180mcu_fd_sc_mcu7t5v0__oai22_1_55/A2 gf180mcu_fd_sc_mcu7t5v0__oai22_1_55/B1
+ gf180mcu_fd_sc_mcu7t5v0__oai22_1_131/B2 vdd vss gf180mcu_fd_sc_mcu7t5v0__dffq_1_119/D
+ gf180mcu_fd_sc_mcu7t5v0__oai22_1_98/A1 vdd vss gf180mcu_fd_sc_mcu7t5v0__oai22_1
Xgf180mcu_fd_sc_mcu7t5v0__oai22_1_142 gf180mcu_fd_sc_mcu7t5v0__oai22_1_55/A2 gf180mcu_fd_sc_mcu7t5v0__oai22_1_55/B1
+ gf180mcu_fd_sc_mcu7t5v0__oai22_1_142/B2 vdd vss gf180mcu_fd_sc_mcu7t5v0__dffq_1_133/D
+ gf180mcu_fd_sc_mcu7t5v0__oai22_1_88/A1 vdd vss gf180mcu_fd_sc_mcu7t5v0__oai22_1
Xgf180mcu_fd_sc_mcu7t5v0__oai22_1_153 gf180mcu_fd_sc_mcu7t5v0__nand2_4_20/ZN gf180mcu_fd_sc_mcu7t5v0__nand2_2_27/ZN
+ gf180mcu_fd_sc_mcu7t5v0__oai22_1_153/B2 vdd vss gf180mcu_fd_sc_mcu7t5v0__dffq_1_148/D
+ gf180mcu_fd_sc_mcu7t5v0__aoi21_4_3/ZN vdd vss gf180mcu_fd_sc_mcu7t5v0__oai22_1
Xgf180mcu_fd_sc_mcu7t5v0__oai22_1_164 gf180mcu_fd_sc_mcu7t5v0__nand2_4_22/ZN gf180mcu_fd_sc_mcu7t5v0__nand2_2_29/ZN
+ gf180mcu_fd_sc_mcu7t5v0__oai22_1_164/B2 vdd vss gf180mcu_fd_sc_mcu7t5v0__dffq_1_275/D
+ gf180mcu_fd_sc_mcu7t5v0__oai22_1_98/A1 vdd vss gf180mcu_fd_sc_mcu7t5v0__oai22_1
Xgf180mcu_fd_sc_mcu7t5v0__oai221_1_3 gf180mcu_fd_sc_mcu7t5v0__oai221_1_3/B1 gf180mcu_fd_sc_mcu7t5v0__oai221_1_3/C
+ vdd vss gf180mcu_fd_sc_mcu7t5v0__aoi221_1_2/C gf180mcu_fd_sc_mcu7t5v0__mux2_1_2/I0
+ gf180mcu_fd_sc_mcu7t5v0__or3_1_4/A1 gf180mcu_fd_sc_mcu7t5v0__nor2_1_70/ZN vdd vss
+ gf180mcu_fd_sc_mcu7t5v0__oai221_1
Xgf180mcu_fd_sc_mcu7t5v0__oai22_1_175 gf180mcu_fd_sc_mcu7t5v0__nand2_4_23/ZN gf180mcu_fd_sc_mcu7t5v0__nand2_2_30/ZN
+ gf180mcu_fd_sc_mcu7t5v0__oai22_1_175/B2 vdd vss gf180mcu_fd_sc_mcu7t5v0__dffq_1_192/D
+ gf180mcu_fd_sc_mcu7t5v0__oai22_1_88/A1 vdd vss gf180mcu_fd_sc_mcu7t5v0__oai22_1
Xgf180mcu_fd_sc_mcu7t5v0__oai22_1_186 gf180mcu_fd_sc_mcu7t5v0__nand2_4_22/ZN gf180mcu_fd_sc_mcu7t5v0__nand2_2_29/ZN
+ gf180mcu_fd_sc_mcu7t5v0__oai22_1_186/B2 vdd vss gf180mcu_fd_sc_mcu7t5v0__dffq_1_174/D
+ gf180mcu_fd_sc_mcu7t5v0__aoi21_4_3/ZN vdd vss gf180mcu_fd_sc_mcu7t5v0__oai22_1
Xgf180mcu_fd_sc_mcu7t5v0__xnor3_1_14 gf180mcu_fd_sc_mcu7t5v0__oai22_1_5/A1 vdd vss
+ gf180mcu_fd_sc_mcu7t5v0__xnor3_1_14/ZN gf180mcu_fd_sc_mcu7t5v0__or2_1_14/A2 gf180mcu_fd_sc_mcu7t5v0__oai22_1_6/B2
+ vdd vss gf180mcu_fd_sc_mcu7t5v0__xnor3_1
Xgf180mcu_fd_sc_mcu7t5v0__oai22_1_197 gf180mcu_fd_sc_mcu7t5v0__nand2_4_18/ZN gf180mcu_fd_sc_mcu7t5v0__nand2_2_25/ZN
+ gf180mcu_fd_sc_mcu7t5v0__oai22_1_197/B2 vdd vss gf180mcu_fd_sc_mcu7t5v0__dffq_1_131/D
+ gf180mcu_fd_sc_mcu7t5v0__oai21_4_9/ZN vdd vss gf180mcu_fd_sc_mcu7t5v0__oai22_1
Xgf180mcu_fd_sc_mcu7t5v0__xnor3_1_25 gf180mcu_fd_sc_mcu7t5v0__nor3_2_6/A3 vdd vss
+ gf180mcu_fd_sc_mcu7t5v0__xor2_1_216/A2 gf180mcu_fd_sc_mcu7t5v0__and2_1_87/A1 gf180mcu_fd_sc_mcu7t5v0__and2_1_87/A2
+ vdd vss gf180mcu_fd_sc_mcu7t5v0__xnor3_1
Xgf180mcu_fd_sc_mcu7t5v0__xnor3_1_36 gf180mcu_fd_sc_mcu7t5v0__or2_1_49/A1 vdd vss
+ gf180mcu_fd_sc_mcu7t5v0__xor2_1_158/A2 gf180mcu_fd_sc_mcu7t5v0__or2_1_43/Z gf180mcu_fd_sc_mcu7t5v0__or3_1_24/A3
+ vdd vss gf180mcu_fd_sc_mcu7t5v0__xnor3_1
Xgf180mcu_fd_sc_mcu7t5v0__xnor3_1_47 gf180mcu_fd_sc_mcu7t5v0__xnor3_1_47/A3 vdd vss
+ gf180mcu_fd_sc_mcu7t5v0__xor2_1_197/A2 gf180mcu_fd_sc_mcu7t5v0__xnor3_1_47/A1 gf180mcu_fd_sc_mcu7t5v0__xnor3_1_47/A2
+ vdd vss gf180mcu_fd_sc_mcu7t5v0__xnor3_1
Xgf180mcu_fd_sc_mcu7t5v0__nor2_1_40 vdd vss gf180mcu_fd_sc_mcu7t5v0__oai21_4_0/A2
+ gf180mcu_fd_sc_mcu7t5v0__dffq_4_4/Q gf180mcu_fd_sc_mcu7t5v0__or2_1_41/A1 vdd vss
+ gf180mcu_fd_sc_mcu7t5v0__nor2_1
Xgf180mcu_fd_sc_mcu7t5v0__nor2_1_51 vdd vss gf180mcu_fd_sc_mcu7t5v0__oai22_4_1/B1
+ gf180mcu_fd_sc_mcu7t5v0__inv_3_0/I gf180mcu_fd_sc_mcu7t5v0__inv_1_15/I vdd vss gf180mcu_fd_sc_mcu7t5v0__nor2_1
Xgf180mcu_fd_sc_mcu7t5v0__nor2_1_62 vdd vss gf180mcu_fd_sc_mcu7t5v0__nor2_1_62/ZN
+ gf180mcu_fd_sc_mcu7t5v0__nor2_2_7/ZN gf180mcu_fd_sc_mcu7t5v0__xor3_1_41/Z vdd vss
+ gf180mcu_fd_sc_mcu7t5v0__nor2_1
Xgf180mcu_fd_sc_mcu7t5v0__nor2_1_73 vdd vss gf180mcu_fd_sc_mcu7t5v0__xor3_1_41/A2
+ gf180mcu_fd_sc_mcu7t5v0__inv_4_6/ZN gf180mcu_fd_sc_mcu7t5v0__or4_1_0/A3 vdd vss
+ gf180mcu_fd_sc_mcu7t5v0__nor2_1
Xgf180mcu_fd_sc_mcu7t5v0__nor2_1_84 vdd vss gf180mcu_fd_sc_mcu7t5v0__nor2_1_84/ZN
+ gf180mcu_fd_sc_mcu7t5v0__nor3_4_3/A1 gf180mcu_fd_sc_mcu7t5v0__inv_2_4/I vdd vss
+ gf180mcu_fd_sc_mcu7t5v0__nor2_1
Xgf180mcu_fd_sc_mcu7t5v0__nor2_1_95 vdd vss gf180mcu_fd_sc_mcu7t5v0__nor2_1_95/ZN
+ gf180mcu_fd_sc_mcu7t5v0__or3_1_8/A2 gf180mcu_fd_sc_mcu7t5v0__and3_1_6/Z vdd vss
+ gf180mcu_fd_sc_mcu7t5v0__nor2_1
Xgf180mcu_fd_sc_mcu7t5v0__nor2_1_240 vdd vss gf180mcu_fd_sc_mcu7t5v0__xor2_1_109/A1
+ gf180mcu_fd_sc_mcu7t5v0__nor2_1_243/ZN gf180mcu_fd_sc_mcu7t5v0__nor3_2_6/A2 vdd
+ vss gf180mcu_fd_sc_mcu7t5v0__nor2_1
Xgf180mcu_fd_sc_mcu7t5v0__nor2_1_251 vdd vss gf180mcu_fd_sc_mcu7t5v0__nor2_1_251/ZN
+ gf180mcu_fd_sc_mcu7t5v0__xor3_1_78/A2 gf180mcu_fd_sc_mcu7t5v0__xor3_1_78/A3 vdd
+ vss gf180mcu_fd_sc_mcu7t5v0__nor2_1
Xgf180mcu_fd_sc_mcu7t5v0__clkinv_2_5 vdd vss gf180mcu_fd_sc_mcu7t5v0__oai31_2_0/ZN
+ gf180mcu_fd_sc_mcu7t5v0__oai21_1_157/B vdd vss gf180mcu_fd_sc_mcu7t5v0__clkinv_2
Xgf180mcu_fd_sc_mcu7t5v0__nor2_1_262 vdd vss gf180mcu_fd_sc_mcu7t5v0__xnor2_1_44/A2
+ gf180mcu_fd_sc_mcu7t5v0__and2_1_94/Z gf180mcu_fd_sc_mcu7t5v0__nor3_1_43/ZN vdd vss
+ gf180mcu_fd_sc_mcu7t5v0__nor2_1
Xgf180mcu_fd_sc_mcu7t5v0__nor2_1_273 vdd vss gf180mcu_fd_sc_mcu7t5v0__nor2_1_273/ZN
+ gf180mcu_fd_sc_mcu7t5v0__or3_1_18/A1 gf180mcu_fd_sc_mcu7t5v0__nor2_1_273/A2 vdd
+ vss gf180mcu_fd_sc_mcu7t5v0__nor2_1
Xgf180mcu_fd_sc_mcu7t5v0__xor3_1_2 gf180mcu_fd_sc_mcu7t5v0__xor3_1_5/Z vdd vss gf180mcu_fd_sc_mcu7t5v0__xor3_1_2/Z
+ gf180mcu_fd_sc_mcu7t5v0__xor3_1_2/A1 gf180mcu_fd_sc_mcu7t5v0__xor3_1_2/A2 vdd vss
+ gf180mcu_fd_sc_mcu7t5v0__xor3_1
Xgf180mcu_fd_sc_mcu7t5v0__oai31_1_6 vdd gf180mcu_fd_sc_mcu7t5v0__xor3_1_63/A1 gf180mcu_fd_sc_mcu7t5v0__oai31_1_6/B
+ gf180mcu_fd_sc_mcu7t5v0__xor2_1_79/A1 gf180mcu_fd_sc_mcu7t5v0__xor2_1_79/A2 vss
+ gf180mcu_fd_sc_mcu7t5v0__xor2_1_220/Z vdd vss gf180mcu_fd_sc_mcu7t5v0__oai31_1
Xgf180mcu_fd_sc_mcu7t5v0__nor2_1_284 vdd vss gf180mcu_fd_sc_mcu7t5v0__oai33_2_3/A2
+ gf180mcu_fd_sc_mcu7t5v0__nor3_4_16/ZN gf180mcu_fd_sc_mcu7t5v0__xor3_1_96/Z vdd vss
+ gf180mcu_fd_sc_mcu7t5v0__nor2_1
Xgf180mcu_fd_sc_mcu7t5v0__nor2_1_295 vdd vss gf180mcu_fd_sc_mcu7t5v0__nor2_1_295/ZN
+ gf180mcu_fd_sc_mcu7t5v0__dffq_1_422/Q gf180mcu_fd_sc_mcu7t5v0__nor2_4_18/ZN vdd
+ vss gf180mcu_fd_sc_mcu7t5v0__nor2_1
Xgf180mcu_fd_sc_mcu7t5v0__nand2_1_16 vdd vss gf180mcu_fd_sc_mcu7t5v0__xnor3_1_9/A1
+ gf180mcu_fd_sc_mcu7t5v0__or2_1_7/A1 gf180mcu_fd_sc_mcu7t5v0__and2_4_2/Z vdd vss
+ gf180mcu_fd_sc_mcu7t5v0__nand2_1
Xgf180mcu_fd_sc_mcu7t5v0__nand2_1_27 vdd vss gf180mcu_fd_sc_mcu7t5v0__oai21_1_4/B
+ gf180mcu_fd_sc_mcu7t5v0__oai21_1_8/A1 gf180mcu_fd_sc_mcu7t5v0__xor3_1_12/Z vdd vss
+ gf180mcu_fd_sc_mcu7t5v0__nand2_1
Xgf180mcu_fd_sc_mcu7t5v0__nand2_1_38 vdd vss gf180mcu_fd_sc_mcu7t5v0__xor3_1_62/A3
+ gf180mcu_fd_sc_mcu7t5v0__inv_12_1/I gf180mcu_fd_sc_mcu7t5v0__and2_2_3/Z vdd vss
+ gf180mcu_fd_sc_mcu7t5v0__nand2_1
Xgf180mcu_fd_sc_mcu7t5v0__nand2_1_49 vdd vss gf180mcu_fd_sc_mcu7t5v0__nand2_1_49/ZN
+ gf180mcu_fd_sc_mcu7t5v0__nand2_1_49/A1 gf180mcu_fd_sc_mcu7t5v0__nand2_1_49/A2 vdd
+ vss gf180mcu_fd_sc_mcu7t5v0__nand2_1
Xgf180mcu_fd_sc_mcu7t5v0__oai21_1_300 vdd gf180mcu_fd_sc_mcu7t5v0__xor2_1_175/Z gf180mcu_fd_sc_mcu7t5v0__and3_1_22/Z
+ gf180mcu_fd_sc_mcu7t5v0__xor2_1_174/A1 gf180mcu_fd_sc_mcu7t5v0__nor3_1_39/ZN vss
+ vdd vss gf180mcu_fd_sc_mcu7t5v0__oai21_1
Xgf180mcu_fd_sc_mcu7t5v0__oai21_1_311 vdd gf180mcu_fd_sc_mcu7t5v0__and2_4_3/Z gf180mcu_fd_sc_mcu7t5v0__or2_1_34/A2
+ gf180mcu_fd_sc_mcu7t5v0__aoi21_1_345/B gf180mcu_fd_sc_mcu7t5v0__dffq_2_102/Q vss
+ vdd vss gf180mcu_fd_sc_mcu7t5v0__oai21_1
Xgf180mcu_fd_sc_mcu7t5v0__oai21_1_322 vdd gf180mcu_fd_sc_mcu7t5v0__oai21_1_322/B gf180mcu_fd_sc_mcu7t5v0__oai21_1_322/A2
+ gf180mcu_fd_sc_mcu7t5v0__oai21_1_321/B gf180mcu_fd_sc_mcu7t5v0__nor2_1_389/A1 vss
+ vdd vss gf180mcu_fd_sc_mcu7t5v0__oai21_1
Xgf180mcu_fd_sc_mcu7t5v0__nor2_4_6 vdd vss gf180mcu_fd_sc_mcu7t5v0__nor2_4_6/ZN gf180mcu_fd_sc_mcu7t5v0__mux2_4_3/Z
+ gf180mcu_fd_sc_mcu7t5v0__nor2_4_6/A2 vdd vss gf180mcu_fd_sc_mcu7t5v0__nor2_4
Xgf180mcu_fd_sc_mcu7t5v0__oai21_1_333 vdd gf180mcu_fd_sc_mcu7t5v0__buf_8_5/Z gf180mcu_fd_sc_mcu7t5v0__oai21_1_94/A2
+ gf180mcu_fd_sc_mcu7t5v0__aoi21_1_97/B gf180mcu_fd_sc_mcu7t5v0__mux2_4_3/I1 vss vdd
+ vss gf180mcu_fd_sc_mcu7t5v0__oai21_1
Xgf180mcu_fd_sc_mcu7t5v0__xnor2_1_4 vdd vss gf180mcu_fd_sc_mcu7t5v0__xor2_1_13/A2
+ gf180mcu_fd_sc_mcu7t5v0__or2_1_1/A1 gf180mcu_fd_sc_mcu7t5v0__or2_1_1/A2 vdd vss
+ gf180mcu_fd_sc_mcu7t5v0__xnor2_1
Xgf180mcu_fd_sc_mcu7t5v0__oai22_1_6 gf180mcu_fd_sc_mcu7t5v0__oai22_1_6/A2 gf180mcu_fd_sc_mcu7t5v0__and2_1_24/Z
+ gf180mcu_fd_sc_mcu7t5v0__oai22_1_6/B2 vdd vss gf180mcu_fd_sc_mcu7t5v0__oai22_1_6/ZN
+ gf180mcu_fd_sc_mcu7t5v0__xor3_1_48/A2 vdd vss gf180mcu_fd_sc_mcu7t5v0__oai22_1
Xgf180mcu_fd_sc_mcu7t5v0__aoi22_1_20 gf180mcu_fd_sc_mcu7t5v0__nor2_4_11/ZN gf180mcu_fd_sc_mcu7t5v0__dffq_1_272/Q
+ vdd vss gf180mcu_fd_sc_mcu7t5v0__aoi22_1_20/ZN gf180mcu_fd_sc_mcu7t5v0__dffq_1_268/Q
+ gf180mcu_fd_sc_mcu7t5v0__nor2_4_10/ZN vdd vss gf180mcu_fd_sc_mcu7t5v0__aoi22_1
Xgf180mcu_fd_sc_mcu7t5v0__aoi22_1_31 gf180mcu_fd_sc_mcu7t5v0__nor2_4_9/ZN gf180mcu_fd_sc_mcu7t5v0__dffq_1_50/Q
+ vdd vss gf180mcu_fd_sc_mcu7t5v0__aoi22_1_31/ZN gf180mcu_fd_sc_mcu7t5v0__dffq_1_53/Q
+ gf180mcu_fd_sc_mcu7t5v0__nor2_4_8/ZN vdd vss gf180mcu_fd_sc_mcu7t5v0__aoi22_1
Xgf180mcu_fd_sc_mcu7t5v0__aoi22_1_42 gf180mcu_fd_sc_mcu7t5v0__nor2_4_11/ZN gf180mcu_fd_sc_mcu7t5v0__dffq_1_75/Q
+ vdd vss gf180mcu_fd_sc_mcu7t5v0__aoi22_1_42/ZN gf180mcu_fd_sc_mcu7t5v0__dffq_1_72/Q
+ gf180mcu_fd_sc_mcu7t5v0__nor2_4_10/ZN vdd vss gf180mcu_fd_sc_mcu7t5v0__aoi22_1
Xgf180mcu_fd_sc_mcu7t5v0__aoi22_1_53 gf180mcu_fd_sc_mcu7t5v0__nor2_4_9/ZN gf180mcu_fd_sc_mcu7t5v0__dffq_1_118/Q
+ vdd vss gf180mcu_fd_sc_mcu7t5v0__aoi22_1_53/ZN gf180mcu_fd_sc_mcu7t5v0__dffq_1_270/Q
+ gf180mcu_fd_sc_mcu7t5v0__nor2_4_8/ZN vdd vss gf180mcu_fd_sc_mcu7t5v0__aoi22_1
Xgf180mcu_fd_sc_mcu7t5v0__aoi22_1_64 gf180mcu_fd_sc_mcu7t5v0__nor2_4_11/ZN gf180mcu_fd_sc_mcu7t5v0__dffq_1_177/Q
+ vdd vss gf180mcu_fd_sc_mcu7t5v0__aoi22_1_64/ZN gf180mcu_fd_sc_mcu7t5v0__dffq_1_181/Q
+ gf180mcu_fd_sc_mcu7t5v0__nor2_4_10/ZN vdd vss gf180mcu_fd_sc_mcu7t5v0__aoi22_1
Xgf180mcu_fd_sc_mcu7t5v0__aoi22_1_75 gf180mcu_fd_sc_mcu7t5v0__nor2_4_11/ZN gf180mcu_fd_sc_mcu7t5v0__dffq_1_129/Q
+ vdd vss gf180mcu_fd_sc_mcu7t5v0__aoi22_1_75/ZN gf180mcu_fd_sc_mcu7t5v0__dffq_1_127/Q
+ gf180mcu_fd_sc_mcu7t5v0__nor2_4_10/ZN vdd vss gf180mcu_fd_sc_mcu7t5v0__aoi22_1
Xgf180mcu_fd_sc_mcu7t5v0__aoi22_1_86 gf180mcu_fd_sc_mcu7t5v0__nor2_4_9/ZN gf180mcu_fd_sc_mcu7t5v0__dffq_1_153/Q
+ vdd vss gf180mcu_fd_sc_mcu7t5v0__aoi22_1_86/ZN gf180mcu_fd_sc_mcu7t5v0__dffq_1_151/Q
+ gf180mcu_fd_sc_mcu7t5v0__nor2_4_8/ZN vdd vss gf180mcu_fd_sc_mcu7t5v0__aoi22_1
Xgf180mcu_fd_sc_mcu7t5v0__aoi22_1_97 gf180mcu_fd_sc_mcu7t5v0__nor2_4_9/ZN gf180mcu_fd_sc_mcu7t5v0__dffq_1_190/Q
+ vdd vss gf180mcu_fd_sc_mcu7t5v0__aoi22_1_97/ZN gf180mcu_fd_sc_mcu7t5v0__dffq_1_185/Q
+ gf180mcu_fd_sc_mcu7t5v0__nor2_4_8/ZN vdd vss gf180mcu_fd_sc_mcu7t5v0__aoi22_1
Xgf180mcu_fd_sc_mcu7t5v0__or3_1_2 gf180mcu_fd_sc_mcu7t5v0__or3_1_2/A3 vdd vss gf180mcu_fd_sc_mcu7t5v0__or3_1_2/Z
+ gf180mcu_fd_sc_mcu7t5v0__or3_1_2/A1 gf180mcu_fd_sc_mcu7t5v0__or3_1_2/A2 vdd vss
+ gf180mcu_fd_sc_mcu7t5v0__or3_1
Xgf180mcu_fd_sc_mcu7t5v0__xnor2_1_80 vdd vss gf180mcu_fd_sc_mcu7t5v0__nor2_1_34/A2
+ gf180mcu_fd_sc_mcu7t5v0__xnor2_1_80/A1 gf180mcu_fd_sc_mcu7t5v0__xnor2_1_80/A2 vdd
+ vss gf180mcu_fd_sc_mcu7t5v0__xnor2_1
Xgf180mcu_fd_sc_mcu7t5v0__inv_1_6 vss gf180mcu_fd_sc_mcu7t5v0__inv_1_6/ZN gf180mcu_fd_sc_mcu7t5v0__inv_1_6/I
+ vdd vdd vss gf180mcu_fd_sc_mcu7t5v0__inv_1
Xgf180mcu_fd_sc_mcu7t5v0__nand3_2_15 gf180mcu_fd_sc_mcu7t5v0__and2_2_4/A2 vdd vss
+ gf180mcu_fd_sc_mcu7t5v0__nor3_2_1/A3 gf180mcu_fd_sc_mcu7t5v0__inv_12_1/I gf180mcu_fd_sc_mcu7t5v0__and2_2_4/A1
+ vdd vss gf180mcu_fd_sc_mcu7t5v0__nand3_2
Xgf180mcu_fd_sc_mcu7t5v0__nand3_2_26 gf180mcu_fd_sc_mcu7t5v0__inv_4_5/I vdd vss gf180mcu_fd_sc_mcu7t5v0__oai31_4_3/B
+ gf180mcu_fd_sc_mcu7t5v0__mux4_4_0/I3 gf180mcu_fd_sc_mcu7t5v0__or2_2_1/A1 vdd vss
+ gf180mcu_fd_sc_mcu7t5v0__nand3_2
Xgf180mcu_fd_sc_mcu7t5v0__mux4_4_1 gf180mcu_fd_sc_mcu7t5v0__mux4_4_1/I0 vss vdd gf180mcu_fd_sc_mcu7t5v0__dffq_2_6/Q
+ gf180mcu_fd_sc_mcu7t5v0__or2_1_33/A1 gf180mcu_fd_sc_mcu7t5v0__inv_1_6/I gf180mcu_fd_sc_mcu7t5v0__mux4_4_1/I3
+ gf180mcu_fd_sc_mcu7t5v0__or3_2_3/A2 gf180mcu_fd_sc_mcu7t5v0__mux4_4_1/Z vdd vss
+ gf180mcu_fd_sc_mcu7t5v0__mux4_4
Xgf180mcu_fd_sc_mcu7t5v0__aoi221_2_1 gf180mcu_fd_sc_mcu7t5v0__nand3_1_40/ZN gf180mcu_fd_sc_mcu7t5v0__nor2_1_104/ZN
+ vdd vss gf180mcu_fd_sc_mcu7t5v0__nor2_1_26/A2 gf180mcu_fd_sc_mcu7t5v0__nor2_2_14/ZN
+ gf180mcu_fd_sc_mcu7t5v0__xor3_2_0/Z gf180mcu_fd_sc_mcu7t5v0__aoi221_2_1/C vdd vss
+ gf180mcu_fd_sc_mcu7t5v0__aoi221_2
Xgf180mcu_fd_sc_mcu7t5v0__oai21_1_130 vdd gf180mcu_fd_sc_mcu7t5v0__oai21_1_130/B gf180mcu_fd_sc_mcu7t5v0__oai21_1_130/A2
+ gf180mcu_fd_sc_mcu7t5v0__oai21_1_180/B gf180mcu_fd_sc_mcu7t5v0__oai32_1_4/B2 vss
+ vdd vss gf180mcu_fd_sc_mcu7t5v0__oai21_1
Xgf180mcu_fd_sc_mcu7t5v0__nor2_2_3 vdd vss gf180mcu_fd_sc_mcu7t5v0__nor2_2_3/ZN gf180mcu_fd_sc_mcu7t5v0__nor3_2_5/A1
+ gf180mcu_fd_sc_mcu7t5v0__nor2_2_3/A2 vdd vss gf180mcu_fd_sc_mcu7t5v0__nor2_2
Xgf180mcu_fd_sc_mcu7t5v0__oai21_1_141 vdd gf180mcu_fd_sc_mcu7t5v0__buf_8_6/Z gf180mcu_fd_sc_mcu7t5v0__aoi22_4_8/ZN
+ gf180mcu_fd_sc_mcu7t5v0__aoi21_1_152/B gf180mcu_fd_sc_mcu7t5v0__dffq_1_330/Q vss
+ vdd vss gf180mcu_fd_sc_mcu7t5v0__oai21_1
Xgf180mcu_fd_sc_mcu7t5v0__oai21_1_152 vdd gf180mcu_fd_sc_mcu7t5v0__oai21_1_157/B gf180mcu_fd_sc_mcu7t5v0__and2_1_58/Z
+ gf180mcu_fd_sc_mcu7t5v0__aoi21_1_164/B gf180mcu_fd_sc_mcu7t5v0__nor4_1_1/A4 vss
+ vdd vss gf180mcu_fd_sc_mcu7t5v0__oai21_1
Xgf180mcu_fd_sc_mcu7t5v0__oai21_1_163 vdd gf180mcu_fd_sc_mcu7t5v0__oai21_1_163/B gf180mcu_fd_sc_mcu7t5v0__and2_1_67/Z
+ gf180mcu_fd_sc_mcu7t5v0__nor2_1_195/A2 gf180mcu_fd_sc_mcu7t5v0__nor3_1_17/A1 vss
+ vdd vss gf180mcu_fd_sc_mcu7t5v0__oai21_1
Xgf180mcu_fd_sc_mcu7t5v0__oai21_1_174 vdd gf180mcu_fd_sc_mcu7t5v0__oai21_1_174/B gf180mcu_fd_sc_mcu7t5v0__nor2_1_211/ZN
+ gf180mcu_fd_sc_mcu7t5v0__xor3_1_70/A2 gf180mcu_fd_sc_mcu7t5v0__and2_1_82/Z vss vdd
+ vss gf180mcu_fd_sc_mcu7t5v0__oai21_1
Xgf180mcu_fd_sc_mcu7t5v0__oai21_1_185 vdd gf180mcu_fd_sc_mcu7t5v0__buf_8_7/Z gf180mcu_fd_sc_mcu7t5v0__nor2_4_31/ZN
+ gf180mcu_fd_sc_mcu7t5v0__aoi21_1_200/B gf180mcu_fd_sc_mcu7t5v0__dffq_1_397/Q vss
+ vdd vss gf180mcu_fd_sc_mcu7t5v0__oai21_1
Xgf180mcu_fd_sc_mcu7t5v0__oai21_1_196 vdd gf180mcu_fd_sc_mcu7t5v0__buf_8_7/Z gf180mcu_fd_sc_mcu7t5v0__nor2_4_31/ZN
+ gf180mcu_fd_sc_mcu7t5v0__aoi21_1_128/B gf180mcu_fd_sc_mcu7t5v0__dffq_1_301/Q vss
+ vdd vss gf180mcu_fd_sc_mcu7t5v0__oai21_1
Xgf180mcu_fd_sc_mcu7t5v0__clkinv_1_12 vdd vss gf180mcu_fd_sc_mcu7t5v0__xor3_1_32/Z
+ gf180mcu_fd_sc_mcu7t5v0__oai21_1_44/A1 vdd vss gf180mcu_fd_sc_mcu7t5v0__clkinv_1
Xgf180mcu_fd_sc_mcu7t5v0__nand2_2_70 vdd vss gf180mcu_fd_sc_mcu7t5v0__oai21_1_28/A1
+ gf180mcu_fd_sc_mcu7t5v0__nor3_4_18/A1 gf180mcu_fd_sc_mcu7t5v0__nor2_2_41/ZN vdd
+ vss gf180mcu_fd_sc_mcu7t5v0__nand2_2
Xgf180mcu_fd_sc_mcu7t5v0__clkinv_1_23 vdd vss gf180mcu_fd_sc_mcu7t5v0__dffq_1_48/Q
+ gf180mcu_fd_sc_mcu7t5v0__oai22_1_32/B2 vdd vss gf180mcu_fd_sc_mcu7t5v0__clkinv_1
Xgf180mcu_fd_sc_mcu7t5v0__clkinv_1_34 vdd vss gf180mcu_fd_sc_mcu7t5v0__dffq_1_24/Q
+ gf180mcu_fd_sc_mcu7t5v0__oai22_1_23/B2 vdd vss gf180mcu_fd_sc_mcu7t5v0__clkinv_1
Xgf180mcu_fd_sc_mcu7t5v0__clkinv_1_45 vdd vss gf180mcu_fd_sc_mcu7t5v0__dffq_1_54/Q
+ gf180mcu_fd_sc_mcu7t5v0__oai22_1_40/A1 vdd vss gf180mcu_fd_sc_mcu7t5v0__clkinv_1
Xgf180mcu_fd_sc_mcu7t5v0__clkinv_1_56 vdd vss gf180mcu_fd_sc_mcu7t5v0__dffq_1_47/Q
+ gf180mcu_fd_sc_mcu7t5v0__oai22_1_45/B2 vdd vss gf180mcu_fd_sc_mcu7t5v0__clkinv_1
Xgf180mcu_fd_sc_mcu7t5v0__clkinv_1_67 vdd vss gf180mcu_fd_sc_mcu7t5v0__dffq_1_61/Q
+ gf180mcu_fd_sc_mcu7t5v0__oai22_1_56/B2 vdd vss gf180mcu_fd_sc_mcu7t5v0__clkinv_1
Xgf180mcu_fd_sc_mcu7t5v0__clkinv_1_78 vdd vss gf180mcu_fd_sc_mcu7t5v0__dffq_1_66/Q
+ gf180mcu_fd_sc_mcu7t5v0__oai22_1_61/B2 vdd vss gf180mcu_fd_sc_mcu7t5v0__clkinv_1
Xgf180mcu_fd_sc_mcu7t5v0__aoi21_1_209 gf180mcu_fd_sc_mcu7t5v0__xor2_1_104/Z vdd vss
+ gf180mcu_fd_sc_mcu7t5v0__xor3_1_76/A2 gf180mcu_fd_sc_mcu7t5v0__or3_1_14/Z gf180mcu_fd_sc_mcu7t5v0__xnor3_1_23/A1
+ vdd vss gf180mcu_fd_sc_mcu7t5v0__aoi21_1
Xgf180mcu_fd_sc_mcu7t5v0__clkinv_1_89 vdd vss gf180mcu_fd_sc_mcu7t5v0__dffq_1_76/Q
+ gf180mcu_fd_sc_mcu7t5v0__oai22_1_74/B2 vdd vss gf180mcu_fd_sc_mcu7t5v0__clkinv_1
Xgf180mcu_fd_sc_mcu7t5v0__oai32_2_1 gf180mcu_fd_sc_mcu7t5v0__nor3_2_9/A3 gf180mcu_fd_sc_mcu7t5v0__oai32_4_2/B1
+ gf180mcu_fd_sc_mcu7t5v0__inv_1_19/I vdd vss gf180mcu_fd_sc_mcu7t5v0__oai32_2_1/ZN
+ gf180mcu_fd_sc_mcu7t5v0__nor3_2_9/A1 gf180mcu_fd_sc_mcu7t5v0__nor3_2_9/A2 vdd vss
+ gf180mcu_fd_sc_mcu7t5v0__oai32_2
Xgf180mcu_fd_sc_mcu7t5v0__nand2_1_509 vdd vss gf180mcu_fd_sc_mcu7t5v0__xor3_1_93/A3
+ gf180mcu_fd_sc_mcu7t5v0__inv_8_2/I gf180mcu_fd_sc_mcu7t5v0__nor4_2_5/A4 vdd vss
+ gf180mcu_fd_sc_mcu7t5v0__nand2_1
Xgf180mcu_fd_sc_mcu7t5v0__nand4_1_5 gf180mcu_fd_sc_mcu7t5v0__oai22_1_8/ZN gf180mcu_fd_sc_mcu7t5v0__nand4_1_5/A4
+ vdd vss gf180mcu_fd_sc_mcu7t5v0__nand4_1_5/ZN gf180mcu_fd_sc_mcu7t5v0__nand4_1_5/A1
+ gf180mcu_fd_sc_mcu7t5v0__nand4_1_5/A2 vdd vss gf180mcu_fd_sc_mcu7t5v0__nand4_1
Xgf180mcu_fd_sc_mcu7t5v0__or3_1_18 gf180mcu_fd_sc_mcu7t5v0__or3_1_18/A3 vdd vss gf180mcu_fd_sc_mcu7t5v0__or3_1_18/Z
+ gf180mcu_fd_sc_mcu7t5v0__or3_1_18/A1 gf180mcu_fd_sc_mcu7t5v0__or3_1_18/A2 vdd vss
+ gf180mcu_fd_sc_mcu7t5v0__or3_1
Xgf180mcu_fd_sc_mcu7t5v0__or3_1_29 gf180mcu_fd_sc_mcu7t5v0__or3_1_29/A3 vdd vss gf180mcu_fd_sc_mcu7t5v0__or3_1_29/Z
+ gf180mcu_fd_sc_mcu7t5v0__or3_1_29/A1 gf180mcu_fd_sc_mcu7t5v0__or3_1_29/A2 vdd vss
+ gf180mcu_fd_sc_mcu7t5v0__or3_1
Xgf180mcu_fd_sc_mcu7t5v0__dffq_4_20 gf180mcu_fd_sc_mcu7t5v0__dffq_4_20/D gf180mcu_fd_sc_mcu7t5v0__dffq_4_20/Q
+ vdd vss gf180mcu_fd_sc_mcu7t5v0__dffq_4_21/CLK vdd vss gf180mcu_fd_sc_mcu7t5v0__dffq_4
Xgf180mcu_fd_sc_mcu7t5v0__dffq_4_31 gf180mcu_fd_sc_mcu7t5v0__dffq_4_31/D gf180mcu_fd_sc_mcu7t5v0__inv_1_20/I
+ vdd vss gf180mcu_fd_sc_mcu7t5v0__dffq_4_44/CLK vdd vss gf180mcu_fd_sc_mcu7t5v0__dffq_4
Xgf180mcu_fd_sc_mcu7t5v0__nor3_4_18 gf180mcu_fd_sc_mcu7t5v0__inv_2_12/ZN vdd vss gf180mcu_fd_sc_mcu7t5v0__nor3_4_18/ZN
+ gf180mcu_fd_sc_mcu7t5v0__nor3_4_18/A1 gf180mcu_fd_sc_mcu7t5v0__nor3_4_18/A2 vdd
+ vss gf180mcu_fd_sc_mcu7t5v0__nor3_4
Xgf180mcu_fd_sc_mcu7t5v0__dffq_4_42 gf180mcu_fd_sc_mcu7t5v0__dffq_4_42/D gf180mcu_fd_sc_mcu7t5v0__or2_4_0/A2
+ vdd vss gf180mcu_fd_sc_mcu7t5v0__dffq_4_1/CLK vdd vss gf180mcu_fd_sc_mcu7t5v0__dffq_4
Xgf180mcu_fd_sc_mcu7t5v0__and2_2_2 vdd vss gf180mcu_fd_sc_mcu7t5v0__and2_2_2/Z gf180mcu_fd_sc_mcu7t5v0__or3_2_0/Z
+ gf180mcu_fd_sc_mcu7t5v0__and2_2_2/A2 vdd vss gf180mcu_fd_sc_mcu7t5v0__and2_2
Xgf180mcu_fd_sc_mcu7t5v0__nand2_1_306 vdd vss gf180mcu_fd_sc_mcu7t5v0__oai211_1_18/B
+ gf180mcu_fd_sc_mcu7t5v0__dffq_2_43/Q gf180mcu_fd_sc_mcu7t5v0__nor2_4_17/ZN vdd vss
+ gf180mcu_fd_sc_mcu7t5v0__nand2_1
Xgf180mcu_fd_sc_mcu7t5v0__nand2_1_317 vdd vss gf180mcu_fd_sc_mcu7t5v0__nor2_1_159/A2
+ gf180mcu_fd_sc_mcu7t5v0__dffq_1_300/Q gf180mcu_fd_sc_mcu7t5v0__nor4_4_2/A3 vdd vss
+ gf180mcu_fd_sc_mcu7t5v0__nand2_1
Xgf180mcu_fd_sc_mcu7t5v0__nand2_1_328 vdd vss gf180mcu_fd_sc_mcu7t5v0__oai21_1_122/B
+ gf180mcu_fd_sc_mcu7t5v0__or3_2_3/A3 gf180mcu_fd_sc_mcu7t5v0__xnor3_1_20/A3 vdd vss
+ gf180mcu_fd_sc_mcu7t5v0__nand2_1
Xgf180mcu_fd_sc_mcu7t5v0__nand2_1_339 vdd vss gf180mcu_fd_sc_mcu7t5v0__oai22_1_265/B1
+ gf180mcu_fd_sc_mcu7t5v0__buf_8_8/I gf180mcu_fd_sc_mcu7t5v0__dffq_2_53/Q vdd vss
+ gf180mcu_fd_sc_mcu7t5v0__nand2_1
Xgf180mcu_fd_sc_mcu7t5v0__dffq_1_403 vdd gf180mcu_fd_sc_mcu7t5v0__nor4_2_4/A2 gf180mcu_fd_sc_mcu7t5v0__dffq_4_21/CLK
+ vss gf180mcu_fd_sc_mcu7t5v0__dffq_1_403/D vdd vss gf180mcu_fd_sc_mcu7t5v0__dffq_1
Xgf180mcu_fd_sc_mcu7t5v0__dffq_1_414 vdd gf180mcu_fd_sc_mcu7t5v0__nor4_4_2/A2 gf180mcu_fd_sc_mcu7t5v0__dffq_4_21/CLK
+ vss gf180mcu_fd_sc_mcu7t5v0__dffq_1_414/D vdd vss gf180mcu_fd_sc_mcu7t5v0__dffq_1
Xgf180mcu_fd_sc_mcu7t5v0__dffq_1_425 vdd gf180mcu_fd_sc_mcu7t5v0__inv_1_18/I gf180mcu_fd_sc_mcu7t5v0__dffq_4_44/CLK
+ vss gf180mcu_fd_sc_mcu7t5v0__dffq_1_425/D vdd vss gf180mcu_fd_sc_mcu7t5v0__dffq_1
Xgf180mcu_fd_sc_mcu7t5v0__dffq_1_436 vdd gf180mcu_fd_sc_mcu7t5v0__dffq_1_436/Q gf180mcu_fd_sc_mcu7t5v0__dffq_4_1/CLK
+ vss gf180mcu_fd_sc_mcu7t5v0__dffq_1_436/D vdd vss gf180mcu_fd_sc_mcu7t5v0__dffq_1
Xgf180mcu_fd_sc_mcu7t5v0__dffq_1_447 vdd gf180mcu_fd_sc_mcu7t5v0__dffq_1_447/Q gf180mcu_fd_sc_mcu7t5v0__dffq_4_1/CLK
+ vss gf180mcu_fd_sc_mcu7t5v0__dffq_1_447/D vdd vss gf180mcu_fd_sc_mcu7t5v0__dffq_1
Xgf180mcu_fd_sc_mcu7t5v0__dffq_1_458 vdd gf180mcu_fd_sc_mcu7t5v0__dffq_1_458/Q gf180mcu_fd_sc_mcu7t5v0__dffq_2_58/CLK
+ vss gf180mcu_fd_sc_mcu7t5v0__dffq_1_458/D vdd vss gf180mcu_fd_sc_mcu7t5v0__dffq_1
Xgf180mcu_fd_sc_mcu7t5v0__or2_1_40 vdd vss gf180mcu_fd_sc_mcu7t5v0__or2_1_40/Z gf180mcu_fd_sc_mcu7t5v0__inv_1_3/I
+ gf180mcu_fd_sc_mcu7t5v0__or2_1_40/A2 vdd vss gf180mcu_fd_sc_mcu7t5v0__or2_1
Xgf180mcu_fd_sc_mcu7t5v0__or2_1_51 vdd vss gf180mcu_fd_sc_mcu7t5v0__or2_1_51/Z gf180mcu_fd_sc_mcu7t5v0__or2_1_51/A1
+ gf180mcu_fd_sc_mcu7t5v0__or2_1_51/A2 vdd vss gf180mcu_fd_sc_mcu7t5v0__or2_1
Xgf180mcu_fd_sc_mcu7t5v0__nor2_4_40 vdd vss gf180mcu_fd_sc_mcu7t5v0__nor2_4_40/ZN
+ gf180mcu_fd_sc_mcu7t5v0__inv_4_7/I gf180mcu_fd_sc_mcu7t5v0__oai31_4_5/A2 vdd vss
+ gf180mcu_fd_sc_mcu7t5v0__nor2_4
Xgf180mcu_fd_sc_mcu7t5v0__clkinv_1_308 vdd vss gf180mcu_fd_sc_mcu7t5v0__xor2_1_92/A1
+ gf180mcu_fd_sc_mcu7t5v0__nand4_1_6/A2 vdd vss gf180mcu_fd_sc_mcu7t5v0__clkinv_1
Xgf180mcu_fd_sc_mcu7t5v0__clkinv_1_319 vdd vss gf180mcu_fd_sc_mcu7t5v0__dffq_1_387/Q
+ gf180mcu_fd_sc_mcu7t5v0__or2_1_20/A2 vdd vss gf180mcu_fd_sc_mcu7t5v0__clkinv_1
Xgf180mcu_fd_sc_mcu7t5v0__nand2_4_6 vdd vss gf180mcu_fd_sc_mcu7t5v0__nand2_4_6/ZN
+ gf180mcu_fd_sc_mcu7t5v0__nor3_4_9/ZN gf180mcu_fd_sc_mcu7t5v0__nor2_4_13/ZN vdd vss
+ gf180mcu_fd_sc_mcu7t5v0__nand2_4
Xgf180mcu_fd_sc_mcu7t5v0__nand2_4_16 vdd vss gf180mcu_fd_sc_mcu7t5v0__oai22_1_55/A2
+ gf180mcu_fd_sc_mcu7t5v0__nor3_4_8/ZN gf180mcu_fd_sc_mcu7t5v0__nor2_4_13/ZN vdd vss
+ gf180mcu_fd_sc_mcu7t5v0__nand2_4
Xgf180mcu_fd_sc_mcu7t5v0__nand2_4_27 vdd vss gf180mcu_fd_sc_mcu7t5v0__nand2_4_27/ZN
+ gf180mcu_fd_sc_mcu7t5v0__nor3_4_8/ZN gf180mcu_fd_sc_mcu7t5v0__nor2_4_4/ZN vdd vss
+ gf180mcu_fd_sc_mcu7t5v0__nand2_4
Xgf180mcu_fd_sc_mcu7t5v0__nand2_4_38 vdd vss gf180mcu_fd_sc_mcu7t5v0__oai21_1_94/A2
+ gf180mcu_fd_sc_mcu7t5v0__nor2_4_14/ZN gf180mcu_fd_sc_mcu7t5v0__or3_1_10/Z vdd vss
+ gf180mcu_fd_sc_mcu7t5v0__nand2_4
Xgf180mcu_fd_sc_mcu7t5v0__aoi21_1_370 gf180mcu_fd_sc_mcu7t5v0__aoi21_1_370/B vdd vss
+ gf180mcu_fd_sc_mcu7t5v0__dffq_1_230/D gf180mcu_fd_sc_mcu7t5v0__oai21_1_94/A2 gf180mcu_fd_sc_mcu7t5v0__aoi221_2_2/ZN
+ vdd vss gf180mcu_fd_sc_mcu7t5v0__aoi21_1
Xgf180mcu_fd_sc_mcu7t5v0__aoi21_1_381 gf180mcu_fd_sc_mcu7t5v0__nor2_2_44/ZN vdd vss
+ gf180mcu_fd_sc_mcu7t5v0__oai221_1_12/B1 gf180mcu_fd_sc_mcu7t5v0__nor3_4_17/ZN gf180mcu_fd_sc_mcu7t5v0__and2_1_42/A1
+ vdd vss gf180mcu_fd_sc_mcu7t5v0__aoi21_1
Xgf180mcu_fd_sc_mcu7t5v0__nand2_1_103 vdd vss gf180mcu_fd_sc_mcu7t5v0__oai22_1_4/A2
+ gf180mcu_fd_sc_mcu7t5v0__dffq_4_37/Q gf180mcu_fd_sc_mcu7t5v0__xor2_1_58/A1 vdd vss
+ gf180mcu_fd_sc_mcu7t5v0__nand2_1
Xgf180mcu_fd_sc_mcu7t5v0__nand2_1_114 vdd vss gf180mcu_fd_sc_mcu7t5v0__or3_1_3/A3
+ gf180mcu_fd_sc_mcu7t5v0__inv_8_2/I gf180mcu_fd_sc_mcu7t5v0__or4_1_1/A1 vdd vss gf180mcu_fd_sc_mcu7t5v0__nand2_1
Xgf180mcu_fd_sc_mcu7t5v0__nand2_1_125 vdd vss gf180mcu_fd_sc_mcu7t5v0__xor2_1_39/A1
+ gf180mcu_fd_sc_mcu7t5v0__nand2_1_125/A1 gf180mcu_fd_sc_mcu7t5v0__and3_1_4/A3 vdd
+ vss gf180mcu_fd_sc_mcu7t5v0__nand2_1
Xgf180mcu_fd_sc_mcu7t5v0__nand2_1_136 vdd vss gf180mcu_fd_sc_mcu7t5v0__xor2_1_43/A2
+ gf180mcu_fd_sc_mcu7t5v0__inv_4_6/I gf180mcu_fd_sc_mcu7t5v0__and2_2_0/Z vdd vss gf180mcu_fd_sc_mcu7t5v0__nand2_1
Xgf180mcu_fd_sc_mcu7t5v0__nand2_1_147 vdd vss gf180mcu_fd_sc_mcu7t5v0__xor2_1_42/A2
+ gf180mcu_fd_sc_mcu7t5v0__inv_12_1/I gf180mcu_fd_sc_mcu7t5v0__xor3_1_20/A2 vdd vss
+ gf180mcu_fd_sc_mcu7t5v0__nand2_1
Xgf180mcu_fd_sc_mcu7t5v0__nand2_1_158 vdd vss gf180mcu_fd_sc_mcu7t5v0__aoi21_1_66/A1
+ gf180mcu_fd_sc_mcu7t5v0__dffq_1_13/Q gf180mcu_fd_sc_mcu7t5v0__or2_4_4/Z vdd vss
+ gf180mcu_fd_sc_mcu7t5v0__nand2_1
Xgf180mcu_fd_sc_mcu7t5v0__nand2_1_169 vdd vss gf180mcu_fd_sc_mcu7t5v0__mux2_1_5/S
+ gf180mcu_fd_sc_mcu7t5v0__oai31_1_3/A1 gf180mcu_fd_sc_mcu7t5v0__inv_1_4/ZN vdd vss
+ gf180mcu_fd_sc_mcu7t5v0__nand2_1
Xgf180mcu_fd_sc_mcu7t5v0__xor3_1_80 gf180mcu_fd_sc_mcu7t5v0__xor3_1_81/Z vdd vss gf180mcu_fd_sc_mcu7t5v0__xor3_1_80/Z
+ gf180mcu_fd_sc_mcu7t5v0__xor3_1_80/A1 gf180mcu_fd_sc_mcu7t5v0__xor3_1_80/A2 vdd
+ vss gf180mcu_fd_sc_mcu7t5v0__xor3_1
Xgf180mcu_fd_sc_mcu7t5v0__xor3_1_91 gf180mcu_fd_sc_mcu7t5v0__xor3_1_91/A3 vdd vss
+ gf180mcu_fd_sc_mcu7t5v0__xor3_1_91/Z gf180mcu_fd_sc_mcu7t5v0__xor3_1_91/A1 gf180mcu_fd_sc_mcu7t5v0__xor3_1_91/A2
+ vdd vss gf180mcu_fd_sc_mcu7t5v0__xor3_1
Xgf180mcu_fd_sc_mcu7t5v0__dffq_1_200 vdd gf180mcu_fd_sc_mcu7t5v0__dffq_1_200/Q gf180mcu_fd_sc_mcu7t5v0__dffq_4_8/CLK
+ vss gf180mcu_fd_sc_mcu7t5v0__dffq_1_200/D vdd vss gf180mcu_fd_sc_mcu7t5v0__dffq_1
Xgf180mcu_fd_sc_mcu7t5v0__dffq_1_211 vdd gf180mcu_fd_sc_mcu7t5v0__dffq_1_211/Q gf180mcu_fd_sc_mcu7t5v0__dffq_4_8/CLK
+ vss gf180mcu_fd_sc_mcu7t5v0__dffq_1_211/D vdd vss gf180mcu_fd_sc_mcu7t5v0__dffq_1
Xgf180mcu_fd_sc_mcu7t5v0__nor2_1_400 vdd vss gf180mcu_fd_sc_mcu7t5v0__mux2_1_14/S
+ gf180mcu_fd_sc_mcu7t5v0__xnor2_1_75/A1 gf180mcu_fd_sc_mcu7t5v0__xnor2_1_75/A2 vdd
+ vss gf180mcu_fd_sc_mcu7t5v0__nor2_1
Xgf180mcu_fd_sc_mcu7t5v0__dffq_1_222 vdd gf180mcu_fd_sc_mcu7t5v0__dffq_1_222/Q gf180mcu_fd_sc_mcu7t5v0__dffq_4_8/CLK
+ vss gf180mcu_fd_sc_mcu7t5v0__dffq_1_222/D vdd vss gf180mcu_fd_sc_mcu7t5v0__dffq_1
Xgf180mcu_fd_sc_mcu7t5v0__nor2_1_411 vdd vss gf180mcu_fd_sc_mcu7t5v0__aoi21_4_13/B
+ gf180mcu_fd_sc_mcu7t5v0__nor2_1_411/A1 gf180mcu_fd_sc_mcu7t5v0__or3_4_0/Z vdd vss
+ gf180mcu_fd_sc_mcu7t5v0__nor2_1
Xgf180mcu_fd_sc_mcu7t5v0__dffq_1_233 vdd gf180mcu_fd_sc_mcu7t5v0__dffq_1_233/Q gf180mcu_fd_sc_mcu7t5v0__dffq_2_26/CLK
+ vss gf180mcu_fd_sc_mcu7t5v0__dffq_1_233/D vdd vss gf180mcu_fd_sc_mcu7t5v0__dffq_1
Xgf180mcu_fd_sc_mcu7t5v0__dffq_1_244 vdd gf180mcu_fd_sc_mcu7t5v0__dffq_1_244/Q gf180mcu_fd_sc_mcu7t5v0__dffq_4_8/CLK
+ vss gf180mcu_fd_sc_mcu7t5v0__dffq_1_244/D vdd vss gf180mcu_fd_sc_mcu7t5v0__dffq_1
Xgf180mcu_fd_sc_mcu7t5v0__dffq_1_255 vdd gf180mcu_fd_sc_mcu7t5v0__dffq_1_255/Q gf180mcu_fd_sc_mcu7t5v0__dffq_4_8/CLK
+ vss gf180mcu_fd_sc_mcu7t5v0__dffq_1_255/D vdd vss gf180mcu_fd_sc_mcu7t5v0__dffq_1
Xgf180mcu_fd_sc_mcu7t5v0__dffq_1_266 vdd gf180mcu_fd_sc_mcu7t5v0__dffq_1_266/Q gf180mcu_fd_sc_mcu7t5v0__dffq_1_99/CLK
+ vss gf180mcu_fd_sc_mcu7t5v0__dffq_1_266/D vdd vss gf180mcu_fd_sc_mcu7t5v0__dffq_1
Xgf180mcu_fd_sc_mcu7t5v0__dffq_1_277 vdd gf180mcu_fd_sc_mcu7t5v0__dffq_1_277/Q gf180mcu_fd_sc_mcu7t5v0__dffq_4_8/CLK
+ vss gf180mcu_fd_sc_mcu7t5v0__dffq_1_277/D vdd vss gf180mcu_fd_sc_mcu7t5v0__dffq_1
Xgf180mcu_fd_sc_mcu7t5v0__dffq_1_288 vdd gf180mcu_fd_sc_mcu7t5v0__dffq_1_288/Q gf180mcu_fd_sc_mcu7t5v0__dffq_2_58/CLK
+ vss gf180mcu_fd_sc_mcu7t5v0__dffq_1_288/D vdd vss gf180mcu_fd_sc_mcu7t5v0__dffq_1
Xgf180mcu_fd_sc_mcu7t5v0__dffq_1_299 vdd gf180mcu_fd_sc_mcu7t5v0__dffq_1_299/Q gf180mcu_fd_sc_mcu7t5v0__dffq_4_21/CLK
+ vss gf180mcu_fd_sc_mcu7t5v0__dffq_1_299/D vdd vss gf180mcu_fd_sc_mcu7t5v0__dffq_1
Xgf180mcu_fd_sc_mcu7t5v0__nand2_1_670 vdd vss gf180mcu_fd_sc_mcu7t5v0__nor2_4_42/A2
+ gf180mcu_fd_sc_mcu7t5v0__dffq_2_93/Q gf180mcu_fd_sc_mcu7t5v0__nor2_2_53/A1 vdd vss
+ gf180mcu_fd_sc_mcu7t5v0__nand2_1
Xgf180mcu_fd_sc_mcu7t5v0__nand2_1_681 vdd vss gf180mcu_fd_sc_mcu7t5v0__xnor3_1_45/A3
+ gf180mcu_fd_sc_mcu7t5v0__inv_4_6/I gf180mcu_fd_sc_mcu7t5v0__and4_1_3/A3 vdd vss
+ gf180mcu_fd_sc_mcu7t5v0__nand2_1
Xgf180mcu_fd_sc_mcu7t5v0__nand2_1_692 vdd vss gf180mcu_fd_sc_mcu7t5v0__xor2_1_199/A2
+ gf180mcu_fd_sc_mcu7t5v0__nand2_1_692/A1 gf180mcu_fd_sc_mcu7t5v0__nand2_1_694/ZN
+ vdd vss gf180mcu_fd_sc_mcu7t5v0__nand2_1
Xgf180mcu_fd_sc_mcu7t5v0__dffq_1_10 vdd gf180mcu_fd_sc_mcu7t5v0__dffq_1_10/Q gf180mcu_fd_sc_mcu7t5v0__dffq_4_6/CLK
+ vss gf180mcu_fd_sc_mcu7t5v0__dffq_1_10/D vdd vss gf180mcu_fd_sc_mcu7t5v0__dffq_1
Xgf180mcu_fd_sc_mcu7t5v0__dffq_1_21 vdd gf180mcu_fd_sc_mcu7t5v0__dffq_1_21/Q gf180mcu_fd_sc_mcu7t5v0__dffq_1_99/CLK
+ vss gf180mcu_fd_sc_mcu7t5v0__dffq_1_21/D vdd vss gf180mcu_fd_sc_mcu7t5v0__dffq_1
Xgf180mcu_fd_sc_mcu7t5v0__clkinv_1_105 vdd vss gf180mcu_fd_sc_mcu7t5v0__dffq_1_88/Q
+ gf180mcu_fd_sc_mcu7t5v0__oai22_1_81/B2 vdd vss gf180mcu_fd_sc_mcu7t5v0__clkinv_1
Xgf180mcu_fd_sc_mcu7t5v0__nor3_1_19 gf180mcu_fd_sc_mcu7t5v0__nor3_1_19/A3 vdd vss
+ gf180mcu_fd_sc_mcu7t5v0__nor3_1_19/ZN gf180mcu_fd_sc_mcu7t5v0__oai31_4_2/ZN gf180mcu_fd_sc_mcu7t5v0__and2_1_62/Z
+ vdd vss gf180mcu_fd_sc_mcu7t5v0__nor3_1
Xgf180mcu_fd_sc_mcu7t5v0__dffq_1_32 vdd gf180mcu_fd_sc_mcu7t5v0__dffq_1_32/Q gf180mcu_fd_sc_mcu7t5v0__dffq_1_99/CLK
+ vss gf180mcu_fd_sc_mcu7t5v0__dffq_1_32/D vdd vss gf180mcu_fd_sc_mcu7t5v0__dffq_1
Xgf180mcu_fd_sc_mcu7t5v0__clkinv_1_116 vdd vss gf180mcu_fd_sc_mcu7t5v0__dffq_1_181/Q
+ gf180mcu_fd_sc_mcu7t5v0__oai22_1_108/B2 vdd vss gf180mcu_fd_sc_mcu7t5v0__clkinv_1
Xgf180mcu_fd_sc_mcu7t5v0__dffq_1_43 vdd gf180mcu_fd_sc_mcu7t5v0__dffq_1_43/Q gf180mcu_fd_sc_mcu7t5v0__dffq_4_8/CLK
+ vss gf180mcu_fd_sc_mcu7t5v0__dffq_1_43/D vdd vss gf180mcu_fd_sc_mcu7t5v0__dffq_1
Xgf180mcu_fd_sc_mcu7t5v0__clkinv_1_127 vdd vss gf180mcu_fd_sc_mcu7t5v0__dffq_1_112/Q
+ gf180mcu_fd_sc_mcu7t5v0__oai22_1_100/B2 vdd vss gf180mcu_fd_sc_mcu7t5v0__clkinv_1
Xgf180mcu_fd_sc_mcu7t5v0__dffq_1_54 vdd gf180mcu_fd_sc_mcu7t5v0__dffq_1_54/Q gf180mcu_fd_sc_mcu7t5v0__dffq_1_99/CLK
+ vss gf180mcu_fd_sc_mcu7t5v0__dffq_1_54/D vdd vss gf180mcu_fd_sc_mcu7t5v0__dffq_1
Xgf180mcu_fd_sc_mcu7t5v0__dffq_1_65 vdd gf180mcu_fd_sc_mcu7t5v0__dffq_1_65/Q gf180mcu_fd_sc_mcu7t5v0__dffq_1_95/CLK
+ vss gf180mcu_fd_sc_mcu7t5v0__dffq_1_65/D vdd vss gf180mcu_fd_sc_mcu7t5v0__dffq_1
Xgf180mcu_fd_sc_mcu7t5v0__clkinv_1_138 vdd vss gf180mcu_fd_sc_mcu7t5v0__dffq_1_135/Q
+ gf180mcu_fd_sc_mcu7t5v0__oai22_1_137/B2 vdd vss gf180mcu_fd_sc_mcu7t5v0__clkinv_1
Xgf180mcu_fd_sc_mcu7t5v0__dffq_1_76 vdd gf180mcu_fd_sc_mcu7t5v0__dffq_1_76/Q gf180mcu_fd_sc_mcu7t5v0__dffq_1_99/CLK
+ vss gf180mcu_fd_sc_mcu7t5v0__dffq_1_76/D vdd vss gf180mcu_fd_sc_mcu7t5v0__dffq_1
Xgf180mcu_fd_sc_mcu7t5v0__clkinv_1_149 vdd vss gf180mcu_fd_sc_mcu7t5v0__dffq_1_132/Q
+ gf180mcu_fd_sc_mcu7t5v0__oai22_1_136/B2 vdd vss gf180mcu_fd_sc_mcu7t5v0__clkinv_1
Xgf180mcu_fd_sc_mcu7t5v0__dffq_1_87 vdd gf180mcu_fd_sc_mcu7t5v0__dffq_1_87/Q gf180mcu_fd_sc_mcu7t5v0__dffq_1_99/CLK
+ vss gf180mcu_fd_sc_mcu7t5v0__dffq_1_87/D vdd vss gf180mcu_fd_sc_mcu7t5v0__dffq_1
Xgf180mcu_fd_sc_mcu7t5v0__dffq_1_98 vdd gf180mcu_fd_sc_mcu7t5v0__dffq_1_98/Q gf180mcu_fd_sc_mcu7t5v0__dffq_1_99/CLK
+ vss gf180mcu_fd_sc_mcu7t5v0__dffq_1_98/D vdd vss gf180mcu_fd_sc_mcu7t5v0__dffq_1
Xgf180mcu_fd_sc_mcu7t5v0__nand2_2_3 vdd vss gf180mcu_fd_sc_mcu7t5v0__nor2_2_6/A2 gf180mcu_fd_sc_mcu7t5v0__dffq_4_3/Q
+ gf180mcu_fd_sc_mcu7t5v0__inv_2_1/ZN vdd vss gf180mcu_fd_sc_mcu7t5v0__nand2_2
Xgf180mcu_fd_sc_mcu7t5v0__aoi211_1_7 gf180mcu_fd_sc_mcu7t5v0__nor2_1_43/ZN gf180mcu_fd_sc_mcu7t5v0__or2_1_23/A1
+ vdd vss gf180mcu_fd_sc_mcu7t5v0__dffq_1_7/D gf180mcu_fd_sc_mcu7t5v0__inv_4_2/ZN
+ gf180mcu_fd_sc_mcu7t5v0__nor2_4_15/ZN vdd vss gf180mcu_fd_sc_mcu7t5v0__aoi211_1
Xgf180mcu_fd_sc_mcu7t5v0__dffq_2_7 gf180mcu_fd_sc_mcu7t5v0__dffq_2_7/D vdd vss gf180mcu_fd_sc_mcu7t5v0__dffq_4_6/CLK
+ gf180mcu_fd_sc_mcu7t5v0__dffq_2_7/Q vdd vss gf180mcu_fd_sc_mcu7t5v0__dffq_2
Xgf180mcu_fd_sc_mcu7t5v0__aoi22_1_4 gf180mcu_fd_sc_mcu7t5v0__and2_2_3/Z gf180mcu_fd_sc_mcu7t5v0__inv_12_1/I
+ vdd vss gf180mcu_fd_sc_mcu7t5v0__aoi22_1_4/ZN gf180mcu_fd_sc_mcu7t5v0__inv_8_1/I
+ gf180mcu_fd_sc_mcu7t5v0__and2_2_2/Z vdd vss gf180mcu_fd_sc_mcu7t5v0__aoi22_1
Xgf180mcu_fd_sc_mcu7t5v0__buf_8_0 gf180mcu_fd_sc_mcu7t5v0__buf_8_8/I gf180mcu_fd_sc_mcu7t5v0__buf_8_1/Z
+ vdd vss vdd vss gf180mcu_fd_sc_mcu7t5v0__buf_8
Xgf180mcu_fd_sc_mcu7t5v0__oai22_1_110 gf180mcu_fd_sc_mcu7t5v0__nand2_4_14/ZN gf180mcu_fd_sc_mcu7t5v0__nand2_2_32/ZN
+ gf180mcu_fd_sc_mcu7t5v0__oai22_1_110/B2 vdd vss gf180mcu_fd_sc_mcu7t5v0__dffq_1_182/D
+ gf180mcu_fd_sc_mcu7t5v0__oai22_1_88/A1 vdd vss gf180mcu_fd_sc_mcu7t5v0__oai22_1
Xgf180mcu_fd_sc_mcu7t5v0__oai22_1_121 gf180mcu_fd_sc_mcu7t5v0__oai22_1_55/A2 gf180mcu_fd_sc_mcu7t5v0__oai22_1_55/B1
+ gf180mcu_fd_sc_mcu7t5v0__oai22_1_121/B2 vdd vss gf180mcu_fd_sc_mcu7t5v0__dffq_1_130/D
+ gf180mcu_fd_sc_mcu7t5v0__aoi21_4_4/ZN vdd vss gf180mcu_fd_sc_mcu7t5v0__oai22_1
Xgf180mcu_fd_sc_mcu7t5v0__oai22_1_132 gf180mcu_fd_sc_mcu7t5v0__nand2_4_19/ZN gf180mcu_fd_sc_mcu7t5v0__nand2_2_26/ZN
+ gf180mcu_fd_sc_mcu7t5v0__oai22_1_132/B2 vdd vss gf180mcu_fd_sc_mcu7t5v0__dffq_1_124/D
+ gf180mcu_fd_sc_mcu7t5v0__oai22_1_98/A1 vdd vss gf180mcu_fd_sc_mcu7t5v0__oai22_1
Xgf180mcu_fd_sc_mcu7t5v0__oai22_1_143 gf180mcu_fd_sc_mcu7t5v0__nand2_4_18/ZN gf180mcu_fd_sc_mcu7t5v0__nand2_2_25/ZN
+ gf180mcu_fd_sc_mcu7t5v0__oai22_1_143/B2 vdd vss gf180mcu_fd_sc_mcu7t5v0__dffq_1_141/D
+ gf180mcu_fd_sc_mcu7t5v0__aoi21_4_5/ZN vdd vss gf180mcu_fd_sc_mcu7t5v0__oai22_1
Xgf180mcu_fd_sc_mcu7t5v0__oai22_1_154 gf180mcu_fd_sc_mcu7t5v0__nand2_4_21/ZN gf180mcu_fd_sc_mcu7t5v0__nand2_2_28/ZN
+ gf180mcu_fd_sc_mcu7t5v0__oai22_1_154/B2 vdd vss gf180mcu_fd_sc_mcu7t5v0__dffq_1_150/D
+ gf180mcu_fd_sc_mcu7t5v0__aoi21_4_3/ZN vdd vss gf180mcu_fd_sc_mcu7t5v0__oai22_1
Xgf180mcu_fd_sc_mcu7t5v0__oai22_1_165 gf180mcu_fd_sc_mcu7t5v0__nand2_4_22/ZN gf180mcu_fd_sc_mcu7t5v0__nand2_2_29/ZN
+ gf180mcu_fd_sc_mcu7t5v0__oai22_1_165/B2 vdd vss gf180mcu_fd_sc_mcu7t5v0__dffq_1_163/D
+ gf180mcu_fd_sc_mcu7t5v0__aoi21_4_2/ZN vdd vss gf180mcu_fd_sc_mcu7t5v0__oai22_1
Xgf180mcu_fd_sc_mcu7t5v0__oai221_1_4 gf180mcu_fd_sc_mcu7t5v0__nor2_1_97/ZN gf180mcu_fd_sc_mcu7t5v0__oai221_1_4/C
+ vdd vss gf180mcu_fd_sc_mcu7t5v0__aoi21_1_86/B gf180mcu_fd_sc_mcu7t5v0__nor2_1_94/A1
+ gf180mcu_fd_sc_mcu7t5v0__xor3_1_56/A2 gf180mcu_fd_sc_mcu7t5v0__oai221_1_4/B2 vdd
+ vss gf180mcu_fd_sc_mcu7t5v0__oai221_1
Xgf180mcu_fd_sc_mcu7t5v0__oai22_1_176 gf180mcu_fd_sc_mcu7t5v0__nand2_4_36/ZN gf180mcu_fd_sc_mcu7t5v0__nand2_2_31/ZN
+ gf180mcu_fd_sc_mcu7t5v0__oai22_1_176/B2 vdd vss gf180mcu_fd_sc_mcu7t5v0__dffq_1_184/D
+ gf180mcu_fd_sc_mcu7t5v0__aoi21_4_1/ZN vdd vss gf180mcu_fd_sc_mcu7t5v0__oai22_1
Xgf180mcu_fd_sc_mcu7t5v0__oai22_1_187 gf180mcu_fd_sc_mcu7t5v0__nand2_4_36/ZN gf180mcu_fd_sc_mcu7t5v0__nand2_2_31/ZN
+ gf180mcu_fd_sc_mcu7t5v0__oai22_1_187/B2 vdd vss gf180mcu_fd_sc_mcu7t5v0__dffq_1_274/D
+ gf180mcu_fd_sc_mcu7t5v0__aoi21_4_2/ZN vdd vss gf180mcu_fd_sc_mcu7t5v0__oai22_1
Xgf180mcu_fd_sc_mcu7t5v0__oai22_1_198 gf180mcu_fd_sc_mcu7t5v0__oai22_1_43/A2 gf180mcu_fd_sc_mcu7t5v0__oai22_1_43/B1
+ gf180mcu_fd_sc_mcu7t5v0__oai22_1_198/B2 vdd vss gf180mcu_fd_sc_mcu7t5v0__dffq_1_201/D
+ gf180mcu_fd_sc_mcu7t5v0__aoi21_4_4/ZN vdd vss gf180mcu_fd_sc_mcu7t5v0__oai22_1
Xgf180mcu_fd_sc_mcu7t5v0__xnor3_1_15 gf180mcu_fd_sc_mcu7t5v0__xor3_1_29/Z vdd vss
+ gf180mcu_fd_sc_mcu7t5v0__xnor3_1_15/ZN gf180mcu_fd_sc_mcu7t5v0__dffq_1_14/Q gf180mcu_fd_sc_mcu7t5v0__xnor3_1_15/A2
+ vdd vss gf180mcu_fd_sc_mcu7t5v0__xnor3_1
Xgf180mcu_fd_sc_mcu7t5v0__xnor3_1_26 gf180mcu_fd_sc_mcu7t5v0__xnor3_1_26/A3 vdd vss
+ gf180mcu_fd_sc_mcu7t5v0__nor3_2_6/A3 gf180mcu_fd_sc_mcu7t5v0__and2_1_89/Z gf180mcu_fd_sc_mcu7t5v0__xnor3_1_26/A2
+ vdd vss gf180mcu_fd_sc_mcu7t5v0__xnor3_1
Xgf180mcu_fd_sc_mcu7t5v0__xnor3_1_37 gf180mcu_fd_sc_mcu7t5v0__and2_1_127/Z vdd vss
+ gf180mcu_fd_sc_mcu7t5v0__xor3_1_118/A3 gf180mcu_fd_sc_mcu7t5v0__or2_1_45/A1 gf180mcu_fd_sc_mcu7t5v0__or2_1_45/A2
+ vdd vss gf180mcu_fd_sc_mcu7t5v0__xnor3_1
Xgf180mcu_fd_sc_mcu7t5v0__xnor3_1_48 gf180mcu_fd_sc_mcu7t5v0__mux2_1_14/Z vdd vss
+ gf180mcu_fd_sc_mcu7t5v0__xor3_1_149/A3 gf180mcu_fd_sc_mcu7t5v0__xnor3_1_48/A1 gf180mcu_fd_sc_mcu7t5v0__xor3_1_145/Z
+ vdd vss gf180mcu_fd_sc_mcu7t5v0__xnor3_1
Xgf180mcu_fd_sc_mcu7t5v0__nor2_1_30 vdd vss gf180mcu_fd_sc_mcu7t5v0__oai21_4_1/A2
+ gf180mcu_fd_sc_mcu7t5v0__dffq_4_4/Q gf180mcu_fd_sc_mcu7t5v0__mux4_4_6/I3 vdd vss
+ gf180mcu_fd_sc_mcu7t5v0__nor2_1
Xgf180mcu_fd_sc_mcu7t5v0__inv_8_0 vss gf180mcu_fd_sc_mcu7t5v0__inv_8_0/ZN gf180mcu_fd_sc_mcu7t5v0__inv_8_0/I
+ vdd vdd vss gf180mcu_fd_sc_mcu7t5v0__inv_8
Xgf180mcu_fd_sc_mcu7t5v0__nor2_1_41 vdd vss gf180mcu_fd_sc_mcu7t5v0__oai21_2_4/A2
+ gf180mcu_fd_sc_mcu7t5v0__dffq_4_4/Q gf180mcu_fd_sc_mcu7t5v0__dffq_2_79/Q vdd vss
+ gf180mcu_fd_sc_mcu7t5v0__nor2_1
Xgf180mcu_fd_sc_mcu7t5v0__nor2_1_52 vdd vss gf180mcu_fd_sc_mcu7t5v0__nor2_1_52/ZN
+ gf180mcu_fd_sc_mcu7t5v0__dffq_1_5/Q gf180mcu_fd_sc_mcu7t5v0__nor2_4_16/ZN vdd vss
+ gf180mcu_fd_sc_mcu7t5v0__nor2_1
Xgf180mcu_fd_sc_mcu7t5v0__nor2_1_63 vdd vss gf180mcu_fd_sc_mcu7t5v0__oai33_2_1/B3
+ gf180mcu_fd_sc_mcu7t5v0__xor3_1_28/A1 gf180mcu_fd_sc_mcu7t5v0__mux2_1_3/Z vdd vss
+ gf180mcu_fd_sc_mcu7t5v0__nor2_1
Xgf180mcu_fd_sc_mcu7t5v0__nor2_1_74 vdd vss gf180mcu_fd_sc_mcu7t5v0__xor2_1_66/A2
+ gf180mcu_fd_sc_mcu7t5v0__and2_1_14/Z gf180mcu_fd_sc_mcu7t5v0__nor4_2_2/ZN vdd vss
+ gf180mcu_fd_sc_mcu7t5v0__nor2_1
Xgf180mcu_fd_sc_mcu7t5v0__nor2_1_85 vdd vss gf180mcu_fd_sc_mcu7t5v0__oai21_4_4/A2
+ gf180mcu_fd_sc_mcu7t5v0__inv_3_0/I gf180mcu_fd_sc_mcu7t5v0__mux4_4_5/I1 vdd vss
+ gf180mcu_fd_sc_mcu7t5v0__nor2_1
Xgf180mcu_fd_sc_mcu7t5v0__nor2_1_96 vdd vss gf180mcu_fd_sc_mcu7t5v0__or3_1_7/A2 gf180mcu_fd_sc_mcu7t5v0__xor2_1_60/A1
+ gf180mcu_fd_sc_mcu7t5v0__xor2_1_56/Z vdd vss gf180mcu_fd_sc_mcu7t5v0__nor2_1
Xgf180mcu_fd_sc_mcu7t5v0__nor2_1_230 vdd vss gf180mcu_fd_sc_mcu7t5v0__or2_1_27/A1
+ gf180mcu_fd_sc_mcu7t5v0__xnor2_1_36/A1 gf180mcu_fd_sc_mcu7t5v0__or2_1_26/Z vdd vss
+ gf180mcu_fd_sc_mcu7t5v0__nor2_1
Xgf180mcu_fd_sc_mcu7t5v0__nor2_1_241 vdd vss gf180mcu_fd_sc_mcu7t5v0__xor2_1_108/A1
+ gf180mcu_fd_sc_mcu7t5v0__nor2_1_244/ZN gf180mcu_fd_sc_mcu7t5v0__nor2_1_248/ZN vdd
+ vss gf180mcu_fd_sc_mcu7t5v0__nor2_1
Xgf180mcu_fd_sc_mcu7t5v0__clkinv_2_6 vdd vss gf180mcu_fd_sc_mcu7t5v0__oai31_4_2/ZN
+ gf180mcu_fd_sc_mcu7t5v0__oai21_1_163/B vdd vss gf180mcu_fd_sc_mcu7t5v0__clkinv_2
Xgf180mcu_fd_sc_mcu7t5v0__nor2_1_252 vdd vss gf180mcu_fd_sc_mcu7t5v0__xor3_1_78/A3
+ gf180mcu_fd_sc_mcu7t5v0__nor2_1_252/A1 gf180mcu_fd_sc_mcu7t5v0__nor2_1_255/ZN vdd
+ vss gf180mcu_fd_sc_mcu7t5v0__nor2_1
Xgf180mcu_fd_sc_mcu7t5v0__nor2_1_263 vdd vss gf180mcu_fd_sc_mcu7t5v0__oai31_1_14/A3
+ gf180mcu_fd_sc_mcu7t5v0__nor2_1_264/ZN gf180mcu_fd_sc_mcu7t5v0__nor2_1_263/A2 vdd
+ vss gf180mcu_fd_sc_mcu7t5v0__nor2_1
Xgf180mcu_fd_sc_mcu7t5v0__nor2_1_274 vdd vss gf180mcu_fd_sc_mcu7t5v0__nor2_1_274/ZN
+ gf180mcu_fd_sc_mcu7t5v0__inv_2_13/I gf180mcu_fd_sc_mcu7t5v0__xor3_2_1/Z vdd vss
+ gf180mcu_fd_sc_mcu7t5v0__nor2_1
Xgf180mcu_fd_sc_mcu7t5v0__oai31_1_7 vdd gf180mcu_fd_sc_mcu7t5v0__xor2_1_82/A1 gf180mcu_fd_sc_mcu7t5v0__oai31_1_7/B
+ gf180mcu_fd_sc_mcu7t5v0__or2_1_18/A1 gf180mcu_fd_sc_mcu7t5v0__xor2_1_86/Z vss gf180mcu_fd_sc_mcu7t5v0__oai31_1_7/A3
+ vdd vss gf180mcu_fd_sc_mcu7t5v0__oai31_1
Xgf180mcu_fd_sc_mcu7t5v0__xor3_1_3 gf180mcu_fd_sc_mcu7t5v0__xor3_1_8/Z vdd vss gf180mcu_fd_sc_mcu7t5v0__xor3_1_3/Z
+ gf180mcu_fd_sc_mcu7t5v0__xor3_1_3/A1 gf180mcu_fd_sc_mcu7t5v0__xor3_1_3/A2 vdd vss
+ gf180mcu_fd_sc_mcu7t5v0__xor3_1
Xgf180mcu_fd_sc_mcu7t5v0__nor2_1_285 vdd vss gf180mcu_fd_sc_mcu7t5v0__xor3_1_156/A1
+ gf180mcu_fd_sc_mcu7t5v0__xor3_1_97/Z gf180mcu_fd_sc_mcu7t5v0__xor3_1_96/A3 vdd vss
+ gf180mcu_fd_sc_mcu7t5v0__nor2_1
Xgf180mcu_fd_sc_mcu7t5v0__nor2_1_296 vdd vss gf180mcu_fd_sc_mcu7t5v0__nor2_1_296/ZN
+ gf180mcu_fd_sc_mcu7t5v0__dffq_1_446/Q gf180mcu_fd_sc_mcu7t5v0__nor2_4_18/ZN vdd
+ vss gf180mcu_fd_sc_mcu7t5v0__nor2_1
Xgf180mcu_fd_sc_mcu7t5v0__nand2_1_17 vdd vss gf180mcu_fd_sc_mcu7t5v0__mux2_1_0/I0
+ gf180mcu_fd_sc_mcu7t5v0__inv_8_0/I gf180mcu_fd_sc_mcu7t5v0__nand3_1_1/A3 vdd vss
+ gf180mcu_fd_sc_mcu7t5v0__nand2_1
Xgf180mcu_fd_sc_mcu7t5v0__nand2_1_28 vdd vss gf180mcu_fd_sc_mcu7t5v0__nand3_1_4/A2
+ gf180mcu_fd_sc_mcu7t5v0__xor2_1_17/A1 gf180mcu_fd_sc_mcu7t5v0__xor2_1_18/Z vdd vss
+ gf180mcu_fd_sc_mcu7t5v0__nand2_1
Xgf180mcu_fd_sc_mcu7t5v0__nand2_1_39 vdd vss gf180mcu_fd_sc_mcu7t5v0__xor3_1_62/A2
+ gf180mcu_fd_sc_mcu7t5v0__inv_8_1/I gf180mcu_fd_sc_mcu7t5v0__and2_2_2/Z vdd vss gf180mcu_fd_sc_mcu7t5v0__nand2_1
Xgf180mcu_fd_sc_mcu7t5v0__oai21_1_301 vdd gf180mcu_fd_sc_mcu7t5v0__nor3_1_38/A3 gf180mcu_fd_sc_mcu7t5v0__or3_1_24/A2
+ gf180mcu_fd_sc_mcu7t5v0__oai21_1_301/ZN gf180mcu_fd_sc_mcu7t5v0__inv_8_2/ZN vss
+ vdd vss gf180mcu_fd_sc_mcu7t5v0__oai21_1
Xgf180mcu_fd_sc_mcu7t5v0__oai21_1_312 vdd gf180mcu_fd_sc_mcu7t5v0__oai21_1_312/B gf180mcu_fd_sc_mcu7t5v0__xor2_1_186/Z
+ gf180mcu_fd_sc_mcu7t5v0__oai21_1_312/ZN gf180mcu_fd_sc_mcu7t5v0__oai211_1_53/C vss
+ vdd vss gf180mcu_fd_sc_mcu7t5v0__oai21_1
Xgf180mcu_fd_sc_mcu7t5v0__oai21_1_323 vdd gf180mcu_fd_sc_mcu7t5v0__nor2_4_42/ZN gf180mcu_fd_sc_mcu7t5v0__and2_1_141/Z
+ gf180mcu_fd_sc_mcu7t5v0__oai21_1_323/ZN gf180mcu_fd_sc_mcu7t5v0__dffq_2_94/Q vss
+ vdd vss gf180mcu_fd_sc_mcu7t5v0__oai21_1
Xgf180mcu_fd_sc_mcu7t5v0__oai21_1_334 vdd gf180mcu_fd_sc_mcu7t5v0__buf_8_4/Z gf180mcu_fd_sc_mcu7t5v0__buf_20_0/I
+ gf180mcu_fd_sc_mcu7t5v0__aoi21_1_287/B gf180mcu_fd_sc_mcu7t5v0__dffq_2_26/Q vss
+ vdd vss gf180mcu_fd_sc_mcu7t5v0__oai21_1
Xgf180mcu_fd_sc_mcu7t5v0__nor2_4_7 vdd vss gf180mcu_fd_sc_mcu7t5v0__nor2_4_7/ZN gf180mcu_fd_sc_mcu7t5v0__nor2_4_7/A1
+ gf180mcu_fd_sc_mcu7t5v0__nor2_4_7/A2 vdd vss gf180mcu_fd_sc_mcu7t5v0__nor2_4
Xgf180mcu_fd_sc_mcu7t5v0__xnor2_1_5 vdd vss gf180mcu_fd_sc_mcu7t5v0__xnor2_1_5/ZN
+ gf180mcu_fd_sc_mcu7t5v0__xnor2_1_5/A1 gf180mcu_fd_sc_mcu7t5v0__xnor2_1_5/A2 vdd
+ vss gf180mcu_fd_sc_mcu7t5v0__xnor2_1
Xgf180mcu_fd_sc_mcu7t5v0__oai22_1_7 gf180mcu_fd_sc_mcu7t5v0__or4_1_0/A3 gf180mcu_fd_sc_mcu7t5v0__nor4_2_0/A4
+ gf180mcu_fd_sc_mcu7t5v0__nor3_2_5/A1 vdd vss gf180mcu_fd_sc_mcu7t5v0__oai22_1_7/ZN
+ gf180mcu_fd_sc_mcu7t5v0__or4_1_0/A2 vdd vss gf180mcu_fd_sc_mcu7t5v0__oai22_1
Xgf180mcu_fd_sc_mcu7t5v0__aoi22_1_10 gf180mcu_fd_sc_mcu7t5v0__aoi22_4_1/ZN gf180mcu_fd_sc_mcu7t5v0__inv_12_1/I
+ vdd vss gf180mcu_fd_sc_mcu7t5v0__or3_1_4/A2 gf180mcu_fd_sc_mcu7t5v0__inv_8_1/I gf180mcu_fd_sc_mcu7t5v0__nor4_2_2/A4
+ vdd vss gf180mcu_fd_sc_mcu7t5v0__aoi22_1
Xgf180mcu_fd_sc_mcu7t5v0__aoi22_1_21 gf180mcu_fd_sc_mcu7t5v0__nor2_4_11/ZN gf180mcu_fd_sc_mcu7t5v0__dffq_1_34/Q
+ vdd vss gf180mcu_fd_sc_mcu7t5v0__aoi22_1_21/ZN gf180mcu_fd_sc_mcu7t5v0__dffq_1_35/Q
+ gf180mcu_fd_sc_mcu7t5v0__nor2_4_10/ZN vdd vss gf180mcu_fd_sc_mcu7t5v0__aoi22_1
Xgf180mcu_fd_sc_mcu7t5v0__aoi22_1_32 gf180mcu_fd_sc_mcu7t5v0__nor2_4_9/ZN gf180mcu_fd_sc_mcu7t5v0__dffq_1_52/Q
+ vdd vss gf180mcu_fd_sc_mcu7t5v0__aoi22_1_32/ZN gf180mcu_fd_sc_mcu7t5v0__dffq_1_54/Q
+ gf180mcu_fd_sc_mcu7t5v0__nor2_4_8/ZN vdd vss gf180mcu_fd_sc_mcu7t5v0__aoi22_1
Xgf180mcu_fd_sc_mcu7t5v0__aoi22_1_43 gf180mcu_fd_sc_mcu7t5v0__nor2_4_9/ZN gf180mcu_fd_sc_mcu7t5v0__dffq_1_76/Q
+ vdd vss gf180mcu_fd_sc_mcu7t5v0__aoi22_1_43/ZN gf180mcu_fd_sc_mcu7t5v0__dffq_1_85/Q
+ gf180mcu_fd_sc_mcu7t5v0__nor2_4_8/ZN vdd vss gf180mcu_fd_sc_mcu7t5v0__aoi22_1
Xgf180mcu_fd_sc_mcu7t5v0__aoi22_1_54 gf180mcu_fd_sc_mcu7t5v0__nor2_4_11/ZN gf180mcu_fd_sc_mcu7t5v0__dffq_1_55/Q
+ vdd vss gf180mcu_fd_sc_mcu7t5v0__aoi22_1_54/ZN gf180mcu_fd_sc_mcu7t5v0__dffq_1_73/Q
+ gf180mcu_fd_sc_mcu7t5v0__nor2_4_10/ZN vdd vss gf180mcu_fd_sc_mcu7t5v0__aoi22_1
Xgf180mcu_fd_sc_mcu7t5v0__aoi22_1_65 gf180mcu_fd_sc_mcu7t5v0__nor2_4_11/ZN gf180mcu_fd_sc_mcu7t5v0__dffq_1_104/Q
+ vdd vss gf180mcu_fd_sc_mcu7t5v0__aoi22_1_65/ZN gf180mcu_fd_sc_mcu7t5v0__dffq_1_103/Q
+ gf180mcu_fd_sc_mcu7t5v0__nor2_4_10/ZN vdd vss gf180mcu_fd_sc_mcu7t5v0__aoi22_1
Xgf180mcu_fd_sc_mcu7t5v0__aoi22_1_76 gf180mcu_fd_sc_mcu7t5v0__nor2_4_9/ZN gf180mcu_fd_sc_mcu7t5v0__dffq_1_130/Q
+ vdd vss gf180mcu_fd_sc_mcu7t5v0__aoi22_1_76/ZN gf180mcu_fd_sc_mcu7t5v0__dffq_1_116/Q
+ gf180mcu_fd_sc_mcu7t5v0__nor2_4_8/ZN vdd vss gf180mcu_fd_sc_mcu7t5v0__aoi22_1
Xgf180mcu_fd_sc_mcu7t5v0__aoi22_1_87 gf180mcu_fd_sc_mcu7t5v0__nor2_4_9/ZN gf180mcu_fd_sc_mcu7t5v0__dffq_1_156/Q
+ vdd vss gf180mcu_fd_sc_mcu7t5v0__aoi22_1_87/ZN gf180mcu_fd_sc_mcu7t5v0__dffq_1_159/Q
+ gf180mcu_fd_sc_mcu7t5v0__nor2_4_8/ZN vdd vss gf180mcu_fd_sc_mcu7t5v0__aoi22_1
Xgf180mcu_fd_sc_mcu7t5v0__aoi22_1_98 gf180mcu_fd_sc_mcu7t5v0__nor2_4_11/ZN gf180mcu_fd_sc_mcu7t5v0__dffq_1_169/Q
+ vdd vss gf180mcu_fd_sc_mcu7t5v0__aoi22_1_98/ZN gf180mcu_fd_sc_mcu7t5v0__dffq_1_174/Q
+ gf180mcu_fd_sc_mcu7t5v0__nor2_4_10/ZN vdd vss gf180mcu_fd_sc_mcu7t5v0__aoi22_1
Xgf180mcu_fd_sc_mcu7t5v0__or3_1_3 gf180mcu_fd_sc_mcu7t5v0__or3_1_3/A3 vdd vss gf180mcu_fd_sc_mcu7t5v0__or3_1_3/Z
+ gf180mcu_fd_sc_mcu7t5v0__or3_1_3/A1 gf180mcu_fd_sc_mcu7t5v0__or3_1_3/A2 vdd vss
+ gf180mcu_fd_sc_mcu7t5v0__or3_1
Xgf180mcu_fd_sc_mcu7t5v0__xnor2_1_70 vdd vss gf180mcu_fd_sc_mcu7t5v0__xnor2_1_70/ZN
+ gf180mcu_fd_sc_mcu7t5v0__xnor2_1_70/A1 gf180mcu_fd_sc_mcu7t5v0__xor3_1_147/Z vdd
+ vss gf180mcu_fd_sc_mcu7t5v0__xnor2_1
Xgf180mcu_fd_sc_mcu7t5v0__xnor2_1_81 vdd vss gf180mcu_fd_sc_mcu7t5v0__xor2_1_218/A2
+ gf180mcu_fd_sc_mcu7t5v0__xnor2_1_83/ZN gf180mcu_fd_sc_mcu7t5v0__xnor2_1_82/ZN vdd
+ vss gf180mcu_fd_sc_mcu7t5v0__xnor2_1
Xgf180mcu_fd_sc_mcu7t5v0__inv_1_7 vss gf180mcu_fd_sc_mcu7t5v0__inv_1_7/ZN gf180mcu_fd_sc_mcu7t5v0__inv_1_7/I
+ vdd vdd vss gf180mcu_fd_sc_mcu7t5v0__inv_1
Xgf180mcu_fd_sc_mcu7t5v0__nand3_2_16 gf180mcu_fd_sc_mcu7t5v0__dffq_2_4/Q vdd vss gf180mcu_fd_sc_mcu7t5v0__oai21_4_14/B
+ gf180mcu_fd_sc_mcu7t5v0__or2_4_0/A1 gf180mcu_fd_sc_mcu7t5v0__or2_4_0/A2 vdd vss
+ gf180mcu_fd_sc_mcu7t5v0__nand3_2
Xgf180mcu_fd_sc_mcu7t5v0__nand3_2_27 gf180mcu_fd_sc_mcu7t5v0__inv_4_5/I vdd vss gf180mcu_fd_sc_mcu7t5v0__oai31_4_4/B
+ gf180mcu_fd_sc_mcu7t5v0__mux4_4_3/I3 gf180mcu_fd_sc_mcu7t5v0__or2_2_1/A1 vdd vss
+ gf180mcu_fd_sc_mcu7t5v0__nand3_2
Xgf180mcu_fd_sc_mcu7t5v0__mux4_4_2 gf180mcu_fd_sc_mcu7t5v0__mux4_4_2/I0 vss vdd gf180mcu_fd_sc_mcu7t5v0__mux4_4_2/I2
+ gf180mcu_fd_sc_mcu7t5v0__inv_1_15/I gf180mcu_fd_sc_mcu7t5v0__inv_1_6/I gf180mcu_fd_sc_mcu7t5v0__mux4_4_2/I3
+ gf180mcu_fd_sc_mcu7t5v0__or3_2_3/A2 gf180mcu_fd_sc_mcu7t5v0__mux4_4_2/Z vdd vss
+ gf180mcu_fd_sc_mcu7t5v0__mux4_4
Xgf180mcu_fd_sc_mcu7t5v0__aoi221_2_2 gf180mcu_fd_sc_mcu7t5v0__nor2_4_14/ZN gf180mcu_fd_sc_mcu7t5v0__dffq_1_229/Q
+ vdd vss gf180mcu_fd_sc_mcu7t5v0__aoi221_2_2/ZN gf180mcu_fd_sc_mcu7t5v0__dffq_1_246/Q
+ gf180mcu_fd_sc_mcu7t5v0__or2_1_34/A2 gf180mcu_fd_sc_mcu7t5v0__and2_1_43/Z vdd vss
+ gf180mcu_fd_sc_mcu7t5v0__aoi221_2
Xgf180mcu_fd_sc_mcu7t5v0__oai21_1_120 vdd gf180mcu_fd_sc_mcu7t5v0__buf_8_6/Z gf180mcu_fd_sc_mcu7t5v0__buf_20_0/I
+ gf180mcu_fd_sc_mcu7t5v0__aoi21_1_140/B gf180mcu_fd_sc_mcu7t5v0__dffq_1_310/Q vss
+ vdd vss gf180mcu_fd_sc_mcu7t5v0__oai21_1
Xgf180mcu_fd_sc_mcu7t5v0__nor2_2_4 vdd vss gf180mcu_fd_sc_mcu7t5v0__nor2_2_4/ZN gf180mcu_fd_sc_mcu7t5v0__or2_4_0/A1
+ gf180mcu_fd_sc_mcu7t5v0__or2_4_0/A2 vdd vss gf180mcu_fd_sc_mcu7t5v0__nor2_2
Xgf180mcu_fd_sc_mcu7t5v0__oai21_1_131 vdd gf180mcu_fd_sc_mcu7t5v0__buf_8_6/Z gf180mcu_fd_sc_mcu7t5v0__nor3_4_14/ZN
+ gf180mcu_fd_sc_mcu7t5v0__aoi21_1_113/B gf180mcu_fd_sc_mcu7t5v0__dffq_1_286/Q vss
+ vdd vss gf180mcu_fd_sc_mcu7t5v0__oai21_1
Xgf180mcu_fd_sc_mcu7t5v0__oai21_1_142 vdd gf180mcu_fd_sc_mcu7t5v0__buf_8_6/Z gf180mcu_fd_sc_mcu7t5v0__aoi22_4_8/ZN
+ gf180mcu_fd_sc_mcu7t5v0__aoi21_1_170/B gf180mcu_fd_sc_mcu7t5v0__dffq_1_381/Q vss
+ vdd vss gf180mcu_fd_sc_mcu7t5v0__oai21_1
Xgf180mcu_fd_sc_mcu7t5v0__oai21_1_153 vdd gf180mcu_fd_sc_mcu7t5v0__buf_8_8/Z gf180mcu_fd_sc_mcu7t5v0__nand2_4_40/ZN
+ gf180mcu_fd_sc_mcu7t5v0__aoi21_1_165/B gf180mcu_fd_sc_mcu7t5v0__dffq_1_344/Q vss
+ vdd vss gf180mcu_fd_sc_mcu7t5v0__oai21_1
Xgf180mcu_fd_sc_mcu7t5v0__oai21_1_164 vdd gf180mcu_fd_sc_mcu7t5v0__oai21_1_164/B gf180mcu_fd_sc_mcu7t5v0__aoi22_4_8/ZN
+ gf180mcu_fd_sc_mcu7t5v0__oai21_1_164/ZN gf180mcu_fd_sc_mcu7t5v0__dffq_1_367/Q vss
+ vdd vss gf180mcu_fd_sc_mcu7t5v0__oai21_1
Xgf180mcu_fd_sc_mcu7t5v0__oai21_1_175 vdd gf180mcu_fd_sc_mcu7t5v0__xor2_1_98/A2 gf180mcu_fd_sc_mcu7t5v0__nor2_1_215/A2
+ gf180mcu_fd_sc_mcu7t5v0__and2_1_82/A2 gf180mcu_fd_sc_mcu7t5v0__and2_1_81/Z vss vdd
+ vss gf180mcu_fd_sc_mcu7t5v0__oai21_1
Xgf180mcu_fd_sc_mcu7t5v0__oai21_1_186 vdd gf180mcu_fd_sc_mcu7t5v0__buf_8_7/Z gf180mcu_fd_sc_mcu7t5v0__nor3_4_15/ZN
+ gf180mcu_fd_sc_mcu7t5v0__aoi21_1_201/B gf180mcu_fd_sc_mcu7t5v0__nor4_2_4/A1 vss
+ vdd vss gf180mcu_fd_sc_mcu7t5v0__oai21_1
Xgf180mcu_fd_sc_mcu7t5v0__oai21_1_197 vdd gf180mcu_fd_sc_mcu7t5v0__buf_8_7/Z gf180mcu_fd_sc_mcu7t5v0__nor3_4_15/ZN
+ gf180mcu_fd_sc_mcu7t5v0__aoi21_1_203/B gf180mcu_fd_sc_mcu7t5v0__nor4_2_4/A3 vss
+ vdd vss gf180mcu_fd_sc_mcu7t5v0__oai21_1
Xgf180mcu_fd_sc_mcu7t5v0__clkinv_1_13 vdd vss gf180mcu_fd_sc_mcu7t5v0__clkinv_1_13/I
+ gf180mcu_fd_sc_mcu7t5v0__dffq_1_12/D vdd vss gf180mcu_fd_sc_mcu7t5v0__clkinv_1
Xgf180mcu_fd_sc_mcu7t5v0__nand2_2_60 vdd vss gf180mcu_fd_sc_mcu7t5v0__oai31_1_16/B
+ gf180mcu_fd_sc_mcu7t5v0__dffq_2_61/Q gf180mcu_fd_sc_mcu7t5v0__nor2_1_282/ZN vdd
+ vss gf180mcu_fd_sc_mcu7t5v0__nand2_2
Xgf180mcu_fd_sc_mcu7t5v0__nand2_2_71 vdd vss gf180mcu_fd_sc_mcu7t5v0__oai32_4_2/B1
+ gf180mcu_fd_sc_mcu7t5v0__aoi22_2_8/A2 gf180mcu_fd_sc_mcu7t5v0__inv_1_20/ZN vdd vss
+ gf180mcu_fd_sc_mcu7t5v0__nand2_2
Xgf180mcu_fd_sc_mcu7t5v0__clkinv_1_24 vdd vss gf180mcu_fd_sc_mcu7t5v0__dffq_1_31/Q
+ gf180mcu_fd_sc_mcu7t5v0__oai22_1_30/B2 vdd vss gf180mcu_fd_sc_mcu7t5v0__clkinv_1
Xgf180mcu_fd_sc_mcu7t5v0__clkinv_1_35 vdd vss gf180mcu_fd_sc_mcu7t5v0__dffq_1_26/Q
+ gf180mcu_fd_sc_mcu7t5v0__oai22_1_20/B2 vdd vss gf180mcu_fd_sc_mcu7t5v0__clkinv_1
Xgf180mcu_fd_sc_mcu7t5v0__clkinv_1_46 vdd vss gf180mcu_fd_sc_mcu7t5v0__dffq_1_41/Q
+ gf180mcu_fd_sc_mcu7t5v0__oai22_1_39/A1 vdd vss gf180mcu_fd_sc_mcu7t5v0__clkinv_1
Xgf180mcu_fd_sc_mcu7t5v0__clkinv_1_57 vdd vss gf180mcu_fd_sc_mcu7t5v0__dffq_1_44/Q
+ gf180mcu_fd_sc_mcu7t5v0__oai22_1_47/A1 vdd vss gf180mcu_fd_sc_mcu7t5v0__clkinv_1
Xgf180mcu_fd_sc_mcu7t5v0__xor2_1_230 vdd vss gf180mcu_fd_sc_mcu7t5v0__xor3_1_75/A3
+ gf180mcu_fd_sc_mcu7t5v0__xor2_1_230/A1 gf180mcu_fd_sc_mcu7t5v0__or2_1_46/A1 vdd
+ vss gf180mcu_fd_sc_mcu7t5v0__xor2_1
Xgf180mcu_fd_sc_mcu7t5v0__clkinv_1_68 vdd vss gf180mcu_fd_sc_mcu7t5v0__dffq_1_59/Q
+ gf180mcu_fd_sc_mcu7t5v0__oai22_1_52/B2 vdd vss gf180mcu_fd_sc_mcu7t5v0__clkinv_1
Xgf180mcu_fd_sc_mcu7t5v0__clkinv_1_79 vdd vss gf180mcu_fd_sc_mcu7t5v0__dffq_1_71/Q
+ gf180mcu_fd_sc_mcu7t5v0__oai22_1_64/B2 vdd vss gf180mcu_fd_sc_mcu7t5v0__clkinv_1
Xgf180mcu_fd_sc_mcu7t5v0__oai32_2_2 gf180mcu_fd_sc_mcu7t5v0__inv_1_21/I gf180mcu_fd_sc_mcu7t5v0__oai32_2_2/B1
+ gf180mcu_fd_sc_mcu7t5v0__oai32_2_2/B2 vdd vss gf180mcu_fd_sc_mcu7t5v0__oai32_2_2/ZN
+ gf180mcu_fd_sc_mcu7t5v0__mux4_4_9/S0 gf180mcu_fd_sc_mcu7t5v0__inv_1_16/I vdd vss
+ gf180mcu_fd_sc_mcu7t5v0__oai32_2
Xgf180mcu_fd_sc_mcu7t5v0__nand4_1_6 gf180mcu_fd_sc_mcu7t5v0__nand4_1_6/A3 gf180mcu_fd_sc_mcu7t5v0__nor3_1_44/A1
+ vdd vss gf180mcu_fd_sc_mcu7t5v0__or3_1_11/A2 gf180mcu_fd_sc_mcu7t5v0__nor4_4_3/A1
+ gf180mcu_fd_sc_mcu7t5v0__nand4_1_6/A2 vdd vss gf180mcu_fd_sc_mcu7t5v0__nand4_1
Xgf180mcu_fd_sc_mcu7t5v0__or3_1_19 gf180mcu_fd_sc_mcu7t5v0__or3_1_19/A3 vdd vss gf180mcu_fd_sc_mcu7t5v0__or3_1_19/Z
+ gf180mcu_fd_sc_mcu7t5v0__or3_1_19/A1 gf180mcu_fd_sc_mcu7t5v0__or3_1_19/A2 vdd vss
+ gf180mcu_fd_sc_mcu7t5v0__or3_1
Xgf180mcu_fd_sc_mcu7t5v0__dffq_4_10 gf180mcu_fd_sc_mcu7t5v0__dffq_4_10/D gf180mcu_fd_sc_mcu7t5v0__or3_2_3/A2
+ vdd vss gf180mcu_fd_sc_mcu7t5v0__dffq_4_9/CLK vdd vss gf180mcu_fd_sc_mcu7t5v0__dffq_4
Xgf180mcu_fd_sc_mcu7t5v0__dffq_4_21 gf180mcu_fd_sc_mcu7t5v0__dffq_4_21/D gf180mcu_fd_sc_mcu7t5v0__nor4_4_2/A3
+ vdd vss gf180mcu_fd_sc_mcu7t5v0__dffq_4_21/CLK vdd vss gf180mcu_fd_sc_mcu7t5v0__dffq_4
Xgf180mcu_fd_sc_mcu7t5v0__dffq_4_32 gf180mcu_fd_sc_mcu7t5v0__dffq_4_32/D gf180mcu_fd_sc_mcu7t5v0__dffq_4_32/Q
+ vdd vss gf180mcu_fd_sc_mcu7t5v0__dffq_4_44/CLK vdd vss gf180mcu_fd_sc_mcu7t5v0__dffq_4
Xgf180mcu_fd_sc_mcu7t5v0__nor3_4_19 gf180mcu_fd_sc_mcu7t5v0__oai31_4_5/A2 vdd vss
+ gf180mcu_fd_sc_mcu7t5v0__nor4_4_4/A1 gf180mcu_fd_sc_mcu7t5v0__inv_1_24/I gf180mcu_fd_sc_mcu7t5v0__inv_4_7/I
+ vdd vss gf180mcu_fd_sc_mcu7t5v0__nor3_4
Xgf180mcu_fd_sc_mcu7t5v0__dffq_4_43 gf180mcu_fd_sc_mcu7t5v0__dffq_4_43/D gf180mcu_fd_sc_mcu7t5v0__inv_8_0/I
+ vdd vss gf180mcu_fd_sc_mcu7t5v0__dffq_4_9/CLK vdd vss gf180mcu_fd_sc_mcu7t5v0__dffq_4
Xgf180mcu_fd_sc_mcu7t5v0__and2_2_3 vdd vss gf180mcu_fd_sc_mcu7t5v0__and2_2_3/Z gf180mcu_fd_sc_mcu7t5v0__and2_2_3/A1
+ gf180mcu_fd_sc_mcu7t5v0__and2_2_3/A2 vdd vss gf180mcu_fd_sc_mcu7t5v0__and2_2
Xgf180mcu_fd_sc_mcu7t5v0__nand2_1_307 vdd vss gf180mcu_fd_sc_mcu7t5v0__xor2_1_88/A2
+ gf180mcu_fd_sc_mcu7t5v0__or4_1_0/A1 gf180mcu_fd_sc_mcu7t5v0__mux4_4_2/Z vdd vss
+ gf180mcu_fd_sc_mcu7t5v0__nand2_1
Xgf180mcu_fd_sc_mcu7t5v0__nand2_1_318 vdd vss gf180mcu_fd_sc_mcu7t5v0__nor2_1_156/A2
+ gf180mcu_fd_sc_mcu7t5v0__dffq_1_303/Q gf180mcu_fd_sc_mcu7t5v0__nor4_4_2/A3 vdd vss
+ gf180mcu_fd_sc_mcu7t5v0__nand2_1
Xgf180mcu_fd_sc_mcu7t5v0__nand2_1_329 vdd vss gf180mcu_fd_sc_mcu7t5v0__xnor2_1_32/A2
+ gf180mcu_fd_sc_mcu7t5v0__inv_12_1/I gf180mcu_fd_sc_mcu7t5v0__or3_1_12/A2 vdd vss
+ gf180mcu_fd_sc_mcu7t5v0__nand2_1
Xgf180mcu_fd_sc_mcu7t5v0__dffq_1_404 vdd gf180mcu_fd_sc_mcu7t5v0__nor4_2_4/A4 gf180mcu_fd_sc_mcu7t5v0__dffq_4_21/CLK
+ vss gf180mcu_fd_sc_mcu7t5v0__dffq_1_404/D vdd vss gf180mcu_fd_sc_mcu7t5v0__dffq_1
Xgf180mcu_fd_sc_mcu7t5v0__dffq_1_415 vdd gf180mcu_fd_sc_mcu7t5v0__or3_2_4/A3 gf180mcu_fd_sc_mcu7t5v0__dffq_4_21/CLK
+ vss gf180mcu_fd_sc_mcu7t5v0__and2_1_74/Z vdd vss gf180mcu_fd_sc_mcu7t5v0__dffq_1
Xgf180mcu_fd_sc_mcu7t5v0__dffq_1_426 vdd gf180mcu_fd_sc_mcu7t5v0__dffq_1_426/Q gf180mcu_fd_sc_mcu7t5v0__dffq_4_44/CLK
+ vss gf180mcu_fd_sc_mcu7t5v0__dffq_1_426/D vdd vss gf180mcu_fd_sc_mcu7t5v0__dffq_1
Xgf180mcu_fd_sc_mcu7t5v0__dffq_1_437 vdd gf180mcu_fd_sc_mcu7t5v0__inv_1_22/I gf180mcu_fd_sc_mcu7t5v0__dffq_4_44/CLK
+ vss gf180mcu_fd_sc_mcu7t5v0__dffq_1_437/D vdd vss gf180mcu_fd_sc_mcu7t5v0__dffq_1
Xgf180mcu_fd_sc_mcu7t5v0__dffq_1_448 vdd gf180mcu_fd_sc_mcu7t5v0__dffq_1_448/Q gf180mcu_fd_sc_mcu7t5v0__dffq_2_58/CLK
+ vss gf180mcu_fd_sc_mcu7t5v0__dffq_1_448/D vdd vss gf180mcu_fd_sc_mcu7t5v0__dffq_1
Xgf180mcu_fd_sc_mcu7t5v0__or2_1_30 vdd vss gf180mcu_fd_sc_mcu7t5v0__or2_1_30/Z gf180mcu_fd_sc_mcu7t5v0__or3_1_16/A2
+ gf180mcu_fd_sc_mcu7t5v0__or2_1_30/A2 vdd vss gf180mcu_fd_sc_mcu7t5v0__or2_1
Xgf180mcu_fd_sc_mcu7t5v0__or2_1_41 vdd vss gf180mcu_fd_sc_mcu7t5v0__or2_1_41/Z gf180mcu_fd_sc_mcu7t5v0__or2_1_41/A1
+ gf180mcu_fd_sc_mcu7t5v0__xor2_1_84/Z vdd vss gf180mcu_fd_sc_mcu7t5v0__or2_1
Xgf180mcu_fd_sc_mcu7t5v0__aoi22_1_180 gf180mcu_fd_sc_mcu7t5v0__mux4_4_19/Z gf180mcu_fd_sc_mcu7t5v0__inv_12_1/I
+ vdd vss gf180mcu_fd_sc_mcu7t5v0__aoi21_2_24/B gf180mcu_fd_sc_mcu7t5v0__inv_8_1/I
+ gf180mcu_fd_sc_mcu7t5v0__mux4_4_6/Z vdd vss gf180mcu_fd_sc_mcu7t5v0__aoi22_1
Xgf180mcu_fd_sc_mcu7t5v0__or2_1_52 vdd vss gf180mcu_fd_sc_mcu7t5v0__or2_1_52/Z gf180mcu_fd_sc_mcu7t5v0__or2_1_52/A1
+ gf180mcu_fd_sc_mcu7t5v0__or2_1_52/A2 vdd vss gf180mcu_fd_sc_mcu7t5v0__or2_1
Xgf180mcu_fd_sc_mcu7t5v0__nor2_4_30 vdd vss gf180mcu_fd_sc_mcu7t5v0__nor2_4_30/ZN
+ gf180mcu_fd_sc_mcu7t5v0__nor2_4_30/A1 gf180mcu_fd_sc_mcu7t5v0__nor2_4_30/A2 vdd
+ vss gf180mcu_fd_sc_mcu7t5v0__nor2_4
Xgf180mcu_fd_sc_mcu7t5v0__nor2_4_41 vdd vss gf180mcu_fd_sc_mcu7t5v0__or4_1_3/A1 gf180mcu_fd_sc_mcu7t5v0__nor2_4_41/A1
+ gf180mcu_fd_sc_mcu7t5v0__nor3_4_22/A3 vdd vss gf180mcu_fd_sc_mcu7t5v0__nor2_4
Xgf180mcu_fd_sc_mcu7t5v0__clkinv_1_309 vdd vss gf180mcu_fd_sc_mcu7t5v0__dffq_1_345/Q
+ gf180mcu_fd_sc_mcu7t5v0__aoi21_1_165/A1 vdd vss gf180mcu_fd_sc_mcu7t5v0__clkinv_1
Xgf180mcu_fd_sc_mcu7t5v0__nand2_4_7 vdd vss gf180mcu_fd_sc_mcu7t5v0__nand2_4_7/ZN
+ gf180mcu_fd_sc_mcu7t5v0__nor3_4_8/ZN gf180mcu_fd_sc_mcu7t5v0__nor2_4_7/ZN vdd vss
+ gf180mcu_fd_sc_mcu7t5v0__nand2_4
Xgf180mcu_fd_sc_mcu7t5v0__nand2_4_17 vdd vss gf180mcu_fd_sc_mcu7t5v0__nand2_4_17/ZN
+ gf180mcu_fd_sc_mcu7t5v0__nor3_4_7/ZN gf180mcu_fd_sc_mcu7t5v0__nor2_4_13/ZN vdd vss
+ gf180mcu_fd_sc_mcu7t5v0__nand2_4
Xgf180mcu_fd_sc_mcu7t5v0__nand2_4_28 vdd vss gf180mcu_fd_sc_mcu7t5v0__nand2_4_28/ZN
+ gf180mcu_fd_sc_mcu7t5v0__nor3_4_7/ZN gf180mcu_fd_sc_mcu7t5v0__nor2_4_4/ZN vdd vss
+ gf180mcu_fd_sc_mcu7t5v0__nand2_4
Xgf180mcu_fd_sc_mcu7t5v0__nand2_4_39 vdd vss gf180mcu_fd_sc_mcu7t5v0__nor2_4_27/A2
+ gf180mcu_fd_sc_mcu7t5v0__and2_1_47/Z gf180mcu_fd_sc_mcu7t5v0__and3_2_1/Z vdd vss
+ gf180mcu_fd_sc_mcu7t5v0__nand2_4
Xgf180mcu_fd_sc_mcu7t5v0__aoi21_1_360 gf180mcu_fd_sc_mcu7t5v0__or2_1_52/A1 vdd vss
+ gf180mcu_fd_sc_mcu7t5v0__xor3_1_150/A2 gf180mcu_fd_sc_mcu7t5v0__dffq_4_37/Q gf180mcu_fd_sc_mcu7t5v0__xor2_1_203/Z
+ vdd vss gf180mcu_fd_sc_mcu7t5v0__aoi21_1
Xgf180mcu_fd_sc_mcu7t5v0__aoi21_1_371 gf180mcu_fd_sc_mcu7t5v0__or2_1_23/A1 vdd vss
+ gf180mcu_fd_sc_mcu7t5v0__dffq_2_104/D gf180mcu_fd_sc_mcu7t5v0__nand2_1_546/ZN gf180mcu_fd_sc_mcu7t5v0__nand2_1_535/ZN
+ vdd vss gf180mcu_fd_sc_mcu7t5v0__aoi21_1
Xgf180mcu_fd_sc_mcu7t5v0__aoi21_1_382 gf180mcu_fd_sc_mcu7t5v0__aoi21_1_382/B vdd vss
+ gf180mcu_fd_sc_mcu7t5v0__xor3_1_177/A1 gf180mcu_fd_sc_mcu7t5v0__inv_4_6/I gf180mcu_fd_sc_mcu7t5v0__xor2_1_224/Z
+ vdd vss gf180mcu_fd_sc_mcu7t5v0__aoi21_1
Xgf180mcu_fd_sc_mcu7t5v0__aoi22_4_10 gf180mcu_fd_sc_mcu7t5v0__nor2_4_40/ZN gf180mcu_fd_sc_mcu7t5v0__oai21_2_13/ZN
+ gf180mcu_fd_sc_mcu7t5v0__aoi22_4_10/B2 vdd vss gf180mcu_fd_sc_mcu7t5v0__xor3_1_162/A2
+ gf180mcu_fd_sc_mcu7t5v0__inv_2_11/ZN vdd vss gf180mcu_fd_sc_mcu7t5v0__aoi22_4
Xgf180mcu_fd_sc_mcu7t5v0__nand2_1_104 vdd vss gf180mcu_fd_sc_mcu7t5v0__or2_1_9/A1
+ gf180mcu_fd_sc_mcu7t5v0__inv_8_0/I gf180mcu_fd_sc_mcu7t5v0__or4_1_1/A3 vdd vss gf180mcu_fd_sc_mcu7t5v0__nand2_1
Xgf180mcu_fd_sc_mcu7t5v0__nand2_1_115 vdd vss gf180mcu_fd_sc_mcu7t5v0__xor3_1_40/A2
+ gf180mcu_fd_sc_mcu7t5v0__inv_8_2/I gf180mcu_fd_sc_mcu7t5v0__or4_1_1/A4 vdd vss gf180mcu_fd_sc_mcu7t5v0__nand2_1
Xgf180mcu_fd_sc_mcu7t5v0__nand2_1_126 vdd vss gf180mcu_fd_sc_mcu7t5v0__oai211_1_8/C
+ gf180mcu_fd_sc_mcu7t5v0__nor2_2_6/ZN gf180mcu_fd_sc_mcu7t5v0__xor2_1_39/Z vdd vss
+ gf180mcu_fd_sc_mcu7t5v0__nand2_1
Xgf180mcu_fd_sc_mcu7t5v0__nand2_1_137 vdd vss gf180mcu_fd_sc_mcu7t5v0__xor2_1_43/A1
+ gf180mcu_fd_sc_mcu7t5v0__or2_1_7/A1 gf180mcu_fd_sc_mcu7t5v0__and2_4_0/Z vdd vss
+ gf180mcu_fd_sc_mcu7t5v0__nand2_1
Xgf180mcu_fd_sc_mcu7t5v0__nand2_1_148 vdd vss gf180mcu_fd_sc_mcu7t5v0__aoi22_4_0/A1
+ gf180mcu_fd_sc_mcu7t5v0__mux4_4_3/I2 gf180mcu_fd_sc_mcu7t5v0__and2_2_6/Z vdd vss
+ gf180mcu_fd_sc_mcu7t5v0__nand2_1
Xgf180mcu_fd_sc_mcu7t5v0__nand2_1_159 vdd vss gf180mcu_fd_sc_mcu7t5v0__xnor3_1_15/A2
+ gf180mcu_fd_sc_mcu7t5v0__nand2_1_195/ZN gf180mcu_fd_sc_mcu7t5v0__and2_1_29/A2 vdd
+ vss gf180mcu_fd_sc_mcu7t5v0__nand2_1
Xgf180mcu_fd_sc_mcu7t5v0__xor3_1_70 gf180mcu_fd_sc_mcu7t5v0__xor2_2_2/Z vdd vss gf180mcu_fd_sc_mcu7t5v0__xor3_1_70/Z
+ gf180mcu_fd_sc_mcu7t5v0__mux4_4_1/I0 gf180mcu_fd_sc_mcu7t5v0__xor3_1_70/A2 vdd vss
+ gf180mcu_fd_sc_mcu7t5v0__xor3_1
Xgf180mcu_fd_sc_mcu7t5v0__xor3_1_81 gf180mcu_fd_sc_mcu7t5v0__xor3_1_84/Z vdd vss gf180mcu_fd_sc_mcu7t5v0__xor3_1_81/Z
+ gf180mcu_fd_sc_mcu7t5v0__xor3_1_81/A1 gf180mcu_fd_sc_mcu7t5v0__xor3_1_81/A2 vdd
+ vss gf180mcu_fd_sc_mcu7t5v0__xor3_1
Xgf180mcu_fd_sc_mcu7t5v0__xor3_1_92 gf180mcu_fd_sc_mcu7t5v0__xor2_2_3/Z vdd vss gf180mcu_fd_sc_mcu7t5v0__xor3_1_92/Z
+ gf180mcu_fd_sc_mcu7t5v0__xor3_1_92/A1 gf180mcu_fd_sc_mcu7t5v0__xor3_1_92/A2 vdd
+ vss gf180mcu_fd_sc_mcu7t5v0__xor3_1
Xgf180mcu_fd_sc_mcu7t5v0__dffq_1_201 vdd gf180mcu_fd_sc_mcu7t5v0__dffq_1_201/Q gf180mcu_fd_sc_mcu7t5v0__dffq_4_8/CLK
+ vss gf180mcu_fd_sc_mcu7t5v0__dffq_1_201/D vdd vss gf180mcu_fd_sc_mcu7t5v0__dffq_1
Xgf180mcu_fd_sc_mcu7t5v0__dffq_1_212 vdd gf180mcu_fd_sc_mcu7t5v0__dffq_1_212/Q gf180mcu_fd_sc_mcu7t5v0__dffq_4_8/CLK
+ vss gf180mcu_fd_sc_mcu7t5v0__dffq_1_212/D vdd vss gf180mcu_fd_sc_mcu7t5v0__dffq_1
Xgf180mcu_fd_sc_mcu7t5v0__dffq_1_223 vdd gf180mcu_fd_sc_mcu7t5v0__dffq_1_223/Q gf180mcu_fd_sc_mcu7t5v0__dffq_2_26/CLK
+ vss gf180mcu_fd_sc_mcu7t5v0__dffq_1_223/D vdd vss gf180mcu_fd_sc_mcu7t5v0__dffq_1
Xgf180mcu_fd_sc_mcu7t5v0__nor2_1_401 vdd vss gf180mcu_fd_sc_mcu7t5v0__nor2_1_401/ZN
+ gf180mcu_fd_sc_mcu7t5v0__dffq_1_428/Q gf180mcu_fd_sc_mcu7t5v0__and3_2_2/Z vdd vss
+ gf180mcu_fd_sc_mcu7t5v0__nor2_1
Xgf180mcu_fd_sc_mcu7t5v0__nor2_1_412 vdd vss gf180mcu_fd_sc_mcu7t5v0__aoi21_4_14/B
+ gf180mcu_fd_sc_mcu7t5v0__or2_4_1/A2 gf180mcu_fd_sc_mcu7t5v0__or3_4_0/Z vdd vss gf180mcu_fd_sc_mcu7t5v0__nor2_1
Xgf180mcu_fd_sc_mcu7t5v0__dffq_1_234 vdd gf180mcu_fd_sc_mcu7t5v0__dffq_1_234/Q gf180mcu_fd_sc_mcu7t5v0__dffq_2_26/CLK
+ vss gf180mcu_fd_sc_mcu7t5v0__dffq_1_234/D vdd vss gf180mcu_fd_sc_mcu7t5v0__dffq_1
Xgf180mcu_fd_sc_mcu7t5v0__dffq_1_245 vdd gf180mcu_fd_sc_mcu7t5v0__dffq_1_245/Q gf180mcu_fd_sc_mcu7t5v0__dffq_2_58/CLK
+ vss gf180mcu_fd_sc_mcu7t5v0__dffq_1_245/D vdd vss gf180mcu_fd_sc_mcu7t5v0__dffq_1
Xgf180mcu_fd_sc_mcu7t5v0__dffq_1_256 vdd gf180mcu_fd_sc_mcu7t5v0__dffq_1_256/Q gf180mcu_fd_sc_mcu7t5v0__dffq_4_8/CLK
+ vss gf180mcu_fd_sc_mcu7t5v0__dffq_1_256/D vdd vss gf180mcu_fd_sc_mcu7t5v0__dffq_1
Xgf180mcu_fd_sc_mcu7t5v0__dffq_1_267 vdd gf180mcu_fd_sc_mcu7t5v0__dffq_1_267/Q gf180mcu_fd_sc_mcu7t5v0__dffq_1_99/CLK
+ vss gf180mcu_fd_sc_mcu7t5v0__dffq_1_267/D vdd vss gf180mcu_fd_sc_mcu7t5v0__dffq_1
Xgf180mcu_fd_sc_mcu7t5v0__dffq_1_278 vdd gf180mcu_fd_sc_mcu7t5v0__dffq_1_278/Q gf180mcu_fd_sc_mcu7t5v0__dffq_4_9/CLK
+ vss gf180mcu_fd_sc_mcu7t5v0__dffq_1_278/D vdd vss gf180mcu_fd_sc_mcu7t5v0__dffq_1
Xgf180mcu_fd_sc_mcu7t5v0__dffq_1_289 vdd gf180mcu_fd_sc_mcu7t5v0__dffq_1_289/Q gf180mcu_fd_sc_mcu7t5v0__dffq_2_58/CLK
+ vss gf180mcu_fd_sc_mcu7t5v0__dffq_1_289/D vdd vss gf180mcu_fd_sc_mcu7t5v0__dffq_1
Xgf180mcu_fd_sc_mcu7t5v0__nand2_1_660 vdd vss gf180mcu_fd_sc_mcu7t5v0__oai22_1_283/A1
+ gf180mcu_fd_sc_mcu7t5v0__inv_8_1/I gf180mcu_fd_sc_mcu7t5v0__and4_1_3/A3 vdd vss
+ gf180mcu_fd_sc_mcu7t5v0__nand2_1
Xgf180mcu_fd_sc_mcu7t5v0__nand2_1_671 vdd vss gf180mcu_fd_sc_mcu7t5v0__nand2_1_671/ZN
+ gf180mcu_fd_sc_mcu7t5v0__nor2_2_55/A2 gf180mcu_fd_sc_mcu7t5v0__nand2_1_671/A2 vdd
+ vss gf180mcu_fd_sc_mcu7t5v0__nand2_1
Xgf180mcu_fd_sc_mcu7t5v0__nand2_1_682 vdd vss gf180mcu_fd_sc_mcu7t5v0__xnor3_1_45/A2
+ gf180mcu_fd_sc_mcu7t5v0__inv_8_2/I gf180mcu_fd_sc_mcu7t5v0__xor3_1_162/A2 vdd vss
+ gf180mcu_fd_sc_mcu7t5v0__nand2_1
Xgf180mcu_fd_sc_mcu7t5v0__nand2_1_693 vdd vss gf180mcu_fd_sc_mcu7t5v0__xnor3_1_46/A3
+ gf180mcu_fd_sc_mcu7t5v0__inv_8_1/I gf180mcu_fd_sc_mcu7t5v0__and3_1_23/A2 vdd vss
+ gf180mcu_fd_sc_mcu7t5v0__nand2_1
Xgf180mcu_fd_sc_mcu7t5v0__dffq_1_11 vdd gf180mcu_fd_sc_mcu7t5v0__inv_2_2/I gf180mcu_fd_sc_mcu7t5v0__dffq_4_6/CLK
+ vss gf180mcu_fd_sc_mcu7t5v0__dffq_1_11/D vdd vss gf180mcu_fd_sc_mcu7t5v0__dffq_1
Xgf180mcu_fd_sc_mcu7t5v0__dffq_1_22 vdd gf180mcu_fd_sc_mcu7t5v0__dffq_1_22/Q gf180mcu_fd_sc_mcu7t5v0__dffq_1_99/CLK
+ vss gf180mcu_fd_sc_mcu7t5v0__dffq_1_22/D vdd vss gf180mcu_fd_sc_mcu7t5v0__dffq_1
Xgf180mcu_fd_sc_mcu7t5v0__dffq_1_33 vdd gf180mcu_fd_sc_mcu7t5v0__dffq_1_33/Q gf180mcu_fd_sc_mcu7t5v0__dffq_1_99/CLK
+ vss gf180mcu_fd_sc_mcu7t5v0__dffq_1_33/D vdd vss gf180mcu_fd_sc_mcu7t5v0__dffq_1
Xgf180mcu_fd_sc_mcu7t5v0__clkinv_1_106 vdd vss gf180mcu_fd_sc_mcu7t5v0__dffq_1_86/Q
+ gf180mcu_fd_sc_mcu7t5v0__oai22_1_88/B2 vdd vss gf180mcu_fd_sc_mcu7t5v0__clkinv_1
Xgf180mcu_fd_sc_mcu7t5v0__dffq_1_44 vdd gf180mcu_fd_sc_mcu7t5v0__dffq_1_44/Q gf180mcu_fd_sc_mcu7t5v0__dffq_4_8/CLK
+ vss gf180mcu_fd_sc_mcu7t5v0__dffq_1_44/D vdd vss gf180mcu_fd_sc_mcu7t5v0__dffq_1
Xgf180mcu_fd_sc_mcu7t5v0__clkinv_1_117 vdd vss gf180mcu_fd_sc_mcu7t5v0__dffq_1_177/Q
+ gf180mcu_fd_sc_mcu7t5v0__oai22_1_192/B2 vdd vss gf180mcu_fd_sc_mcu7t5v0__clkinv_1
Xgf180mcu_fd_sc_mcu7t5v0__clkinv_1_128 vdd vss gf180mcu_fd_sc_mcu7t5v0__dffq_1_108/Q
+ gf180mcu_fd_sc_mcu7t5v0__oai22_1_119/B2 vdd vss gf180mcu_fd_sc_mcu7t5v0__clkinv_1
Xgf180mcu_fd_sc_mcu7t5v0__dffq_1_55 vdd gf180mcu_fd_sc_mcu7t5v0__dffq_1_55/Q gf180mcu_fd_sc_mcu7t5v0__dffq_1_99/CLK
+ vss gf180mcu_fd_sc_mcu7t5v0__dffq_1_55/D vdd vss gf180mcu_fd_sc_mcu7t5v0__dffq_1
Xgf180mcu_fd_sc_mcu7t5v0__clkinv_1_139 vdd vss gf180mcu_fd_sc_mcu7t5v0__dffq_1_133/Q
+ gf180mcu_fd_sc_mcu7t5v0__oai22_1_142/B2 vdd vss gf180mcu_fd_sc_mcu7t5v0__clkinv_1
Xgf180mcu_fd_sc_mcu7t5v0__dffq_1_66 vdd gf180mcu_fd_sc_mcu7t5v0__dffq_1_66/Q gf180mcu_fd_sc_mcu7t5v0__dffq_1_95/CLK
+ vss gf180mcu_fd_sc_mcu7t5v0__dffq_1_66/D vdd vss gf180mcu_fd_sc_mcu7t5v0__dffq_1
Xgf180mcu_fd_sc_mcu7t5v0__dffq_1_77 vdd gf180mcu_fd_sc_mcu7t5v0__dffq_1_77/Q gf180mcu_fd_sc_mcu7t5v0__dffq_1_99/CLK
+ vss gf180mcu_fd_sc_mcu7t5v0__dffq_1_77/D vdd vss gf180mcu_fd_sc_mcu7t5v0__dffq_1
Xgf180mcu_fd_sc_mcu7t5v0__dffq_1_88 vdd gf180mcu_fd_sc_mcu7t5v0__dffq_1_88/Q gf180mcu_fd_sc_mcu7t5v0__dffq_1_99/CLK
+ vss gf180mcu_fd_sc_mcu7t5v0__dffq_1_88/D vdd vss gf180mcu_fd_sc_mcu7t5v0__dffq_1
Xgf180mcu_fd_sc_mcu7t5v0__dffq_1_99 vdd gf180mcu_fd_sc_mcu7t5v0__dffq_1_99/Q gf180mcu_fd_sc_mcu7t5v0__dffq_1_99/CLK
+ vss gf180mcu_fd_sc_mcu7t5v0__dffq_1_99/D vdd vss gf180mcu_fd_sc_mcu7t5v0__dffq_1
Xgf180mcu_fd_sc_mcu7t5v0__nand2_2_4 vdd vss gf180mcu_fd_sc_mcu7t5v0__mux2_1_6/S gf180mcu_fd_sc_mcu7t5v0__inv_8_1/I
+ gf180mcu_fd_sc_mcu7t5v0__or4_1_1/A2 vdd vss gf180mcu_fd_sc_mcu7t5v0__nand2_2
Xgf180mcu_fd_sc_mcu7t5v0__aoi211_1_8 gf180mcu_fd_sc_mcu7t5v0__nor2_1_44/ZN gf180mcu_fd_sc_mcu7t5v0__or2_1_23/A1
+ vdd vss gf180mcu_fd_sc_mcu7t5v0__dffq_1_2/D gf180mcu_fd_sc_mcu7t5v0__nor2_1_144/A1
+ gf180mcu_fd_sc_mcu7t5v0__nor2_4_15/ZN vdd vss gf180mcu_fd_sc_mcu7t5v0__aoi211_1
Xgf180mcu_fd_sc_mcu7t5v0__dffq_2_8 gf180mcu_fd_sc_mcu7t5v0__dffq_2_8/D vdd vss gf180mcu_fd_sc_mcu7t5v0__dffq_4_6/CLK
+ gf180mcu_fd_sc_mcu7t5v0__dffq_2_8/Q vdd vss gf180mcu_fd_sc_mcu7t5v0__dffq_2
Xgf180mcu_fd_sc_mcu7t5v0__aoi21_1_190 gf180mcu_fd_sc_mcu7t5v0__inv_8_1/I vdd vss gf180mcu_fd_sc_mcu7t5v0__oai21_1_177/A2
+ gf180mcu_fd_sc_mcu7t5v0__or3_1_12/Z gf180mcu_fd_sc_mcu7t5v0__nand3_1_62/A3 vdd vss
+ gf180mcu_fd_sc_mcu7t5v0__aoi21_1
Xgf180mcu_fd_sc_mcu7t5v0__aoi22_1_5 gf180mcu_fd_sc_mcu7t5v0__or2_1_4/Z gf180mcu_fd_sc_mcu7t5v0__aoi22_1_5/B2
+ vdd vss gf180mcu_fd_sc_mcu7t5v0__nor2_1_27/A2 gf180mcu_fd_sc_mcu7t5v0__dffq_2_9/Q
+ gf180mcu_fd_sc_mcu7t5v0__or2_4_4/Z vdd vss gf180mcu_fd_sc_mcu7t5v0__aoi22_1
Xgf180mcu_fd_sc_mcu7t5v0__buf_8_1 gf180mcu_fd_sc_mcu7t5v0__buf_8_1/Z rst_n vdd vss
+ vdd vss gf180mcu_fd_sc_mcu7t5v0__buf_8
Xgf180mcu_fd_sc_mcu7t5v0__oai22_1_100 gf180mcu_fd_sc_mcu7t5v0__oai22_1_99/A2 gf180mcu_fd_sc_mcu7t5v0__oai22_1_99/B1
+ gf180mcu_fd_sc_mcu7t5v0__oai22_1_100/B2 vdd vss gf180mcu_fd_sc_mcu7t5v0__dffq_1_112/D
+ gf180mcu_fd_sc_mcu7t5v0__aoi21_4_3/ZN vdd vss gf180mcu_fd_sc_mcu7t5v0__oai22_1
Xgf180mcu_fd_sc_mcu7t5v0__oai22_1_111 gf180mcu_fd_sc_mcu7t5v0__nand2_4_15/ZN gf180mcu_fd_sc_mcu7t5v0__nand2_2_21/ZN
+ gf180mcu_fd_sc_mcu7t5v0__oai22_1_111/B2 vdd vss gf180mcu_fd_sc_mcu7t5v0__dffq_1_104/D
+ gf180mcu_fd_sc_mcu7t5v0__aoi21_4_1/ZN vdd vss gf180mcu_fd_sc_mcu7t5v0__oai22_1
Xgf180mcu_fd_sc_mcu7t5v0__oai22_1_122 gf180mcu_fd_sc_mcu7t5v0__nand2_4_17/ZN gf180mcu_fd_sc_mcu7t5v0__nand2_2_23/ZN
+ gf180mcu_fd_sc_mcu7t5v0__oai22_1_122/B2 vdd vss gf180mcu_fd_sc_mcu7t5v0__dffq_1_270/D
+ gf180mcu_fd_sc_mcu7t5v0__aoi21_4_5/ZN vdd vss gf180mcu_fd_sc_mcu7t5v0__oai22_1
Xgf180mcu_fd_sc_mcu7t5v0__oai22_1_133 gf180mcu_fd_sc_mcu7t5v0__nand2_4_18/ZN gf180mcu_fd_sc_mcu7t5v0__nand2_2_25/ZN
+ gf180mcu_fd_sc_mcu7t5v0__oai22_1_133/B2 vdd vss gf180mcu_fd_sc_mcu7t5v0__dffq_1_126/D
+ gf180mcu_fd_sc_mcu7t5v0__oai22_1_98/A1 vdd vss gf180mcu_fd_sc_mcu7t5v0__oai22_1
Xgf180mcu_fd_sc_mcu7t5v0__oai22_1_144 gf180mcu_fd_sc_mcu7t5v0__nand2_4_20/ZN gf180mcu_fd_sc_mcu7t5v0__nand2_2_27/ZN
+ gf180mcu_fd_sc_mcu7t5v0__oai22_1_144/B2 vdd vss gf180mcu_fd_sc_mcu7t5v0__dffq_1_140/D
+ gf180mcu_fd_sc_mcu7t5v0__aoi21_4_4/ZN vdd vss gf180mcu_fd_sc_mcu7t5v0__oai22_1
Xgf180mcu_fd_sc_mcu7t5v0__oai22_1_155 gf180mcu_fd_sc_mcu7t5v0__nand2_4_20/ZN gf180mcu_fd_sc_mcu7t5v0__nand2_2_27/ZN
+ gf180mcu_fd_sc_mcu7t5v0__oai22_1_155/B2 vdd vss gf180mcu_fd_sc_mcu7t5v0__dffq_1_151/D
+ gf180mcu_fd_sc_mcu7t5v0__oai21_4_9/ZN vdd vss gf180mcu_fd_sc_mcu7t5v0__oai22_1
Xgf180mcu_fd_sc_mcu7t5v0__oai22_1_166 gf180mcu_fd_sc_mcu7t5v0__nand2_4_23/ZN gf180mcu_fd_sc_mcu7t5v0__nand2_2_30/ZN
+ gf180mcu_fd_sc_mcu7t5v0__oai22_1_166/B2 vdd vss gf180mcu_fd_sc_mcu7t5v0__dffq_1_162/D
+ gf180mcu_fd_sc_mcu7t5v0__aoi21_4_2/ZN vdd vss gf180mcu_fd_sc_mcu7t5v0__oai22_1
Xgf180mcu_fd_sc_mcu7t5v0__oai22_1_177 gf180mcu_fd_sc_mcu7t5v0__nand2_4_36/ZN gf180mcu_fd_sc_mcu7t5v0__nand2_2_31/ZN
+ gf180mcu_fd_sc_mcu7t5v0__oai22_1_177/B2 vdd vss gf180mcu_fd_sc_mcu7t5v0__dffq_1_185/D
+ gf180mcu_fd_sc_mcu7t5v0__oai22_1_88/A1 vdd vss gf180mcu_fd_sc_mcu7t5v0__oai22_1
Xgf180mcu_fd_sc_mcu7t5v0__oai221_1_5 gf180mcu_fd_sc_mcu7t5v0__nor2_1_34/A2 gf180mcu_fd_sc_mcu7t5v0__oai221_1_5/C
+ vdd vss gf180mcu_fd_sc_mcu7t5v0__oai221_1_5/ZN gf180mcu_fd_sc_mcu7t5v0__and2_1_36/Z
+ gf180mcu_fd_sc_mcu7t5v0__oai221_1_5/A2 gf180mcu_fd_sc_mcu7t5v0__oai221_1_5/B2 vdd
+ vss gf180mcu_fd_sc_mcu7t5v0__oai221_1
Xgf180mcu_fd_sc_mcu7t5v0__oai22_1_188 gf180mcu_fd_sc_mcu7t5v0__nand2_4_23/ZN gf180mcu_fd_sc_mcu7t5v0__nand2_2_30/ZN
+ gf180mcu_fd_sc_mcu7t5v0__oai22_1_188/B2 vdd vss gf180mcu_fd_sc_mcu7t5v0__dffq_1_169/D
+ gf180mcu_fd_sc_mcu7t5v0__aoi21_4_3/ZN vdd vss gf180mcu_fd_sc_mcu7t5v0__oai22_1
Xgf180mcu_fd_sc_mcu7t5v0__oai22_1_199 gf180mcu_fd_sc_mcu7t5v0__oai22_1_43/A2 gf180mcu_fd_sc_mcu7t5v0__oai22_1_43/B1
+ gf180mcu_fd_sc_mcu7t5v0__oai22_1_199/B2 vdd vss gf180mcu_fd_sc_mcu7t5v0__dffq_1_195/D
+ gf180mcu_fd_sc_mcu7t5v0__aoi21_4_2/ZN vdd vss gf180mcu_fd_sc_mcu7t5v0__oai22_1
Xgf180mcu_fd_sc_mcu7t5v0__xnor3_1_16 gf180mcu_fd_sc_mcu7t5v0__xor3_1_1/A3 vdd vss
+ gf180mcu_fd_sc_mcu7t5v0__oai32_1_1/B1 gf180mcu_fd_sc_mcu7t5v0__xor3_1_1/A1 gf180mcu_fd_sc_mcu7t5v0__xor3_1_47/Z
+ vdd vss gf180mcu_fd_sc_mcu7t5v0__xnor3_1
Xgf180mcu_fd_sc_mcu7t5v0__xnor3_1_27 gf180mcu_fd_sc_mcu7t5v0__xnor3_1_27/A3 vdd vss
+ gf180mcu_fd_sc_mcu7t5v0__xor3_1_84/A1 gf180mcu_fd_sc_mcu7t5v0__xnor3_1_27/A1 gf180mcu_fd_sc_mcu7t5v0__xor2_1_114/Z
+ vdd vss gf180mcu_fd_sc_mcu7t5v0__xnor3_1
Xgf180mcu_fd_sc_mcu7t5v0__xnor3_1_38 gf180mcu_fd_sc_mcu7t5v0__xnor3_1_38/A3 vdd vss
+ gf180mcu_fd_sc_mcu7t5v0__xor3_1_178/A3 gf180mcu_fd_sc_mcu7t5v0__or2_1_46/A2 gf180mcu_fd_sc_mcu7t5v0__and2_1_128/Z
+ vdd vss gf180mcu_fd_sc_mcu7t5v0__xnor3_1
Xgf180mcu_fd_sc_mcu7t5v0__xnor3_1_49 gf180mcu_fd_sc_mcu7t5v0__xnor3_1_49/A3 vdd vss
+ gf180mcu_fd_sc_mcu7t5v0__xnor3_1_49/ZN gf180mcu_fd_sc_mcu7t5v0__dffq_2_80/Q gf180mcu_fd_sc_mcu7t5v0__xnor3_1_49/A2
+ vdd vss gf180mcu_fd_sc_mcu7t5v0__xnor3_1
Xgf180mcu_fd_sc_mcu7t5v0__nor2_1_20 vdd vss gf180mcu_fd_sc_mcu7t5v0__nor2_1_55/A2
+ gf180mcu_fd_sc_mcu7t5v0__or3_2_2/A1 gf180mcu_fd_sc_mcu7t5v0__and2_1_8/Z vdd vss
+ gf180mcu_fd_sc_mcu7t5v0__nor2_1
Xgf180mcu_fd_sc_mcu7t5v0__nor2_1_31 vdd vss gf180mcu_fd_sc_mcu7t5v0__oai21_2_2/A2
+ gf180mcu_fd_sc_mcu7t5v0__dffq_4_4/Q gf180mcu_fd_sc_mcu7t5v0__mux4_4_9/I3 vdd vss
+ gf180mcu_fd_sc_mcu7t5v0__nor2_1
Xgf180mcu_fd_sc_mcu7t5v0__inv_8_1 vss gf180mcu_fd_sc_mcu7t5v0__or4_1_0/A2 gf180mcu_fd_sc_mcu7t5v0__inv_8_1/I
+ vdd vdd vss gf180mcu_fd_sc_mcu7t5v0__inv_8
Xgf180mcu_fd_sc_mcu7t5v0__nor2_1_42 vdd vss gf180mcu_fd_sc_mcu7t5v0__oai21_2_3/A2
+ gf180mcu_fd_sc_mcu7t5v0__dffq_4_4/Q gf180mcu_fd_sc_mcu7t5v0__dffq_2_65/Q vdd vss
+ gf180mcu_fd_sc_mcu7t5v0__nor2_1
Xgf180mcu_fd_sc_mcu7t5v0__nor2_1_53 vdd vss gf180mcu_fd_sc_mcu7t5v0__nor2_1_53/ZN
+ gf180mcu_fd_sc_mcu7t5v0__dffq_1_10/Q gf180mcu_fd_sc_mcu7t5v0__nor2_4_15/ZN vdd vss
+ gf180mcu_fd_sc_mcu7t5v0__nor2_1
Xgf180mcu_fd_sc_mcu7t5v0__nor2_1_64 vdd vss gf180mcu_fd_sc_mcu7t5v0__nor2_1_64/ZN
+ gf180mcu_fd_sc_mcu7t5v0__or2_1_11/Z gf180mcu_fd_sc_mcu7t5v0__xor3_1_31/Z vdd vss
+ gf180mcu_fd_sc_mcu7t5v0__nor2_1
Xgf180mcu_fd_sc_mcu7t5v0__nor2_1_75 vdd vss gf180mcu_fd_sc_mcu7t5v0__nor2_1_75/ZN
+ gf180mcu_fd_sc_mcu7t5v0__inv_4_6/I gf180mcu_fd_sc_mcu7t5v0__xor2_1_64/Z vdd vss
+ gf180mcu_fd_sc_mcu7t5v0__nor2_1
Xgf180mcu_fd_sc_mcu7t5v0__nor2_1_86 vdd vss gf180mcu_fd_sc_mcu7t5v0__nor2_1_86/ZN
+ gf180mcu_fd_sc_mcu7t5v0__inv_8_0/I gf180mcu_fd_sc_mcu7t5v0__xor2_1_49/Z vdd vss
+ gf180mcu_fd_sc_mcu7t5v0__nor2_1
Xgf180mcu_fd_sc_mcu7t5v0__nor2_1_97 vdd vss gf180mcu_fd_sc_mcu7t5v0__nor2_1_97/ZN
+ gf180mcu_fd_sc_mcu7t5v0__or4_1_0/A1 gf180mcu_fd_sc_mcu7t5v0__or4_1_1/A4 vdd vss
+ gf180mcu_fd_sc_mcu7t5v0__nor2_1
Xgf180mcu_fd_sc_mcu7t5v0__nor2_1_220 vdd vss gf180mcu_fd_sc_mcu7t5v0__xor2_1_107/A1
+ gf180mcu_fd_sc_mcu7t5v0__xor3_1_72/A3 gf180mcu_fd_sc_mcu7t5v0__xnor3_1_22/A2 vdd
+ vss gf180mcu_fd_sc_mcu7t5v0__nor2_1
Xgf180mcu_fd_sc_mcu7t5v0__nor2_1_231 vdd vss gf180mcu_fd_sc_mcu7t5v0__xor3_1_75/A2
+ gf180mcu_fd_sc_mcu7t5v0__or3_1_24/A1 gf180mcu_fd_sc_mcu7t5v0__inv_1_13/I vdd vss
+ gf180mcu_fd_sc_mcu7t5v0__nor2_1
Xgf180mcu_fd_sc_mcu7t5v0__nor2_1_242 vdd vss gf180mcu_fd_sc_mcu7t5v0__aoi21_2_7/B
+ gf180mcu_fd_sc_mcu7t5v0__xor2_1_109/A1 gf180mcu_fd_sc_mcu7t5v0__xor2_1_109/A2 vdd
+ vss gf180mcu_fd_sc_mcu7t5v0__nor2_1
Xgf180mcu_fd_sc_mcu7t5v0__nor2_1_253 vdd vss gf180mcu_fd_sc_mcu7t5v0__nor2_1_253/ZN
+ gf180mcu_fd_sc_mcu7t5v0__nor2_1_253/A1 gf180mcu_fd_sc_mcu7t5v0__xor3_1_79/A3 vdd
+ vss gf180mcu_fd_sc_mcu7t5v0__nor2_1
Xgf180mcu_fd_sc_mcu7t5v0__clkinv_2_7 vdd vss gf180mcu_fd_sc_mcu7t5v0__clkinv_2_7/I
+ gf180mcu_fd_sc_mcu7t5v0__oai31_1_9/A3 vdd vss gf180mcu_fd_sc_mcu7t5v0__clkinv_2
Xgf180mcu_fd_sc_mcu7t5v0__nor2_1_264 vdd vss gf180mcu_fd_sc_mcu7t5v0__nor2_1_264/ZN
+ gf180mcu_fd_sc_mcu7t5v0__or2_1_7/A1 gf180mcu_fd_sc_mcu7t5v0__nor2_2_39/ZN vdd vss
+ gf180mcu_fd_sc_mcu7t5v0__nor2_1
Xgf180mcu_fd_sc_mcu7t5v0__xor3_1_4 gf180mcu_fd_sc_mcu7t5v0__xor3_1_4/A3 vdd vss gf180mcu_fd_sc_mcu7t5v0__xor3_1_4/Z
+ gf180mcu_fd_sc_mcu7t5v0__xor3_1_4/A1 gf180mcu_fd_sc_mcu7t5v0__xor3_1_4/A2 vdd vss
+ gf180mcu_fd_sc_mcu7t5v0__xor3_1
Xgf180mcu_fd_sc_mcu7t5v0__nor2_1_275 vdd vss gf180mcu_fd_sc_mcu7t5v0__nor2_1_275/ZN
+ gf180mcu_fd_sc_mcu7t5v0__mux4_4_7/I1 gf180mcu_fd_sc_mcu7t5v0__xor2_2_4/Z vdd vss
+ gf180mcu_fd_sc_mcu7t5v0__nor2_1
Xgf180mcu_fd_sc_mcu7t5v0__oai31_1_8 vdd gf180mcu_fd_sc_mcu7t5v0__oai31_1_8/ZN gf180mcu_fd_sc_mcu7t5v0__or3_1_29/Z
+ gf180mcu_fd_sc_mcu7t5v0__mux2_1_10/S gf180mcu_fd_sc_mcu7t5v0__oai31_1_8/A2 vss gf180mcu_fd_sc_mcu7t5v0__or3_1_29/A3
+ vdd vss gf180mcu_fd_sc_mcu7t5v0__oai31_1
Xgf180mcu_fd_sc_mcu7t5v0__nor2_1_286 vdd vss gf180mcu_fd_sc_mcu7t5v0__xor3_1_92/A2
+ gf180mcu_fd_sc_mcu7t5v0__nor2_1_383/ZN gf180mcu_fd_sc_mcu7t5v0__and2_1_110/Z vdd
+ vss gf180mcu_fd_sc_mcu7t5v0__nor2_1
Xgf180mcu_fd_sc_mcu7t5v0__nor2_1_297 vdd vss gf180mcu_fd_sc_mcu7t5v0__nor2_1_297/ZN
+ gf180mcu_fd_sc_mcu7t5v0__dffq_1_416/Q gf180mcu_fd_sc_mcu7t5v0__nor2_4_18/ZN vdd
+ vss gf180mcu_fd_sc_mcu7t5v0__nor2_1
Xgf180mcu_fd_sc_mcu7t5v0__nand2_1_490 vdd vss gf180mcu_fd_sc_mcu7t5v0__oai21_1_227/A2
+ gf180mcu_fd_sc_mcu7t5v0__dffq_4_37/Q gf180mcu_fd_sc_mcu7t5v0__xnor2_1_47/A1 vdd
+ vss gf180mcu_fd_sc_mcu7t5v0__nand2_1
Xgf180mcu_fd_sc_mcu7t5v0__nand2_1_18 vdd vss gf180mcu_fd_sc_mcu7t5v0__nor2_1_21/A1
+ gf180mcu_fd_sc_mcu7t5v0__or3_2_2/A1 gf180mcu_fd_sc_mcu7t5v0__and2_1_8/Z vdd vss
+ gf180mcu_fd_sc_mcu7t5v0__nand2_1
Xgf180mcu_fd_sc_mcu7t5v0__nand2_1_29 vdd vss gf180mcu_fd_sc_mcu7t5v0__xor2_1_19/A1
+ gf180mcu_fd_sc_mcu7t5v0__dffq_4_37/Q gf180mcu_fd_sc_mcu7t5v0__and2_4_1/Z vdd vss
+ gf180mcu_fd_sc_mcu7t5v0__nand2_1
Xgf180mcu_fd_sc_mcu7t5v0__oai21_1_302 vdd gf180mcu_fd_sc_mcu7t5v0__oai21_1_302/B gf180mcu_fd_sc_mcu7t5v0__xor2_1_178/Z
+ gf180mcu_fd_sc_mcu7t5v0__xor3_1_135/A1 gf180mcu_fd_sc_mcu7t5v0__xor3_1_137/A1 vss
+ vdd vss gf180mcu_fd_sc_mcu7t5v0__oai21_1
Xgf180mcu_fd_sc_mcu7t5v0__oai21_1_313 vdd gf180mcu_fd_sc_mcu7t5v0__oai21_1_313/B gf180mcu_fd_sc_mcu7t5v0__nor2_1_384/ZN
+ gf180mcu_fd_sc_mcu7t5v0__xor2_1_184/A1 gf180mcu_fd_sc_mcu7t5v0__xor3_1_143/A2 vss
+ vdd vss gf180mcu_fd_sc_mcu7t5v0__oai21_1
Xgf180mcu_fd_sc_mcu7t5v0__oai21_1_324 vdd gf180mcu_fd_sc_mcu7t5v0__oai21_1_324/B gf180mcu_fd_sc_mcu7t5v0__or3_1_26/A3
+ gf180mcu_fd_sc_mcu7t5v0__xnor2_1_70/A1 gf180mcu_fd_sc_mcu7t5v0__or3_1_26/A1 vss
+ vdd vss gf180mcu_fd_sc_mcu7t5v0__oai21_1
Xgf180mcu_fd_sc_mcu7t5v0__nor2_4_8 vdd vss gf180mcu_fd_sc_mcu7t5v0__nor2_4_8/ZN gf180mcu_fd_sc_mcu7t5v0__inv_3_1/ZN
+ gf180mcu_fd_sc_mcu7t5v0__inv_3_2/ZN vdd vss gf180mcu_fd_sc_mcu7t5v0__nor2_4
Xgf180mcu_fd_sc_mcu7t5v0__oai21_1_335 vdd gf180mcu_fd_sc_mcu7t5v0__buf_12_0/Z gf180mcu_fd_sc_mcu7t5v0__buf_20_0/Z
+ gf180mcu_fd_sc_mcu7t5v0__aoi21_1_268/B gf180mcu_fd_sc_mcu7t5v0__dffq_1_447/Q vss
+ vdd vss gf180mcu_fd_sc_mcu7t5v0__oai21_1
Xgf180mcu_fd_sc_mcu7t5v0__xnor2_1_6 vdd vss gf180mcu_fd_sc_mcu7t5v0__or2_1_8/A2 gf180mcu_fd_sc_mcu7t5v0__mux4_4_4/Z
+ gf180mcu_fd_sc_mcu7t5v0__xnor2_1_6/A2 vdd vss gf180mcu_fd_sc_mcu7t5v0__xnor2_1
Xgf180mcu_fd_sc_mcu7t5v0__oai22_1_8 gf180mcu_fd_sc_mcu7t5v0__oai22_1_8/A2 gf180mcu_fd_sc_mcu7t5v0__oai22_1_8/B1
+ gf180mcu_fd_sc_mcu7t5v0__nor3_4_3/ZN vdd vss gf180mcu_fd_sc_mcu7t5v0__oai22_1_8/ZN
+ gf180mcu_fd_sc_mcu7t5v0__inv_4_6/I vdd vss gf180mcu_fd_sc_mcu7t5v0__oai22_1
Xgf180mcu_fd_sc_mcu7t5v0__aoi22_1_11 gf180mcu_fd_sc_mcu7t5v0__or4_1_1/A2 gf180mcu_fd_sc_mcu7t5v0__inv_8_0/I
+ vdd vss gf180mcu_fd_sc_mcu7t5v0__oai22_2_0/B2 gf180mcu_fd_sc_mcu7t5v0__or4_1_0/A1
+ gf180mcu_fd_sc_mcu7t5v0__or4_1_1/A1 vdd vss gf180mcu_fd_sc_mcu7t5v0__aoi22_1
Xgf180mcu_fd_sc_mcu7t5v0__aoi22_1_22 gf180mcu_fd_sc_mcu7t5v0__nor2_4_11/ZN gf180mcu_fd_sc_mcu7t5v0__dffq_1_32/Q
+ vdd vss gf180mcu_fd_sc_mcu7t5v0__aoi22_1_22/ZN gf180mcu_fd_sc_mcu7t5v0__dffq_1_28/Q
+ gf180mcu_fd_sc_mcu7t5v0__nor2_4_10/ZN vdd vss gf180mcu_fd_sc_mcu7t5v0__aoi22_1
Xgf180mcu_fd_sc_mcu7t5v0__aoi22_1_33 gf180mcu_fd_sc_mcu7t5v0__nor2_4_9/ZN gf180mcu_fd_sc_mcu7t5v0__dffq_1_29/Q
+ vdd vss gf180mcu_fd_sc_mcu7t5v0__aoi22_1_33/ZN gf180mcu_fd_sc_mcu7t5v0__dffq_1_44/Q
+ gf180mcu_fd_sc_mcu7t5v0__nor2_4_8/ZN vdd vss gf180mcu_fd_sc_mcu7t5v0__aoi22_1
Xgf180mcu_fd_sc_mcu7t5v0__aoi22_1_44 gf180mcu_fd_sc_mcu7t5v0__nor2_4_9/ZN gf180mcu_fd_sc_mcu7t5v0__dffq_1_90/Q
+ vdd vss gf180mcu_fd_sc_mcu7t5v0__aoi22_1_44/ZN gf180mcu_fd_sc_mcu7t5v0__dffq_1_94/Q
+ gf180mcu_fd_sc_mcu7t5v0__nor2_4_8/ZN vdd vss gf180mcu_fd_sc_mcu7t5v0__aoi22_1
Xgf180mcu_fd_sc_mcu7t5v0__aoi22_1_55 gf180mcu_fd_sc_mcu7t5v0__nor2_4_9/ZN gf180mcu_fd_sc_mcu7t5v0__dffq_1_91/Q
+ vdd vss gf180mcu_fd_sc_mcu7t5v0__aoi22_1_55/ZN gf180mcu_fd_sc_mcu7t5v0__dffq_1_95/Q
+ gf180mcu_fd_sc_mcu7t5v0__nor2_4_8/ZN vdd vss gf180mcu_fd_sc_mcu7t5v0__aoi22_1
Xgf180mcu_fd_sc_mcu7t5v0__aoi22_1_66 gf180mcu_fd_sc_mcu7t5v0__nor2_4_11/ZN gf180mcu_fd_sc_mcu7t5v0__dffq_1_101/Q
+ vdd vss gf180mcu_fd_sc_mcu7t5v0__aoi22_1_66/ZN gf180mcu_fd_sc_mcu7t5v0__dffq_1_105/Q
+ gf180mcu_fd_sc_mcu7t5v0__nor2_4_10/ZN vdd vss gf180mcu_fd_sc_mcu7t5v0__aoi22_1
Xgf180mcu_fd_sc_mcu7t5v0__aoi22_1_77 gf180mcu_fd_sc_mcu7t5v0__nor2_4_9/ZN gf180mcu_fd_sc_mcu7t5v0__dffq_1_134/Q
+ vdd vss gf180mcu_fd_sc_mcu7t5v0__aoi22_1_77/ZN gf180mcu_fd_sc_mcu7t5v0__dffq_1_137/Q
+ gf180mcu_fd_sc_mcu7t5v0__nor2_4_8/ZN vdd vss gf180mcu_fd_sc_mcu7t5v0__aoi22_1
Xgf180mcu_fd_sc_mcu7t5v0__aoi22_1_88 gf180mcu_fd_sc_mcu7t5v0__nor2_4_11/ZN gf180mcu_fd_sc_mcu7t5v0__dffq_1_155/Q
+ vdd vss gf180mcu_fd_sc_mcu7t5v0__aoi22_1_88/ZN gf180mcu_fd_sc_mcu7t5v0__dffq_1_183/Q
+ gf180mcu_fd_sc_mcu7t5v0__nor2_4_10/ZN vdd vss gf180mcu_fd_sc_mcu7t5v0__aoi22_1
Xgf180mcu_fd_sc_mcu7t5v0__aoi22_1_99 gf180mcu_fd_sc_mcu7t5v0__nor2_4_9/ZN gf180mcu_fd_sc_mcu7t5v0__dffq_1_167/Q
+ vdd vss gf180mcu_fd_sc_mcu7t5v0__aoi22_1_99/ZN gf180mcu_fd_sc_mcu7t5v0__dffq_1_273/Q
+ gf180mcu_fd_sc_mcu7t5v0__nor2_4_8/ZN vdd vss gf180mcu_fd_sc_mcu7t5v0__aoi22_1
Xgf180mcu_fd_sc_mcu7t5v0__or3_1_4 gf180mcu_fd_sc_mcu7t5v0__or3_1_4/A3 vdd vss gf180mcu_fd_sc_mcu7t5v0__or3_1_4/Z
+ gf180mcu_fd_sc_mcu7t5v0__or3_1_4/A1 gf180mcu_fd_sc_mcu7t5v0__or3_1_4/A2 vdd vss
+ gf180mcu_fd_sc_mcu7t5v0__or3_1
Xgf180mcu_fd_sc_mcu7t5v0__xnor2_1_60 vdd vss gf180mcu_fd_sc_mcu7t5v0__xnor2_1_61/A2
+ gf180mcu_fd_sc_mcu7t5v0__oai32_1_9/B2 gf180mcu_fd_sc_mcu7t5v0__xor3_1_136/Z vdd
+ vss gf180mcu_fd_sc_mcu7t5v0__xnor2_1
Xgf180mcu_fd_sc_mcu7t5v0__xnor2_1_71 vdd vss gf180mcu_fd_sc_mcu7t5v0__xor3_1_150/A3
+ gf180mcu_fd_sc_mcu7t5v0__oai31_4_5/ZN gf180mcu_fd_sc_mcu7t5v0__xnor2_1_71/A2 vdd
+ vss gf180mcu_fd_sc_mcu7t5v0__xnor2_1
Xgf180mcu_fd_sc_mcu7t5v0__xnor2_1_82 vdd vss gf180mcu_fd_sc_mcu7t5v0__xnor2_1_82/ZN
+ gf180mcu_fd_sc_mcu7t5v0__xnor2_1_82/A1 gf180mcu_fd_sc_mcu7t5v0__xnor2_1_82/A2 vdd
+ vss gf180mcu_fd_sc_mcu7t5v0__xnor2_1
Xgf180mcu_fd_sc_mcu7t5v0__inv_1_8 vss gf180mcu_fd_sc_mcu7t5v0__inv_1_8/ZN gf180mcu_fd_sc_mcu7t5v0__inv_1_8/I
+ vdd vdd vss gf180mcu_fd_sc_mcu7t5v0__inv_1
Xgf180mcu_fd_sc_mcu7t5v0__nand3_2_17 gf180mcu_fd_sc_mcu7t5v0__inv_4_1/ZN vdd vss gf180mcu_fd_sc_mcu7t5v0__nand3_2_17/ZN
+ gf180mcu_fd_sc_mcu7t5v0__dffq_1_13/Q gf180mcu_fd_sc_mcu7t5v0__inv_3_0/I vdd vss
+ gf180mcu_fd_sc_mcu7t5v0__nand3_2
Xgf180mcu_fd_sc_mcu7t5v0__nand3_2_28 gf180mcu_fd_sc_mcu7t5v0__mux4_2_1/I2 vdd vss
+ gf180mcu_fd_sc_mcu7t5v0__nand3_2_28/ZN gf180mcu_fd_sc_mcu7t5v0__inv_4_7/I gf180mcu_fd_sc_mcu7t5v0__dffq_4_35/Q
+ vdd vss gf180mcu_fd_sc_mcu7t5v0__nand3_2
Xgf180mcu_fd_sc_mcu7t5v0__mux4_4_3 gf180mcu_fd_sc_mcu7t5v0__mux4_4_3/I0 vss vdd gf180mcu_fd_sc_mcu7t5v0__mux4_4_3/I2
+ gf180mcu_fd_sc_mcu7t5v0__inv_1_2/I gf180mcu_fd_sc_mcu7t5v0__inv_1_6/I gf180mcu_fd_sc_mcu7t5v0__mux4_4_3/I3
+ gf180mcu_fd_sc_mcu7t5v0__or3_2_3/A2 gf180mcu_fd_sc_mcu7t5v0__mux4_4_3/Z vdd vss
+ gf180mcu_fd_sc_mcu7t5v0__mux4_4
Xgf180mcu_fd_sc_mcu7t5v0__aoi221_2_3 gf180mcu_fd_sc_mcu7t5v0__nor2_4_14/ZN gf180mcu_fd_sc_mcu7t5v0__dffq_1_284/Q
+ vdd vss gf180mcu_fd_sc_mcu7t5v0__aoi221_2_3/ZN gf180mcu_fd_sc_mcu7t5v0__dffq_1_313/Q
+ gf180mcu_fd_sc_mcu7t5v0__or2_1_34/A2 gf180mcu_fd_sc_mcu7t5v0__and2_1_44/Z vdd vss
+ gf180mcu_fd_sc_mcu7t5v0__aoi221_2
Xgf180mcu_fd_sc_mcu7t5v0__oai21_1_110 vdd gf180mcu_fd_sc_mcu7t5v0__buf_8_7/Z gf180mcu_fd_sc_mcu7t5v0__dffq_1_303/Q
+ gf180mcu_fd_sc_mcu7t5v0__aoi21_1_132/B gf180mcu_fd_sc_mcu7t5v0__dffq_4_20/Q vss
+ vdd vss gf180mcu_fd_sc_mcu7t5v0__oai21_1
Xgf180mcu_fd_sc_mcu7t5v0__oai21_1_121 vdd gf180mcu_fd_sc_mcu7t5v0__buf_8_6/Z gf180mcu_fd_sc_mcu7t5v0__buf_20_0/I
+ gf180mcu_fd_sc_mcu7t5v0__aoi21_1_214/B gf180mcu_fd_sc_mcu7t5v0__dffq_1_311/Q vss
+ vdd vss gf180mcu_fd_sc_mcu7t5v0__oai21_1
Xgf180mcu_fd_sc_mcu7t5v0__oai21_1_132 vdd gf180mcu_fd_sc_mcu7t5v0__buf_8_6/Z gf180mcu_fd_sc_mcu7t5v0__nand2_4_40/ZN
+ gf180mcu_fd_sc_mcu7t5v0__aoi21_1_161/B gf180mcu_fd_sc_mcu7t5v0__dffq_1_334/Q vss
+ vdd vss gf180mcu_fd_sc_mcu7t5v0__oai21_1
Xgf180mcu_fd_sc_mcu7t5v0__nor2_2_5 vdd vss gf180mcu_fd_sc_mcu7t5v0__nor2_2_5/ZN gf180mcu_fd_sc_mcu7t5v0__dffq_4_4/Q
+ gf180mcu_fd_sc_mcu7t5v0__inv_2_0/I vdd vss gf180mcu_fd_sc_mcu7t5v0__nor2_2
Xgf180mcu_fd_sc_mcu7t5v0__oai21_1_143 vdd gf180mcu_fd_sc_mcu7t5v0__buf_8_6/Z gf180mcu_fd_sc_mcu7t5v0__nand3_1_55/A2
+ gf180mcu_fd_sc_mcu7t5v0__aoi21_1_154/B gf180mcu_fd_sc_mcu7t5v0__dffq_1_335/Q vss
+ vdd vss gf180mcu_fd_sc_mcu7t5v0__oai21_1
Xgf180mcu_fd_sc_mcu7t5v0__oai21_1_154 vdd gf180mcu_fd_sc_mcu7t5v0__oai21_1_154/B gf180mcu_fd_sc_mcu7t5v0__or2_1_20/A2
+ gf180mcu_fd_sc_mcu7t5v0__and2_1_57/A2 gf180mcu_fd_sc_mcu7t5v0__dffq_1_344/Q vss
+ vdd vss gf180mcu_fd_sc_mcu7t5v0__oai21_1
Xgf180mcu_fd_sc_mcu7t5v0__oai21_1_165 vdd gf180mcu_fd_sc_mcu7t5v0__buf_8_8/Z gf180mcu_fd_sc_mcu7t5v0__nand3_1_55/A2
+ gf180mcu_fd_sc_mcu7t5v0__aoi21_1_151/B gf180mcu_fd_sc_mcu7t5v0__dffq_1_345/Q vss
+ vdd vss gf180mcu_fd_sc_mcu7t5v0__oai21_1
Xgf180mcu_fd_sc_mcu7t5v0__oai21_1_176 vdd gf180mcu_fd_sc_mcu7t5v0__or3_1_12/A2 gf180mcu_fd_sc_mcu7t5v0__or3_1_12/A3
+ gf180mcu_fd_sc_mcu7t5v0__nand3_1_62/A3 gf180mcu_fd_sc_mcu7t5v0__inv_1_13/I vss vdd
+ vss gf180mcu_fd_sc_mcu7t5v0__oai21_1
Xgf180mcu_fd_sc_mcu7t5v0__oai21_1_187 vdd gf180mcu_fd_sc_mcu7t5v0__buf_8_7/Z gf180mcu_fd_sc_mcu7t5v0__nor3_4_15/ZN
+ gf180mcu_fd_sc_mcu7t5v0__aoi21_1_202/B gf180mcu_fd_sc_mcu7t5v0__nor4_2_4/A2 vss
+ vdd vss gf180mcu_fd_sc_mcu7t5v0__oai21_1
Xgf180mcu_fd_sc_mcu7t5v0__oai21_1_198 vdd gf180mcu_fd_sc_mcu7t5v0__buf_8_6/Z gf180mcu_fd_sc_mcu7t5v0__aoi22_4_8/ZN
+ gf180mcu_fd_sc_mcu7t5v0__nor2_1_234/A1 gf180mcu_fd_sc_mcu7t5v0__dffq_1_408/Q vss
+ vdd vss gf180mcu_fd_sc_mcu7t5v0__oai21_1
Xgf180mcu_fd_sc_mcu7t5v0__nand2_2_50 vdd vss gf180mcu_fd_sc_mcu7t5v0__oai32_1_5/B1
+ gf180mcu_fd_sc_mcu7t5v0__inv_1_7/I gf180mcu_fd_sc_mcu7t5v0__dffq_2_40/Q vdd vss
+ gf180mcu_fd_sc_mcu7t5v0__nand2_2
Xgf180mcu_fd_sc_mcu7t5v0__nand2_2_61 vdd vss gf180mcu_fd_sc_mcu7t5v0__oai32_1_7/B1
+ gf180mcu_fd_sc_mcu7t5v0__nand3_1_73/ZN gf180mcu_fd_sc_mcu7t5v0__nand2_2_61/A2 vdd
+ vss gf180mcu_fd_sc_mcu7t5v0__nand2_2
Xgf180mcu_fd_sc_mcu7t5v0__clkinv_1_14 vdd vss gf180mcu_fd_sc_mcu7t5v0__xor3_1_47/A1
+ gf180mcu_fd_sc_mcu7t5v0__aoi21_1_59/A1 vdd vss gf180mcu_fd_sc_mcu7t5v0__clkinv_1
Xgf180mcu_fd_sc_mcu7t5v0__clkinv_1_25 vdd vss gf180mcu_fd_sc_mcu7t5v0__dffq_1_50/Q
+ gf180mcu_fd_sc_mcu7t5v0__oai22_1_15/B2 vdd vss gf180mcu_fd_sc_mcu7t5v0__clkinv_1
Xgf180mcu_fd_sc_mcu7t5v0__nand2_2_72 vdd vss gf180mcu_fd_sc_mcu7t5v0__xor3_2_2/A2
+ gf180mcu_fd_sc_mcu7t5v0__xor2_1_158/A1 gf180mcu_fd_sc_mcu7t5v0__xor2_1_158/A2 vdd
+ vss gf180mcu_fd_sc_mcu7t5v0__nand2_2
Xgf180mcu_fd_sc_mcu7t5v0__clkinv_1_36 vdd vss gf180mcu_fd_sc_mcu7t5v0__dffq_1_34/Q
+ gf180mcu_fd_sc_mcu7t5v0__oai22_1_22/B2 vdd vss gf180mcu_fd_sc_mcu7t5v0__clkinv_1
Xgf180mcu_fd_sc_mcu7t5v0__clkinv_1_47 vdd vss gf180mcu_fd_sc_mcu7t5v0__dffq_1_37/Q
+ gf180mcu_fd_sc_mcu7t5v0__oai22_1_36/B2 vdd vss gf180mcu_fd_sc_mcu7t5v0__clkinv_1
Xgf180mcu_fd_sc_mcu7t5v0__clkinv_1_58 vdd vss gf180mcu_fd_sc_mcu7t5v0__dffq_1_51/Q
+ gf180mcu_fd_sc_mcu7t5v0__oai22_1_24/B2 vdd vss gf180mcu_fd_sc_mcu7t5v0__clkinv_1
Xgf180mcu_fd_sc_mcu7t5v0__xor2_1_220 vdd vss gf180mcu_fd_sc_mcu7t5v0__xor2_1_220/Z
+ gf180mcu_fd_sc_mcu7t5v0__nor3_1_6/A1 gf180mcu_fd_sc_mcu7t5v0__nor2_1_37/ZN vdd vss
+ gf180mcu_fd_sc_mcu7t5v0__xor2_1
Xgf180mcu_fd_sc_mcu7t5v0__clkinv_1_69 vdd vss gf180mcu_fd_sc_mcu7t5v0__dffq_1_68/Q
+ gf180mcu_fd_sc_mcu7t5v0__oai22_1_53/B2 vdd vss gf180mcu_fd_sc_mcu7t5v0__clkinv_1
Xgf180mcu_fd_sc_mcu7t5v0__nand4_1_7 gf180mcu_fd_sc_mcu7t5v0__nand4_1_8/ZN gf180mcu_fd_sc_mcu7t5v0__nor4_1_4/ZN
+ vdd vss gf180mcu_fd_sc_mcu7t5v0__nand4_1_7/ZN gf180mcu_fd_sc_mcu7t5v0__buf_8_7/Z
+ gf180mcu_fd_sc_mcu7t5v0__nand4_1_7/A2 vdd vss gf180mcu_fd_sc_mcu7t5v0__nand4_1
Xgf180mcu_fd_sc_mcu7t5v0__mux4_2_0 gf180mcu_fd_sc_mcu7t5v0__mux4_2_0/I0 vss vdd gf180mcu_fd_sc_mcu7t5v0__dffq_2_8/Q
+ gf180mcu_fd_sc_mcu7t5v0__or2_1_34/A1 gf180mcu_fd_sc_mcu7t5v0__inv_1_6/I gf180mcu_fd_sc_mcu7t5v0__mux4_2_1/I3
+ gf180mcu_fd_sc_mcu7t5v0__or3_2_3/A2 gf180mcu_fd_sc_mcu7t5v0__or2_1_7/A2 vdd vss
+ gf180mcu_fd_sc_mcu7t5v0__mux4_2
Xgf180mcu_fd_sc_mcu7t5v0__and2_2_10 vdd vss gf180mcu_fd_sc_mcu7t5v0__nor4_2_5/A1 gf180mcu_fd_sc_mcu7t5v0__and2_2_10/A1
+ gf180mcu_fd_sc_mcu7t5v0__oai22_4_3/ZN vdd vss gf180mcu_fd_sc_mcu7t5v0__and2_2
Xgf180mcu_fd_sc_mcu7t5v0__dffq_4_11 gf180mcu_fd_sc_mcu7t5v0__dffq_4_11/D gf180mcu_fd_sc_mcu7t5v0__nor4_4_0/A1
+ vdd vss gf180mcu_fd_sc_mcu7t5v0__dffq_4_9/CLK vdd vss gf180mcu_fd_sc_mcu7t5v0__dffq_4
Xgf180mcu_fd_sc_mcu7t5v0__dffq_4_22 gf180mcu_fd_sc_mcu7t5v0__dffq_4_22/D gf180mcu_fd_sc_mcu7t5v0__or2_1_33/A1
+ vdd vss gf180mcu_fd_sc_mcu7t5v0__dffq_4_1/CLK vdd vss gf180mcu_fd_sc_mcu7t5v0__dffq_4
Xgf180mcu_fd_sc_mcu7t5v0__dffq_4_33 gf180mcu_fd_sc_mcu7t5v0__dffq_4_33/D gf180mcu_fd_sc_mcu7t5v0__or2_2_1/A1
+ vdd vss gf180mcu_fd_sc_mcu7t5v0__dffq_4_44/CLK vdd vss gf180mcu_fd_sc_mcu7t5v0__dffq_4
Xgf180mcu_fd_sc_mcu7t5v0__dffq_4_44 gf180mcu_fd_sc_mcu7t5v0__dffq_4_44/D gf180mcu_fd_sc_mcu7t5v0__inv_12_1/I
+ vdd vss gf180mcu_fd_sc_mcu7t5v0__dffq_4_44/CLK vdd vss gf180mcu_fd_sc_mcu7t5v0__dffq_4
Xgf180mcu_fd_sc_mcu7t5v0__and2_2_4 vdd vss gf180mcu_fd_sc_mcu7t5v0__and2_2_4/Z gf180mcu_fd_sc_mcu7t5v0__and2_2_4/A1
+ gf180mcu_fd_sc_mcu7t5v0__and2_2_4/A2 vdd vss gf180mcu_fd_sc_mcu7t5v0__and2_2
Xgf180mcu_fd_sc_mcu7t5v0__oai21_2_10 gf180mcu_fd_sc_mcu7t5v0__or3_1_17/A2 gf180mcu_fd_sc_mcu7t5v0__aoi21_2_9/A2
+ gf180mcu_fd_sc_mcu7t5v0__or3_1_17/A1 vss gf180mcu_fd_sc_mcu7t5v0__xor3_1_89/Z vdd
+ vdd vss gf180mcu_fd_sc_mcu7t5v0__oai21_2
Xgf180mcu_fd_sc_mcu7t5v0__nand2_1_308 vdd vss gf180mcu_fd_sc_mcu7t5v0__nand2_1_308/ZN
+ gf180mcu_fd_sc_mcu7t5v0__dffq_1_286/Q gf180mcu_fd_sc_mcu7t5v0__or3_2_4/Z vdd vss
+ gf180mcu_fd_sc_mcu7t5v0__nand2_1
Xgf180mcu_fd_sc_mcu7t5v0__nand2_1_319 vdd vss gf180mcu_fd_sc_mcu7t5v0__nand2_1_319/ZN
+ gf180mcu_fd_sc_mcu7t5v0__dffq_2_27/Q gf180mcu_fd_sc_mcu7t5v0__nor3_4_12/ZN vdd vss
+ gf180mcu_fd_sc_mcu7t5v0__nand2_1
Xgf180mcu_fd_sc_mcu7t5v0__dffq_1_405 vdd gf180mcu_fd_sc_mcu7t5v0__dffq_1_405/Q gf180mcu_fd_sc_mcu7t5v0__dffq_4_21/CLK
+ vss gf180mcu_fd_sc_mcu7t5v0__dffq_1_405/D vdd vss gf180mcu_fd_sc_mcu7t5v0__dffq_1
Xgf180mcu_fd_sc_mcu7t5v0__dffq_1_416 vdd gf180mcu_fd_sc_mcu7t5v0__dffq_1_416/Q gf180mcu_fd_sc_mcu7t5v0__dffq_4_1/CLK
+ vss gf180mcu_fd_sc_mcu7t5v0__dffq_1_416/D vdd vss gf180mcu_fd_sc_mcu7t5v0__dffq_1
Xgf180mcu_fd_sc_mcu7t5v0__dffq_1_427 vdd gf180mcu_fd_sc_mcu7t5v0__dffq_1_427/Q gf180mcu_fd_sc_mcu7t5v0__dffq_4_44/CLK
+ vss gf180mcu_fd_sc_mcu7t5v0__dffq_1_427/D vdd vss gf180mcu_fd_sc_mcu7t5v0__dffq_1
Xgf180mcu_fd_sc_mcu7t5v0__dffq_1_438 vdd gf180mcu_fd_sc_mcu7t5v0__mux4_4_16/I0 gf180mcu_fd_sc_mcu7t5v0__dffq_4_44/CLK
+ vss gf180mcu_fd_sc_mcu7t5v0__dffq_1_438/D vdd vss gf180mcu_fd_sc_mcu7t5v0__dffq_1
Xgf180mcu_fd_sc_mcu7t5v0__dffq_1_449 vdd gf180mcu_fd_sc_mcu7t5v0__dffq_1_449/Q gf180mcu_fd_sc_mcu7t5v0__dffq_2_58/CLK
+ vss gf180mcu_fd_sc_mcu7t5v0__dffq_1_449/D vdd vss gf180mcu_fd_sc_mcu7t5v0__dffq_1
Xgf180mcu_fd_sc_mcu7t5v0__or2_1_20 vdd vss gf180mcu_fd_sc_mcu7t5v0__or2_1_20/Z gf180mcu_fd_sc_mcu7t5v0__or2_1_20/A1
+ gf180mcu_fd_sc_mcu7t5v0__or2_1_20/A2 vdd vss gf180mcu_fd_sc_mcu7t5v0__or2_1
Xgf180mcu_fd_sc_mcu7t5v0__or2_1_31 vdd vss gf180mcu_fd_sc_mcu7t5v0__or2_1_31/Z gf180mcu_fd_sc_mcu7t5v0__or2_1_31/A1
+ gf180mcu_fd_sc_mcu7t5v0__or2_1_31/A2 vdd vss gf180mcu_fd_sc_mcu7t5v0__or2_1
Xgf180mcu_fd_sc_mcu7t5v0__aoi22_1_170 gf180mcu_fd_sc_mcu7t5v0__or3_1_12/A2 gf180mcu_fd_sc_mcu7t5v0__dffq_4_37/Q
+ vdd vss gf180mcu_fd_sc_mcu7t5v0__nor2_1_355/A2 gf180mcu_fd_sc_mcu7t5v0__inv_4_6/I
+ gf180mcu_fd_sc_mcu7t5v0__inv_1_13/ZN vdd vss gf180mcu_fd_sc_mcu7t5v0__aoi22_1
Xgf180mcu_fd_sc_mcu7t5v0__or2_1_42 vdd vss gf180mcu_fd_sc_mcu7t5v0__or2_1_42/Z gf180mcu_fd_sc_mcu7t5v0__or2_1_42/A1
+ gf180mcu_fd_sc_mcu7t5v0__or2_1_42/A2 vdd vss gf180mcu_fd_sc_mcu7t5v0__or2_1
Xgf180mcu_fd_sc_mcu7t5v0__aoi22_1_181 gf180mcu_fd_sc_mcu7t5v0__or2_1_7/Z gf180mcu_fd_sc_mcu7t5v0__nor2_2_44/ZN
+ vdd vss gf180mcu_fd_sc_mcu7t5v0__oai211_1_7/C gf180mcu_fd_sc_mcu7t5v0__or2_1_7/A1
+ gf180mcu_fd_sc_mcu7t5v0__nor2_2_42/ZN vdd vss gf180mcu_fd_sc_mcu7t5v0__aoi22_1
Xgf180mcu_fd_sc_mcu7t5v0__or2_1_53 vdd vss gf180mcu_fd_sc_mcu7t5v0__or2_1_53/Z gf180mcu_fd_sc_mcu7t5v0__or2_1_53/A1
+ gf180mcu_fd_sc_mcu7t5v0__or2_1_53/A2 vdd vss gf180mcu_fd_sc_mcu7t5v0__or2_1
Xgf180mcu_fd_sc_mcu7t5v0__nor2_4_20 vdd vss gf180mcu_fd_sc_mcu7t5v0__nor2_4_20/ZN
+ gf180mcu_fd_sc_mcu7t5v0__or2_4_2/Z gf180mcu_fd_sc_mcu7t5v0__nor2_4_21/A2 vdd vss
+ gf180mcu_fd_sc_mcu7t5v0__nor2_4
Xgf180mcu_fd_sc_mcu7t5v0__nor2_4_31 vdd vss gf180mcu_fd_sc_mcu7t5v0__nor2_4_31/ZN
+ gf180mcu_fd_sc_mcu7t5v0__inv_1_11/ZN gf180mcu_fd_sc_mcu7t5v0__nor3_4_15/A2 vdd vss
+ gf180mcu_fd_sc_mcu7t5v0__nor2_4
Xgf180mcu_fd_sc_mcu7t5v0__nor2_4_42 vdd vss gf180mcu_fd_sc_mcu7t5v0__nor2_4_42/ZN
+ gf180mcu_fd_sc_mcu7t5v0__nor2_4_42/A1 gf180mcu_fd_sc_mcu7t5v0__nor2_4_42/A2 vdd
+ vss gf180mcu_fd_sc_mcu7t5v0__nor2_4
Xgf180mcu_fd_sc_mcu7t5v0__nand2_4_8 vdd vss gf180mcu_fd_sc_mcu7t5v0__nand2_4_8/ZN
+ gf180mcu_fd_sc_mcu7t5v0__nor3_4_7/ZN gf180mcu_fd_sc_mcu7t5v0__nor2_4_7/ZN vdd vss
+ gf180mcu_fd_sc_mcu7t5v0__nand2_4
Xgf180mcu_fd_sc_mcu7t5v0__nand2_4_18 vdd vss gf180mcu_fd_sc_mcu7t5v0__nand2_4_18/ZN
+ gf180mcu_fd_sc_mcu7t5v0__nor3_4_9/ZN gf180mcu_fd_sc_mcu7t5v0__nor2_4_12/ZN vdd vss
+ gf180mcu_fd_sc_mcu7t5v0__nand2_4
Xgf180mcu_fd_sc_mcu7t5v0__nand2_4_29 vdd vss gf180mcu_fd_sc_mcu7t5v0__nand2_4_29/ZN
+ gf180mcu_fd_sc_mcu7t5v0__nor3_4_9/ZN gf180mcu_fd_sc_mcu7t5v0__nor2_4_4/ZN vdd vss
+ gf180mcu_fd_sc_mcu7t5v0__nand2_4
Xgf180mcu_fd_sc_mcu7t5v0__aoi21_1_350 gf180mcu_fd_sc_mcu7t5v0__aoi21_1_350/B vdd vss
+ gf180mcu_fd_sc_mcu7t5v0__dffq_2_93/D gf180mcu_fd_sc_mcu7t5v0__nand2_1_651/A2 gf180mcu_fd_sc_mcu7t5v0__buf_20_0/I
+ vdd vss gf180mcu_fd_sc_mcu7t5v0__aoi21_1
Xgf180mcu_fd_sc_mcu7t5v0__aoi21_1_361 gf180mcu_fd_sc_mcu7t5v0__and3_1_23/Z vdd vss
+ gf180mcu_fd_sc_mcu7t5v0__xnor2_1_73/A2 gf180mcu_fd_sc_mcu7t5v0__and2_1_151/Z gf180mcu_fd_sc_mcu7t5v0__and2_1_146/Z
+ vdd vss gf180mcu_fd_sc_mcu7t5v0__aoi21_1
Xgf180mcu_fd_sc_mcu7t5v0__aoi21_1_372 gf180mcu_fd_sc_mcu7t5v0__dffq_1_337/Q vdd vss
+ gf180mcu_fd_sc_mcu7t5v0__aoi211_1_51/B gf180mcu_fd_sc_mcu7t5v0__nand4_2_5/A2 gf180mcu_fd_sc_mcu7t5v0__nor3_1_44/A1
+ vdd vss gf180mcu_fd_sc_mcu7t5v0__aoi21_1
Xgf180mcu_fd_sc_mcu7t5v0__aoi21_1_383 gf180mcu_fd_sc_mcu7t5v0__aoi21_1_383/B vdd vss
+ gf180mcu_fd_sc_mcu7t5v0__xnor3_1_51/A1 gf180mcu_fd_sc_mcu7t5v0__xnor2_1_86/A1 gf180mcu_fd_sc_mcu7t5v0__xor2_1_168/Z
+ vdd vss gf180mcu_fd_sc_mcu7t5v0__aoi21_1
Xgf180mcu_fd_sc_mcu7t5v0__aoi22_4_11 gf180mcu_fd_sc_mcu7t5v0__nor2_4_40/ZN gf180mcu_fd_sc_mcu7t5v0__aoi22_4_11/B1
+ gf180mcu_fd_sc_mcu7t5v0__oai21_2_14/ZN vdd vss gf180mcu_fd_sc_mcu7t5v0__and4_1_3/A4
+ gf180mcu_fd_sc_mcu7t5v0__xor2_1_157/A1 vdd vss gf180mcu_fd_sc_mcu7t5v0__aoi22_4
Xgf180mcu_fd_sc_mcu7t5v0__nand2_1_105 vdd vss gf180mcu_fd_sc_mcu7t5v0__or2_1_11/A2
+ gf180mcu_fd_sc_mcu7t5v0__or4_1_0/A1 gf180mcu_fd_sc_mcu7t5v0__or4_1_1/A2 vdd vss
+ gf180mcu_fd_sc_mcu7t5v0__nand2_1
Xgf180mcu_fd_sc_mcu7t5v0__nand2_1_116 vdd vss gf180mcu_fd_sc_mcu7t5v0__or2_1_9/A2
+ gf180mcu_fd_sc_mcu7t5v0__inv_8_1/I gf180mcu_fd_sc_mcu7t5v0__or4_1_1/A4 vdd vss gf180mcu_fd_sc_mcu7t5v0__nand2_1
Xgf180mcu_fd_sc_mcu7t5v0__nand2_1_127 vdd vss gf180mcu_fd_sc_mcu7t5v0__oai21_1_52/A2
+ gf180mcu_fd_sc_mcu7t5v0__inv_8_2/I gf180mcu_fd_sc_mcu7t5v0__aoi22_4_1/ZN vdd vss
+ gf180mcu_fd_sc_mcu7t5v0__nand2_1
Xgf180mcu_fd_sc_mcu7t5v0__nand2_1_138 vdd vss gf180mcu_fd_sc_mcu7t5v0__aoi21_1_50/A2
+ gf180mcu_fd_sc_mcu7t5v0__xor3_1_57/A1 gf180mcu_fd_sc_mcu7t5v0__xor3_1_57/A3 vdd
+ vss gf180mcu_fd_sc_mcu7t5v0__nand2_1
Xgf180mcu_fd_sc_mcu7t5v0__nand2_1_149 vdd vss gf180mcu_fd_sc_mcu7t5v0__oai21_1_56/B
+ gf180mcu_fd_sc_mcu7t5v0__inv_1_3/ZN gf180mcu_fd_sc_mcu7t5v0__nor2_4_2/ZN vdd vss
+ gf180mcu_fd_sc_mcu7t5v0__nand2_1
Xgf180mcu_fd_sc_mcu7t5v0__xor3_1_60 gf180mcu_fd_sc_mcu7t5v0__nor3_2_1/A3 vdd vss gf180mcu_fd_sc_mcu7t5v0__xor3_1_60/Z
+ gf180mcu_fd_sc_mcu7t5v0__and2_1_3/A1 gf180mcu_fd_sc_mcu7t5v0__nor3_4_0/A3 vdd vss
+ gf180mcu_fd_sc_mcu7t5v0__xor3_1
Xgf180mcu_fd_sc_mcu7t5v0__xor3_1_71 gf180mcu_fd_sc_mcu7t5v0__and2_1_84/Z vdd vss gf180mcu_fd_sc_mcu7t5v0__xor3_1_71/Z
+ gf180mcu_fd_sc_mcu7t5v0__mux4_4_4/I0 gf180mcu_fd_sc_mcu7t5v0__and2_1_82/Z vdd vss
+ gf180mcu_fd_sc_mcu7t5v0__xor3_1
Xgf180mcu_fd_sc_mcu7t5v0__xor3_1_82 gf180mcu_fd_sc_mcu7t5v0__xor3_1_82/A3 vdd vss
+ gf180mcu_fd_sc_mcu7t5v0__xor3_1_82/Z gf180mcu_fd_sc_mcu7t5v0__xor3_1_82/A1 gf180mcu_fd_sc_mcu7t5v0__xor3_1_82/A2
+ vdd vss gf180mcu_fd_sc_mcu7t5v0__xor3_1
Xgf180mcu_fd_sc_mcu7t5v0__xor3_1_93 gf180mcu_fd_sc_mcu7t5v0__xor3_1_93/A3 vdd vss
+ gf180mcu_fd_sc_mcu7t5v0__xor3_1_93/Z gf180mcu_fd_sc_mcu7t5v0__xor3_1_93/A1 gf180mcu_fd_sc_mcu7t5v0__xor3_1_93/A2
+ vdd vss gf180mcu_fd_sc_mcu7t5v0__xor3_1
Xgf180mcu_fd_sc_mcu7t5v0__dffq_1_202 vdd gf180mcu_fd_sc_mcu7t5v0__dffq_1_202/Q gf180mcu_fd_sc_mcu7t5v0__dffq_4_8/CLK
+ vss gf180mcu_fd_sc_mcu7t5v0__dffq_1_202/D vdd vss gf180mcu_fd_sc_mcu7t5v0__dffq_1
Xgf180mcu_fd_sc_mcu7t5v0__dffq_1_213 vdd gf180mcu_fd_sc_mcu7t5v0__dffq_1_213/Q gf180mcu_fd_sc_mcu7t5v0__dffq_4_8/CLK
+ vss gf180mcu_fd_sc_mcu7t5v0__dffq_1_213/D vdd vss gf180mcu_fd_sc_mcu7t5v0__dffq_1
Xgf180mcu_fd_sc_mcu7t5v0__nor2_1_402 vdd vss gf180mcu_fd_sc_mcu7t5v0__dffq_2_92/D
+ gf180mcu_fd_sc_mcu7t5v0__aoi21_1_7/B gf180mcu_fd_sc_mcu7t5v0__nor2_1_402/A2 vdd
+ vss gf180mcu_fd_sc_mcu7t5v0__nor2_1
Xgf180mcu_fd_sc_mcu7t5v0__dffq_1_224 vdd gf180mcu_fd_sc_mcu7t5v0__dffq_1_224/Q gf180mcu_fd_sc_mcu7t5v0__dffq_2_26/CLK
+ vss gf180mcu_fd_sc_mcu7t5v0__dffq_1_224/D vdd vss gf180mcu_fd_sc_mcu7t5v0__dffq_1
Xgf180mcu_fd_sc_mcu7t5v0__dffq_1_235 vdd gf180mcu_fd_sc_mcu7t5v0__dffq_1_235/Q gf180mcu_fd_sc_mcu7t5v0__dffq_2_26/CLK
+ vss gf180mcu_fd_sc_mcu7t5v0__dffq_1_235/D vdd vss gf180mcu_fd_sc_mcu7t5v0__dffq_1
Xgf180mcu_fd_sc_mcu7t5v0__dffq_1_246 vdd gf180mcu_fd_sc_mcu7t5v0__dffq_1_246/Q gf180mcu_fd_sc_mcu7t5v0__dffq_2_26/CLK
+ vss gf180mcu_fd_sc_mcu7t5v0__dffq_1_246/D vdd vss gf180mcu_fd_sc_mcu7t5v0__dffq_1
Xgf180mcu_fd_sc_mcu7t5v0__dffq_1_257 vdd gf180mcu_fd_sc_mcu7t5v0__dffq_1_257/Q gf180mcu_fd_sc_mcu7t5v0__dffq_1_99/CLK
+ vss gf180mcu_fd_sc_mcu7t5v0__dffq_1_257/D vdd vss gf180mcu_fd_sc_mcu7t5v0__dffq_1
Xgf180mcu_fd_sc_mcu7t5v0__dffq_1_268 vdd gf180mcu_fd_sc_mcu7t5v0__dffq_1_268/Q gf180mcu_fd_sc_mcu7t5v0__dffq_1_99/CLK
+ vss gf180mcu_fd_sc_mcu7t5v0__dffq_1_268/D vdd vss gf180mcu_fd_sc_mcu7t5v0__dffq_1
Xgf180mcu_fd_sc_mcu7t5v0__dffq_1_279 vdd gf180mcu_fd_sc_mcu7t5v0__dffq_1_279/Q gf180mcu_fd_sc_mcu7t5v0__dffq_4_9/CLK
+ vss gf180mcu_fd_sc_mcu7t5v0__dffq_1_279/D vdd vss gf180mcu_fd_sc_mcu7t5v0__dffq_1
Xgf180mcu_fd_sc_mcu7t5v0__nand2_1_650 vdd vss gf180mcu_fd_sc_mcu7t5v0__nand2_1_671/A2
+ gf180mcu_fd_sc_mcu7t5v0__nor2_1_387/ZN gf180mcu_fd_sc_mcu7t5v0__xnor2_1_66/A1 vdd
+ vss gf180mcu_fd_sc_mcu7t5v0__nand2_1
Xgf180mcu_fd_sc_mcu7t5v0__nand2_1_661 vdd vss gf180mcu_fd_sc_mcu7t5v0__oai21_1_319/A2
+ gf180mcu_fd_sc_mcu7t5v0__dffq_4_37/Q gf180mcu_fd_sc_mcu7t5v0__and3_1_23/A2 vdd vss
+ gf180mcu_fd_sc_mcu7t5v0__nand2_1
Xgf180mcu_fd_sc_mcu7t5v0__nand2_1_672 vdd vss gf180mcu_fd_sc_mcu7t5v0__oai211_1_54/B
+ gf180mcu_fd_sc_mcu7t5v0__nor2_2_53/ZN gf180mcu_fd_sc_mcu7t5v0__xor3_1_154/A3 vdd
+ vss gf180mcu_fd_sc_mcu7t5v0__nand2_1
Xgf180mcu_fd_sc_mcu7t5v0__nand2_1_683 vdd vss gf180mcu_fd_sc_mcu7t5v0__xnor3_1_45/A1
+ gf180mcu_fd_sc_mcu7t5v0__dffq_4_37/Q gf180mcu_fd_sc_mcu7t5v0__and4_1_3/A4 vdd vss
+ gf180mcu_fd_sc_mcu7t5v0__nand2_1
Xgf180mcu_fd_sc_mcu7t5v0__nand2_1_694 vdd vss gf180mcu_fd_sc_mcu7t5v0__nand2_1_694/ZN
+ gf180mcu_fd_sc_mcu7t5v0__xnor3_1_46/ZN gf180mcu_fd_sc_mcu7t5v0__xor2_1_200/Z vdd
+ vss gf180mcu_fd_sc_mcu7t5v0__nand2_1
Xgf180mcu_fd_sc_mcu7t5v0__dffq_1_12 vdd gf180mcu_fd_sc_mcu7t5v0__inv_2_3/I gf180mcu_fd_sc_mcu7t5v0__dffq_4_6/CLK
+ vss gf180mcu_fd_sc_mcu7t5v0__dffq_1_12/D vdd vss gf180mcu_fd_sc_mcu7t5v0__dffq_1
Xgf180mcu_fd_sc_mcu7t5v0__clkinv_1_107 vdd vss gf180mcu_fd_sc_mcu7t5v0__dffq_1_78/Q
+ gf180mcu_fd_sc_mcu7t5v0__oai22_1_76/B2 vdd vss gf180mcu_fd_sc_mcu7t5v0__clkinv_1
Xgf180mcu_fd_sc_mcu7t5v0__dffq_1_23 vdd gf180mcu_fd_sc_mcu7t5v0__dffq_1_23/Q gf180mcu_fd_sc_mcu7t5v0__dffq_1_99/CLK
+ vss gf180mcu_fd_sc_mcu7t5v0__dffq_1_23/D vdd vss gf180mcu_fd_sc_mcu7t5v0__dffq_1
Xgf180mcu_fd_sc_mcu7t5v0__dffq_1_34 vdd gf180mcu_fd_sc_mcu7t5v0__dffq_1_34/Q gf180mcu_fd_sc_mcu7t5v0__dffq_1_99/CLK
+ vss gf180mcu_fd_sc_mcu7t5v0__dffq_1_34/D vdd vss gf180mcu_fd_sc_mcu7t5v0__dffq_1
Xgf180mcu_fd_sc_mcu7t5v0__clkinv_1_118 vdd vss gf180mcu_fd_sc_mcu7t5v0__dffq_1_178/Q
+ gf180mcu_fd_sc_mcu7t5v0__oai22_1_193/B2 vdd vss gf180mcu_fd_sc_mcu7t5v0__clkinv_1
Xgf180mcu_fd_sc_mcu7t5v0__dffq_1_45 vdd gf180mcu_fd_sc_mcu7t5v0__dffq_1_45/Q gf180mcu_fd_sc_mcu7t5v0__dffq_4_8/CLK
+ vss gf180mcu_fd_sc_mcu7t5v0__dffq_1_45/D vdd vss gf180mcu_fd_sc_mcu7t5v0__dffq_1
Xgf180mcu_fd_sc_mcu7t5v0__dffq_1_56 vdd gf180mcu_fd_sc_mcu7t5v0__dffq_1_56/Q gf180mcu_fd_sc_mcu7t5v0__dffq_1_95/CLK
+ vss gf180mcu_fd_sc_mcu7t5v0__dffq_1_56/D vdd vss gf180mcu_fd_sc_mcu7t5v0__dffq_1
Xgf180mcu_fd_sc_mcu7t5v0__clkinv_1_129 vdd vss gf180mcu_fd_sc_mcu7t5v0__dffq_1_105/Q
+ gf180mcu_fd_sc_mcu7t5v0__oai22_1_120/B2 vdd vss gf180mcu_fd_sc_mcu7t5v0__clkinv_1
Xgf180mcu_fd_sc_mcu7t5v0__dffq_1_67 vdd gf180mcu_fd_sc_mcu7t5v0__dffq_1_67/Q gf180mcu_fd_sc_mcu7t5v0__dffq_1_95/CLK
+ vss gf180mcu_fd_sc_mcu7t5v0__dffq_1_67/D vdd vss gf180mcu_fd_sc_mcu7t5v0__dffq_1
Xgf180mcu_fd_sc_mcu7t5v0__dffq_1_78 vdd gf180mcu_fd_sc_mcu7t5v0__dffq_1_78/Q gf180mcu_fd_sc_mcu7t5v0__dffq_1_99/CLK
+ vss gf180mcu_fd_sc_mcu7t5v0__dffq_1_78/D vdd vss gf180mcu_fd_sc_mcu7t5v0__dffq_1
Xgf180mcu_fd_sc_mcu7t5v0__dffq_1_89 vdd gf180mcu_fd_sc_mcu7t5v0__dffq_1_89/Q gf180mcu_fd_sc_mcu7t5v0__dffq_1_99/CLK
+ vss gf180mcu_fd_sc_mcu7t5v0__dffq_1_89/D vdd vss gf180mcu_fd_sc_mcu7t5v0__dffq_1
Xgf180mcu_fd_sc_mcu7t5v0__nand2_2_5 vdd vss gf180mcu_fd_sc_mcu7t5v0__or3_1_4/A1 gf180mcu_fd_sc_mcu7t5v0__inv_8_0/I
+ gf180mcu_fd_sc_mcu7t5v0__and2_2_4/Z vdd vss gf180mcu_fd_sc_mcu7t5v0__nand2_2
Xgf180mcu_fd_sc_mcu7t5v0__aoi211_1_9 gf180mcu_fd_sc_mcu7t5v0__nor2_1_45/ZN gf180mcu_fd_sc_mcu7t5v0__or2_1_23/A1
+ vdd vss gf180mcu_fd_sc_mcu7t5v0__dffq_1_9/D gf180mcu_fd_sc_mcu7t5v0__nor2_1_411/A1
+ gf180mcu_fd_sc_mcu7t5v0__nor2_4_15/ZN vdd vss gf180mcu_fd_sc_mcu7t5v0__aoi211_1
Xgf180mcu_fd_sc_mcu7t5v0__dffq_2_9 gf180mcu_fd_sc_mcu7t5v0__dffq_2_9/D vdd vss gf180mcu_fd_sc_mcu7t5v0__dffq_4_6/CLK
+ gf180mcu_fd_sc_mcu7t5v0__dffq_2_9/Q vdd vss gf180mcu_fd_sc_mcu7t5v0__dffq_2
Xgf180mcu_fd_sc_mcu7t5v0__aoi21_1_180 gf180mcu_fd_sc_mcu7t5v0__nor2_2_20/ZN vdd vss
+ gf180mcu_fd_sc_mcu7t5v0__oai21_1_171/B gf180mcu_fd_sc_mcu7t5v0__oai31_1_9/A2 gf180mcu_fd_sc_mcu7t5v0__or3_1_13/A3
+ vdd vss gf180mcu_fd_sc_mcu7t5v0__aoi21_1
Xgf180mcu_fd_sc_mcu7t5v0__aoi21_1_191 gf180mcu_fd_sc_mcu7t5v0__and2_1_83/Z vdd vss
+ gf180mcu_fd_sc_mcu7t5v0__or2_1_25/A1 gf180mcu_fd_sc_mcu7t5v0__nor2_1_221/A1 gf180mcu_fd_sc_mcu7t5v0__xor2_1_102/Z
+ vdd vss gf180mcu_fd_sc_mcu7t5v0__aoi21_1
Xgf180mcu_fd_sc_mcu7t5v0__aoi22_1_6 gf180mcu_fd_sc_mcu7t5v0__mux4_4_1/Z gf180mcu_fd_sc_mcu7t5v0__inv_12_1/I
+ vdd vss gf180mcu_fd_sc_mcu7t5v0__nor3_1_6/A3 gf180mcu_fd_sc_mcu7t5v0__inv_8_1/I
+ gf180mcu_fd_sc_mcu7t5v0__mux4_4_4/Z vdd vss gf180mcu_fd_sc_mcu7t5v0__aoi22_1
Xgf180mcu_fd_sc_mcu7t5v0__buf_8_2 gf180mcu_fd_sc_mcu7t5v0__buf_8_2/Z gf180mcu_fd_sc_mcu7t5v0__buf_8_5/I
+ vdd vss vdd vss gf180mcu_fd_sc_mcu7t5v0__buf_8
Xgf180mcu_fd_sc_mcu7t5v0__oai22_1_101 gf180mcu_fd_sc_mcu7t5v0__oai22_1_99/A2 gf180mcu_fd_sc_mcu7t5v0__oai22_1_99/B1
+ gf180mcu_fd_sc_mcu7t5v0__oai22_1_101/B2 vdd vss gf180mcu_fd_sc_mcu7t5v0__dffq_1_114/D
+ gf180mcu_fd_sc_mcu7t5v0__aoi21_4_2/ZN vdd vss gf180mcu_fd_sc_mcu7t5v0__oai22_1
Xgf180mcu_fd_sc_mcu7t5v0__oai22_1_112 gf180mcu_fd_sc_mcu7t5v0__oai22_1_99/A2 gf180mcu_fd_sc_mcu7t5v0__oai22_1_99/B1
+ gf180mcu_fd_sc_mcu7t5v0__oai22_1_112/B2 vdd vss gf180mcu_fd_sc_mcu7t5v0__dffq_1_107/D
+ gf180mcu_fd_sc_mcu7t5v0__aoi21_4_1/ZN vdd vss gf180mcu_fd_sc_mcu7t5v0__oai22_1
Xgf180mcu_fd_sc_mcu7t5v0__oai22_1_123 gf180mcu_fd_sc_mcu7t5v0__nand2_4_17/ZN gf180mcu_fd_sc_mcu7t5v0__nand2_2_23/ZN
+ gf180mcu_fd_sc_mcu7t5v0__oai22_1_123/B2 vdd vss gf180mcu_fd_sc_mcu7t5v0__dffq_1_116/D
+ gf180mcu_fd_sc_mcu7t5v0__aoi21_4_4/ZN vdd vss gf180mcu_fd_sc_mcu7t5v0__oai22_1
Xgf180mcu_fd_sc_mcu7t5v0__oai22_1_134 gf180mcu_fd_sc_mcu7t5v0__oai22_1_55/A2 gf180mcu_fd_sc_mcu7t5v0__oai22_1_55/B1
+ gf180mcu_fd_sc_mcu7t5v0__oai22_1_134/B2 vdd vss gf180mcu_fd_sc_mcu7t5v0__dffq_1_134/D
+ gf180mcu_fd_sc_mcu7t5v0__aoi21_4_2/ZN vdd vss gf180mcu_fd_sc_mcu7t5v0__oai22_1
Xgf180mcu_fd_sc_mcu7t5v0__oai22_1_145 gf180mcu_fd_sc_mcu7t5v0__nand2_4_19/ZN gf180mcu_fd_sc_mcu7t5v0__nand2_2_26/ZN
+ gf180mcu_fd_sc_mcu7t5v0__oai22_1_145/B2 vdd vss gf180mcu_fd_sc_mcu7t5v0__dffq_1_142/D
+ gf180mcu_fd_sc_mcu7t5v0__aoi21_4_5/ZN vdd vss gf180mcu_fd_sc_mcu7t5v0__oai22_1
Xgf180mcu_fd_sc_mcu7t5v0__oai22_1_156 gf180mcu_fd_sc_mcu7t5v0__nand2_4_20/ZN gf180mcu_fd_sc_mcu7t5v0__nand2_2_27/ZN
+ gf180mcu_fd_sc_mcu7t5v0__oai22_1_156/B2 vdd vss gf180mcu_fd_sc_mcu7t5v0__dffq_1_152/D
+ gf180mcu_fd_sc_mcu7t5v0__aoi21_4_5/ZN vdd vss gf180mcu_fd_sc_mcu7t5v0__oai22_1
Xgf180mcu_fd_sc_mcu7t5v0__oai22_1_167 gf180mcu_fd_sc_mcu7t5v0__nand2_4_23/ZN gf180mcu_fd_sc_mcu7t5v0__nand2_2_30/ZN
+ gf180mcu_fd_sc_mcu7t5v0__oai22_1_167/B2 vdd vss gf180mcu_fd_sc_mcu7t5v0__dffq_1_161/D
+ gf180mcu_fd_sc_mcu7t5v0__oai22_1_98/A1 vdd vss gf180mcu_fd_sc_mcu7t5v0__oai22_1
Xgf180mcu_fd_sc_mcu7t5v0__oai221_1_6 gf180mcu_fd_sc_mcu7t5v0__xor3_1_177/Z gf180mcu_fd_sc_mcu7t5v0__oai221_1_6/C
+ vdd vss gf180mcu_fd_sc_mcu7t5v0__oai221_1_6/ZN gf180mcu_fd_sc_mcu7t5v0__oai221_1_7/A1
+ gf180mcu_fd_sc_mcu7t5v0__xor3_1_69/A3 gf180mcu_fd_sc_mcu7t5v0__clkinv_2_7/I vdd
+ vss gf180mcu_fd_sc_mcu7t5v0__oai221_1
Xgf180mcu_fd_sc_mcu7t5v0__oai22_1_178 gf180mcu_fd_sc_mcu7t5v0__nand2_4_24/ZN gf180mcu_fd_sc_mcu7t5v0__nand2_2_52/ZN
+ gf180mcu_fd_sc_mcu7t5v0__oai22_1_178/B2 vdd vss gf180mcu_fd_sc_mcu7t5v0__dffq_1_165/D
+ gf180mcu_fd_sc_mcu7t5v0__aoi21_4_4/ZN vdd vss gf180mcu_fd_sc_mcu7t5v0__oai22_1
Xgf180mcu_fd_sc_mcu7t5v0__oai22_1_189 gf180mcu_fd_sc_mcu7t5v0__nand2_4_23/ZN gf180mcu_fd_sc_mcu7t5v0__nand2_2_30/ZN
+ gf180mcu_fd_sc_mcu7t5v0__oai22_1_189/B2 vdd vss gf180mcu_fd_sc_mcu7t5v0__dffq_1_175/D
+ gf180mcu_fd_sc_mcu7t5v0__aoi21_4_4/ZN vdd vss gf180mcu_fd_sc_mcu7t5v0__oai22_1
Xgf180mcu_fd_sc_mcu7t5v0__xnor3_1_17 gf180mcu_fd_sc_mcu7t5v0__xor2_1_8/Z vdd vss gf180mcu_fd_sc_mcu7t5v0__xor2_1_23/A2
+ gf180mcu_fd_sc_mcu7t5v0__dffq_2_6/Q gf180mcu_fd_sc_mcu7t5v0__nor2_1_8/ZN vdd vss
+ gf180mcu_fd_sc_mcu7t5v0__xnor3_1
Xgf180mcu_fd_sc_mcu7t5v0__xnor3_1_28 gf180mcu_fd_sc_mcu7t5v0__xnor3_1_28/A3 vdd vss
+ gf180mcu_fd_sc_mcu7t5v0__xor2_1_142/A2 gf180mcu_fd_sc_mcu7t5v0__xor3_1_100/Z gf180mcu_fd_sc_mcu7t5v0__xnor3_1_28/A2
+ vdd vss gf180mcu_fd_sc_mcu7t5v0__xnor3_1
Xgf180mcu_fd_sc_mcu7t5v0__xnor3_1_39 gf180mcu_fd_sc_mcu7t5v0__xor3_1_121/Z vdd vss
+ gf180mcu_fd_sc_mcu7t5v0__xor3_1_117/A3 gf180mcu_fd_sc_mcu7t5v0__xnor3_1_39/A1 gf180mcu_fd_sc_mcu7t5v0__nor3_1_36/ZN
+ vdd vss gf180mcu_fd_sc_mcu7t5v0__xnor3_1
Xgf180mcu_fd_sc_mcu7t5v0__nor2_1_10 vdd vss gf180mcu_fd_sc_mcu7t5v0__oai32_1_0/A2
+ gf180mcu_fd_sc_mcu7t5v0__xor3_1_4/Z gf180mcu_fd_sc_mcu7t5v0__xor3_1_8/A3 vdd vss
+ gf180mcu_fd_sc_mcu7t5v0__nor2_1
Xgf180mcu_fd_sc_mcu7t5v0__nor2_1_21 vdd vss gf180mcu_fd_sc_mcu7t5v0__or3_1_1/A2 gf180mcu_fd_sc_mcu7t5v0__nor2_1_21/A1
+ gf180mcu_fd_sc_mcu7t5v0__xor2_1_13/Z vdd vss gf180mcu_fd_sc_mcu7t5v0__nor2_1
Xgf180mcu_fd_sc_mcu7t5v0__nor2_1_32 vdd vss gf180mcu_fd_sc_mcu7t5v0__nor2_1_32/ZN
+ gf180mcu_fd_sc_mcu7t5v0__dffq_1_1/Q gf180mcu_fd_sc_mcu7t5v0__nor2_4_19/ZN vdd vss
+ gf180mcu_fd_sc_mcu7t5v0__nor2_1
Xgf180mcu_fd_sc_mcu7t5v0__nor2_1_43 vdd vss gf180mcu_fd_sc_mcu7t5v0__nor2_1_43/ZN
+ gf180mcu_fd_sc_mcu7t5v0__dffq_1_7/Q gf180mcu_fd_sc_mcu7t5v0__nor2_4_15/ZN vdd vss
+ gf180mcu_fd_sc_mcu7t5v0__nor2_1
Xgf180mcu_fd_sc_mcu7t5v0__inv_8_2 vss gf180mcu_fd_sc_mcu7t5v0__inv_8_2/ZN gf180mcu_fd_sc_mcu7t5v0__inv_8_2/I
+ vdd vdd vss gf180mcu_fd_sc_mcu7t5v0__inv_8
Xgf180mcu_fd_sc_mcu7t5v0__nor2_1_54 vdd vss gf180mcu_fd_sc_mcu7t5v0__dffq_2_3/D gf180mcu_fd_sc_mcu7t5v0__nor2_1_54/A1
+ gf180mcu_fd_sc_mcu7t5v0__nor2_1_54/A2 vdd vss gf180mcu_fd_sc_mcu7t5v0__nor2_1
Xgf180mcu_fd_sc_mcu7t5v0__nor2_1_65 vdd vss gf180mcu_fd_sc_mcu7t5v0__nor2_1_65/ZN
+ gf180mcu_fd_sc_mcu7t5v0__and2_1_21/Z gf180mcu_fd_sc_mcu7t5v0__nor2_1_65/A2 vdd vss
+ gf180mcu_fd_sc_mcu7t5v0__nor2_1
Xgf180mcu_fd_sc_mcu7t5v0__nor2_1_76 vdd vss gf180mcu_fd_sc_mcu7t5v0__nor2_1_76/ZN
+ gf180mcu_fd_sc_mcu7t5v0__dffq_4_3/Q gf180mcu_fd_sc_mcu7t5v0__inv_2_1/I vdd vss gf180mcu_fd_sc_mcu7t5v0__nor2_1
Xgf180mcu_fd_sc_mcu7t5v0__nor2_1_87 vdd vss gf180mcu_fd_sc_mcu7t5v0__oai22_1_8/B1
+ gf180mcu_fd_sc_mcu7t5v0__nor2_1_89/A1 gf180mcu_fd_sc_mcu7t5v0__inv_1_4/ZN vdd vss
+ gf180mcu_fd_sc_mcu7t5v0__nor2_1
Xgf180mcu_fd_sc_mcu7t5v0__nor2_1_98 vdd vss gf180mcu_fd_sc_mcu7t5v0__nor2_1_98/ZN
+ gf180mcu_fd_sc_mcu7t5v0__inv_8_1/I gf180mcu_fd_sc_mcu7t5v0__or4_1_1/A2 vdd vss gf180mcu_fd_sc_mcu7t5v0__nor2_1
Xgf180mcu_fd_sc_mcu7t5v0__nor2_1_210 vdd vss gf180mcu_fd_sc_mcu7t5v0__dffq_1_391/D
+ gf180mcu_fd_sc_mcu7t5v0__or2_1_23/A1 gf180mcu_fd_sc_mcu7t5v0__nor2_1_210/A2 vdd
+ vss gf180mcu_fd_sc_mcu7t5v0__nor2_1
Xgf180mcu_fd_sc_mcu7t5v0__nor2_1_221 vdd vss gf180mcu_fd_sc_mcu7t5v0__nor2_1_221/ZN
+ gf180mcu_fd_sc_mcu7t5v0__nor2_1_221/A1 gf180mcu_fd_sc_mcu7t5v0__xor2_1_102/Z vdd
+ vss gf180mcu_fd_sc_mcu7t5v0__nor2_1
Xgf180mcu_fd_sc_mcu7t5v0__nor2_1_232 vdd vss gf180mcu_fd_sc_mcu7t5v0__nor2_1_232/ZN
+ gf180mcu_fd_sc_mcu7t5v0__xor2_1_107/A1 gf180mcu_fd_sc_mcu7t5v0__xor2_1_107/A2 vdd
+ vss gf180mcu_fd_sc_mcu7t5v0__nor2_1
Xgf180mcu_fd_sc_mcu7t5v0__nor2_1_243 vdd vss gf180mcu_fd_sc_mcu7t5v0__nor2_1_243/ZN
+ gf180mcu_fd_sc_mcu7t5v0__or2_1_28/A2 gf180mcu_fd_sc_mcu7t5v0__nand4_2_3/ZN vdd vss
+ gf180mcu_fd_sc_mcu7t5v0__nor2_1
Xgf180mcu_fd_sc_mcu7t5v0__nor2_1_254 vdd vss gf180mcu_fd_sc_mcu7t5v0__xor2_1_145/A1
+ gf180mcu_fd_sc_mcu7t5v0__xnor2_1_42/ZN gf180mcu_fd_sc_mcu7t5v0__xnor2_1_41/A2 vdd
+ vss gf180mcu_fd_sc_mcu7t5v0__nor2_1
Xgf180mcu_fd_sc_mcu7t5v0__clkinv_2_8 vdd vss gf180mcu_fd_sc_mcu7t5v0__dffq_2_98/Q
+ gf180mcu_fd_sc_mcu7t5v0__nor2_2_31/A1 vdd vss gf180mcu_fd_sc_mcu7t5v0__clkinv_2
Xgf180mcu_fd_sc_mcu7t5v0__nor2_1_265 vdd vss gf180mcu_fd_sc_mcu7t5v0__nor2_1_265/ZN
+ gf180mcu_fd_sc_mcu7t5v0__mux2_1_8/I1 gf180mcu_fd_sc_mcu7t5v0__and3_2_3/Z vdd vss
+ gf180mcu_fd_sc_mcu7t5v0__nor2_1
Xgf180mcu_fd_sc_mcu7t5v0__nor2_1_276 vdd vss gf180mcu_fd_sc_mcu7t5v0__nor2_1_276/ZN
+ gf180mcu_fd_sc_mcu7t5v0__or3_1_18/A1 gf180mcu_fd_sc_mcu7t5v0__nor3_1_42/ZN vdd vss
+ gf180mcu_fd_sc_mcu7t5v0__nor2_1
Xgf180mcu_fd_sc_mcu7t5v0__xor3_1_5 gf180mcu_fd_sc_mcu7t5v0__xor3_1_62/Z vdd vss gf180mcu_fd_sc_mcu7t5v0__xor3_1_5/Z
+ gf180mcu_fd_sc_mcu7t5v0__xor3_1_5/A1 gf180mcu_fd_sc_mcu7t5v0__xor3_1_5/A2 vdd vss
+ gf180mcu_fd_sc_mcu7t5v0__xor3_1
Xgf180mcu_fd_sc_mcu7t5v0__oai31_1_9 vdd gf180mcu_fd_sc_mcu7t5v0__oai31_1_9/ZN gf180mcu_fd_sc_mcu7t5v0__oai31_1_9/B
+ gf180mcu_fd_sc_mcu7t5v0__xor2_1_89/A2 gf180mcu_fd_sc_mcu7t5v0__oai31_1_9/A2 vss
+ gf180mcu_fd_sc_mcu7t5v0__oai31_1_9/A3 vdd vss gf180mcu_fd_sc_mcu7t5v0__oai31_1
Xgf180mcu_fd_sc_mcu7t5v0__nor2_1_287 vdd vss gf180mcu_fd_sc_mcu7t5v0__xor3_1_97/A3
+ gf180mcu_fd_sc_mcu7t5v0__inv_8_2/ZN gf180mcu_fd_sc_mcu7t5v0__nor2_2_32/A2 vdd vss
+ gf180mcu_fd_sc_mcu7t5v0__nor2_1
Xgf180mcu_fd_sc_mcu7t5v0__nor2_1_298 vdd vss gf180mcu_fd_sc_mcu7t5v0__nor2_1_298/ZN
+ gf180mcu_fd_sc_mcu7t5v0__dffq_1_447/Q gf180mcu_fd_sc_mcu7t5v0__nor2_4_16/ZN vdd
+ vss gf180mcu_fd_sc_mcu7t5v0__nor2_1
Xgf180mcu_fd_sc_mcu7t5v0__nand2_1_480 vdd vss gf180mcu_fd_sc_mcu7t5v0__nand2_1_480/ZN
+ gf180mcu_fd_sc_mcu7t5v0__nor2_1_270/ZN gf180mcu_fd_sc_mcu7t5v0__oai32_1_7/B1 vdd
+ vss gf180mcu_fd_sc_mcu7t5v0__nand2_1
Xgf180mcu_fd_sc_mcu7t5v0__nand2_1_491 vdd vss gf180mcu_fd_sc_mcu7t5v0__xnor3_1_29/A2
+ gf180mcu_fd_sc_mcu7t5v0__inv_4_6/I gf180mcu_fd_sc_mcu7t5v0__and2_2_9/Z vdd vss gf180mcu_fd_sc_mcu7t5v0__nand2_1
Xgf180mcu_fd_sc_mcu7t5v0__nand2_1_19 vdd vss gf180mcu_fd_sc_mcu7t5v0__aoi21_1_9/A1
+ gf180mcu_fd_sc_mcu7t5v0__nor2_1_21/A1 gf180mcu_fd_sc_mcu7t5v0__xor2_1_13/Z vdd vss
+ gf180mcu_fd_sc_mcu7t5v0__nand2_1
Xgf180mcu_fd_sc_mcu7t5v0__oai21_1_303 vdd gf180mcu_fd_sc_mcu7t5v0__xor3_1_139/A2 gf180mcu_fd_sc_mcu7t5v0__or3_1_24/A2
+ gf180mcu_fd_sc_mcu7t5v0__and3_1_22/A2 gf180mcu_fd_sc_mcu7t5v0__inv_8_0/ZN vss vdd
+ vss gf180mcu_fd_sc_mcu7t5v0__oai21_1
Xgf180mcu_fd_sc_mcu7t5v0__oai21_1_314 vdd gf180mcu_fd_sc_mcu7t5v0__oai21_1_314/B gf180mcu_fd_sc_mcu7t5v0__oai21_1_314/A2
+ gf180mcu_fd_sc_mcu7t5v0__oai211_1_46/B gf180mcu_fd_sc_mcu7t5v0__or3_1_25/A2 vss
+ vdd vss gf180mcu_fd_sc_mcu7t5v0__oai21_1
Xgf180mcu_fd_sc_mcu7t5v0__oai21_1_325 vdd gf180mcu_fd_sc_mcu7t5v0__oai21_1_325/B gf180mcu_fd_sc_mcu7t5v0__nor2_1_396/ZN
+ gf180mcu_fd_sc_mcu7t5v0__xor3_1_144/A1 gf180mcu_fd_sc_mcu7t5v0__xor3_1_150/A2 vss
+ vdd vss gf180mcu_fd_sc_mcu7t5v0__oai21_1
Xgf180mcu_fd_sc_mcu7t5v0__oai21_1_336 vdd gf180mcu_fd_sc_mcu7t5v0__oai21_1_336/B gf180mcu_fd_sc_mcu7t5v0__oai21_1_336/A2
+ gf180mcu_fd_sc_mcu7t5v0__xnor2_1_37/A1 gf180mcu_fd_sc_mcu7t5v0__or2_1_28/Z vss vdd
+ vss gf180mcu_fd_sc_mcu7t5v0__oai21_1
Xgf180mcu_fd_sc_mcu7t5v0__nor2_4_9 vdd vss gf180mcu_fd_sc_mcu7t5v0__nor2_4_9/ZN gf180mcu_fd_sc_mcu7t5v0__inv_3_1/I
+ gf180mcu_fd_sc_mcu7t5v0__inv_3_2/ZN vdd vss gf180mcu_fd_sc_mcu7t5v0__nor2_4
Xgf180mcu_fd_sc_mcu7t5v0__xnor2_1_7 vdd vss gf180mcu_fd_sc_mcu7t5v0__xnor2_1_7/ZN
+ gf180mcu_fd_sc_mcu7t5v0__xnor2_1_7/A1 gf180mcu_fd_sc_mcu7t5v0__xor2_1_19/Z vdd vss
+ gf180mcu_fd_sc_mcu7t5v0__xnor2_1
Xgf180mcu_fd_sc_mcu7t5v0__oai22_1_9 gf180mcu_fd_sc_mcu7t5v0__xor2_1_58/A1 gf180mcu_fd_sc_mcu7t5v0__oai22_1_9/B1
+ gf180mcu_fd_sc_mcu7t5v0__nor3_4_3/ZN vdd vss gf180mcu_fd_sc_mcu7t5v0__oai22_1_9/ZN
+ gf180mcu_fd_sc_mcu7t5v0__dffq_4_37/Q vdd vss gf180mcu_fd_sc_mcu7t5v0__oai22_1
Xgf180mcu_fd_sc_mcu7t5v0__aoi22_1_12 gf180mcu_fd_sc_mcu7t5v0__nor2_4_2/ZN gf180mcu_fd_sc_mcu7t5v0__or2_1_34/A1
+ vdd vss gf180mcu_fd_sc_mcu7t5v0__nand2_2_7/A2 gf180mcu_fd_sc_mcu7t5v0__dffq_2_8/Q
+ gf180mcu_fd_sc_mcu7t5v0__and2_2_6/Z vdd vss gf180mcu_fd_sc_mcu7t5v0__aoi22_1
Xgf180mcu_fd_sc_mcu7t5v0__aoi22_1_23 gf180mcu_fd_sc_mcu7t5v0__nor2_4_11/ZN gf180mcu_fd_sc_mcu7t5v0__dffq_1_27/Q
+ vdd vss gf180mcu_fd_sc_mcu7t5v0__aoi22_1_23/ZN gf180mcu_fd_sc_mcu7t5v0__dffq_1_277/Q
+ gf180mcu_fd_sc_mcu7t5v0__nor2_4_10/ZN vdd vss gf180mcu_fd_sc_mcu7t5v0__aoi22_1
Xgf180mcu_fd_sc_mcu7t5v0__aoi22_1_34 gf180mcu_fd_sc_mcu7t5v0__nor2_4_11/ZN gf180mcu_fd_sc_mcu7t5v0__dffq_1_57/Q
+ vdd vss gf180mcu_fd_sc_mcu7t5v0__aoi22_1_34/ZN gf180mcu_fd_sc_mcu7t5v0__dffq_1_56/Q
+ gf180mcu_fd_sc_mcu7t5v0__nor2_4_10/ZN vdd vss gf180mcu_fd_sc_mcu7t5v0__aoi22_1
Xgf180mcu_fd_sc_mcu7t5v0__aoi22_1_45 gf180mcu_fd_sc_mcu7t5v0__nor2_4_9/ZN gf180mcu_fd_sc_mcu7t5v0__dffq_1_92/Q
+ vdd vss gf180mcu_fd_sc_mcu7t5v0__aoi22_1_45/ZN gf180mcu_fd_sc_mcu7t5v0__dffq_1_96/Q
+ gf180mcu_fd_sc_mcu7t5v0__nor2_4_8/ZN vdd vss gf180mcu_fd_sc_mcu7t5v0__aoi22_1
Xgf180mcu_fd_sc_mcu7t5v0__aoi22_1_56 gf180mcu_fd_sc_mcu7t5v0__nor2_4_9/ZN gf180mcu_fd_sc_mcu7t5v0__dffq_1_111/Q
+ vdd vss gf180mcu_fd_sc_mcu7t5v0__aoi22_1_56/ZN gf180mcu_fd_sc_mcu7t5v0__dffq_1_108/Q
+ gf180mcu_fd_sc_mcu7t5v0__nor2_4_8/ZN vdd vss gf180mcu_fd_sc_mcu7t5v0__aoi22_1
Xgf180mcu_fd_sc_mcu7t5v0__aoi22_1_67 gf180mcu_fd_sc_mcu7t5v0__aoi22_1_67/B1 gf180mcu_fd_sc_mcu7t5v0__nor2_4_7/ZN
+ vdd vss gf180mcu_fd_sc_mcu7t5v0__nand3_1_37/A1 gf180mcu_fd_sc_mcu7t5v0__nor3_4_6/ZN
+ gf180mcu_fd_sc_mcu7t5v0__aoi22_1_67/A2 vdd vss gf180mcu_fd_sc_mcu7t5v0__aoi22_1
Xgf180mcu_fd_sc_mcu7t5v0__aoi22_1_78 gf180mcu_fd_sc_mcu7t5v0__nor2_4_11/ZN gf180mcu_fd_sc_mcu7t5v0__dffq_1_132/Q
+ vdd vss gf180mcu_fd_sc_mcu7t5v0__aoi22_1_78/ZN gf180mcu_fd_sc_mcu7t5v0__dffq_1_138/Q
+ gf180mcu_fd_sc_mcu7t5v0__nor2_4_10/ZN vdd vss gf180mcu_fd_sc_mcu7t5v0__aoi22_1
Xgf180mcu_fd_sc_mcu7t5v0__aoi22_1_89 gf180mcu_fd_sc_mcu7t5v0__nor2_4_11/ZN gf180mcu_fd_sc_mcu7t5v0__dffq_1_161/Q
+ vdd vss gf180mcu_fd_sc_mcu7t5v0__aoi22_1_89/ZN gf180mcu_fd_sc_mcu7t5v0__dffq_1_275/Q
+ gf180mcu_fd_sc_mcu7t5v0__nor2_4_10/ZN vdd vss gf180mcu_fd_sc_mcu7t5v0__aoi22_1
Xgf180mcu_fd_sc_mcu7t5v0__xnor2_1_50 vdd vss gf180mcu_fd_sc_mcu7t5v0__nor3_1_29/A3
+ gf180mcu_fd_sc_mcu7t5v0__xnor2_1_50/A1 gf180mcu_fd_sc_mcu7t5v0__or2_1_38/A1 vdd
+ vss gf180mcu_fd_sc_mcu7t5v0__xnor2_1
Xgf180mcu_fd_sc_mcu7t5v0__or3_1_5 gf180mcu_fd_sc_mcu7t5v0__or3_1_5/A3 vdd vss gf180mcu_fd_sc_mcu7t5v0__or3_1_5/Z
+ gf180mcu_fd_sc_mcu7t5v0__or3_1_5/A1 gf180mcu_fd_sc_mcu7t5v0__or3_1_5/A2 vdd vss
+ gf180mcu_fd_sc_mcu7t5v0__or3_1
Xgf180mcu_fd_sc_mcu7t5v0__xnor2_1_61 vdd vss gf180mcu_fd_sc_mcu7t5v0__or2_1_50/A2
+ gf180mcu_fd_sc_mcu7t5v0__xnor2_1_61/A1 gf180mcu_fd_sc_mcu7t5v0__xnor2_1_61/A2 vdd
+ vss gf180mcu_fd_sc_mcu7t5v0__xnor2_1
Xgf180mcu_fd_sc_mcu7t5v0__xnor2_1_72 vdd vss gf180mcu_fd_sc_mcu7t5v0__xnor2_1_75/A2
+ gf180mcu_fd_sc_mcu7t5v0__xnor3_1_46/ZN gf180mcu_fd_sc_mcu7t5v0__xor2_1_200/Z vdd
+ vss gf180mcu_fd_sc_mcu7t5v0__xnor2_1
Xgf180mcu_fd_sc_mcu7t5v0__xnor2_1_83 vdd vss gf180mcu_fd_sc_mcu7t5v0__xnor2_1_83/ZN
+ gf180mcu_fd_sc_mcu7t5v0__xnor2_1_83/A1 gf180mcu_fd_sc_mcu7t5v0__xnor2_1_83/A2 vdd
+ vss gf180mcu_fd_sc_mcu7t5v0__xnor2_1
Xgf180mcu_fd_sc_mcu7t5v0__inv_1_9 vss gf180mcu_fd_sc_mcu7t5v0__inv_1_9/ZN gf180mcu_fd_sc_mcu7t5v0__inv_1_9/I
+ vdd vdd vss gf180mcu_fd_sc_mcu7t5v0__inv_1
Xgf180mcu_fd_sc_mcu7t5v0__nand3_2_18 gf180mcu_fd_sc_mcu7t5v0__dffq_4_7/Q vdd vss gf180mcu_fd_sc_mcu7t5v0__oai221_1_5/B2
+ gf180mcu_fd_sc_mcu7t5v0__dffq_4_8/Q gf180mcu_fd_sc_mcu7t5v0__inv_2_6/ZN vdd vss
+ gf180mcu_fd_sc_mcu7t5v0__nand3_2
Xgf180mcu_fd_sc_mcu7t5v0__nand3_2_29 gf180mcu_fd_sc_mcu7t5v0__mux4_4_7/I0 vdd vss
+ gf180mcu_fd_sc_mcu7t5v0__nand3_2_29/ZN gf180mcu_fd_sc_mcu7t5v0__inv_4_7/I gf180mcu_fd_sc_mcu7t5v0__dffq_4_35/Q
+ vdd vss gf180mcu_fd_sc_mcu7t5v0__nand3_2
Xgf180mcu_fd_sc_mcu7t5v0__mux4_4_4 gf180mcu_fd_sc_mcu7t5v0__mux4_4_4/I0 vss vdd gf180mcu_fd_sc_mcu7t5v0__dffq_2_7/Q
+ gf180mcu_fd_sc_mcu7t5v0__mux4_4_4/I1 gf180mcu_fd_sc_mcu7t5v0__inv_1_6/I gf180mcu_fd_sc_mcu7t5v0__mux4_4_4/I3
+ gf180mcu_fd_sc_mcu7t5v0__or3_2_3/A2 gf180mcu_fd_sc_mcu7t5v0__mux4_4_4/Z vdd vss
+ gf180mcu_fd_sc_mcu7t5v0__mux4_4
Xgf180mcu_fd_sc_mcu7t5v0__aoi221_2_4 gf180mcu_fd_sc_mcu7t5v0__nor2_4_14/ZN gf180mcu_fd_sc_mcu7t5v0__dffq_1_449/Q
+ vdd vss gf180mcu_fd_sc_mcu7t5v0__aoi221_2_4/ZN gf180mcu_fd_sc_mcu7t5v0__dffq_1_314/Q
+ gf180mcu_fd_sc_mcu7t5v0__or2_1_34/A2 gf180mcu_fd_sc_mcu7t5v0__and2_1_49/Z vdd vss
+ gf180mcu_fd_sc_mcu7t5v0__aoi221_2
Xgf180mcu_fd_sc_mcu7t5v0__oai21_1_100 vdd gf180mcu_fd_sc_mcu7t5v0__buf_8_5/I gf180mcu_fd_sc_mcu7t5v0__oai21_1_94/A2
+ gf180mcu_fd_sc_mcu7t5v0__aoi21_1_110/B gf180mcu_fd_sc_mcu7t5v0__mux2_2_0/I1 vss
+ vdd vss gf180mcu_fd_sc_mcu7t5v0__oai21_1
Xgf180mcu_fd_sc_mcu7t5v0__oai21_1_111 vdd gf180mcu_fd_sc_mcu7t5v0__buf_8_6/Z gf180mcu_fd_sc_mcu7t5v0__dffq_1_316/Q
+ gf180mcu_fd_sc_mcu7t5v0__aoi21_1_130/B gf180mcu_fd_sc_mcu7t5v0__dffq_4_20/Q vss
+ vdd vss gf180mcu_fd_sc_mcu7t5v0__oai21_1
Xgf180mcu_fd_sc_mcu7t5v0__oai21_1_122 vdd gf180mcu_fd_sc_mcu7t5v0__oai21_1_122/B gf180mcu_fd_sc_mcu7t5v0__nor2_1_172/ZN
+ gf180mcu_fd_sc_mcu7t5v0__xor2_1_96/A1 gf180mcu_fd_sc_mcu7t5v0__xnor3_1_20/A2 vss
+ vdd vss gf180mcu_fd_sc_mcu7t5v0__oai21_1
Xgf180mcu_fd_sc_mcu7t5v0__nor2_2_6 vdd vss gf180mcu_fd_sc_mcu7t5v0__nor2_2_6/ZN gf180mcu_fd_sc_mcu7t5v0__nor2_2_6/A1
+ gf180mcu_fd_sc_mcu7t5v0__nor2_2_6/A2 vdd vss gf180mcu_fd_sc_mcu7t5v0__nor2_2
Xgf180mcu_fd_sc_mcu7t5v0__oai21_1_133 vdd gf180mcu_fd_sc_mcu7t5v0__buf_8_6/Z gf180mcu_fd_sc_mcu7t5v0__nand3_1_55/A2
+ gf180mcu_fd_sc_mcu7t5v0__aoi21_1_158/B gf180mcu_fd_sc_mcu7t5v0__dffq_1_334/Q vss
+ vdd vss gf180mcu_fd_sc_mcu7t5v0__oai21_1
Xgf180mcu_fd_sc_mcu7t5v0__oai21_1_144 vdd gf180mcu_fd_sc_mcu7t5v0__buf_8_6/Z gf180mcu_fd_sc_mcu7t5v0__nand3_1_55/A2
+ gf180mcu_fd_sc_mcu7t5v0__aoi21_1_156/B gf180mcu_fd_sc_mcu7t5v0__dffq_1_336/Q vss
+ vdd vss gf180mcu_fd_sc_mcu7t5v0__oai21_1
Xgf180mcu_fd_sc_mcu7t5v0__oai21_1_155 vdd gf180mcu_fd_sc_mcu7t5v0__oai21_1_157/B gf180mcu_fd_sc_mcu7t5v0__and2_1_54/Z
+ gf180mcu_fd_sc_mcu7t5v0__nor2_1_187/A2 gf180mcu_fd_sc_mcu7t5v0__nor4_1_1/A1 vss
+ vdd vss gf180mcu_fd_sc_mcu7t5v0__oai21_1
Xgf180mcu_fd_sc_mcu7t5v0__oai21_1_166 vdd gf180mcu_fd_sc_mcu7t5v0__buf_8_8/Z gf180mcu_fd_sc_mcu7t5v0__nand2_4_40/ZN
+ gf180mcu_fd_sc_mcu7t5v0__aoi21_1_176/B gf180mcu_fd_sc_mcu7t5v0__dffq_1_345/Q vss
+ vdd vss gf180mcu_fd_sc_mcu7t5v0__oai21_1
Xgf180mcu_fd_sc_mcu7t5v0__oai21_1_177 vdd gf180mcu_fd_sc_mcu7t5v0__oai21_1_177/B gf180mcu_fd_sc_mcu7t5v0__oai21_1_177/A2
+ gf180mcu_fd_sc_mcu7t5v0__nor2_1_221/A1 gf180mcu_fd_sc_mcu7t5v0__nor2_1_219/ZN vss
+ vdd vss gf180mcu_fd_sc_mcu7t5v0__oai21_1
Xgf180mcu_fd_sc_mcu7t5v0__oai21_1_188 vdd gf180mcu_fd_sc_mcu7t5v0__buf_8_7/Z gf180mcu_fd_sc_mcu7t5v0__nor3_4_15/ZN
+ gf180mcu_fd_sc_mcu7t5v0__aoi21_1_204/B gf180mcu_fd_sc_mcu7t5v0__nor4_2_4/A4 vss
+ vdd vss gf180mcu_fd_sc_mcu7t5v0__oai21_1
Xgf180mcu_fd_sc_mcu7t5v0__oai21_1_199 vdd gf180mcu_fd_sc_mcu7t5v0__buf_8_6/Z gf180mcu_fd_sc_mcu7t5v0__aoi22_4_8/ZN
+ gf180mcu_fd_sc_mcu7t5v0__aoi21_1_157/B gf180mcu_fd_sc_mcu7t5v0__dffq_1_411/Q vss
+ vdd vss gf180mcu_fd_sc_mcu7t5v0__oai21_1
Xgf180mcu_fd_sc_mcu7t5v0__nand2_2_40 vdd vss gf180mcu_fd_sc_mcu7t5v0__nor2_4_6/A2
+ gf180mcu_fd_sc_mcu7t5v0__mux2_2_0/Z gf180mcu_fd_sc_mcu7t5v0__or2_2_0/A2 vdd vss
+ gf180mcu_fd_sc_mcu7t5v0__nand2_2
Xgf180mcu_fd_sc_mcu7t5v0__nand2_2_51 vdd vss gf180mcu_fd_sc_mcu7t5v0__nand2_4_30/A2
+ gf180mcu_fd_sc_mcu7t5v0__nand3_1_49/ZN gf180mcu_fd_sc_mcu7t5v0__nand3_1_53/ZN vdd
+ vss gf180mcu_fd_sc_mcu7t5v0__nand2_2
Xgf180mcu_fd_sc_mcu7t5v0__nand2_2_62 vdd vss gf180mcu_fd_sc_mcu7t5v0__aoi21_4_7/A1
+ gf180mcu_fd_sc_mcu7t5v0__inv_1_2/I gf180mcu_fd_sc_mcu7t5v0__and2_1_104/Z vdd vss
+ gf180mcu_fd_sc_mcu7t5v0__nand2_2
Xgf180mcu_fd_sc_mcu7t5v0__clkinv_1_15 vdd vss gf180mcu_fd_sc_mcu7t5v0__mux4_4_7/I1
+ gf180mcu_fd_sc_mcu7t5v0__oai21_4_14/A1 vdd vss gf180mcu_fd_sc_mcu7t5v0__clkinv_1
Xgf180mcu_fd_sc_mcu7t5v0__nand2_2_73 vdd vss gf180mcu_fd_sc_mcu7t5v0__oai21_1_298/B
+ gf180mcu_fd_sc_mcu7t5v0__dffq_2_87/Q gf180mcu_fd_sc_mcu7t5v0__nor2_2_50/ZN vdd vss
+ gf180mcu_fd_sc_mcu7t5v0__nand2_2
Xgf180mcu_fd_sc_mcu7t5v0__clkinv_1_26 vdd vss gf180mcu_fd_sc_mcu7t5v0__dffq_1_23/Q
+ gf180mcu_fd_sc_mcu7t5v0__oai22_1_16/B2 vdd vss gf180mcu_fd_sc_mcu7t5v0__clkinv_1
Xgf180mcu_fd_sc_mcu7t5v0__clkinv_1_37 vdd vss gf180mcu_fd_sc_mcu7t5v0__dffq_1_28/Q
+ gf180mcu_fd_sc_mcu7t5v0__oai22_1_26/B2 vdd vss gf180mcu_fd_sc_mcu7t5v0__clkinv_1
Xgf180mcu_fd_sc_mcu7t5v0__xor2_1_210 vdd vss gf180mcu_fd_sc_mcu7t5v0__xor2_1_210/Z
+ gf180mcu_fd_sc_mcu7t5v0__xor3_1_161/Z gf180mcu_fd_sc_mcu7t5v0__xor3_1_160/Z vdd
+ vss gf180mcu_fd_sc_mcu7t5v0__xor2_1
Xgf180mcu_fd_sc_mcu7t5v0__clkinv_1_48 vdd vss gf180mcu_fd_sc_mcu7t5v0__dffq_1_36/Q
+ gf180mcu_fd_sc_mcu7t5v0__oai22_1_38/A1 vdd vss gf180mcu_fd_sc_mcu7t5v0__clkinv_1
Xgf180mcu_fd_sc_mcu7t5v0__xor2_1_221 vdd vss gf180mcu_fd_sc_mcu7t5v0__xor2_1_221/Z
+ gf180mcu_fd_sc_mcu7t5v0__mux4_4_0/Z gf180mcu_fd_sc_mcu7t5v0__xor2_1_221/A2 vdd vss
+ gf180mcu_fd_sc_mcu7t5v0__xor2_1
Xgf180mcu_fd_sc_mcu7t5v0__clkinv_1_59 vdd vss gf180mcu_fd_sc_mcu7t5v0__dffq_1_49/Q
+ gf180mcu_fd_sc_mcu7t5v0__oai22_1_257/B2 vdd vss gf180mcu_fd_sc_mcu7t5v0__clkinv_1
Xgf180mcu_fd_sc_mcu7t5v0__clkinv_1_290 vdd vss gf180mcu_fd_sc_mcu7t5v0__clkinv_1_290/I
+ gf180mcu_fd_sc_mcu7t5v0__aoi22_4_3/B1 vdd vss gf180mcu_fd_sc_mcu7t5v0__clkinv_1
Xgf180mcu_fd_sc_mcu7t5v0__nand4_1_8 gf180mcu_fd_sc_mcu7t5v0__nor3_1_24/A2 gf180mcu_fd_sc_mcu7t5v0__nand4_1_9/ZN
+ vdd vss gf180mcu_fd_sc_mcu7t5v0__nand4_1_8/ZN gf180mcu_fd_sc_mcu7t5v0__buf_8_8/Z
+ gf180mcu_fd_sc_mcu7t5v0__nand4_1_8/A2 vdd vss gf180mcu_fd_sc_mcu7t5v0__nand4_1
Xgf180mcu_fd_sc_mcu7t5v0__mux4_2_1 gf180mcu_fd_sc_mcu7t5v0__inv_1_22/I vss vdd gf180mcu_fd_sc_mcu7t5v0__mux4_2_1/I2
+ gf180mcu_fd_sc_mcu7t5v0__mux4_2_1/I1 gf180mcu_fd_sc_mcu7t5v0__inv_4_5/I gf180mcu_fd_sc_mcu7t5v0__mux4_2_1/I3
+ gf180mcu_fd_sc_mcu7t5v0__or2_2_1/A1 gf180mcu_fd_sc_mcu7t5v0__mux4_2_1/Z vdd vss
+ gf180mcu_fd_sc_mcu7t5v0__mux4_2
Xgf180mcu_fd_sc_mcu7t5v0__and2_2_11 vdd vss gf180mcu_fd_sc_mcu7t5v0__nor4_2_5/A3 gf180mcu_fd_sc_mcu7t5v0__and2_2_11/A1
+ gf180mcu_fd_sc_mcu7t5v0__and2_2_11/A2 vdd vss gf180mcu_fd_sc_mcu7t5v0__and2_2
Xgf180mcu_fd_sc_mcu7t5v0__dffq_4_12 gf180mcu_fd_sc_mcu7t5v0__dffq_4_12/D gf180mcu_fd_sc_mcu7t5v0__or4_1_0/A1
+ vdd vss gf180mcu_fd_sc_mcu7t5v0__dffq_4_9/CLK vdd vss gf180mcu_fd_sc_mcu7t5v0__dffq_4
Xgf180mcu_fd_sc_mcu7t5v0__dffq_4_23 gf180mcu_fd_sc_mcu7t5v0__dffq_4_23/D gf180mcu_fd_sc_mcu7t5v0__inv_4_4/I
+ vdd vss gf180mcu_fd_sc_mcu7t5v0__dffq_4_1/CLK vdd vss gf180mcu_fd_sc_mcu7t5v0__dffq_4
Xgf180mcu_fd_sc_mcu7t5v0__dffq_4_34 gf180mcu_fd_sc_mcu7t5v0__dffq_4_34/D gf180mcu_fd_sc_mcu7t5v0__inv_4_7/I
+ vdd vss gf180mcu_fd_sc_mcu7t5v0__dffq_4_44/CLK vdd vss gf180mcu_fd_sc_mcu7t5v0__dffq_4
Xgf180mcu_fd_sc_mcu7t5v0__dffq_4_45 gf180mcu_fd_sc_mcu7t5v0__dffq_4_45/D gf180mcu_fd_sc_mcu7t5v0__inv_1_2/I
+ vdd vss gf180mcu_fd_sc_mcu7t5v0__dffq_4_1/CLK vdd vss gf180mcu_fd_sc_mcu7t5v0__dffq_4
Xgf180mcu_fd_sc_mcu7t5v0__and2_2_5 vdd vss gf180mcu_fd_sc_mcu7t5v0__and2_2_5/Z gf180mcu_fd_sc_mcu7t5v0__mux4_4_3/I2
+ gf180mcu_fd_sc_mcu7t5v0__and2_2_6/Z vdd vss gf180mcu_fd_sc_mcu7t5v0__and2_2
Xgf180mcu_fd_sc_mcu7t5v0__oai21_2_11 gf180mcu_fd_sc_mcu7t5v0__oai21_2_11/A2 gf180mcu_fd_sc_mcu7t5v0__and2_2_11/A2
+ gf180mcu_fd_sc_mcu7t5v0__inv_4_4/I vss gf180mcu_fd_sc_mcu7t5v0__oai21_2_11/B vdd
+ vdd vss gf180mcu_fd_sc_mcu7t5v0__oai21_2
Xgf180mcu_fd_sc_mcu7t5v0__nand2_1_309 vdd vss gf180mcu_fd_sc_mcu7t5v0__nand2_1_309/ZN
+ gf180mcu_fd_sc_mcu7t5v0__dffq_1_287/Q gf180mcu_fd_sc_mcu7t5v0__or3_1_10/Z vdd vss
+ gf180mcu_fd_sc_mcu7t5v0__nand2_1
Xgf180mcu_fd_sc_mcu7t5v0__dffq_1_406 vdd gf180mcu_fd_sc_mcu7t5v0__dffq_1_406/Q gf180mcu_fd_sc_mcu7t5v0__dffq_4_21/CLK
+ vss gf180mcu_fd_sc_mcu7t5v0__dffq_1_406/D vdd vss gf180mcu_fd_sc_mcu7t5v0__dffq_1
Xgf180mcu_fd_sc_mcu7t5v0__dffq_1_417 vdd gf180mcu_fd_sc_mcu7t5v0__dffq_1_417/Q gf180mcu_fd_sc_mcu7t5v0__dffq_4_1/CLK
+ vss gf180mcu_fd_sc_mcu7t5v0__dffq_1_417/D vdd vss gf180mcu_fd_sc_mcu7t5v0__dffq_1
Xgf180mcu_fd_sc_mcu7t5v0__dffq_1_428 vdd gf180mcu_fd_sc_mcu7t5v0__dffq_1_428/Q gf180mcu_fd_sc_mcu7t5v0__dffq_4_44/CLK
+ vss gf180mcu_fd_sc_mcu7t5v0__dffq_1_428/D vdd vss gf180mcu_fd_sc_mcu7t5v0__dffq_1
Xgf180mcu_fd_sc_mcu7t5v0__dffq_1_439 vdd gf180mcu_fd_sc_mcu7t5v0__dffq_1_439/Q gf180mcu_fd_sc_mcu7t5v0__dffq_4_44/CLK
+ vss gf180mcu_fd_sc_mcu7t5v0__dffq_1_439/D vdd vss gf180mcu_fd_sc_mcu7t5v0__dffq_1
Xgf180mcu_fd_sc_mcu7t5v0__or2_1_10 vdd vss gf180mcu_fd_sc_mcu7t5v0__or2_1_10/Z gf180mcu_fd_sc_mcu7t5v0__or2_1_9/Z
+ gf180mcu_fd_sc_mcu7t5v0__or2_1_10/A2 vdd vss gf180mcu_fd_sc_mcu7t5v0__or2_1
Xgf180mcu_fd_sc_mcu7t5v0__aoi22_1_160 gf180mcu_fd_sc_mcu7t5v0__and3_2_2/A2 gf180mcu_fd_sc_mcu7t5v0__dffq_1_327/Q
+ vdd vss gf180mcu_fd_sc_mcu7t5v0__clkinv_1_289/I gf180mcu_fd_sc_mcu7t5v0__dffq_1_408/Q
+ gf180mcu_fd_sc_mcu7t5v0__nor2_4_23/ZN vdd vss gf180mcu_fd_sc_mcu7t5v0__aoi22_1
Xgf180mcu_fd_sc_mcu7t5v0__or2_1_21 vdd vss gf180mcu_fd_sc_mcu7t5v0__or2_1_21/Z gf180mcu_fd_sc_mcu7t5v0__or2_1_21/A1
+ gf180mcu_fd_sc_mcu7t5v0__or2_1_21/A2 vdd vss gf180mcu_fd_sc_mcu7t5v0__or2_1
Xgf180mcu_fd_sc_mcu7t5v0__or2_1_32 vdd vss gf180mcu_fd_sc_mcu7t5v0__or2_1_32/Z gf180mcu_fd_sc_mcu7t5v0__or2_1_32/A1
+ gf180mcu_fd_sc_mcu7t5v0__or2_1_32/A2 vdd vss gf180mcu_fd_sc_mcu7t5v0__or2_1
Xgf180mcu_fd_sc_mcu7t5v0__or2_1_43 vdd vss gf180mcu_fd_sc_mcu7t5v0__or2_1_43/Z gf180mcu_fd_sc_mcu7t5v0__or4_1_0/A2
+ gf180mcu_fd_sc_mcu7t5v0__or3_1_24/A2 vdd vss gf180mcu_fd_sc_mcu7t5v0__or2_1
Xgf180mcu_fd_sc_mcu7t5v0__aoi22_1_171 gf180mcu_fd_sc_mcu7t5v0__xor2_1_209/Z gf180mcu_fd_sc_mcu7t5v0__nor2_2_57/ZN
+ vdd vss gf180mcu_fd_sc_mcu7t5v0__oai211_1_51/B gf180mcu_fd_sc_mcu7t5v0__nor2_1_387/ZN
+ gf180mcu_fd_sc_mcu7t5v0__aoi22_1_171/A2 vdd vss gf180mcu_fd_sc_mcu7t5v0__aoi22_1
Xgf180mcu_fd_sc_mcu7t5v0__or2_1_54 vdd vss gf180mcu_fd_sc_mcu7t5v0__or2_1_54/Z gf180mcu_fd_sc_mcu7t5v0__or2_1_54/A1
+ gf180mcu_fd_sc_mcu7t5v0__or2_1_54/A2 vdd vss gf180mcu_fd_sc_mcu7t5v0__or2_1
Xgf180mcu_fd_sc_mcu7t5v0__aoi22_1_182 gf180mcu_fd_sc_mcu7t5v0__nor2_4_9/ZN gf180mcu_fd_sc_mcu7t5v0__dffq_1_458/Q
+ vdd vss gf180mcu_fd_sc_mcu7t5v0__nand2_1_248/A1 gf180mcu_fd_sc_mcu7t5v0__dffq_1_170/Q
+ gf180mcu_fd_sc_mcu7t5v0__nor2_4_8/ZN vdd vss gf180mcu_fd_sc_mcu7t5v0__aoi22_1
Xgf180mcu_fd_sc_mcu7t5v0__nor2_4_10 vdd vss gf180mcu_fd_sc_mcu7t5v0__nor2_4_10/ZN
+ gf180mcu_fd_sc_mcu7t5v0__inv_3_1/ZN gf180mcu_fd_sc_mcu7t5v0__inv_3_2/I vdd vss gf180mcu_fd_sc_mcu7t5v0__nor2_4
Xgf180mcu_fd_sc_mcu7t5v0__nor2_4_21 vdd vss gf180mcu_fd_sc_mcu7t5v0__nor2_4_21/ZN
+ gf180mcu_fd_sc_mcu7t5v0__nor2_4_22/A1 gf180mcu_fd_sc_mcu7t5v0__nor2_4_21/A2 vdd
+ vss gf180mcu_fd_sc_mcu7t5v0__nor2_4
Xgf180mcu_fd_sc_mcu7t5v0__nor2_4_32 vdd vss gf180mcu_fd_sc_mcu7t5v0__nor2_4_32/ZN
+ gf180mcu_fd_sc_mcu7t5v0__nor4_4_2/A3 gf180mcu_fd_sc_mcu7t5v0__or2_4_3/Z vdd vss
+ gf180mcu_fd_sc_mcu7t5v0__nor2_4
Xgf180mcu_fd_sc_mcu7t5v0__nor2_4_43 vdd vss gf180mcu_fd_sc_mcu7t5v0__oai22_1_1/B2
+ gf180mcu_fd_sc_mcu7t5v0__dffq_4_8/Q gf180mcu_fd_sc_mcu7t5v0__oai32_1_3/A3 vdd vss
+ gf180mcu_fd_sc_mcu7t5v0__nor2_4
Xgf180mcu_fd_sc_mcu7t5v0__nand2_4_9 vdd vss gf180mcu_fd_sc_mcu7t5v0__nand2_4_9/ZN
+ gf180mcu_fd_sc_mcu7t5v0__nor3_4_10/ZN gf180mcu_fd_sc_mcu7t5v0__nor2_4_7/ZN vdd vss
+ gf180mcu_fd_sc_mcu7t5v0__nand2_4
Xgf180mcu_fd_sc_mcu7t5v0__nand2_4_19 vdd vss gf180mcu_fd_sc_mcu7t5v0__nand2_4_19/ZN
+ gf180mcu_fd_sc_mcu7t5v0__nor3_4_10/ZN gf180mcu_fd_sc_mcu7t5v0__nor2_4_12/ZN vdd
+ vss gf180mcu_fd_sc_mcu7t5v0__nand2_4
Xgf180mcu_fd_sc_mcu7t5v0__aoi21_1_340 gf180mcu_fd_sc_mcu7t5v0__aoi21_1_7/B vdd vss
+ gf180mcu_fd_sc_mcu7t5v0__dffq_2_89/D gf180mcu_fd_sc_mcu7t5v0__nand2_1_638/ZN gf180mcu_fd_sc_mcu7t5v0__oai211_1_46/ZN
+ vdd vss gf180mcu_fd_sc_mcu7t5v0__aoi21_1
Xgf180mcu_fd_sc_mcu7t5v0__aoi21_1_351 gf180mcu_fd_sc_mcu7t5v0__xor2_1_188/Z vdd vss
+ gf180mcu_fd_sc_mcu7t5v0__or2_1_52/A1 gf180mcu_fd_sc_mcu7t5v0__nand3_1_97/A1 gf180mcu_fd_sc_mcu7t5v0__nand3_1_97/A2
+ vdd vss gf180mcu_fd_sc_mcu7t5v0__aoi21_1
Xgf180mcu_fd_sc_mcu7t5v0__aoi21_1_362 gf180mcu_fd_sc_mcu7t5v0__xor2_1_201/Z vdd vss
+ gf180mcu_fd_sc_mcu7t5v0__oai21_1_328/A2 gf180mcu_fd_sc_mcu7t5v0__nor2_2_58/ZN gf180mcu_fd_sc_mcu7t5v0__xor2_1_204/Z
+ vdd vss gf180mcu_fd_sc_mcu7t5v0__aoi21_1
Xgf180mcu_fd_sc_mcu7t5v0__aoi21_1_373 gf180mcu_fd_sc_mcu7t5v0__oai21_1_41/ZN vdd vss
+ gf180mcu_fd_sc_mcu7t5v0__aoi211_1_6/B gf180mcu_fd_sc_mcu7t5v0__mux4_4_2/I2 gf180mcu_fd_sc_mcu7t5v0__nor2_2_3/ZN
+ vdd vss gf180mcu_fd_sc_mcu7t5v0__aoi21_1
Xgf180mcu_fd_sc_mcu7t5v0__aoi22_4_12 gf180mcu_fd_sc_mcu7t5v0__nor2_4_39/ZN gf180mcu_fd_sc_mcu7t5v0__oai21_2_15/ZN
+ gf180mcu_fd_sc_mcu7t5v0__aoi22_2_8/ZN vdd vss gf180mcu_fd_sc_mcu7t5v0__xor3_1_119/A2
+ gf180mcu_fd_sc_mcu7t5v0__inv_1_22/ZN vdd vss gf180mcu_fd_sc_mcu7t5v0__aoi22_4
Xgf180mcu_fd_sc_mcu7t5v0__nand2_1_106 vdd vss gf180mcu_fd_sc_mcu7t5v0__xor3_1_32/A2
+ gf180mcu_fd_sc_mcu7t5v0__inv_8_2/I gf180mcu_fd_sc_mcu7t5v0__or4_1_1/A3 vdd vss gf180mcu_fd_sc_mcu7t5v0__nand2_1
Xgf180mcu_fd_sc_mcu7t5v0__nand2_1_117 vdd vss gf180mcu_fd_sc_mcu7t5v0__xor2_1_63/A1
+ gf180mcu_fd_sc_mcu7t5v0__inv_12_1/I gf180mcu_fd_sc_mcu7t5v0__or4_1_1/A4 vdd vss
+ gf180mcu_fd_sc_mcu7t5v0__nand2_1
Xgf180mcu_fd_sc_mcu7t5v0__nand2_1_128 vdd vss gf180mcu_fd_sc_mcu7t5v0__oai221_1_3/C
+ gf180mcu_fd_sc_mcu7t5v0__inv_8_0/I gf180mcu_fd_sc_mcu7t5v0__nor2_4_1/ZN vdd vss
+ gf180mcu_fd_sc_mcu7t5v0__nand2_1
Xgf180mcu_fd_sc_mcu7t5v0__nand2_1_139 vdd vss gf180mcu_fd_sc_mcu7t5v0__xor3_1_46/A3
+ gf180mcu_fd_sc_mcu7t5v0__inv_8_2/I gf180mcu_fd_sc_mcu7t5v0__nor4_2_2/A4 vdd vss
+ gf180mcu_fd_sc_mcu7t5v0__nand2_1
Xgf180mcu_fd_sc_mcu7t5v0__xor3_1_50 gf180mcu_fd_sc_mcu7t5v0__xor2_1_39/Z vdd vss gf180mcu_fd_sc_mcu7t5v0__xor3_1_50/Z
+ gf180mcu_fd_sc_mcu7t5v0__dffq_2_23/Q gf180mcu_fd_sc_mcu7t5v0__xor3_1_50/A2 vdd vss
+ gf180mcu_fd_sc_mcu7t5v0__xor3_1
Xgf180mcu_fd_sc_mcu7t5v0__xor3_1_61 gf180mcu_fd_sc_mcu7t5v0__xor3_1_10/Z vdd vss gf180mcu_fd_sc_mcu7t5v0__xor3_1_61/Z
+ gf180mcu_fd_sc_mcu7t5v0__xor3_1_61/A1 gf180mcu_fd_sc_mcu7t5v0__xor3_1_61/A2 vdd
+ vss gf180mcu_fd_sc_mcu7t5v0__xor3_1
Xgf180mcu_fd_sc_mcu7t5v0__xor3_1_72 gf180mcu_fd_sc_mcu7t5v0__xor3_1_72/A3 vdd vss
+ gf180mcu_fd_sc_mcu7t5v0__xor3_1_72/Z gf180mcu_fd_sc_mcu7t5v0__or3_1_13/A3 gf180mcu_fd_sc_mcu7t5v0__xor3_1_72/A2
+ vdd vss gf180mcu_fd_sc_mcu7t5v0__xor3_1
Xgf180mcu_fd_sc_mcu7t5v0__xor3_1_83 gf180mcu_fd_sc_mcu7t5v0__xor3_1_83/A3 vdd vss
+ gf180mcu_fd_sc_mcu7t5v0__xor3_1_83/Z gf180mcu_fd_sc_mcu7t5v0__xor3_1_83/A1 gf180mcu_fd_sc_mcu7t5v0__xor3_1_83/A2
+ vdd vss gf180mcu_fd_sc_mcu7t5v0__xor3_1
Xgf180mcu_fd_sc_mcu7t5v0__xor3_1_94 gf180mcu_fd_sc_mcu7t5v0__xor3_1_95/Z vdd vss gf180mcu_fd_sc_mcu7t5v0__xor3_1_94/Z
+ gf180mcu_fd_sc_mcu7t5v0__xor3_1_94/A1 gf180mcu_fd_sc_mcu7t5v0__xor3_1_94/A2 vdd
+ vss gf180mcu_fd_sc_mcu7t5v0__xor3_1
Xgf180mcu_fd_sc_mcu7t5v0__dffq_1_203 vdd gf180mcu_fd_sc_mcu7t5v0__dffq_1_203/Q gf180mcu_fd_sc_mcu7t5v0__dffq_4_8/CLK
+ vss gf180mcu_fd_sc_mcu7t5v0__dffq_1_203/D vdd vss gf180mcu_fd_sc_mcu7t5v0__dffq_1
Xgf180mcu_fd_sc_mcu7t5v0__dffq_1_214 vdd gf180mcu_fd_sc_mcu7t5v0__dffq_1_214/Q gf180mcu_fd_sc_mcu7t5v0__dffq_4_8/CLK
+ vss gf180mcu_fd_sc_mcu7t5v0__dffq_1_214/D vdd vss gf180mcu_fd_sc_mcu7t5v0__dffq_1
Xgf180mcu_fd_sc_mcu7t5v0__nor2_1_403 vdd vss gf180mcu_fd_sc_mcu7t5v0__xor3_1_108/A2
+ gf180mcu_fd_sc_mcu7t5v0__or4_1_0/A2 gf180mcu_fd_sc_mcu7t5v0__oai32_4_0/ZN vdd vss
+ gf180mcu_fd_sc_mcu7t5v0__nor2_1
Xgf180mcu_fd_sc_mcu7t5v0__dffq_1_225 vdd gf180mcu_fd_sc_mcu7t5v0__dffq_1_225/Q gf180mcu_fd_sc_mcu7t5v0__dffq_2_26/CLK
+ vss gf180mcu_fd_sc_mcu7t5v0__dffq_1_225/D vdd vss gf180mcu_fd_sc_mcu7t5v0__dffq_1
Xgf180mcu_fd_sc_mcu7t5v0__dffq_1_236 vdd gf180mcu_fd_sc_mcu7t5v0__dffq_1_236/Q gf180mcu_fd_sc_mcu7t5v0__dffq_4_8/CLK
+ vss gf180mcu_fd_sc_mcu7t5v0__dffq_1_236/D vdd vss gf180mcu_fd_sc_mcu7t5v0__dffq_1
Xgf180mcu_fd_sc_mcu7t5v0__dffq_1_247 vdd gf180mcu_fd_sc_mcu7t5v0__dffq_1_247/Q gf180mcu_fd_sc_mcu7t5v0__dffq_2_58/CLK
+ vss gf180mcu_fd_sc_mcu7t5v0__dffq_1_247/D vdd vss gf180mcu_fd_sc_mcu7t5v0__dffq_1
Xgf180mcu_fd_sc_mcu7t5v0__dffq_1_258 vdd gf180mcu_fd_sc_mcu7t5v0__dffq_1_258/Q gf180mcu_fd_sc_mcu7t5v0__dffq_1_99/CLK
+ vss gf180mcu_fd_sc_mcu7t5v0__dffq_1_258/D vdd vss gf180mcu_fd_sc_mcu7t5v0__dffq_1
Xgf180mcu_fd_sc_mcu7t5v0__dffq_1_269 vdd gf180mcu_fd_sc_mcu7t5v0__dffq_1_269/Q gf180mcu_fd_sc_mcu7t5v0__dffq_1_95/CLK
+ vss gf180mcu_fd_sc_mcu7t5v0__dffq_1_269/D vdd vss gf180mcu_fd_sc_mcu7t5v0__dffq_1
Xgf180mcu_fd_sc_mcu7t5v0__nand2_1_640 vdd vss gf180mcu_fd_sc_mcu7t5v0__oai21_1_310/B
+ gf180mcu_fd_sc_mcu7t5v0__dffq_2_88/Q gf180mcu_fd_sc_mcu7t5v0__xor3_1_154/A3 vdd
+ vss gf180mcu_fd_sc_mcu7t5v0__nand2_1
Xgf180mcu_fd_sc_mcu7t5v0__nand2_1_651 vdd vss gf180mcu_fd_sc_mcu7t5v0__nor3_1_41/A2
+ gf180mcu_fd_sc_mcu7t5v0__nor2_2_54/A1 gf180mcu_fd_sc_mcu7t5v0__nand2_1_651/A2 vdd
+ vss gf180mcu_fd_sc_mcu7t5v0__nand2_1
Xgf180mcu_fd_sc_mcu7t5v0__nand2_1_662 vdd vss gf180mcu_fd_sc_mcu7t5v0__nand4_1_22/A2
+ gf180mcu_fd_sc_mcu7t5v0__nor2_2_53/ZN gf180mcu_fd_sc_mcu7t5v0__or2_1_53/A2 vdd vss
+ gf180mcu_fd_sc_mcu7t5v0__nand2_1
Xgf180mcu_fd_sc_mcu7t5v0__nand2_1_673 vdd vss gf180mcu_fd_sc_mcu7t5v0__xnor3_1_43/A2
+ gf180mcu_fd_sc_mcu7t5v0__inv_12_1/I gf180mcu_fd_sc_mcu7t5v0__xor3_1_162/A2 vdd vss
+ gf180mcu_fd_sc_mcu7t5v0__nand2_1
Xgf180mcu_fd_sc_mcu7t5v0__nand2_1_684 vdd vss gf180mcu_fd_sc_mcu7t5v0__xnor3_1_47/A3
+ gf180mcu_fd_sc_mcu7t5v0__dffq_4_37/Q gf180mcu_fd_sc_mcu7t5v0__and4_1_3/A3 vdd vss
+ gf180mcu_fd_sc_mcu7t5v0__nand2_1
Xgf180mcu_fd_sc_mcu7t5v0__nand2_1_695 vdd vss gf180mcu_fd_sc_mcu7t5v0__oai21_1_326/B
+ gf180mcu_fd_sc_mcu7t5v0__nor3_1_41/A3 gf180mcu_fd_sc_mcu7t5v0__and2_1_150/Z vdd
+ vss gf180mcu_fd_sc_mcu7t5v0__nand2_1
Xgf180mcu_fd_sc_mcu7t5v0__dffq_1_13 vdd gf180mcu_fd_sc_mcu7t5v0__dffq_1_13/Q gf180mcu_fd_sc_mcu7t5v0__dffq_4_6/CLK
+ vss gf180mcu_fd_sc_mcu7t5v0__dffq_1_13/D vdd vss gf180mcu_fd_sc_mcu7t5v0__dffq_1
Xgf180mcu_fd_sc_mcu7t5v0__dffq_1_24 vdd gf180mcu_fd_sc_mcu7t5v0__dffq_1_24/Q gf180mcu_fd_sc_mcu7t5v0__dffq_1_99/CLK
+ vss gf180mcu_fd_sc_mcu7t5v0__dffq_1_24/D vdd vss gf180mcu_fd_sc_mcu7t5v0__dffq_1
Xgf180mcu_fd_sc_mcu7t5v0__clkinv_1_108 vdd vss gf180mcu_fd_sc_mcu7t5v0__dffq_1_74/Q
+ gf180mcu_fd_sc_mcu7t5v0__oai22_1_90/B2 vdd vss gf180mcu_fd_sc_mcu7t5v0__clkinv_1
Xgf180mcu_fd_sc_mcu7t5v0__dffq_1_35 vdd gf180mcu_fd_sc_mcu7t5v0__dffq_1_35/Q gf180mcu_fd_sc_mcu7t5v0__dffq_1_99/CLK
+ vss gf180mcu_fd_sc_mcu7t5v0__dffq_1_35/D vdd vss gf180mcu_fd_sc_mcu7t5v0__dffq_1
Xgf180mcu_fd_sc_mcu7t5v0__clkinv_1_119 vdd vss gf180mcu_fd_sc_mcu7t5v0__dffq_1_101/Q
+ gf180mcu_fd_sc_mcu7t5v0__oai22_1_118/B2 vdd vss gf180mcu_fd_sc_mcu7t5v0__clkinv_1
Xgf180mcu_fd_sc_mcu7t5v0__dffq_1_46 vdd gf180mcu_fd_sc_mcu7t5v0__dffq_1_46/Q gf180mcu_fd_sc_mcu7t5v0__dffq_4_8/CLK
+ vss gf180mcu_fd_sc_mcu7t5v0__dffq_1_46/D vdd vss gf180mcu_fd_sc_mcu7t5v0__dffq_1
Xgf180mcu_fd_sc_mcu7t5v0__dffq_1_57 vdd gf180mcu_fd_sc_mcu7t5v0__dffq_1_57/Q gf180mcu_fd_sc_mcu7t5v0__dffq_1_95/CLK
+ vss gf180mcu_fd_sc_mcu7t5v0__dffq_1_57/D vdd vss gf180mcu_fd_sc_mcu7t5v0__dffq_1
Xgf180mcu_fd_sc_mcu7t5v0__dffq_1_68 vdd gf180mcu_fd_sc_mcu7t5v0__dffq_1_68/Q gf180mcu_fd_sc_mcu7t5v0__dffq_1_95/CLK
+ vss gf180mcu_fd_sc_mcu7t5v0__dffq_1_68/D vdd vss gf180mcu_fd_sc_mcu7t5v0__dffq_1
Xgf180mcu_fd_sc_mcu7t5v0__dffq_1_79 vdd gf180mcu_fd_sc_mcu7t5v0__dffq_1_79/Q gf180mcu_fd_sc_mcu7t5v0__dffq_1_96/CLK
+ vss gf180mcu_fd_sc_mcu7t5v0__dffq_1_79/D vdd vss gf180mcu_fd_sc_mcu7t5v0__dffq_1
Xgf180mcu_fd_sc_mcu7t5v0__nand2_2_6 vdd vss gf180mcu_fd_sc_mcu7t5v0__oai211_4_1/B
+ gf180mcu_fd_sc_mcu7t5v0__inv_1_2/ZN gf180mcu_fd_sc_mcu7t5v0__nor2_4_2/ZN vdd vss
+ gf180mcu_fd_sc_mcu7t5v0__nand2_2
Xgf180mcu_fd_sc_mcu7t5v0__aoi21_1_170 gf180mcu_fd_sc_mcu7t5v0__aoi21_1_170/B vdd vss
+ gf180mcu_fd_sc_mcu7t5v0__dffq_1_381/D gf180mcu_fd_sc_mcu7t5v0__aoi22_4_8/ZN gf180mcu_fd_sc_mcu7t5v0__aoi21_1_170/A2
+ vdd vss gf180mcu_fd_sc_mcu7t5v0__aoi21_1
Xgf180mcu_fd_sc_mcu7t5v0__aoi21_1_181 gf180mcu_fd_sc_mcu7t5v0__aoi21_1_181/B vdd vss
+ gf180mcu_fd_sc_mcu7t5v0__aoi221_1_30/C gf180mcu_fd_sc_mcu7t5v0__inv_8_2/ZN gf180mcu_fd_sc_mcu7t5v0__or2_1_24/A2
+ vdd vss gf180mcu_fd_sc_mcu7t5v0__aoi21_1
Xgf180mcu_fd_sc_mcu7t5v0__aoi21_1_192 gf180mcu_fd_sc_mcu7t5v0__or3_1_12/A3 vdd vss
+ gf180mcu_fd_sc_mcu7t5v0__xor2_1_100/A2 gf180mcu_fd_sc_mcu7t5v0__inv_1_13/I gf180mcu_fd_sc_mcu7t5v0__xor3_1_74/A2
+ vdd vss gf180mcu_fd_sc_mcu7t5v0__aoi21_1
Xgf180mcu_fd_sc_mcu7t5v0__aoi22_1_7 gf180mcu_fd_sc_mcu7t5v0__nand4_1_1/ZN gf180mcu_fd_sc_mcu7t5v0__aoi22_1_7/B2
+ vdd vss gf180mcu_fd_sc_mcu7t5v0__nor2_1_46/A2 gf180mcu_fd_sc_mcu7t5v0__dffq_2_14/Q
+ gf180mcu_fd_sc_mcu7t5v0__or2_4_4/Z vdd vss gf180mcu_fd_sc_mcu7t5v0__aoi22_1
Xgf180mcu_fd_sc_mcu7t5v0__buf_8_3 gf180mcu_fd_sc_mcu7t5v0__buf_8_5/I gf180mcu_fd_sc_mcu7t5v0__buf_8_8/I
+ vdd vss vdd vss gf180mcu_fd_sc_mcu7t5v0__buf_8
Xgf180mcu_fd_sc_mcu7t5v0__oai22_1_102 gf180mcu_fd_sc_mcu7t5v0__nand2_4_14/ZN gf180mcu_fd_sc_mcu7t5v0__nand2_2_32/ZN
+ gf180mcu_fd_sc_mcu7t5v0__oai22_1_102/B2 vdd vss gf180mcu_fd_sc_mcu7t5v0__dffq_1_80/D
+ gf180mcu_fd_sc_mcu7t5v0__aoi21_4_3/ZN vdd vss gf180mcu_fd_sc_mcu7t5v0__oai22_1
Xgf180mcu_fd_sc_mcu7t5v0__oai22_1_113 gf180mcu_fd_sc_mcu7t5v0__oai22_1_99/A2 gf180mcu_fd_sc_mcu7t5v0__oai22_1_99/B1
+ gf180mcu_fd_sc_mcu7t5v0__oai22_1_113/B2 vdd vss gf180mcu_fd_sc_mcu7t5v0__dffq_1_113/D
+ gf180mcu_fd_sc_mcu7t5v0__oai22_1_88/A1 vdd vss gf180mcu_fd_sc_mcu7t5v0__oai22_1
Xgf180mcu_fd_sc_mcu7t5v0__oai22_1_124 gf180mcu_fd_sc_mcu7t5v0__nand2_4_17/ZN gf180mcu_fd_sc_mcu7t5v0__nand2_2_23/ZN
+ gf180mcu_fd_sc_mcu7t5v0__oai22_1_124/B2 vdd vss gf180mcu_fd_sc_mcu7t5v0__dffq_1_115/D
+ gf180mcu_fd_sc_mcu7t5v0__oai21_4_9/ZN vdd vss gf180mcu_fd_sc_mcu7t5v0__oai22_1
Xgf180mcu_fd_sc_mcu7t5v0__oai22_1_135 gf180mcu_fd_sc_mcu7t5v0__nand2_4_18/ZN gf180mcu_fd_sc_mcu7t5v0__nand2_2_25/ZN
+ gf180mcu_fd_sc_mcu7t5v0__oai22_1_135/B2 vdd vss gf180mcu_fd_sc_mcu7t5v0__dffq_1_123/D
+ gf180mcu_fd_sc_mcu7t5v0__aoi21_4_1/ZN vdd vss gf180mcu_fd_sc_mcu7t5v0__oai22_1
Xgf180mcu_fd_sc_mcu7t5v0__oai22_1_146 gf180mcu_fd_sc_mcu7t5v0__nand2_4_21/ZN gf180mcu_fd_sc_mcu7t5v0__nand2_2_28/ZN
+ gf180mcu_fd_sc_mcu7t5v0__oai22_1_146/B2 vdd vss gf180mcu_fd_sc_mcu7t5v0__dffq_1_139/D
+ gf180mcu_fd_sc_mcu7t5v0__aoi21_4_4/ZN vdd vss gf180mcu_fd_sc_mcu7t5v0__oai22_1
Xgf180mcu_fd_sc_mcu7t5v0__oai22_1_157 gf180mcu_fd_sc_mcu7t5v0__nand2_4_21/ZN gf180mcu_fd_sc_mcu7t5v0__nand2_2_28/ZN
+ gf180mcu_fd_sc_mcu7t5v0__oai22_1_157/B2 vdd vss gf180mcu_fd_sc_mcu7t5v0__dffq_1_154/D
+ gf180mcu_fd_sc_mcu7t5v0__aoi21_4_5/ZN vdd vss gf180mcu_fd_sc_mcu7t5v0__oai22_1
Xgf180mcu_fd_sc_mcu7t5v0__oai22_1_168 gf180mcu_fd_sc_mcu7t5v0__nand2_4_22/ZN gf180mcu_fd_sc_mcu7t5v0__nand2_2_29/ZN
+ gf180mcu_fd_sc_mcu7t5v0__oai22_1_168/B2 vdd vss gf180mcu_fd_sc_mcu7t5v0__dffq_1_186/D
+ gf180mcu_fd_sc_mcu7t5v0__aoi21_4_4/ZN vdd vss gf180mcu_fd_sc_mcu7t5v0__oai22_1
Xgf180mcu_fd_sc_mcu7t5v0__oai221_1_7 gf180mcu_fd_sc_mcu7t5v0__xor2_1_154/Z gf180mcu_fd_sc_mcu7t5v0__oai221_1_7/C
+ vdd vss gf180mcu_fd_sc_mcu7t5v0__oai221_1_7/ZN gf180mcu_fd_sc_mcu7t5v0__oai221_1_7/A1
+ gf180mcu_fd_sc_mcu7t5v0__xor2_2_2/Z gf180mcu_fd_sc_mcu7t5v0__clkinv_2_7/I vdd vss
+ gf180mcu_fd_sc_mcu7t5v0__oai221_1
Xgf180mcu_fd_sc_mcu7t5v0__oai22_1_179 gf180mcu_fd_sc_mcu7t5v0__nand2_4_24/ZN gf180mcu_fd_sc_mcu7t5v0__nand2_2_52/ZN
+ gf180mcu_fd_sc_mcu7t5v0__oai22_1_179/B2 vdd vss gf180mcu_fd_sc_mcu7t5v0__dffq_1_189/D
+ gf180mcu_fd_sc_mcu7t5v0__aoi21_4_1/ZN vdd vss gf180mcu_fd_sc_mcu7t5v0__oai22_1
Xgf180mcu_fd_sc_mcu7t5v0__xnor3_1_18 gf180mcu_fd_sc_mcu7t5v0__xnor3_1_18/A3 vdd vss
+ gf180mcu_fd_sc_mcu7t5v0__xor2_1_79/A1 gf180mcu_fd_sc_mcu7t5v0__xnor3_1_18/A1 gf180mcu_fd_sc_mcu7t5v0__xnor3_1_18/A2
+ vdd vss gf180mcu_fd_sc_mcu7t5v0__xnor3_1
Xgf180mcu_fd_sc_mcu7t5v0__xnor3_1_29 gf180mcu_fd_sc_mcu7t5v0__xnor3_1_29/A3 vdd vss
+ gf180mcu_fd_sc_mcu7t5v0__xor3_1_95/A3 gf180mcu_fd_sc_mcu7t5v0__xnor3_1_29/A1 gf180mcu_fd_sc_mcu7t5v0__xnor3_1_29/A2
+ vdd vss gf180mcu_fd_sc_mcu7t5v0__xnor3_1
Xgf180mcu_fd_sc_mcu7t5v0__nor2_1_11 vdd vss gf180mcu_fd_sc_mcu7t5v0__oai21_1_3/A2
+ gf180mcu_fd_sc_mcu7t5v0__or3_2_0/A1 gf180mcu_fd_sc_mcu7t5v0__xor3_1_7/Z vdd vss
+ gf180mcu_fd_sc_mcu7t5v0__nor2_1
Xgf180mcu_fd_sc_mcu7t5v0__nor2_1_22 vdd vss gf180mcu_fd_sc_mcu7t5v0__nor2_1_22/ZN
+ gf180mcu_fd_sc_mcu7t5v0__nor2_1_22/A1 gf180mcu_fd_sc_mcu7t5v0__nor3_1_3/A2 vdd vss
+ gf180mcu_fd_sc_mcu7t5v0__nor2_1
Xgf180mcu_fd_sc_mcu7t5v0__nor2_1_33 vdd vss gf180mcu_fd_sc_mcu7t5v0__nor2_1_33/ZN
+ gf180mcu_fd_sc_mcu7t5v0__inv_4_6/ZN gf180mcu_fd_sc_mcu7t5v0__or3_1_9/A2 vdd vss
+ gf180mcu_fd_sc_mcu7t5v0__nor2_1
Xgf180mcu_fd_sc_mcu7t5v0__nor2_1_44 vdd vss gf180mcu_fd_sc_mcu7t5v0__nor2_1_44/ZN
+ gf180mcu_fd_sc_mcu7t5v0__dffq_1_2/Q gf180mcu_fd_sc_mcu7t5v0__nor2_4_15/ZN vdd vss
+ gf180mcu_fd_sc_mcu7t5v0__nor2_1
Xgf180mcu_fd_sc_mcu7t5v0__nor2_1_55 vdd vss gf180mcu_fd_sc_mcu7t5v0__nor2_1_55/ZN
+ gf180mcu_fd_sc_mcu7t5v0__oai31_1_0/B gf180mcu_fd_sc_mcu7t5v0__nor2_1_55/A2 vdd vss
+ gf180mcu_fd_sc_mcu7t5v0__nor2_1
Xgf180mcu_fd_sc_mcu7t5v0__nor2_1_66 vdd vss gf180mcu_fd_sc_mcu7t5v0__nor2_1_66/ZN
+ gf180mcu_fd_sc_mcu7t5v0__dffq_2_4/Q gf180mcu_fd_sc_mcu7t5v0__xor2_2_0/Z vdd vss
+ gf180mcu_fd_sc_mcu7t5v0__nor2_1
Xgf180mcu_fd_sc_mcu7t5v0__nor2_1_77 vdd vss gf180mcu_fd_sc_mcu7t5v0__dffq_2_23/D gf180mcu_fd_sc_mcu7t5v0__nor2_1_77/A1
+ gf180mcu_fd_sc_mcu7t5v0__nor2_1_77/A2 vdd vss gf180mcu_fd_sc_mcu7t5v0__nor2_1
Xgf180mcu_fd_sc_mcu7t5v0__nor2_1_88 vdd vss gf180mcu_fd_sc_mcu7t5v0__nor2_1_88/ZN
+ gf180mcu_fd_sc_mcu7t5v0__nor2_1_94/A1 gf180mcu_fd_sc_mcu7t5v0__or2_1_17/A2 vdd vss
+ gf180mcu_fd_sc_mcu7t5v0__nor2_1
Xgf180mcu_fd_sc_mcu7t5v0__nor2_1_99 vdd vss gf180mcu_fd_sc_mcu7t5v0__oai32_1_1/A2
+ gf180mcu_fd_sc_mcu7t5v0__xor3_1_47/Z gf180mcu_fd_sc_mcu7t5v0__xor3_1_1/A3 vdd vss
+ gf180mcu_fd_sc_mcu7t5v0__nor2_1
Xgf180mcu_fd_sc_mcu7t5v0__nor2_1_200 vdd vss gf180mcu_fd_sc_mcu7t5v0__dffq_1_357/D
+ gf180mcu_fd_sc_mcu7t5v0__and2_1_65/Z gf180mcu_fd_sc_mcu7t5v0__nor2_1_200/A2 vdd
+ vss gf180mcu_fd_sc_mcu7t5v0__nor2_1
Xgf180mcu_fd_sc_mcu7t5v0__nor2_1_211 vdd vss gf180mcu_fd_sc_mcu7t5v0__nor2_1_211/ZN
+ gf180mcu_fd_sc_mcu7t5v0__mux4_4_4/I0 gf180mcu_fd_sc_mcu7t5v0__and2_1_84/Z vdd vss
+ gf180mcu_fd_sc_mcu7t5v0__nor2_1
Xgf180mcu_fd_sc_mcu7t5v0__nor2_1_222 vdd vss gf180mcu_fd_sc_mcu7t5v0__dffq_4_18/D
+ gf180mcu_fd_sc_mcu7t5v0__aoi21_1_7/B gf180mcu_fd_sc_mcu7t5v0__nor2_1_222/A2 vdd
+ vss gf180mcu_fd_sc_mcu7t5v0__nor2_1
Xgf180mcu_fd_sc_mcu7t5v0__nor2_1_233 vdd vss gf180mcu_fd_sc_mcu7t5v0__dffq_2_51/D
+ gf180mcu_fd_sc_mcu7t5v0__or2_1_23/A1 gf180mcu_fd_sc_mcu7t5v0__nor2_1_233/A2 vdd
+ vss gf180mcu_fd_sc_mcu7t5v0__nor2_1
Xgf180mcu_fd_sc_mcu7t5v0__nor2_1_244 vdd vss gf180mcu_fd_sc_mcu7t5v0__nor2_1_244/ZN
+ gf180mcu_fd_sc_mcu7t5v0__nor2_1_244/A1 gf180mcu_fd_sc_mcu7t5v0__xor2_1_110/Z vdd
+ vss gf180mcu_fd_sc_mcu7t5v0__nor2_1
Xgf180mcu_fd_sc_mcu7t5v0__nor2_1_255 vdd vss gf180mcu_fd_sc_mcu7t5v0__nor2_1_255/ZN
+ gf180mcu_fd_sc_mcu7t5v0__xnor2_1_42/A1 gf180mcu_fd_sc_mcu7t5v0__xnor2_1_43/ZN vdd
+ vss gf180mcu_fd_sc_mcu7t5v0__nor2_1
Xgf180mcu_fd_sc_mcu7t5v0__clkinv_2_9 vdd vss gf180mcu_fd_sc_mcu7t5v0__mux4_4_4/I1
+ gf180mcu_fd_sc_mcu7t5v0__xor2_1_147/A1 vdd vss gf180mcu_fd_sc_mcu7t5v0__clkinv_2
Xgf180mcu_fd_sc_mcu7t5v0__nor2_1_266 vdd vss gf180mcu_fd_sc_mcu7t5v0__or2_1_35/A2
+ gf180mcu_fd_sc_mcu7t5v0__and2_1_98/A1 gf180mcu_fd_sc_mcu7t5v0__xor3_1_88/Z vdd vss
+ gf180mcu_fd_sc_mcu7t5v0__nor2_1
Xgf180mcu_fd_sc_mcu7t5v0__nor2_1_277 vdd vss gf180mcu_fd_sc_mcu7t5v0__nor2_1_277/ZN
+ gf180mcu_fd_sc_mcu7t5v0__or3_1_18/A1 gf180mcu_fd_sc_mcu7t5v0__aoi21_2_9/ZN vdd vss
+ gf180mcu_fd_sc_mcu7t5v0__nor2_1
Xgf180mcu_fd_sc_mcu7t5v0__xor3_1_6 gf180mcu_fd_sc_mcu7t5v0__xor3_1_0/Z vdd vss gf180mcu_fd_sc_mcu7t5v0__xor3_1_6/Z
+ gf180mcu_fd_sc_mcu7t5v0__xor3_1_6/A1 gf180mcu_fd_sc_mcu7t5v0__xor3_1_6/A2 vdd vss
+ gf180mcu_fd_sc_mcu7t5v0__xor3_1
Xgf180mcu_fd_sc_mcu7t5v0__nor2_1_288 vdd vss gf180mcu_fd_sc_mcu7t5v0__xor3_1_102/A2
+ gf180mcu_fd_sc_mcu7t5v0__or3_1_24/A1 gf180mcu_fd_sc_mcu7t5v0__nor2_2_32/A2 vdd vss
+ gf180mcu_fd_sc_mcu7t5v0__nor2_1
Xgf180mcu_fd_sc_mcu7t5v0__nor2_1_299 vdd vss gf180mcu_fd_sc_mcu7t5v0__nor2_1_299/ZN
+ gf180mcu_fd_sc_mcu7t5v0__mux4_4_9/S0 gf180mcu_fd_sc_mcu7t5v0__inv_1_16/ZN vdd vss
+ gf180mcu_fd_sc_mcu7t5v0__nor2_1
Xgf180mcu_fd_sc_mcu7t5v0__nand2_1_470 vdd vss gf180mcu_fd_sc_mcu7t5v0__nand4_1_15/A4
+ gf180mcu_fd_sc_mcu7t5v0__or4_1_0/A1 gf180mcu_fd_sc_mcu7t5v0__nor2_2_37/ZN vdd vss
+ gf180mcu_fd_sc_mcu7t5v0__nand2_1
Xgf180mcu_fd_sc_mcu7t5v0__nand2_1_481 vdd vss gf180mcu_fd_sc_mcu7t5v0__nand4_1_14/A3
+ gf180mcu_fd_sc_mcu7t5v0__nand3_1_70/A2 gf180mcu_fd_sc_mcu7t5v0__nor2_1_276/ZN vdd
+ vss gf180mcu_fd_sc_mcu7t5v0__nand2_1
Xgf180mcu_fd_sc_mcu7t5v0__nand2_1_492 vdd vss gf180mcu_fd_sc_mcu7t5v0__xnor3_1_29/A1
+ gf180mcu_fd_sc_mcu7t5v0__or2_1_7/A1 gf180mcu_fd_sc_mcu7t5v0__nor4_2_5/A1 vdd vss
+ gf180mcu_fd_sc_mcu7t5v0__nand2_1
Xgf180mcu_fd_sc_mcu7t5v0__oai21_1_304 vdd gf180mcu_fd_sc_mcu7t5v0__xor3_1_137/A2 gf180mcu_fd_sc_mcu7t5v0__nor2_1_381/ZN
+ gf180mcu_fd_sc_mcu7t5v0__oai21_1_302/B gf180mcu_fd_sc_mcu7t5v0__nor2_1_380/A1 vss
+ vdd vss gf180mcu_fd_sc_mcu7t5v0__oai21_1
Xgf180mcu_fd_sc_mcu7t5v0__oai21_1_315 vdd gf180mcu_fd_sc_mcu7t5v0__nor2_2_56/ZN gf180mcu_fd_sc_mcu7t5v0__xor3_1_163/Z
+ gf180mcu_fd_sc_mcu7t5v0__oai221_1_14/A2 gf180mcu_fd_sc_mcu7t5v0__and2_1_142/A1 vss
+ vdd vss gf180mcu_fd_sc_mcu7t5v0__oai21_1
Xgf180mcu_fd_sc_mcu7t5v0__oai21_1_326 vdd gf180mcu_fd_sc_mcu7t5v0__oai21_1_326/B gf180mcu_fd_sc_mcu7t5v0__nor2_1_397/ZN
+ gf180mcu_fd_sc_mcu7t5v0__xor2_1_199/A1 gf180mcu_fd_sc_mcu7t5v0__xnor3_1_46/A3 vss
+ vdd vss gf180mcu_fd_sc_mcu7t5v0__oai21_1
Xgf180mcu_fd_sc_mcu7t5v0__oai21_1_337 vdd gf180mcu_fd_sc_mcu7t5v0__oai21_1_337/B gf180mcu_fd_sc_mcu7t5v0__oai21_1_337/A2
+ gf180mcu_fd_sc_mcu7t5v0__oai21_1_25/B gf180mcu_fd_sc_mcu7t5v0__oai21_1_28/A1 vss
+ vdd vss gf180mcu_fd_sc_mcu7t5v0__oai21_1
Xgf180mcu_fd_sc_mcu7t5v0__xnor2_1_8 vdd vss gf180mcu_fd_sc_mcu7t5v0__xor3_1_8/A3 gf180mcu_fd_sc_mcu7t5v0__xnor3_1_7/ZN
+ gf180mcu_fd_sc_mcu7t5v0__xnor2_1_8/A2 vdd vss gf180mcu_fd_sc_mcu7t5v0__xnor2_1
Xgf180mcu_fd_sc_mcu7t5v0__aoi22_1_13 gf180mcu_fd_sc_mcu7t5v0__nor2_2_9/ZN gf180mcu_fd_sc_mcu7t5v0__and4_1_0/A4
+ vdd vss gf180mcu_fd_sc_mcu7t5v0__nor2_1_92/A2 gf180mcu_fd_sc_mcu7t5v0__inv_2_4/I
+ gf180mcu_fd_sc_mcu7t5v0__inv_4_0/I vdd vss gf180mcu_fd_sc_mcu7t5v0__aoi22_1
Xgf180mcu_fd_sc_mcu7t5v0__aoi22_1_24 gf180mcu_fd_sc_mcu7t5v0__nor2_4_11/ZN gf180mcu_fd_sc_mcu7t5v0__dffq_1_33/Q
+ vdd vss gf180mcu_fd_sc_mcu7t5v0__aoi22_1_24/ZN gf180mcu_fd_sc_mcu7t5v0__dffq_1_19/Q
+ gf180mcu_fd_sc_mcu7t5v0__nor2_4_10/ZN vdd vss gf180mcu_fd_sc_mcu7t5v0__aoi22_1
Xgf180mcu_fd_sc_mcu7t5v0__aoi22_1_35 gf180mcu_fd_sc_mcu7t5v0__nor2_4_11/ZN gf180mcu_fd_sc_mcu7t5v0__dffq_1_59/Q
+ vdd vss gf180mcu_fd_sc_mcu7t5v0__aoi22_1_35/ZN gf180mcu_fd_sc_mcu7t5v0__dffq_1_61/Q
+ gf180mcu_fd_sc_mcu7t5v0__nor2_4_10/ZN vdd vss gf180mcu_fd_sc_mcu7t5v0__aoi22_1
Xgf180mcu_fd_sc_mcu7t5v0__aoi22_1_46 gf180mcu_fd_sc_mcu7t5v0__nor2_4_9/ZN gf180mcu_fd_sc_mcu7t5v0__dffq_1_79/Q
+ vdd vss gf180mcu_fd_sc_mcu7t5v0__aoi22_1_46/ZN gf180mcu_fd_sc_mcu7t5v0__dffq_1_84/Q
+ gf180mcu_fd_sc_mcu7t5v0__nor2_4_8/ZN vdd vss gf180mcu_fd_sc_mcu7t5v0__aoi22_1
Xgf180mcu_fd_sc_mcu7t5v0__aoi22_1_57 gf180mcu_fd_sc_mcu7t5v0__nor2_4_9/ZN gf180mcu_fd_sc_mcu7t5v0__dffq_1_112/Q
+ vdd vss gf180mcu_fd_sc_mcu7t5v0__aoi22_1_57/ZN gf180mcu_fd_sc_mcu7t5v0__dffq_1_83/Q
+ gf180mcu_fd_sc_mcu7t5v0__nor2_4_8/ZN vdd vss gf180mcu_fd_sc_mcu7t5v0__aoi22_1
Xgf180mcu_fd_sc_mcu7t5v0__aoi22_1_68 gf180mcu_fd_sc_mcu7t5v0__nor2_4_9/ZN gf180mcu_fd_sc_mcu7t5v0__dffq_1_113/Q
+ vdd vss gf180mcu_fd_sc_mcu7t5v0__aoi22_1_68/ZN gf180mcu_fd_sc_mcu7t5v0__dffq_1_110/Q
+ gf180mcu_fd_sc_mcu7t5v0__nor2_4_8/ZN vdd vss gf180mcu_fd_sc_mcu7t5v0__aoi22_1
Xgf180mcu_fd_sc_mcu7t5v0__aoi22_1_79 gf180mcu_fd_sc_mcu7t5v0__nor2_4_11/ZN gf180mcu_fd_sc_mcu7t5v0__dffq_1_142/Q
+ vdd vss gf180mcu_fd_sc_mcu7t5v0__aoi22_1_79/ZN gf180mcu_fd_sc_mcu7t5v0__dffq_1_141/Q
+ gf180mcu_fd_sc_mcu7t5v0__nor2_4_10/ZN vdd vss gf180mcu_fd_sc_mcu7t5v0__aoi22_1
Xgf180mcu_fd_sc_mcu7t5v0__xnor2_1_40 vdd vss gf180mcu_fd_sc_mcu7t5v0__aoi21_2_7/A2
+ gf180mcu_fd_sc_mcu7t5v0__xor3_1_83/Z gf180mcu_fd_sc_mcu7t5v0__xnor2_1_41/ZN vdd
+ vss gf180mcu_fd_sc_mcu7t5v0__xnor2_1
Xgf180mcu_fd_sc_mcu7t5v0__or3_1_6 gf180mcu_fd_sc_mcu7t5v0__or3_1_6/A3 vdd vss gf180mcu_fd_sc_mcu7t5v0__or3_1_6/Z
+ gf180mcu_fd_sc_mcu7t5v0__or3_1_6/A1 gf180mcu_fd_sc_mcu7t5v0__or3_1_6/A2 vdd vss
+ gf180mcu_fd_sc_mcu7t5v0__or3_1
Xgf180mcu_fd_sc_mcu7t5v0__xnor2_1_51 vdd vss gf180mcu_fd_sc_mcu7t5v0__xnor3_1_32/A2
+ gf180mcu_fd_sc_mcu7t5v0__xnor2_1_51/A1 gf180mcu_fd_sc_mcu7t5v0__oai22_2_1/ZN vdd
+ vss gf180mcu_fd_sc_mcu7t5v0__xnor2_1
Xgf180mcu_fd_sc_mcu7t5v0__xnor2_1_62 vdd vss gf180mcu_fd_sc_mcu7t5v0__xor3_1_136/A3
+ gf180mcu_fd_sc_mcu7t5v0__xnor2_1_62/A1 gf180mcu_fd_sc_mcu7t5v0__nor3_1_40/A3 vdd
+ vss gf180mcu_fd_sc_mcu7t5v0__xnor2_1
Xgf180mcu_fd_sc_mcu7t5v0__xnor2_1_73 vdd vss gf180mcu_fd_sc_mcu7t5v0__xor2_1_202/A1
+ gf180mcu_fd_sc_mcu7t5v0__xnor2_1_73/A1 gf180mcu_fd_sc_mcu7t5v0__xnor2_1_73/A2 vdd
+ vss gf180mcu_fd_sc_mcu7t5v0__xnor2_1
Xgf180mcu_fd_sc_mcu7t5v0__xnor2_1_84 vdd vss gf180mcu_fd_sc_mcu7t5v0__and3_1_5/A3
+ gf180mcu_fd_sc_mcu7t5v0__mux4_4_5/I1 gf180mcu_fd_sc_mcu7t5v0__xor2_1_219/Z vdd vss
+ gf180mcu_fd_sc_mcu7t5v0__xnor2_1
Xgf180mcu_fd_sc_mcu7t5v0__nor3_2_10 gf180mcu_fd_sc_mcu7t5v0__inv_4_5/ZN vdd vss gf180mcu_fd_sc_mcu7t5v0__oai32_4_1/A2
+ gf180mcu_fd_sc_mcu7t5v0__nor3_2_10/A1 gf180mcu_fd_sc_mcu7t5v0__or2_2_1/A1 vdd vss
+ gf180mcu_fd_sc_mcu7t5v0__nor3_2
Xgf180mcu_fd_sc_mcu7t5v0__nand3_2_19 gf180mcu_fd_sc_mcu7t5v0__oai32_1_3/A3 vdd vss
+ gf180mcu_fd_sc_mcu7t5v0__oai21_1_16/A1 gf180mcu_fd_sc_mcu7t5v0__nor2_2_15/A2 gf180mcu_fd_sc_mcu7t5v0__oai32_1_3/B2
+ vdd vss gf180mcu_fd_sc_mcu7t5v0__nand3_2
Xgf180mcu_fd_sc_mcu7t5v0__mux4_4_5 gf180mcu_fd_sc_mcu7t5v0__mux4_4_5/I0 vss vdd gf180mcu_fd_sc_mcu7t5v0__or2_1_5/A1
+ gf180mcu_fd_sc_mcu7t5v0__mux4_4_5/I1 gf180mcu_fd_sc_mcu7t5v0__inv_1_6/I gf180mcu_fd_sc_mcu7t5v0__mux4_4_5/I3
+ gf180mcu_fd_sc_mcu7t5v0__or3_2_3/A2 gf180mcu_fd_sc_mcu7t5v0__inv_1_5/I vdd vss gf180mcu_fd_sc_mcu7t5v0__mux4_4
Xgf180mcu_fd_sc_mcu7t5v0__aoi21_1_90 gf180mcu_fd_sc_mcu7t5v0__aoi21_1_90/B vdd vss
+ gf180mcu_fd_sc_mcu7t5v0__oai21_1_54/A2 gf180mcu_fd_sc_mcu7t5v0__nor2_4_3/ZN gf180mcu_fd_sc_mcu7t5v0__xor3_1_56/Z
+ vdd vss gf180mcu_fd_sc_mcu7t5v0__aoi21_1
Xgf180mcu_fd_sc_mcu7t5v0__aoi221_2_5 gf180mcu_fd_sc_mcu7t5v0__nor2_4_14/ZN gf180mcu_fd_sc_mcu7t5v0__dffq_1_288/Q
+ vdd vss gf180mcu_fd_sc_mcu7t5v0__aoi221_2_5/ZN gf180mcu_fd_sc_mcu7t5v0__dffq_1_315/Q
+ gf180mcu_fd_sc_mcu7t5v0__or2_1_34/A2 gf180mcu_fd_sc_mcu7t5v0__nor3_1_10/ZN vdd vss
+ gf180mcu_fd_sc_mcu7t5v0__aoi221_2
Xgf180mcu_fd_sc_mcu7t5v0__oai21_1_101 vdd gf180mcu_fd_sc_mcu7t5v0__nor3_2_3/ZN gf180mcu_fd_sc_mcu7t5v0__or3_1_10/A3
+ gf180mcu_fd_sc_mcu7t5v0__oai21_1_101/ZN gf180mcu_fd_sc_mcu7t5v0__or3_1_10/A1 vss
+ vdd vss gf180mcu_fd_sc_mcu7t5v0__oai21_1
Xgf180mcu_fd_sc_mcu7t5v0__oai21_1_112 vdd gf180mcu_fd_sc_mcu7t5v0__buf_8_7/Z gf180mcu_fd_sc_mcu7t5v0__nor2_4_31/ZN
+ gf180mcu_fd_sc_mcu7t5v0__aoi21_1_131/B gf180mcu_fd_sc_mcu7t5v0__dffq_1_304/Q vss
+ vdd vss gf180mcu_fd_sc_mcu7t5v0__oai21_1
Xgf180mcu_fd_sc_mcu7t5v0__oai21_1_123 vdd gf180mcu_fd_sc_mcu7t5v0__and2_4_3/Z gf180mcu_fd_sc_mcu7t5v0__or2_1_34/A2
+ gf180mcu_fd_sc_mcu7t5v0__aoi21_1_141/B gf180mcu_fd_sc_mcu7t5v0__or3_2_3/A3 vss vdd
+ vss gf180mcu_fd_sc_mcu7t5v0__oai21_1
Xgf180mcu_fd_sc_mcu7t5v0__nor2_2_7 vdd vss gf180mcu_fd_sc_mcu7t5v0__nor2_2_7/ZN gf180mcu_fd_sc_mcu7t5v0__xor3_1_34/Z
+ gf180mcu_fd_sc_mcu7t5v0__nor2_2_7/A2 vdd vss gf180mcu_fd_sc_mcu7t5v0__nor2_2
Xgf180mcu_fd_sc_mcu7t5v0__oai21_1_134 vdd gf180mcu_fd_sc_mcu7t5v0__buf_8_6/Z gf180mcu_fd_sc_mcu7t5v0__nand2_4_40/ZN
+ gf180mcu_fd_sc_mcu7t5v0__aoi21_1_160/B gf180mcu_fd_sc_mcu7t5v0__dffq_1_325/Q vss
+ vdd vss gf180mcu_fd_sc_mcu7t5v0__oai21_1
Xgf180mcu_fd_sc_mcu7t5v0__oai21_1_145 vdd gf180mcu_fd_sc_mcu7t5v0__buf_8_8/Z gf180mcu_fd_sc_mcu7t5v0__nand3_1_55/A2
+ gf180mcu_fd_sc_mcu7t5v0__aoi21_1_149/B gf180mcu_fd_sc_mcu7t5v0__dffq_1_324/Q vss
+ vdd vss gf180mcu_fd_sc_mcu7t5v0__oai21_1
Xgf180mcu_fd_sc_mcu7t5v0__oai21_1_156 vdd gf180mcu_fd_sc_mcu7t5v0__oai21_1_157/B gf180mcu_fd_sc_mcu7t5v0__and2_1_52/Z
+ gf180mcu_fd_sc_mcu7t5v0__nor2_1_189/A2 gf180mcu_fd_sc_mcu7t5v0__nor4_1_0/A1 vss
+ vdd vss gf180mcu_fd_sc_mcu7t5v0__oai21_1
Xgf180mcu_fd_sc_mcu7t5v0__oai21_1_167 vdd gf180mcu_fd_sc_mcu7t5v0__or2_1_20/Z gf180mcu_fd_sc_mcu7t5v0__nand2_4_40/ZN
+ gf180mcu_fd_sc_mcu7t5v0__oai21_1_167/ZN gf180mcu_fd_sc_mcu7t5v0__and3_1_9/Z vss
+ vdd vss gf180mcu_fd_sc_mcu7t5v0__oai21_1
Xgf180mcu_fd_sc_mcu7t5v0__oai21_1_178 vdd gf180mcu_fd_sc_mcu7t5v0__or3_1_13/A3 gf180mcu_fd_sc_mcu7t5v0__inv_1_13/I
+ gf180mcu_fd_sc_mcu7t5v0__nand4_2_2/A3 gf180mcu_fd_sc_mcu7t5v0__inv_8_0/ZN vss vdd
+ vss gf180mcu_fd_sc_mcu7t5v0__oai21_1
Xgf180mcu_fd_sc_mcu7t5v0__oai21_1_189 vdd gf180mcu_fd_sc_mcu7t5v0__buf_8_7/Z gf180mcu_fd_sc_mcu7t5v0__nor3_4_15/ZN
+ gf180mcu_fd_sc_mcu7t5v0__aoi21_1_205/B gf180mcu_fd_sc_mcu7t5v0__dffq_1_398/Q vss
+ vdd vss gf180mcu_fd_sc_mcu7t5v0__oai21_1
Xgf180mcu_fd_sc_mcu7t5v0__nand2_2_30 vdd vss gf180mcu_fd_sc_mcu7t5v0__nand2_2_30/ZN
+ gf180mcu_fd_sc_mcu7t5v0__buf_8_2/Z gf180mcu_fd_sc_mcu7t5v0__nand2_4_23/ZN vdd vss
+ gf180mcu_fd_sc_mcu7t5v0__nand2_2
Xgf180mcu_fd_sc_mcu7t5v0__nand2_2_41 vdd vss gf180mcu_fd_sc_mcu7t5v0__nor2_4_7/A2
+ gf180mcu_fd_sc_mcu7t5v0__or2_2_0/A1 gf180mcu_fd_sc_mcu7t5v0__or2_2_0/A2 vdd vss
+ gf180mcu_fd_sc_mcu7t5v0__nand2_2
Xgf180mcu_fd_sc_mcu7t5v0__nand2_2_52 vdd vss gf180mcu_fd_sc_mcu7t5v0__nand2_2_52/ZN
+ gf180mcu_fd_sc_mcu7t5v0__buf_8_5/I gf180mcu_fd_sc_mcu7t5v0__nand2_4_24/ZN vdd vss
+ gf180mcu_fd_sc_mcu7t5v0__nand2_2
Xgf180mcu_fd_sc_mcu7t5v0__clkinv_1_16 vdd vss gf180mcu_fd_sc_mcu7t5v0__clkinv_1_16/I
+ gf180mcu_fd_sc_mcu7t5v0__aoi21_1_79/B vdd vss gf180mcu_fd_sc_mcu7t5v0__clkinv_1
Xgf180mcu_fd_sc_mcu7t5v0__nand2_2_63 vdd vss gf180mcu_fd_sc_mcu7t5v0__xor3_1_90/A2
+ gf180mcu_fd_sc_mcu7t5v0__nand2_2_63/A1 gf180mcu_fd_sc_mcu7t5v0__nand2_2_63/A2 vdd
+ vss gf180mcu_fd_sc_mcu7t5v0__nand2_2
Xgf180mcu_fd_sc_mcu7t5v0__clkinv_1_27 vdd vss gf180mcu_fd_sc_mcu7t5v0__dffq_1_267/Q
+ gf180mcu_fd_sc_mcu7t5v0__oai22_1_261/B2 vdd vss gf180mcu_fd_sc_mcu7t5v0__clkinv_1
Xgf180mcu_fd_sc_mcu7t5v0__xor2_1_200 vdd vss gf180mcu_fd_sc_mcu7t5v0__xor2_1_200/Z
+ gf180mcu_fd_sc_mcu7t5v0__xor2_1_200/A1 gf180mcu_fd_sc_mcu7t5v0__xor2_1_200/A2 vdd
+ vss gf180mcu_fd_sc_mcu7t5v0__xor2_1
Xgf180mcu_fd_sc_mcu7t5v0__nand2_2_74 vdd vss gf180mcu_fd_sc_mcu7t5v0__nand2_2_74/ZN
+ gf180mcu_fd_sc_mcu7t5v0__inv_3_4/ZN gf180mcu_fd_sc_mcu7t5v0__nor2_2_47/ZN vdd vss
+ gf180mcu_fd_sc_mcu7t5v0__nand2_2
Xgf180mcu_fd_sc_mcu7t5v0__clkinv_1_38 vdd vss gf180mcu_fd_sc_mcu7t5v0__dffq_1_32/Q
+ gf180mcu_fd_sc_mcu7t5v0__oai22_1_31/B2 vdd vss gf180mcu_fd_sc_mcu7t5v0__clkinv_1
Xgf180mcu_fd_sc_mcu7t5v0__xor2_1_211 vdd vss gf180mcu_fd_sc_mcu7t5v0__xor2_1_211/Z
+ gf180mcu_fd_sc_mcu7t5v0__xor3_1_162/A2 gf180mcu_fd_sc_mcu7t5v0__xor3_1_162/A3 vdd
+ vss gf180mcu_fd_sc_mcu7t5v0__xor2_1
Xgf180mcu_fd_sc_mcu7t5v0__clkinv_1_49 vdd vss gf180mcu_fd_sc_mcu7t5v0__dffq_1_38/Q
+ gf180mcu_fd_sc_mcu7t5v0__oai22_1_37/B2 vdd vss gf180mcu_fd_sc_mcu7t5v0__clkinv_1
Xgf180mcu_fd_sc_mcu7t5v0__xor2_1_222 vdd vss gf180mcu_fd_sc_mcu7t5v0__xor2_1_222/Z
+ gf180mcu_fd_sc_mcu7t5v0__or2_1_18/Z gf180mcu_fd_sc_mcu7t5v0__oai31_1_7/A3 vdd vss
+ gf180mcu_fd_sc_mcu7t5v0__xor2_1
Xgf180mcu_fd_sc_mcu7t5v0__clkinv_1_280 vdd vss gf180mcu_fd_sc_mcu7t5v0__dffq_2_34/Q
+ gf180mcu_fd_sc_mcu7t5v0__aoi221_1_17/A1 vdd vss gf180mcu_fd_sc_mcu7t5v0__clkinv_1
Xgf180mcu_fd_sc_mcu7t5v0__clkinv_1_291 vdd vss gf180mcu_fd_sc_mcu7t5v0__dffq_1_458/Q
+ gf180mcu_fd_sc_mcu7t5v0__oai22_1_264/B2 vdd vss gf180mcu_fd_sc_mcu7t5v0__clkinv_1
Xgf180mcu_fd_sc_mcu7t5v0__nand4_1_9 gf180mcu_fd_sc_mcu7t5v0__nor4_2_4/ZN gf180mcu_fd_sc_mcu7t5v0__nand4_1_9/A4
+ vdd vss gf180mcu_fd_sc_mcu7t5v0__nand4_1_9/ZN gf180mcu_fd_sc_mcu7t5v0__nor3_1_24/A1
+ gf180mcu_fd_sc_mcu7t5v0__nand4_1_9/A2 vdd vss gf180mcu_fd_sc_mcu7t5v0__nand4_1
Xgf180mcu_fd_sc_mcu7t5v0__and2_2_12 vdd vss gf180mcu_fd_sc_mcu7t5v0__and2_2_12/Z gf180mcu_fd_sc_mcu7t5v0__inv_12_1/I
+ gf180mcu_fd_sc_mcu7t5v0__mux4_4_6/Z vdd vss gf180mcu_fd_sc_mcu7t5v0__and2_2
Xgf180mcu_fd_sc_mcu7t5v0__dffq_4_13 gf180mcu_fd_sc_mcu7t5v0__dffq_4_13/D gf180mcu_fd_sc_mcu7t5v0__or3_4_0/A1
+ vdd vss gf180mcu_fd_sc_mcu7t5v0__dffq_4_9/CLK vdd vss gf180mcu_fd_sc_mcu7t5v0__dffq_4
Xgf180mcu_fd_sc_mcu7t5v0__dffq_4_24 gf180mcu_fd_sc_mcu7t5v0__dffq_4_24/D gf180mcu_fd_sc_mcu7t5v0__or2_1_36/A2
+ vdd vss gf180mcu_fd_sc_mcu7t5v0__dffq_4_1/CLK vdd vss gf180mcu_fd_sc_mcu7t5v0__dffq_4
Xgf180mcu_fd_sc_mcu7t5v0__dffq_4_35 gf180mcu_fd_sc_mcu7t5v0__dffq_4_35/D gf180mcu_fd_sc_mcu7t5v0__dffq_4_35/Q
+ vdd vss gf180mcu_fd_sc_mcu7t5v0__dffq_4_44/CLK vdd vss gf180mcu_fd_sc_mcu7t5v0__dffq_4
Xgf180mcu_fd_sc_mcu7t5v0__and2_2_6 vdd vss gf180mcu_fd_sc_mcu7t5v0__and2_2_6/Z gf180mcu_fd_sc_mcu7t5v0__inv_3_0/I
+ gf180mcu_fd_sc_mcu7t5v0__inv_4_1/I vdd vss gf180mcu_fd_sc_mcu7t5v0__and2_2
Xgf180mcu_fd_sc_mcu7t5v0__oai21_2_12 gf180mcu_fd_sc_mcu7t5v0__nor3_2_7/ZN gf180mcu_fd_sc_mcu7t5v0__oai33_2_3/A1
+ gf180mcu_fd_sc_mcu7t5v0__xor3_2_1/A1 vss gf180mcu_fd_sc_mcu7t5v0__xor3_1_102/Z vdd
+ vdd vss gf180mcu_fd_sc_mcu7t5v0__oai21_2
Xgf180mcu_fd_sc_mcu7t5v0__dffq_1_407 vdd gf180mcu_fd_sc_mcu7t5v0__dffq_1_407/Q gf180mcu_fd_sc_mcu7t5v0__dffq_4_21/CLK
+ vss gf180mcu_fd_sc_mcu7t5v0__dffq_1_407/D vdd vss gf180mcu_fd_sc_mcu7t5v0__dffq_1
Xgf180mcu_fd_sc_mcu7t5v0__dffq_1_418 vdd gf180mcu_fd_sc_mcu7t5v0__dffq_1_418/Q gf180mcu_fd_sc_mcu7t5v0__dffq_4_1/CLK
+ vss gf180mcu_fd_sc_mcu7t5v0__dffq_1_418/D vdd vss gf180mcu_fd_sc_mcu7t5v0__dffq_1
Xgf180mcu_fd_sc_mcu7t5v0__dffq_1_429 vdd gf180mcu_fd_sc_mcu7t5v0__dffq_1_429/Q gf180mcu_fd_sc_mcu7t5v0__dffq_4_44/CLK
+ vss gf180mcu_fd_sc_mcu7t5v0__dffq_1_429/D vdd vss gf180mcu_fd_sc_mcu7t5v0__dffq_1
Xgf180mcu_fd_sc_mcu7t5v0__or2_1_11 vdd vss gf180mcu_fd_sc_mcu7t5v0__or2_1_11/Z gf180mcu_fd_sc_mcu7t5v0__or2_1_11/A1
+ gf180mcu_fd_sc_mcu7t5v0__or2_1_11/A2 vdd vss gf180mcu_fd_sc_mcu7t5v0__or2_1
Xgf180mcu_fd_sc_mcu7t5v0__aoi22_1_150 gf180mcu_fd_sc_mcu7t5v0__and3_2_2/A2 gf180mcu_fd_sc_mcu7t5v0__dffq_1_328/Q
+ vdd vss gf180mcu_fd_sc_mcu7t5v0__clkinv_1_290/I gf180mcu_fd_sc_mcu7t5v0__dffq_1_409/Q
+ gf180mcu_fd_sc_mcu7t5v0__nor2_4_23/ZN vdd vss gf180mcu_fd_sc_mcu7t5v0__aoi22_1
Xgf180mcu_fd_sc_mcu7t5v0__or2_1_22 vdd vss gf180mcu_fd_sc_mcu7t5v0__or2_1_22/Z gf180mcu_fd_sc_mcu7t5v0__or2_1_23/A1
+ uart_rx vdd vss gf180mcu_fd_sc_mcu7t5v0__or2_1
Xgf180mcu_fd_sc_mcu7t5v0__aoi22_1_161 gf180mcu_fd_sc_mcu7t5v0__nor2_2_36/ZN gf180mcu_fd_sc_mcu7t5v0__dffq_2_95/Q
+ vdd vss gf180mcu_fd_sc_mcu7t5v0__nand2_2_63/A2 gf180mcu_fd_sc_mcu7t5v0__or2_1_34/A1
+ gf180mcu_fd_sc_mcu7t5v0__and2_1_104/Z vdd vss gf180mcu_fd_sc_mcu7t5v0__aoi22_1
Xgf180mcu_fd_sc_mcu7t5v0__aoi22_1_172 gf180mcu_fd_sc_mcu7t5v0__and4_1_3/A4 gf180mcu_fd_sc_mcu7t5v0__or4_1_0/A1
+ vdd vss gf180mcu_fd_sc_mcu7t5v0__oai22_1_280/A2 gf180mcu_fd_sc_mcu7t5v0__inv_8_2/I
+ gf180mcu_fd_sc_mcu7t5v0__and4_1_3/A3 vdd vss gf180mcu_fd_sc_mcu7t5v0__aoi22_1
Xgf180mcu_fd_sc_mcu7t5v0__or2_1_33 vdd vss gf180mcu_fd_sc_mcu7t5v0__or2_1_33/Z gf180mcu_fd_sc_mcu7t5v0__or2_1_33/A1
+ gf180mcu_fd_sc_mcu7t5v0__xor3_1_82/Z vdd vss gf180mcu_fd_sc_mcu7t5v0__or2_1
Xgf180mcu_fd_sc_mcu7t5v0__or2_1_44 vdd vss gf180mcu_fd_sc_mcu7t5v0__or2_1_44/Z gf180mcu_fd_sc_mcu7t5v0__inv_1_21/I
+ gf180mcu_fd_sc_mcu7t5v0__or2_1_44/A2 vdd vss gf180mcu_fd_sc_mcu7t5v0__or2_1
Xgf180mcu_fd_sc_mcu7t5v0__aoi22_1_183 gf180mcu_fd_sc_mcu7t5v0__nor2_4_9/ZN gf180mcu_fd_sc_mcu7t5v0__dffq_1_320/Q
+ vdd vss gf180mcu_fd_sc_mcu7t5v0__nand2_1_272/A1 gf180mcu_fd_sc_mcu7t5v0__dffq_1_456/Q
+ gf180mcu_fd_sc_mcu7t5v0__nor2_4_8/ZN vdd vss gf180mcu_fd_sc_mcu7t5v0__aoi22_1
Xgf180mcu_fd_sc_mcu7t5v0__or2_1_55 vdd vss gf180mcu_fd_sc_mcu7t5v0__or2_1_55/Z gf180mcu_fd_sc_mcu7t5v0__or2_1_55/A1
+ gf180mcu_fd_sc_mcu7t5v0__xor2_1_82/Z vdd vss gf180mcu_fd_sc_mcu7t5v0__or2_1
Xgf180mcu_fd_sc_mcu7t5v0__nor2_4_11 vdd vss gf180mcu_fd_sc_mcu7t5v0__nor2_4_11/ZN
+ gf180mcu_fd_sc_mcu7t5v0__inv_3_1/I gf180mcu_fd_sc_mcu7t5v0__inv_3_2/I vdd vss gf180mcu_fd_sc_mcu7t5v0__nor2_4
Xgf180mcu_fd_sc_mcu7t5v0__nor2_4_22 vdd vss gf180mcu_fd_sc_mcu7t5v0__nor2_4_22/ZN
+ gf180mcu_fd_sc_mcu7t5v0__nor2_4_22/A1 gf180mcu_fd_sc_mcu7t5v0__nor2_4_24/A1 vdd
+ vss gf180mcu_fd_sc_mcu7t5v0__nor2_4
Xgf180mcu_fd_sc_mcu7t5v0__nor2_4_33 vdd vss gf180mcu_fd_sc_mcu7t5v0__nor2_4_33/ZN
+ gf180mcu_fd_sc_mcu7t5v0__inv_2_9/ZN gf180mcu_fd_sc_mcu7t5v0__and3_2_3/A3 vdd vss
+ gf180mcu_fd_sc_mcu7t5v0__nor2_4
Xgf180mcu_fd_sc_mcu7t5v0__nor2_4_44 vdd vss gf180mcu_fd_sc_mcu7t5v0__nor2_4_44/ZN
+ gf180mcu_fd_sc_mcu7t5v0__nor3_4_5/A1 gf180mcu_fd_sc_mcu7t5v0__oai32_1_3/A3 vdd vss
+ gf180mcu_fd_sc_mcu7t5v0__nor2_4
Xgf180mcu_fd_sc_mcu7t5v0__aoi21_1_330 gf180mcu_fd_sc_mcu7t5v0__nor2_2_46/ZN vdd vss
+ gf180mcu_fd_sc_mcu7t5v0__oai221_1_13/B1 gf180mcu_fd_sc_mcu7t5v0__nor3_4_21/ZN gf180mcu_fd_sc_mcu7t5v0__xor3_1_124/A1
+ vdd vss gf180mcu_fd_sc_mcu7t5v0__aoi21_1
Xgf180mcu_fd_sc_mcu7t5v0__aoi21_1_341 gf180mcu_fd_sc_mcu7t5v0__or2_4_4/Z vdd vss gf180mcu_fd_sc_mcu7t5v0__aoi221_1_56/B2
+ gf180mcu_fd_sc_mcu7t5v0__oai211_1_53/C gf180mcu_fd_sc_mcu7t5v0__oai211_1_54/ZN vdd
+ vss gf180mcu_fd_sc_mcu7t5v0__aoi21_1
Xgf180mcu_fd_sc_mcu7t5v0__aoi21_1_352 gf180mcu_fd_sc_mcu7t5v0__aoi21_1_352/B vdd vss
+ gf180mcu_fd_sc_mcu7t5v0__oai21_1_314/B gf180mcu_fd_sc_mcu7t5v0__nor2_2_53/ZN gf180mcu_fd_sc_mcu7t5v0__xor2_1_194/Z
+ vdd vss gf180mcu_fd_sc_mcu7t5v0__aoi21_1
Xgf180mcu_fd_sc_mcu7t5v0__aoi21_1_363 gf180mcu_fd_sc_mcu7t5v0__xnor2_1_66/A2 vdd vss
+ gf180mcu_fd_sc_mcu7t5v0__xor2_1_203/A2 gf180mcu_fd_sc_mcu7t5v0__oai31_1_19/B gf180mcu_fd_sc_mcu7t5v0__xnor2_1_66/A1
+ vdd vss gf180mcu_fd_sc_mcu7t5v0__aoi21_1
Xgf180mcu_fd_sc_mcu7t5v0__aoi21_1_374 gf180mcu_fd_sc_mcu7t5v0__xor2_1_218/A2 vdd vss
+ gf180mcu_fd_sc_mcu7t5v0__xor2_1_116/A1 gf180mcu_fd_sc_mcu7t5v0__nand3_1_101/ZN gf180mcu_fd_sc_mcu7t5v0__or3_1_27/Z
+ vdd vss gf180mcu_fd_sc_mcu7t5v0__aoi21_1
Xgf180mcu_fd_sc_mcu7t5v0__nand2_1_107 vdd vss gf180mcu_fd_sc_mcu7t5v0__xor3_1_40/A3
+ gf180mcu_fd_sc_mcu7t5v0__dffq_4_37/Q gf180mcu_fd_sc_mcu7t5v0__or4_1_1/A3 vdd vss
+ gf180mcu_fd_sc_mcu7t5v0__nand2_1
Xgf180mcu_fd_sc_mcu7t5v0__nand2_1_118 vdd vss gf180mcu_fd_sc_mcu7t5v0__nand2_1_125/A1
+ gf180mcu_fd_sc_mcu7t5v0__xor2_1_38/A1 gf180mcu_fd_sc_mcu7t5v0__xor2_1_38/A2 vdd
+ vss gf180mcu_fd_sc_mcu7t5v0__nand2_1
Xgf180mcu_fd_sc_mcu7t5v0__nand2_1_129 vdd vss gf180mcu_fd_sc_mcu7t5v0__xor3_1_46/A2
+ gf180mcu_fd_sc_mcu7t5v0__dffq_4_37/Q gf180mcu_fd_sc_mcu7t5v0__and2_2_4/Z vdd vss
+ gf180mcu_fd_sc_mcu7t5v0__nand2_1
Xgf180mcu_fd_sc_mcu7t5v0__xor3_1_40 gf180mcu_fd_sc_mcu7t5v0__xor3_1_40/A3 vdd vss
+ gf180mcu_fd_sc_mcu7t5v0__xor3_1_40/Z gf180mcu_fd_sc_mcu7t5v0__xor3_1_40/A1 gf180mcu_fd_sc_mcu7t5v0__xor3_1_40/A2
+ vdd vss gf180mcu_fd_sc_mcu7t5v0__xor3_1
Xgf180mcu_fd_sc_mcu7t5v0__xor3_1_51 gf180mcu_fd_sc_mcu7t5v0__xor2_1_49/Z vdd vss gf180mcu_fd_sc_mcu7t5v0__xor3_1_51/Z
+ gf180mcu_fd_sc_mcu7t5v0__inv_8_0/ZN gf180mcu_fd_sc_mcu7t5v0__xor3_1_51/A2 vdd vss
+ gf180mcu_fd_sc_mcu7t5v0__xor3_1
Xgf180mcu_fd_sc_mcu7t5v0__xor3_1_62 gf180mcu_fd_sc_mcu7t5v0__xor3_1_62/A3 vdd vss
+ gf180mcu_fd_sc_mcu7t5v0__xor3_1_62/Z gf180mcu_fd_sc_mcu7t5v0__xor3_1_62/A1 gf180mcu_fd_sc_mcu7t5v0__xor3_1_62/A2
+ vdd vss gf180mcu_fd_sc_mcu7t5v0__xor3_1
Xgf180mcu_fd_sc_mcu7t5v0__xor3_1_73 gf180mcu_fd_sc_mcu7t5v0__xor3_1_73/A3 vdd vss
+ gf180mcu_fd_sc_mcu7t5v0__xor3_1_73/Z gf180mcu_fd_sc_mcu7t5v0__nor3_2_4/ZN gf180mcu_fd_sc_mcu7t5v0__xor3_1_73/A2
+ vdd vss gf180mcu_fd_sc_mcu7t5v0__xor3_1
Xgf180mcu_fd_sc_mcu7t5v0__xor3_1_84 gf180mcu_fd_sc_mcu7t5v0__xor3_1_84/A3 vdd vss
+ gf180mcu_fd_sc_mcu7t5v0__xor3_1_84/Z gf180mcu_fd_sc_mcu7t5v0__xor3_1_84/A1 gf180mcu_fd_sc_mcu7t5v0__xor3_1_84/A2
+ vdd vss gf180mcu_fd_sc_mcu7t5v0__xor3_1
Xgf180mcu_fd_sc_mcu7t5v0__xor3_1_95 gf180mcu_fd_sc_mcu7t5v0__xor3_1_95/A3 vdd vss
+ gf180mcu_fd_sc_mcu7t5v0__xor3_1_95/Z gf180mcu_fd_sc_mcu7t5v0__xor3_1_95/A1 gf180mcu_fd_sc_mcu7t5v0__xor3_1_95/A2
+ vdd vss gf180mcu_fd_sc_mcu7t5v0__xor3_1
Xgf180mcu_fd_sc_mcu7t5v0__dffq_1_204 vdd gf180mcu_fd_sc_mcu7t5v0__dffq_1_204/Q gf180mcu_fd_sc_mcu7t5v0__dffq_4_8/CLK
+ vss gf180mcu_fd_sc_mcu7t5v0__dffq_1_204/D vdd vss gf180mcu_fd_sc_mcu7t5v0__dffq_1
Xgf180mcu_fd_sc_mcu7t5v0__dffq_1_215 vdd gf180mcu_fd_sc_mcu7t5v0__dffq_1_215/Q gf180mcu_fd_sc_mcu7t5v0__dffq_2_26/CLK
+ vss gf180mcu_fd_sc_mcu7t5v0__dffq_1_215/D vdd vss gf180mcu_fd_sc_mcu7t5v0__dffq_1
Xgf180mcu_fd_sc_mcu7t5v0__nor2_1_404 vdd vss gf180mcu_fd_sc_mcu7t5v0__nor2_1_404/ZN
+ gf180mcu_fd_sc_mcu7t5v0__dffq_1_450/Q gf180mcu_fd_sc_mcu7t5v0__nor2_4_17/ZN vdd
+ vss gf180mcu_fd_sc_mcu7t5v0__nor2_1
Xgf180mcu_fd_sc_mcu7t5v0__dffq_1_226 vdd gf180mcu_fd_sc_mcu7t5v0__dffq_1_226/Q gf180mcu_fd_sc_mcu7t5v0__dffq_2_26/CLK
+ vss gf180mcu_fd_sc_mcu7t5v0__dffq_1_226/D vdd vss gf180mcu_fd_sc_mcu7t5v0__dffq_1
Xgf180mcu_fd_sc_mcu7t5v0__dffq_1_237 vdd gf180mcu_fd_sc_mcu7t5v0__dffq_1_237/Q gf180mcu_fd_sc_mcu7t5v0__dffq_4_8/CLK
+ vss gf180mcu_fd_sc_mcu7t5v0__dffq_1_237/D vdd vss gf180mcu_fd_sc_mcu7t5v0__dffq_1
Xgf180mcu_fd_sc_mcu7t5v0__dffq_1_248 vdd gf180mcu_fd_sc_mcu7t5v0__dffq_1_248/Q gf180mcu_fd_sc_mcu7t5v0__dffq_4_8/CLK
+ vss gf180mcu_fd_sc_mcu7t5v0__dffq_1_248/D vdd vss gf180mcu_fd_sc_mcu7t5v0__dffq_1
Xgf180mcu_fd_sc_mcu7t5v0__dffq_1_259 vdd gf180mcu_fd_sc_mcu7t5v0__dffq_1_259/Q gf180mcu_fd_sc_mcu7t5v0__dffq_2_26/CLK
+ vss gf180mcu_fd_sc_mcu7t5v0__dffq_1_259/D vdd vss gf180mcu_fd_sc_mcu7t5v0__dffq_1
Xgf180mcu_fd_sc_mcu7t5v0__nand2_1_630 vdd vss gf180mcu_fd_sc_mcu7t5v0__oai32_1_9/A1
+ gf180mcu_fd_sc_mcu7t5v0__xor3_1_132/Z gf180mcu_fd_sc_mcu7t5v0__xor2_1_179/Z vdd
+ vss gf180mcu_fd_sc_mcu7t5v0__nand2_1
Xgf180mcu_fd_sc_mcu7t5v0__nand2_1_641 vdd vss gf180mcu_fd_sc_mcu7t5v0__nand2_1_641/ZN
+ gf180mcu_fd_sc_mcu7t5v0__or2_1_53/A1 gf180mcu_fd_sc_mcu7t5v0__or2_4_4/Z vdd vss
+ gf180mcu_fd_sc_mcu7t5v0__nand2_1
Xgf180mcu_fd_sc_mcu7t5v0__nand2_1_652 vdd vss gf180mcu_fd_sc_mcu7t5v0__or2_1_52/A2
+ gf180mcu_fd_sc_mcu7t5v0__nor2_2_56/ZN gf180mcu_fd_sc_mcu7t5v0__nand3_1_97/ZN vdd
+ vss gf180mcu_fd_sc_mcu7t5v0__nand2_1
Xgf180mcu_fd_sc_mcu7t5v0__nand2_1_663 vdd vss gf180mcu_fd_sc_mcu7t5v0__xnor3_1_43/A3
+ gf180mcu_fd_sc_mcu7t5v0__inv_8_0/I gf180mcu_fd_sc_mcu7t5v0__and4_1_3/A3 vdd vss
+ gf180mcu_fd_sc_mcu7t5v0__nand2_1
Xgf180mcu_fd_sc_mcu7t5v0__nand2_1_674 vdd vss gf180mcu_fd_sc_mcu7t5v0__xnor3_1_44/A3
+ gf180mcu_fd_sc_mcu7t5v0__or4_1_0/A1 gf180mcu_fd_sc_mcu7t5v0__and4_1_3/A3 vdd vss
+ gf180mcu_fd_sc_mcu7t5v0__nand2_1
Xgf180mcu_fd_sc_mcu7t5v0__nand2_1_685 vdd vss gf180mcu_fd_sc_mcu7t5v0__xnor3_1_47/A2
+ gf180mcu_fd_sc_mcu7t5v0__or4_1_0/A1 gf180mcu_fd_sc_mcu7t5v0__xor3_1_162/A2 vdd vss
+ gf180mcu_fd_sc_mcu7t5v0__nand2_1
Xgf180mcu_fd_sc_mcu7t5v0__nand2_1_696 vdd vss gf180mcu_fd_sc_mcu7t5v0__xnor3_1_47/A1
+ gf180mcu_fd_sc_mcu7t5v0__inv_8_2/I gf180mcu_fd_sc_mcu7t5v0__and4_1_3/A4 vdd vss
+ gf180mcu_fd_sc_mcu7t5v0__nand2_1
Xgf180mcu_fd_sc_mcu7t5v0__dffq_1_14 vdd gf180mcu_fd_sc_mcu7t5v0__dffq_1_14/Q gf180mcu_fd_sc_mcu7t5v0__dffq_4_6/CLK
+ vss gf180mcu_fd_sc_mcu7t5v0__dffq_1_14/D vdd vss gf180mcu_fd_sc_mcu7t5v0__dffq_1
Xgf180mcu_fd_sc_mcu7t5v0__dffq_1_25 vdd gf180mcu_fd_sc_mcu7t5v0__dffq_1_25/Q gf180mcu_fd_sc_mcu7t5v0__dffq_1_99/CLK
+ vss gf180mcu_fd_sc_mcu7t5v0__dffq_1_25/D vdd vss gf180mcu_fd_sc_mcu7t5v0__dffq_1
Xgf180mcu_fd_sc_mcu7t5v0__clkinv_1_109 vdd vss gf180mcu_fd_sc_mcu7t5v0__dffq_1_114/Q
+ gf180mcu_fd_sc_mcu7t5v0__oai22_1_101/B2 vdd vss gf180mcu_fd_sc_mcu7t5v0__clkinv_1
Xgf180mcu_fd_sc_mcu7t5v0__dffq_1_36 vdd gf180mcu_fd_sc_mcu7t5v0__dffq_1_36/Q gf180mcu_fd_sc_mcu7t5v0__dffq_1_99/CLK
+ vss gf180mcu_fd_sc_mcu7t5v0__dffq_1_36/D vdd vss gf180mcu_fd_sc_mcu7t5v0__dffq_1
Xgf180mcu_fd_sc_mcu7t5v0__dffq_1_47 vdd gf180mcu_fd_sc_mcu7t5v0__dffq_1_47/Q gf180mcu_fd_sc_mcu7t5v0__dffq_4_8/CLK
+ vss gf180mcu_fd_sc_mcu7t5v0__dffq_1_47/D vdd vss gf180mcu_fd_sc_mcu7t5v0__dffq_1
Xgf180mcu_fd_sc_mcu7t5v0__dffq_1_58 vdd gf180mcu_fd_sc_mcu7t5v0__dffq_1_58/Q gf180mcu_fd_sc_mcu7t5v0__dffq_1_95/CLK
+ vss gf180mcu_fd_sc_mcu7t5v0__dffq_1_58/D vdd vss gf180mcu_fd_sc_mcu7t5v0__dffq_1
Xgf180mcu_fd_sc_mcu7t5v0__dffq_1_69 vdd gf180mcu_fd_sc_mcu7t5v0__dffq_1_69/Q gf180mcu_fd_sc_mcu7t5v0__dffq_1_95/CLK
+ vss gf180mcu_fd_sc_mcu7t5v0__dffq_1_69/D vdd vss gf180mcu_fd_sc_mcu7t5v0__dffq_1
Xgf180mcu_fd_sc_mcu7t5v0__nand2_2_7 vdd vss gf180mcu_fd_sc_mcu7t5v0__xor3_1_20/A2
+ gf180mcu_fd_sc_mcu7t5v0__nand2_2_7/A1 gf180mcu_fd_sc_mcu7t5v0__nand2_2_7/A2 vdd
+ vss gf180mcu_fd_sc_mcu7t5v0__nand2_2
Xgf180mcu_fd_sc_mcu7t5v0__aoi21_1_160 gf180mcu_fd_sc_mcu7t5v0__aoi21_1_160/B vdd vss
+ gf180mcu_fd_sc_mcu7t5v0__dffq_1_334/D gf180mcu_fd_sc_mcu7t5v0__aoi21_1_160/A1 gf180mcu_fd_sc_mcu7t5v0__nand2_4_40/ZN
+ vdd vss gf180mcu_fd_sc_mcu7t5v0__aoi21_1
Xgf180mcu_fd_sc_mcu7t5v0__aoi21_1_171 gf180mcu_fd_sc_mcu7t5v0__nand4_2_1/A1 vdd vss
+ gf180mcu_fd_sc_mcu7t5v0__nor2_1_206/A2 gf180mcu_fd_sc_mcu7t5v0__nand4_2_1/A2 gf180mcu_fd_sc_mcu7t5v0__aoi211_4_0/ZN
+ vdd vss gf180mcu_fd_sc_mcu7t5v0__aoi21_1
Xgf180mcu_fd_sc_mcu7t5v0__aoi21_1_182 gf180mcu_fd_sc_mcu7t5v0__aoi21_1_182/B vdd vss
+ gf180mcu_fd_sc_mcu7t5v0__oai21_1_179/B gf180mcu_fd_sc_mcu7t5v0__nor2_2_22/ZN gf180mcu_fd_sc_mcu7t5v0__xor2_1_97/A2
+ vdd vss gf180mcu_fd_sc_mcu7t5v0__aoi21_1
Xgf180mcu_fd_sc_mcu7t5v0__aoi21_1_193 gf180mcu_fd_sc_mcu7t5v0__clkinv_2_7/I vdd vss
+ gf180mcu_fd_sc_mcu7t5v0__aoi221_1_32/B2 gf180mcu_fd_sc_mcu7t5v0__or2_1_25/A1 gf180mcu_fd_sc_mcu7t5v0__or2_1_25/A2
+ vdd vss gf180mcu_fd_sc_mcu7t5v0__aoi21_1
Xgf180mcu_fd_sc_mcu7t5v0__aoi22_1_8 gf180mcu_fd_sc_mcu7t5v0__and4_1_0/A4 gf180mcu_fd_sc_mcu7t5v0__inv_12_1/I
+ vdd vss gf180mcu_fd_sc_mcu7t5v0__or3_1_3/A2 gf180mcu_fd_sc_mcu7t5v0__or4_1_0/A1
+ gf180mcu_fd_sc_mcu7t5v0__or4_1_1/A2 vdd vss gf180mcu_fd_sc_mcu7t5v0__aoi22_1
Xgf180mcu_fd_sc_mcu7t5v0__buf_8_4 gf180mcu_fd_sc_mcu7t5v0__buf_8_4/Z gf180mcu_fd_sc_mcu7t5v0__buf_8_5/I
+ vdd vss vdd vss gf180mcu_fd_sc_mcu7t5v0__buf_8
Xgf180mcu_fd_sc_mcu7t5v0__oai22_1_103 gf180mcu_fd_sc_mcu7t5v0__nand2_4_15/ZN gf180mcu_fd_sc_mcu7t5v0__nand2_2_21/ZN
+ gf180mcu_fd_sc_mcu7t5v0__oai22_1_103/B2 vdd vss gf180mcu_fd_sc_mcu7t5v0__dffq_1_100/D
+ gf180mcu_fd_sc_mcu7t5v0__oai21_4_9/ZN vdd vss gf180mcu_fd_sc_mcu7t5v0__oai22_1
Xgf180mcu_fd_sc_mcu7t5v0__oai22_1_114 gf180mcu_fd_sc_mcu7t5v0__oai22_1_97/A2 gf180mcu_fd_sc_mcu7t5v0__oai22_1_97/B1
+ gf180mcu_fd_sc_mcu7t5v0__oai22_1_114/B2 vdd vss gf180mcu_fd_sc_mcu7t5v0__dffq_1_259/D
+ gf180mcu_fd_sc_mcu7t5v0__aoi21_4_4/ZN vdd vss gf180mcu_fd_sc_mcu7t5v0__oai22_1
Xgf180mcu_fd_sc_mcu7t5v0__oai22_1_125 gf180mcu_fd_sc_mcu7t5v0__oai22_1_55/A2 gf180mcu_fd_sc_mcu7t5v0__oai22_1_55/B1
+ gf180mcu_fd_sc_mcu7t5v0__oai22_1_125/B2 vdd vss gf180mcu_fd_sc_mcu7t5v0__dffq_1_118/D
+ gf180mcu_fd_sc_mcu7t5v0__aoi21_4_5/ZN vdd vss gf180mcu_fd_sc_mcu7t5v0__oai22_1
Xgf180mcu_fd_sc_mcu7t5v0__oai22_1_136 gf180mcu_fd_sc_mcu7t5v0__nand2_4_19/ZN gf180mcu_fd_sc_mcu7t5v0__nand2_2_26/ZN
+ gf180mcu_fd_sc_mcu7t5v0__oai22_1_136/B2 vdd vss gf180mcu_fd_sc_mcu7t5v0__dffq_1_132/D
+ gf180mcu_fd_sc_mcu7t5v0__aoi21_4_2/ZN vdd vss gf180mcu_fd_sc_mcu7t5v0__oai22_1
Xgf180mcu_fd_sc_mcu7t5v0__oai22_1_147 gf180mcu_fd_sc_mcu7t5v0__nand2_4_18/ZN gf180mcu_fd_sc_mcu7t5v0__nand2_2_25/ZN
+ gf180mcu_fd_sc_mcu7t5v0__oai22_1_147/B2 vdd vss gf180mcu_fd_sc_mcu7t5v0__dffq_1_143/D
+ gf180mcu_fd_sc_mcu7t5v0__aoi21_4_3/ZN vdd vss gf180mcu_fd_sc_mcu7t5v0__oai22_1
Xgf180mcu_fd_sc_mcu7t5v0__oai22_1_158 gf180mcu_fd_sc_mcu7t5v0__nand2_4_21/ZN gf180mcu_fd_sc_mcu7t5v0__nand2_2_28/ZN
+ gf180mcu_fd_sc_mcu7t5v0__oai22_1_158/B2 vdd vss gf180mcu_fd_sc_mcu7t5v0__dffq_1_153/D
+ gf180mcu_fd_sc_mcu7t5v0__oai21_4_9/ZN vdd vss gf180mcu_fd_sc_mcu7t5v0__oai22_1
Xgf180mcu_fd_sc_mcu7t5v0__oai22_1_169 gf180mcu_fd_sc_mcu7t5v0__nand2_4_22/ZN gf180mcu_fd_sc_mcu7t5v0__nand2_2_29/ZN
+ gf180mcu_fd_sc_mcu7t5v0__oai22_1_169/B2 vdd vss gf180mcu_fd_sc_mcu7t5v0__dffq_1_187/D
+ gf180mcu_fd_sc_mcu7t5v0__aoi21_4_1/ZN vdd vss gf180mcu_fd_sc_mcu7t5v0__oai22_1
Xgf180mcu_fd_sc_mcu7t5v0__oai221_1_8 gf180mcu_fd_sc_mcu7t5v0__oai221_1_8/B1 gf180mcu_fd_sc_mcu7t5v0__or2_1_34/A2
+ vdd vss gf180mcu_fd_sc_mcu7t5v0__oai221_1_8/ZN gf180mcu_fd_sc_mcu7t5v0__oai221_1_8/A1
+ gf180mcu_fd_sc_mcu7t5v0__xor2_1_96/Z gf180mcu_fd_sc_mcu7t5v0__oai221_1_8/B2 vdd
+ vss gf180mcu_fd_sc_mcu7t5v0__oai221_1
Xgf180mcu_fd_sc_mcu7t5v0__xnor3_1_19 gf180mcu_fd_sc_mcu7t5v0__xor2_1_83/Z vdd vss
+ gf180mcu_fd_sc_mcu7t5v0__or3_1_29/A3 gf180mcu_fd_sc_mcu7t5v0__xor2_1_88/A1 gf180mcu_fd_sc_mcu7t5v0__xor2_1_88/A2
+ vdd vss gf180mcu_fd_sc_mcu7t5v0__xnor3_1
Xgf180mcu_fd_sc_mcu7t5v0__nor2_1_12 vdd vss gf180mcu_fd_sc_mcu7t5v0__dffq_2_0/D gf180mcu_fd_sc_mcu7t5v0__aoi21_1_7/B
+ gf180mcu_fd_sc_mcu7t5v0__nor2_1_12/A2 vdd vss gf180mcu_fd_sc_mcu7t5v0__nor2_1
Xgf180mcu_fd_sc_mcu7t5v0__nor2_1_23 vdd vss gf180mcu_fd_sc_mcu7t5v0__nor2_1_23/ZN
+ gf180mcu_fd_sc_mcu7t5v0__nor3_1_9/A1 gf180mcu_fd_sc_mcu7t5v0__xor3_1_14/Z vdd vss
+ gf180mcu_fd_sc_mcu7t5v0__nor2_1
Xgf180mcu_fd_sc_mcu7t5v0__nor2_1_34 vdd vss gf180mcu_fd_sc_mcu7t5v0__or2_1_6/A1 gf180mcu_fd_sc_mcu7t5v0__oai22_4_0/A2
+ gf180mcu_fd_sc_mcu7t5v0__nor2_1_34/A2 vdd vss gf180mcu_fd_sc_mcu7t5v0__nor2_1
Xgf180mcu_fd_sc_mcu7t5v0__nor2_1_45 vdd vss gf180mcu_fd_sc_mcu7t5v0__nor2_1_45/ZN
+ gf180mcu_fd_sc_mcu7t5v0__dffq_1_9/Q gf180mcu_fd_sc_mcu7t5v0__nor2_4_15/ZN vdd vss
+ gf180mcu_fd_sc_mcu7t5v0__nor2_1
Xgf180mcu_fd_sc_mcu7t5v0__nor2_1_56 vdd vss gf180mcu_fd_sc_mcu7t5v0__nor2_1_56/ZN
+ gf180mcu_fd_sc_mcu7t5v0__or2_1_2/A2 gf180mcu_fd_sc_mcu7t5v0__xnor3_1_7/A3 vdd vss
+ gf180mcu_fd_sc_mcu7t5v0__nor2_1
Xgf180mcu_fd_sc_mcu7t5v0__nor2_1_67 vdd vss gf180mcu_fd_sc_mcu7t5v0__xor3_1_43/A2
+ gf180mcu_fd_sc_mcu7t5v0__or3_1_5/A1 gf180mcu_fd_sc_mcu7t5v0__or3_1_5/A2 vdd vss
+ gf180mcu_fd_sc_mcu7t5v0__nor2_1
Xgf180mcu_fd_sc_mcu7t5v0__nor2_1_78 vdd vss gf180mcu_fd_sc_mcu7t5v0__nor2_1_78/ZN
+ gf180mcu_fd_sc_mcu7t5v0__oai31_1_0/B gf180mcu_fd_sc_mcu7t5v0__xor3_1_50/Z vdd vss
+ gf180mcu_fd_sc_mcu7t5v0__nor2_1
Xgf180mcu_fd_sc_mcu7t5v0__nor2_1_89 vdd vss gf180mcu_fd_sc_mcu7t5v0__oai22_1_9/B1
+ gf180mcu_fd_sc_mcu7t5v0__nor2_1_89/A1 gf180mcu_fd_sc_mcu7t5v0__nor2_1_89/A2 vdd
+ vss gf180mcu_fd_sc_mcu7t5v0__nor2_1
Xgf180mcu_fd_sc_mcu7t5v0__nor2_1_201 vdd vss gf180mcu_fd_sc_mcu7t5v0__dffq_1_359/D
+ gf180mcu_fd_sc_mcu7t5v0__oai31_4_2/ZN gf180mcu_fd_sc_mcu7t5v0__xor2_1_95/Z vdd vss
+ gf180mcu_fd_sc_mcu7t5v0__nor2_1
Xgf180mcu_fd_sc_mcu7t5v0__nor2_1_212 vdd vss gf180mcu_fd_sc_mcu7t5v0__dffq_2_56/D
+ gf180mcu_fd_sc_mcu7t5v0__or2_1_23/A1 gf180mcu_fd_sc_mcu7t5v0__nor2_1_212/A2 vdd
+ vss gf180mcu_fd_sc_mcu7t5v0__nor2_1
Xgf180mcu_fd_sc_mcu7t5v0__nor2_1_223 vdd vss gf180mcu_fd_sc_mcu7t5v0__dffq_2_54/D
+ gf180mcu_fd_sc_mcu7t5v0__or2_1_23/A1 gf180mcu_fd_sc_mcu7t5v0__nor2_1_223/A2 vdd
+ vss gf180mcu_fd_sc_mcu7t5v0__nor2_1
Xgf180mcu_fd_sc_mcu7t5v0__nor2_1_234 vdd vss gf180mcu_fd_sc_mcu7t5v0__dffq_1_408/D
+ gf180mcu_fd_sc_mcu7t5v0__nor2_1_234/A1 gf180mcu_fd_sc_mcu7t5v0__nor2_1_234/A2 vdd
+ vss gf180mcu_fd_sc_mcu7t5v0__nor2_1
Xgf180mcu_fd_sc_mcu7t5v0__nor2_1_245 vdd vss gf180mcu_fd_sc_mcu7t5v0__xor2_1_216/A1
+ gf180mcu_fd_sc_mcu7t5v0__xnor2_1_83/ZN gf180mcu_fd_sc_mcu7t5v0__xnor2_1_82/ZN vdd
+ vss gf180mcu_fd_sc_mcu7t5v0__nor2_1
Xgf180mcu_fd_sc_mcu7t5v0__nor2_1_256 vdd vss gf180mcu_fd_sc_mcu7t5v0__nor2_1_256/ZN
+ gf180mcu_fd_sc_mcu7t5v0__xor3_1_82/A2 gf180mcu_fd_sc_mcu7t5v0__xor3_1_82/A3 vdd
+ vss gf180mcu_fd_sc_mcu7t5v0__nor2_1
Xgf180mcu_fd_sc_mcu7t5v0__nor2_1_267 vdd vss gf180mcu_fd_sc_mcu7t5v0__oai22_4_3/B1
+ gf180mcu_fd_sc_mcu7t5v0__or2_1_36/A2 gf180mcu_fd_sc_mcu7t5v0__dffq_2_94/Q vdd vss
+ gf180mcu_fd_sc_mcu7t5v0__nor2_1
Xgf180mcu_fd_sc_mcu7t5v0__nor2_1_278 vdd vss gf180mcu_fd_sc_mcu7t5v0__xor2_1_137/A2
+ gf180mcu_fd_sc_mcu7t5v0__aoi21_2_11/B gf180mcu_fd_sc_mcu7t5v0__nor4_2_5/ZN vdd vss
+ gf180mcu_fd_sc_mcu7t5v0__nor2_1
Xgf180mcu_fd_sc_mcu7t5v0__xor3_1_7 gf180mcu_fd_sc_mcu7t5v0__xor3_1_7/A3 vdd vss gf180mcu_fd_sc_mcu7t5v0__xor3_1_7/Z
+ gf180mcu_fd_sc_mcu7t5v0__xor3_1_7/A1 gf180mcu_fd_sc_mcu7t5v0__xor3_1_7/A2 vdd vss
+ gf180mcu_fd_sc_mcu7t5v0__xor3_1
Xgf180mcu_fd_sc_mcu7t5v0__nor2_1_289 vdd vss gf180mcu_fd_sc_mcu7t5v0__xor3_1_97/A2
+ gf180mcu_fd_sc_mcu7t5v0__xnor2_1_50/A1 gf180mcu_fd_sc_mcu7t5v0__or2_1_38/A1 vdd
+ vss gf180mcu_fd_sc_mcu7t5v0__nor2_1
Xgf180mcu_fd_sc_mcu7t5v0__nand2_1_460 vdd vss gf180mcu_fd_sc_mcu7t5v0__nand2_2_63/A1
+ gf180mcu_fd_sc_mcu7t5v0__dffq_1_14/Q gf180mcu_fd_sc_mcu7t5v0__nor2_2_38/ZN vdd vss
+ gf180mcu_fd_sc_mcu7t5v0__nand2_1
Xgf180mcu_fd_sc_mcu7t5v0__nand2_1_471 vdd vss gf180mcu_fd_sc_mcu7t5v0__nand4_1_15/A3
+ gf180mcu_fd_sc_mcu7t5v0__nor2_1_270/ZN gf180mcu_fd_sc_mcu7t5v0__xor3_1_100/A1 vdd
+ vss gf180mcu_fd_sc_mcu7t5v0__nand2_1
Xgf180mcu_fd_sc_mcu7t5v0__nand2_1_482 vdd vss gf180mcu_fd_sc_mcu7t5v0__nand2_1_482/ZN
+ gf180mcu_fd_sc_mcu7t5v0__dffq_1_443/Q gf180mcu_fd_sc_mcu7t5v0__or2_4_4/Z vdd vss
+ gf180mcu_fd_sc_mcu7t5v0__nand2_1
Xgf180mcu_fd_sc_mcu7t5v0__nand2_1_493 vdd vss gf180mcu_fd_sc_mcu7t5v0__xor2_1_139/A2
+ gf180mcu_fd_sc_mcu7t5v0__inv_12_1/I gf180mcu_fd_sc_mcu7t5v0__xor3_1_90/A2 vdd vss
+ gf180mcu_fd_sc_mcu7t5v0__nand2_1
Xgf180mcu_fd_sc_mcu7t5v0__oai21_1_305 vdd gf180mcu_fd_sc_mcu7t5v0__or2_1_50/Z gf180mcu_fd_sc_mcu7t5v0__xnor2_1_61/A2
+ gf180mcu_fd_sc_mcu7t5v0__xor3_1_134/A1 gf180mcu_fd_sc_mcu7t5v0__xnor2_1_61/A1 vss
+ vdd vss gf180mcu_fd_sc_mcu7t5v0__oai21_1
Xgf180mcu_fd_sc_mcu7t5v0__oai21_1_316 vdd gf180mcu_fd_sc_mcu7t5v0__xor3_1_162/Z gf180mcu_fd_sc_mcu7t5v0__and2_1_142/Z
+ gf180mcu_fd_sc_mcu7t5v0__nand3_1_95/A2 gf180mcu_fd_sc_mcu7t5v0__nor2_1_391/ZN vss
+ vdd vss gf180mcu_fd_sc_mcu7t5v0__oai21_1
Xgf180mcu_fd_sc_mcu7t5v0__oai21_1_327 vdd gf180mcu_fd_sc_mcu7t5v0__or2_1_54/Z gf180mcu_fd_sc_mcu7t5v0__xor3_1_153/A3
+ gf180mcu_fd_sc_mcu7t5v0__xor2_1_201/A1 gf180mcu_fd_sc_mcu7t5v0__xor3_1_153/A1 vss
+ vdd vss gf180mcu_fd_sc_mcu7t5v0__oai21_1
Xgf180mcu_fd_sc_mcu7t5v0__oai21_1_338 vdd gf180mcu_fd_sc_mcu7t5v0__xor2_1_26/Z gf180mcu_fd_sc_mcu7t5v0__or3_1_28/A2
+ gf180mcu_fd_sc_mcu7t5v0__and3_1_3/A2 gf180mcu_fd_sc_mcu7t5v0__or3_1_28/A1 vss vdd
+ vss gf180mcu_fd_sc_mcu7t5v0__oai21_1
Xgf180mcu_fd_sc_mcu7t5v0__xnor2_1_9 vdd vss gf180mcu_fd_sc_mcu7t5v0__xor2_1_37/A2
+ gf180mcu_fd_sc_mcu7t5v0__xnor2_1_9/A1 gf180mcu_fd_sc_mcu7t5v0__xor2_1_33/Z vdd vss
+ gf180mcu_fd_sc_mcu7t5v0__xnor2_1
Xgf180mcu_fd_sc_mcu7t5v0__aoi22_1_14 gf180mcu_fd_sc_mcu7t5v0__nor3_4_3/ZN gf180mcu_fd_sc_mcu7t5v0__or2_1_16/Z
+ vdd vss gf180mcu_fd_sc_mcu7t5v0__oai211_1_16/C gf180mcu_fd_sc_mcu7t5v0__or2_1_7/A1
+ gf180mcu_fd_sc_mcu7t5v0__nor3_4_4/ZN vdd vss gf180mcu_fd_sc_mcu7t5v0__aoi22_1
Xgf180mcu_fd_sc_mcu7t5v0__aoi22_1_25 gf180mcu_fd_sc_mcu7t5v0__nor2_4_11/ZN gf180mcu_fd_sc_mcu7t5v0__dffq_1_26/Q
+ vdd vss gf180mcu_fd_sc_mcu7t5v0__aoi22_1_25/ZN gf180mcu_fd_sc_mcu7t5v0__dffq_1_24/Q
+ gf180mcu_fd_sc_mcu7t5v0__nor2_4_10/ZN vdd vss gf180mcu_fd_sc_mcu7t5v0__aoi22_1
Xgf180mcu_fd_sc_mcu7t5v0__aoi22_1_36 gf180mcu_fd_sc_mcu7t5v0__nor2_4_11/ZN gf180mcu_fd_sc_mcu7t5v0__dffq_1_62/Q
+ vdd vss gf180mcu_fd_sc_mcu7t5v0__aoi22_1_36/ZN gf180mcu_fd_sc_mcu7t5v0__dffq_1_60/Q
+ gf180mcu_fd_sc_mcu7t5v0__nor2_4_10/ZN vdd vss gf180mcu_fd_sc_mcu7t5v0__aoi22_1
Xgf180mcu_fd_sc_mcu7t5v0__aoi22_1_47 gf180mcu_fd_sc_mcu7t5v0__nor2_4_11/ZN gf180mcu_fd_sc_mcu7t5v0__dffq_1_88/Q
+ vdd vss gf180mcu_fd_sc_mcu7t5v0__aoi22_1_47/ZN gf180mcu_fd_sc_mcu7t5v0__dffq_1_81/Q
+ gf180mcu_fd_sc_mcu7t5v0__nor2_4_10/ZN vdd vss gf180mcu_fd_sc_mcu7t5v0__aoi22_1
Xgf180mcu_fd_sc_mcu7t5v0__aoi22_1_58 gf180mcu_fd_sc_mcu7t5v0__nor2_4_9/ZN gf180mcu_fd_sc_mcu7t5v0__dffq_1_114/Q
+ vdd vss gf180mcu_fd_sc_mcu7t5v0__aoi22_1_58/ZN gf180mcu_fd_sc_mcu7t5v0__dffq_1_260/Q
+ gf180mcu_fd_sc_mcu7t5v0__nor2_4_8/ZN vdd vss gf180mcu_fd_sc_mcu7t5v0__aoi22_1
Xgf180mcu_fd_sc_mcu7t5v0__aoi22_1_69 gf180mcu_fd_sc_mcu7t5v0__nor2_4_9/ZN gf180mcu_fd_sc_mcu7t5v0__dffq_1_107/Q
+ vdd vss gf180mcu_fd_sc_mcu7t5v0__aoi22_1_69/ZN gf180mcu_fd_sc_mcu7t5v0__dffq_1_109/Q
+ gf180mcu_fd_sc_mcu7t5v0__nor2_4_8/ZN vdd vss gf180mcu_fd_sc_mcu7t5v0__aoi22_1
Xgf180mcu_fd_sc_mcu7t5v0__xnor2_1_30 vdd vss gf180mcu_fd_sc_mcu7t5v0__oai31_1_7/A3
+ gf180mcu_fd_sc_mcu7t5v0__oai31_1_8/ZN gf180mcu_fd_sc_mcu7t5v0__xor2_1_87/Z vdd vss
+ gf180mcu_fd_sc_mcu7t5v0__xnor2_1
Xgf180mcu_fd_sc_mcu7t5v0__xnor2_1_41 vdd vss gf180mcu_fd_sc_mcu7t5v0__xnor2_1_41/ZN
+ gf180mcu_fd_sc_mcu7t5v0__xnor2_1_42/ZN gf180mcu_fd_sc_mcu7t5v0__xnor2_1_41/A2 vdd
+ vss gf180mcu_fd_sc_mcu7t5v0__xnor2_1
Xgf180mcu_fd_sc_mcu7t5v0__xnor2_1_52 vdd vss gf180mcu_fd_sc_mcu7t5v0__nor3_2_8/A2
+ gf180mcu_fd_sc_mcu7t5v0__xor3_2_1/A1 gf180mcu_fd_sc_mcu7t5v0__xor3_2_1/A3 vdd vss
+ gf180mcu_fd_sc_mcu7t5v0__xnor2_1
Xgf180mcu_fd_sc_mcu7t5v0__or3_1_7 gf180mcu_fd_sc_mcu7t5v0__or3_1_7/A3 vdd vss gf180mcu_fd_sc_mcu7t5v0__or3_1_7/Z
+ gf180mcu_fd_sc_mcu7t5v0__or3_1_7/A1 gf180mcu_fd_sc_mcu7t5v0__or3_1_7/A2 vdd vss
+ gf180mcu_fd_sc_mcu7t5v0__or3_1
Xgf180mcu_fd_sc_mcu7t5v0__xnor2_1_63 vdd vss gf180mcu_fd_sc_mcu7t5v0__nor3_1_40/A1
+ gf180mcu_fd_sc_mcu7t5v0__xnor2_1_63/A1 gf180mcu_fd_sc_mcu7t5v0__xnor2_1_64/ZN vdd
+ vss gf180mcu_fd_sc_mcu7t5v0__xnor2_1
Xgf180mcu_fd_sc_mcu7t5v0__xnor2_1_74 vdd vss gf180mcu_fd_sc_mcu7t5v0__xnor2_1_74/ZN
+ gf180mcu_fd_sc_mcu7t5v0__xnor2_1_74/A1 gf180mcu_fd_sc_mcu7t5v0__xor2_1_198/Z vdd
+ vss gf180mcu_fd_sc_mcu7t5v0__xnor2_1
Xgf180mcu_fd_sc_mcu7t5v0__xnor2_1_85 vdd vss gf180mcu_fd_sc_mcu7t5v0__xnor2_1_85/ZN
+ gf180mcu_fd_sc_mcu7t5v0__xor3_1_68/Z gf180mcu_fd_sc_mcu7t5v0__xor3_1_173/Z vdd vss
+ gf180mcu_fd_sc_mcu7t5v0__xnor2_1
Xgf180mcu_fd_sc_mcu7t5v0__nor3_2_11 gf180mcu_fd_sc_mcu7t5v0__inv_4_5/I vdd vss gf180mcu_fd_sc_mcu7t5v0__oai32_4_1/A1
+ gf180mcu_fd_sc_mcu7t5v0__nor3_2_11/A1 gf180mcu_fd_sc_mcu7t5v0__nor3_2_11/A2 vdd
+ vss gf180mcu_fd_sc_mcu7t5v0__nor3_2
Xgf180mcu_fd_sc_mcu7t5v0__dffq_2_90 gf180mcu_fd_sc_mcu7t5v0__dffq_2_90/D vdd vss gf180mcu_fd_sc_mcu7t5v0__dffq_4_1/CLK
+ gf180mcu_fd_sc_mcu7t5v0__or2_1_53/A1 vdd vss gf180mcu_fd_sc_mcu7t5v0__dffq_2
Xgf180mcu_fd_sc_mcu7t5v0__oai21_1_0 vdd gf180mcu_fd_sc_mcu7t5v0__xor2_1_0/Z gf180mcu_fd_sc_mcu7t5v0__xor3_1_0/A1
+ gf180mcu_fd_sc_mcu7t5v0__nor2_1_1/A1 gf180mcu_fd_sc_mcu7t5v0__xor3_1_6/A1 vss vdd
+ vss gf180mcu_fd_sc_mcu7t5v0__oai21_1
Xgf180mcu_fd_sc_mcu7t5v0__nand2_1_290 vdd vss gf180mcu_fd_sc_mcu7t5v0__or2_1_56/A2
+ gf180mcu_fd_sc_mcu7t5v0__inv_8_1/I gf180mcu_fd_sc_mcu7t5v0__mux4_4_3/Z vdd vss gf180mcu_fd_sc_mcu7t5v0__nand2_1
Xgf180mcu_fd_sc_mcu7t5v0__mux4_4_6 gf180mcu_fd_sc_mcu7t5v0__mux4_4_6/I0 vss vdd gf180mcu_fd_sc_mcu7t5v0__or3_2_2/A1
+ gf180mcu_fd_sc_mcu7t5v0__inv_1_24/I gf180mcu_fd_sc_mcu7t5v0__mux4_4_9/S0 gf180mcu_fd_sc_mcu7t5v0__mux4_4_6/I3
+ gf180mcu_fd_sc_mcu7t5v0__inv_1_16/I gf180mcu_fd_sc_mcu7t5v0__mux4_4_6/Z vdd vss
+ gf180mcu_fd_sc_mcu7t5v0__mux4_4
Xgf180mcu_fd_sc_mcu7t5v0__aoi21_1_80 gf180mcu_fd_sc_mcu7t5v0__nor3_4_3/ZN vdd vss
+ gf180mcu_fd_sc_mcu7t5v0__aoi21_1_80/ZN gf180mcu_fd_sc_mcu7t5v0__inv_12_1/I gf180mcu_fd_sc_mcu7t5v0__nor3_4_4/ZN
+ vdd vss gf180mcu_fd_sc_mcu7t5v0__aoi21_1
Xgf180mcu_fd_sc_mcu7t5v0__aoi21_1_91 gf180mcu_fd_sc_mcu7t5v0__xnor3_1_4/ZN vdd vss
+ gf180mcu_fd_sc_mcu7t5v0__or2_1_0/A2 gf180mcu_fd_sc_mcu7t5v0__xor3_1_7/A2 gf180mcu_fd_sc_mcu7t5v0__xor2_1_9/Z
+ vdd vss gf180mcu_fd_sc_mcu7t5v0__aoi21_1
Xgf180mcu_fd_sc_mcu7t5v0__aoi221_2_6 gf180mcu_fd_sc_mcu7t5v0__nor2_1_299/ZN gf180mcu_fd_sc_mcu7t5v0__dffq_2_23/Q
+ vdd vss gf180mcu_fd_sc_mcu7t5v0__nor2_2_39/A1 gf180mcu_fd_sc_mcu7t5v0__mux4_2_1/I1
+ gf180mcu_fd_sc_mcu7t5v0__nor2_1_300/ZN gf180mcu_fd_sc_mcu7t5v0__aoi221_2_6/C vdd
+ vss gf180mcu_fd_sc_mcu7t5v0__aoi221_2
Xgf180mcu_fd_sc_mcu7t5v0__oai21_1_102 vdd gf180mcu_fd_sc_mcu7t5v0__buf_8_6/Z gf180mcu_fd_sc_mcu7t5v0__nor2_4_31/ZN
+ gf180mcu_fd_sc_mcu7t5v0__aoi21_1_120/B gf180mcu_fd_sc_mcu7t5v0__dffq_1_294/Q vss
+ vdd vss gf180mcu_fd_sc_mcu7t5v0__oai21_1
Xgf180mcu_fd_sc_mcu7t5v0__oai21_1_113 vdd gf180mcu_fd_sc_mcu7t5v0__buf_8_6/Z gf180mcu_fd_sc_mcu7t5v0__nor2_4_31/ZN
+ gf180mcu_fd_sc_mcu7t5v0__aoi21_1_119/B gf180mcu_fd_sc_mcu7t5v0__dffq_1_317/Q vss
+ vdd vss gf180mcu_fd_sc_mcu7t5v0__oai21_1
Xgf180mcu_fd_sc_mcu7t5v0__oai21_1_124 vdd gf180mcu_fd_sc_mcu7t5v0__oai21_1_124/B gf180mcu_fd_sc_mcu7t5v0__xnor3_1_20/ZN
+ gf180mcu_fd_sc_mcu7t5v0__oai21_1_124/ZN gf180mcu_fd_sc_mcu7t5v0__oai221_1_8/A1 vss
+ vdd vss gf180mcu_fd_sc_mcu7t5v0__oai21_1
Xgf180mcu_fd_sc_mcu7t5v0__oai21_1_135 vdd gf180mcu_fd_sc_mcu7t5v0__buf_8_6/Z gf180mcu_fd_sc_mcu7t5v0__nand3_1_55/A2
+ gf180mcu_fd_sc_mcu7t5v0__aoi21_1_145/B gf180mcu_fd_sc_mcu7t5v0__dffq_1_325/Q vss
+ vdd vss gf180mcu_fd_sc_mcu7t5v0__oai21_1
Xgf180mcu_fd_sc_mcu7t5v0__nor2_2_8 vdd vss gf180mcu_fd_sc_mcu7t5v0__nor2_2_8/ZN gf180mcu_fd_sc_mcu7t5v0__inv_3_0/I
+ gf180mcu_fd_sc_mcu7t5v0__nor2_2_8/A2 vdd vss gf180mcu_fd_sc_mcu7t5v0__nor2_2
Xgf180mcu_fd_sc_mcu7t5v0__oai21_1_146 vdd gf180mcu_fd_sc_mcu7t5v0__buf_8_8/Z gf180mcu_fd_sc_mcu7t5v0__nand2_4_40/ZN
+ gf180mcu_fd_sc_mcu7t5v0__aoi21_1_159/B gf180mcu_fd_sc_mcu7t5v0__dffq_1_326/Q vss
+ vdd vss gf180mcu_fd_sc_mcu7t5v0__oai21_1
Xgf180mcu_fd_sc_mcu7t5v0__oai21_1_157 vdd gf180mcu_fd_sc_mcu7t5v0__oai21_1_157/B gf180mcu_fd_sc_mcu7t5v0__and2_1_53/Z
+ gf180mcu_fd_sc_mcu7t5v0__nor2_1_181/A2 gf180mcu_fd_sc_mcu7t5v0__nor4_1_0/A2 vss
+ vdd vss gf180mcu_fd_sc_mcu7t5v0__oai21_1
Xgf180mcu_fd_sc_mcu7t5v0__oai21_1_168 vdd gf180mcu_fd_sc_mcu7t5v0__buf_8_8/Z gf180mcu_fd_sc_mcu7t5v0__nor3_4_15/ZN
+ gf180mcu_fd_sc_mcu7t5v0__aoi21_1_178/B gf180mcu_fd_sc_mcu7t5v0__nor3_1_24/A1 vss
+ vdd vss gf180mcu_fd_sc_mcu7t5v0__oai21_1
Xgf180mcu_fd_sc_mcu7t5v0__oai21_1_179 vdd gf180mcu_fd_sc_mcu7t5v0__oai21_1_179/B gf180mcu_fd_sc_mcu7t5v0__oai21_1_179/A2
+ gf180mcu_fd_sc_mcu7t5v0__oai221_1_8/B2 gf180mcu_fd_sc_mcu7t5v0__nor2_1_221/ZN vss
+ vdd vss gf180mcu_fd_sc_mcu7t5v0__oai21_1
Xgf180mcu_fd_sc_mcu7t5v0__nand2_2_20 vdd vss gf180mcu_fd_sc_mcu7t5v0__oai22_1_95/B1
+ gf180mcu_fd_sc_mcu7t5v0__buf_8_2/Z gf180mcu_fd_sc_mcu7t5v0__nand2_4_9/ZN vdd vss
+ gf180mcu_fd_sc_mcu7t5v0__nand2_2
Xgf180mcu_fd_sc_mcu7t5v0__nand2_2_31 vdd vss gf180mcu_fd_sc_mcu7t5v0__nand2_2_31/ZN
+ gf180mcu_fd_sc_mcu7t5v0__buf_8_8/I gf180mcu_fd_sc_mcu7t5v0__nand2_4_36/ZN vdd vss
+ gf180mcu_fd_sc_mcu7t5v0__nand2_2
Xgf180mcu_fd_sc_mcu7t5v0__nand2_2_42 vdd vss gf180mcu_fd_sc_mcu7t5v0__nand2_2_42/ZN
+ gf180mcu_fd_sc_mcu7t5v0__buf_8_5/I gf180mcu_fd_sc_mcu7t5v0__nand2_4_31/ZN vdd vss
+ gf180mcu_fd_sc_mcu7t5v0__nand2_2
Xgf180mcu_fd_sc_mcu7t5v0__nand2_2_53 vdd vss gf180mcu_fd_sc_mcu7t5v0__aoi22_4_8/B1
+ gf180mcu_fd_sc_mcu7t5v0__dffq_2_52/Q gf180mcu_fd_sc_mcu7t5v0__inv_2_8/ZN vdd vss
+ gf180mcu_fd_sc_mcu7t5v0__nand2_2
Xgf180mcu_fd_sc_mcu7t5v0__nand2_2_64 vdd vss gf180mcu_fd_sc_mcu7t5v0__oai22_2_1/A1
+ gf180mcu_fd_sc_mcu7t5v0__inv_8_1/I gf180mcu_fd_sc_mcu7t5v0__nor4_2_5/A4 vdd vss
+ gf180mcu_fd_sc_mcu7t5v0__nand2_2
Xgf180mcu_fd_sc_mcu7t5v0__clkinv_1_17 vdd vss gf180mcu_fd_sc_mcu7t5v0__oai22_1_4/A2
+ gf180mcu_fd_sc_mcu7t5v0__nor2_1_89/A2 vdd vss gf180mcu_fd_sc_mcu7t5v0__clkinv_1
Xgf180mcu_fd_sc_mcu7t5v0__clkinv_1_28 vdd vss gf180mcu_fd_sc_mcu7t5v0__dffq_1_21/Q
+ gf180mcu_fd_sc_mcu7t5v0__oai22_1_19/B2 vdd vss gf180mcu_fd_sc_mcu7t5v0__clkinv_1
Xgf180mcu_fd_sc_mcu7t5v0__xor2_1_201 vdd vss gf180mcu_fd_sc_mcu7t5v0__xor2_1_201/Z
+ gf180mcu_fd_sc_mcu7t5v0__xor2_1_201/A1 gf180mcu_fd_sc_mcu7t5v0__xor2_1_202/Z vdd
+ vss gf180mcu_fd_sc_mcu7t5v0__xor2_1
Xgf180mcu_fd_sc_mcu7t5v0__nand2_2_75 vdd vss gf180mcu_fd_sc_mcu7t5v0__or3_1_24/A3
+ gf180mcu_fd_sc_mcu7t5v0__inv_8_0/I gf180mcu_fd_sc_mcu7t5v0__inv_1_23/I vdd vss gf180mcu_fd_sc_mcu7t5v0__nand2_2
Xgf180mcu_fd_sc_mcu7t5v0__clkinv_1_39 vdd vss gf180mcu_fd_sc_mcu7t5v0__dffq_1_27/Q
+ gf180mcu_fd_sc_mcu7t5v0__oai22_1_25/B2 vdd vss gf180mcu_fd_sc_mcu7t5v0__clkinv_1
Xgf180mcu_fd_sc_mcu7t5v0__xor2_1_212 vdd vss gf180mcu_fd_sc_mcu7t5v0__xor2_1_212/Z
+ gf180mcu_fd_sc_mcu7t5v0__xor2_1_212/A1 gf180mcu_fd_sc_mcu7t5v0__aoi21_1_93/B vdd
+ vss gf180mcu_fd_sc_mcu7t5v0__xor2_1
Xgf180mcu_fd_sc_mcu7t5v0__xor2_1_223 vdd vss gf180mcu_fd_sc_mcu7t5v0__xor2_1_223/Z
+ gf180mcu_fd_sc_mcu7t5v0__mux4_4_3/Z gf180mcu_fd_sc_mcu7t5v0__xor3_1_174/A3 vdd vss
+ gf180mcu_fd_sc_mcu7t5v0__xor2_1
Xgf180mcu_fd_sc_mcu7t5v0__clkinv_1_270 vdd vss gf180mcu_fd_sc_mcu7t5v0__dffq_1_83/Q
+ gf180mcu_fd_sc_mcu7t5v0__oai22_1_85/B2 vdd vss gf180mcu_fd_sc_mcu7t5v0__clkinv_1
Xgf180mcu_fd_sc_mcu7t5v0__clkinv_1_281 vdd vss gf180mcu_fd_sc_mcu7t5v0__or3_2_4/Z
+ gf180mcu_fd_sc_mcu7t5v0__nor2_1_152/A2 vdd vss gf180mcu_fd_sc_mcu7t5v0__clkinv_1
Xgf180mcu_fd_sc_mcu7t5v0__clkinv_1_292 vdd vss gf180mcu_fd_sc_mcu7t5v0__dffq_1_335/Q
+ gf180mcu_fd_sc_mcu7t5v0__aoi21_1_161/A1 vdd vss gf180mcu_fd_sc_mcu7t5v0__clkinv_1
Xgf180mcu_fd_sc_mcu7t5v0__dffq_4_14 gf180mcu_fd_sc_mcu7t5v0__dffq_4_14/D gf180mcu_fd_sc_mcu7t5v0__or3_4_0/A3
+ vdd vss gf180mcu_fd_sc_mcu7t5v0__dffq_4_9/CLK vdd vss gf180mcu_fd_sc_mcu7t5v0__dffq_4
Xgf180mcu_fd_sc_mcu7t5v0__dffq_4_25 gf180mcu_fd_sc_mcu7t5v0__dffq_4_25/D gf180mcu_fd_sc_mcu7t5v0__or2_1_7/A1
+ vdd vss gf180mcu_fd_sc_mcu7t5v0__dffq_4_1/CLK vdd vss gf180mcu_fd_sc_mcu7t5v0__dffq_4
Xgf180mcu_fd_sc_mcu7t5v0__dffq_4_36 gf180mcu_fd_sc_mcu7t5v0__dffq_4_36/D gf180mcu_fd_sc_mcu7t5v0__inv_4_6/I
+ vdd vss gf180mcu_fd_sc_mcu7t5v0__dffq_4_1/CLK vdd vss gf180mcu_fd_sc_mcu7t5v0__dffq_4
Xgf180mcu_fd_sc_mcu7t5v0__and2_2_7 vdd vss gf180mcu_fd_sc_mcu7t5v0__and2_2_7/Z gf180mcu_fd_sc_mcu7t5v0__or2_4_0/A1
+ gf180mcu_fd_sc_mcu7t5v0__or2_4_0/A2 vdd vss gf180mcu_fd_sc_mcu7t5v0__and2_2
Xgf180mcu_fd_sc_mcu7t5v0__oai21_2_13 gf180mcu_fd_sc_mcu7t5v0__dffq_4_35/Q gf180mcu_fd_sc_mcu7t5v0__oai21_2_13/ZN
+ gf180mcu_fd_sc_mcu7t5v0__mux4_4_13/I0 vss gf180mcu_fd_sc_mcu7t5v0__inv_4_7/ZN vdd
+ vdd vss gf180mcu_fd_sc_mcu7t5v0__oai21_2
Xgf180mcu_fd_sc_mcu7t5v0__dffq_1_408 vdd gf180mcu_fd_sc_mcu7t5v0__dffq_1_408/Q gf180mcu_fd_sc_mcu7t5v0__dffq_2_58/CLK
+ vss gf180mcu_fd_sc_mcu7t5v0__dffq_1_408/D vdd vss gf180mcu_fd_sc_mcu7t5v0__dffq_1
Xgf180mcu_fd_sc_mcu7t5v0__dffq_1_419 vdd gf180mcu_fd_sc_mcu7t5v0__dffq_1_419/Q gf180mcu_fd_sc_mcu7t5v0__dffq_4_1/CLK
+ vss gf180mcu_fd_sc_mcu7t5v0__dffq_1_419/D vdd vss gf180mcu_fd_sc_mcu7t5v0__dffq_1
Xgf180mcu_fd_sc_mcu7t5v0__aoi22_1_140 gf180mcu_fd_sc_mcu7t5v0__nor2_4_9/ZN gf180mcu_fd_sc_mcu7t5v0__dffq_1_263/Q
+ vdd vss gf180mcu_fd_sc_mcu7t5v0__nand2_1_265/A1 gf180mcu_fd_sc_mcu7t5v0__dffq_1_258/Q
+ gf180mcu_fd_sc_mcu7t5v0__nor2_4_8/ZN vdd vss gf180mcu_fd_sc_mcu7t5v0__aoi22_1
Xgf180mcu_fd_sc_mcu7t5v0__aoi22_1_151 gf180mcu_fd_sc_mcu7t5v0__and3_2_2/A2 gf180mcu_fd_sc_mcu7t5v0__dffq_1_332/Q
+ vdd vss gf180mcu_fd_sc_mcu7t5v0__clkinv_1_323/I gf180mcu_fd_sc_mcu7t5v0__dffq_1_410/Q
+ gf180mcu_fd_sc_mcu7t5v0__nor2_4_23/ZN vdd vss gf180mcu_fd_sc_mcu7t5v0__aoi22_1
Xgf180mcu_fd_sc_mcu7t5v0__or2_1_12 vdd vss gf180mcu_fd_sc_mcu7t5v0__or2_1_12/Z gf180mcu_fd_sc_mcu7t5v0__or2_1_12/A1
+ gf180mcu_fd_sc_mcu7t5v0__xor3_1_28/Z vdd vss gf180mcu_fd_sc_mcu7t5v0__or2_1
Xgf180mcu_fd_sc_mcu7t5v0__or2_1_23 vdd vss gf180mcu_fd_sc_mcu7t5v0__or2_1_23/Z gf180mcu_fd_sc_mcu7t5v0__or2_1_23/A1
+ gf180mcu_fd_sc_mcu7t5v0__or2_1_23/A2 vdd vss gf180mcu_fd_sc_mcu7t5v0__or2_1
Xgf180mcu_fd_sc_mcu7t5v0__aoi22_1_162 gf180mcu_fd_sc_mcu7t5v0__nor2_2_37/ZN gf180mcu_fd_sc_mcu7t5v0__inv_12_1/I
+ vdd vss gf180mcu_fd_sc_mcu7t5v0__nand2_1_466/A1 gf180mcu_fd_sc_mcu7t5v0__nor2_2_32/ZN
+ gf180mcu_fd_sc_mcu7t5v0__nand2_1_468/ZN vdd vss gf180mcu_fd_sc_mcu7t5v0__aoi22_1
Xgf180mcu_fd_sc_mcu7t5v0__or2_1_34 vdd vss gf180mcu_fd_sc_mcu7t5v0__or2_1_34/Z gf180mcu_fd_sc_mcu7t5v0__or2_1_34/A1
+ gf180mcu_fd_sc_mcu7t5v0__or2_1_34/A2 vdd vss gf180mcu_fd_sc_mcu7t5v0__or2_1
Xgf180mcu_fd_sc_mcu7t5v0__aoi22_1_173 gf180mcu_fd_sc_mcu7t5v0__xnor2_1_66/A1 gf180mcu_fd_sc_mcu7t5v0__inv_12_1/I
+ vdd vss gf180mcu_fd_sc_mcu7t5v0__aoi21_1_359/B gf180mcu_fd_sc_mcu7t5v0__inv_8_1/I
+ gf180mcu_fd_sc_mcu7t5v0__xor2_1_192/A1 vdd vss gf180mcu_fd_sc_mcu7t5v0__aoi22_1
Xgf180mcu_fd_sc_mcu7t5v0__or2_1_45 vdd vss gf180mcu_fd_sc_mcu7t5v0__or2_1_45/Z gf180mcu_fd_sc_mcu7t5v0__or2_1_45/A1
+ gf180mcu_fd_sc_mcu7t5v0__or2_1_45/A2 vdd vss gf180mcu_fd_sc_mcu7t5v0__or2_1
Xgf180mcu_fd_sc_mcu7t5v0__or2_1_56 vdd vss gf180mcu_fd_sc_mcu7t5v0__or2_1_56/Z gf180mcu_fd_sc_mcu7t5v0__or3_1_29/A2
+ gf180mcu_fd_sc_mcu7t5v0__or2_1_56/A2 vdd vss gf180mcu_fd_sc_mcu7t5v0__or2_1
Xgf180mcu_fd_sc_mcu7t5v0__nor2_4_12 vdd vss gf180mcu_fd_sc_mcu7t5v0__nor2_4_12/ZN
+ gf180mcu_fd_sc_mcu7t5v0__nor2_4_7/A1 gf180mcu_fd_sc_mcu7t5v0__nor2_4_6/A2 vdd vss
+ gf180mcu_fd_sc_mcu7t5v0__nor2_4
Xgf180mcu_fd_sc_mcu7t5v0__nor2_4_23 vdd vss gf180mcu_fd_sc_mcu7t5v0__nor2_4_23/ZN
+ gf180mcu_fd_sc_mcu7t5v0__nor4_4_0/A1 gf180mcu_fd_sc_mcu7t5v0__inv_2_7/I vdd vss
+ gf180mcu_fd_sc_mcu7t5v0__nor2_4
Xgf180mcu_fd_sc_mcu7t5v0__nor2_4_34 vdd vss gf180mcu_fd_sc_mcu7t5v0__nor2_4_34/ZN
+ gf180mcu_fd_sc_mcu7t5v0__oai32_1_6/A2 gf180mcu_fd_sc_mcu7t5v0__nor2_4_34/A2 vdd
+ vss gf180mcu_fd_sc_mcu7t5v0__nor2_4
Xgf180mcu_fd_sc_mcu7t5v0__nor2_4_45 vdd vss gf180mcu_fd_sc_mcu7t5v0__nor2_4_45/ZN
+ gf180mcu_fd_sc_mcu7t5v0__nor3_2_5/A1 gf180mcu_fd_sc_mcu7t5v0__nor2_4_45/A2 vdd vss
+ gf180mcu_fd_sc_mcu7t5v0__nor2_4
Xgf180mcu_fd_sc_mcu7t5v0__aoi21_1_320 gf180mcu_fd_sc_mcu7t5v0__aoi21_1_7/B vdd vss
+ gf180mcu_fd_sc_mcu7t5v0__dffq_2_81/D gf180mcu_fd_sc_mcu7t5v0__nand2_1_578/ZN gf180mcu_fd_sc_mcu7t5v0__oai211_1_41/ZN
+ vdd vss gf180mcu_fd_sc_mcu7t5v0__aoi21_1
Xgf180mcu_fd_sc_mcu7t5v0__aoi21_1_331 gf180mcu_fd_sc_mcu7t5v0__xor3_1_140/Z vdd vss
+ gf180mcu_fd_sc_mcu7t5v0__or3_1_23/A2 gf180mcu_fd_sc_mcu7t5v0__nand2_1_635/ZN gf180mcu_fd_sc_mcu7t5v0__nand3_1_87/A2
+ vdd vss gf180mcu_fd_sc_mcu7t5v0__aoi21_1
Xgf180mcu_fd_sc_mcu7t5v0__aoi21_1_342 gf180mcu_fd_sc_mcu7t5v0__and2_1_136/Z vdd vss
+ gf180mcu_fd_sc_mcu7t5v0__xor3_1_151/A2 gf180mcu_fd_sc_mcu7t5v0__xor3_1_152/A2 gf180mcu_fd_sc_mcu7t5v0__or2_1_53/Z
+ vdd vss gf180mcu_fd_sc_mcu7t5v0__aoi21_1
Xgf180mcu_fd_sc_mcu7t5v0__aoi21_1_353 gf180mcu_fd_sc_mcu7t5v0__xor2_1_191/Z vdd vss
+ gf180mcu_fd_sc_mcu7t5v0__or3_1_25/A2 gf180mcu_fd_sc_mcu7t5v0__nand3_1_95/A1 gf180mcu_fd_sc_mcu7t5v0__nand3_1_95/A2
+ vdd vss gf180mcu_fd_sc_mcu7t5v0__aoi21_1
Xgf180mcu_fd_sc_mcu7t5v0__aoi21_1_364 gf180mcu_fd_sc_mcu7t5v0__and2_1_138/Z vdd vss
+ gf180mcu_fd_sc_mcu7t5v0__xor3_1_154/A2 gf180mcu_fd_sc_mcu7t5v0__xor2_1_184/A1 gf180mcu_fd_sc_mcu7t5v0__xor2_1_205/Z
+ vdd vss gf180mcu_fd_sc_mcu7t5v0__aoi21_1
Xgf180mcu_fd_sc_mcu7t5v0__aoi21_1_375 gf180mcu_fd_sc_mcu7t5v0__nor2_1_80/A2 vdd vss
+ gf180mcu_fd_sc_mcu7t5v0__xor3_1_87/A2 gf180mcu_fd_sc_mcu7t5v0__mux4_4_5/I1 gf180mcu_fd_sc_mcu7t5v0__xor2_1_219/Z
+ vdd vss gf180mcu_fd_sc_mcu7t5v0__aoi21_1
Xgf180mcu_fd_sc_mcu7t5v0__nand2_1_108 vdd vss gf180mcu_fd_sc_mcu7t5v0__oai21_1_46/B
+ gf180mcu_fd_sc_mcu7t5v0__xor2_1_34/A1 gf180mcu_fd_sc_mcu7t5v0__xor3_1_35/Z vdd vss
+ gf180mcu_fd_sc_mcu7t5v0__nand2_1
Xgf180mcu_fd_sc_mcu7t5v0__nand2_1_119 vdd vss gf180mcu_fd_sc_mcu7t5v0__oai21_1_47/B
+ gf180mcu_fd_sc_mcu7t5v0__and2_1_21/Z gf180mcu_fd_sc_mcu7t5v0__nor2_1_65/A2 vdd vss
+ gf180mcu_fd_sc_mcu7t5v0__nand2_1
Xgf180mcu_fd_sc_mcu7t5v0__xor3_1_30 gf180mcu_fd_sc_mcu7t5v0__or2_1_10/A2 vdd vss gf180mcu_fd_sc_mcu7t5v0__xor3_1_30/Z
+ gf180mcu_fd_sc_mcu7t5v0__or2_1_9/Z gf180mcu_fd_sc_mcu7t5v0__xor3_1_30/A2 vdd vss
+ gf180mcu_fd_sc_mcu7t5v0__xor3_1
Xgf180mcu_fd_sc_mcu7t5v0__xor3_1_41 gf180mcu_fd_sc_mcu7t5v0__xor3_1_41/A3 vdd vss
+ gf180mcu_fd_sc_mcu7t5v0__xor3_1_41/Z gf180mcu_fd_sc_mcu7t5v0__xor3_1_38/Z gf180mcu_fd_sc_mcu7t5v0__xor3_1_41/A2
+ vdd vss gf180mcu_fd_sc_mcu7t5v0__xor3_1
Xgf180mcu_fd_sc_mcu7t5v0__xor3_1_52 gf180mcu_fd_sc_mcu7t5v0__mux2_1_5/Z vdd vss gf180mcu_fd_sc_mcu7t5v0__xor3_1_52/Z
+ gf180mcu_fd_sc_mcu7t5v0__xor3_1_40/Z gf180mcu_fd_sc_mcu7t5v0__xor2_1_59/Z vdd vss
+ gf180mcu_fd_sc_mcu7t5v0__xor3_1
Xgf180mcu_fd_sc_mcu7t5v0__xor3_1_63 gf180mcu_fd_sc_mcu7t5v0__xor3_1_18/Z vdd vss gf180mcu_fd_sc_mcu7t5v0__xor3_1_63/Z
+ gf180mcu_fd_sc_mcu7t5v0__xor3_1_63/A1 gf180mcu_fd_sc_mcu7t5v0__xor3_1_63/A2 vdd
+ vss gf180mcu_fd_sc_mcu7t5v0__xor3_1
Xgf180mcu_fd_sc_mcu7t5v0__xor3_1_74 gf180mcu_fd_sc_mcu7t5v0__xor3_1_74/A3 vdd vss
+ gf180mcu_fd_sc_mcu7t5v0__xor3_1_74/Z gf180mcu_fd_sc_mcu7t5v0__inv_8_1/I gf180mcu_fd_sc_mcu7t5v0__xor3_1_74/A2
+ vdd vss gf180mcu_fd_sc_mcu7t5v0__xor3_1
Xgf180mcu_fd_sc_mcu7t5v0__xor3_1_85 gf180mcu_fd_sc_mcu7t5v0__xor3_1_85/A3 vdd vss
+ gf180mcu_fd_sc_mcu7t5v0__xor3_1_85/Z gf180mcu_fd_sc_mcu7t5v0__xor3_1_85/A1 gf180mcu_fd_sc_mcu7t5v0__xor3_1_85/A2
+ vdd vss gf180mcu_fd_sc_mcu7t5v0__xor3_1
Xgf180mcu_fd_sc_mcu7t5v0__xor3_1_96 gf180mcu_fd_sc_mcu7t5v0__xor3_1_96/A3 vdd vss
+ gf180mcu_fd_sc_mcu7t5v0__xor3_1_96/Z gf180mcu_fd_sc_mcu7t5v0__xor3_1_96/A1 gf180mcu_fd_sc_mcu7t5v0__xor3_1_97/Z
+ vdd vss gf180mcu_fd_sc_mcu7t5v0__xor3_1
Xgf180mcu_fd_sc_mcu7t5v0__nor3_1_0 gf180mcu_fd_sc_mcu7t5v0__nor3_1_0/A3 vdd vss gf180mcu_fd_sc_mcu7t5v0__xor3_1_0/A1
+ gf180mcu_fd_sc_mcu7t5v0__xor3_1_6/A1 gf180mcu_fd_sc_mcu7t5v0__nor3_1_0/A2 vdd vss
+ gf180mcu_fd_sc_mcu7t5v0__nor3_1
Xgf180mcu_fd_sc_mcu7t5v0__dffq_1_205 vdd gf180mcu_fd_sc_mcu7t5v0__dffq_1_205/Q gf180mcu_fd_sc_mcu7t5v0__dffq_4_8/CLK
+ vss gf180mcu_fd_sc_mcu7t5v0__dffq_1_205/D vdd vss gf180mcu_fd_sc_mcu7t5v0__dffq_1
Xgf180mcu_fd_sc_mcu7t5v0__dffq_1_216 vdd gf180mcu_fd_sc_mcu7t5v0__dffq_1_216/Q gf180mcu_fd_sc_mcu7t5v0__dffq_4_8/CLK
+ vss gf180mcu_fd_sc_mcu7t5v0__dffq_1_216/D vdd vss gf180mcu_fd_sc_mcu7t5v0__dffq_1
Xgf180mcu_fd_sc_mcu7t5v0__nor2_1_405 vdd vss gf180mcu_fd_sc_mcu7t5v0__nor2_1_405/ZN
+ gf180mcu_fd_sc_mcu7t5v0__dffq_1_314/Q gf180mcu_fd_sc_mcu7t5v0__nor2_4_21/ZN vdd
+ vss gf180mcu_fd_sc_mcu7t5v0__nor2_1
Xgf180mcu_fd_sc_mcu7t5v0__dffq_1_227 vdd gf180mcu_fd_sc_mcu7t5v0__dffq_1_227/Q gf180mcu_fd_sc_mcu7t5v0__dffq_2_26/CLK
+ vss gf180mcu_fd_sc_mcu7t5v0__dffq_1_227/D vdd vss gf180mcu_fd_sc_mcu7t5v0__dffq_1
Xgf180mcu_fd_sc_mcu7t5v0__dffq_1_238 vdd gf180mcu_fd_sc_mcu7t5v0__dffq_1_238/Q gf180mcu_fd_sc_mcu7t5v0__dffq_4_8/CLK
+ vss gf180mcu_fd_sc_mcu7t5v0__dffq_1_238/D vdd vss gf180mcu_fd_sc_mcu7t5v0__dffq_1
Xgf180mcu_fd_sc_mcu7t5v0__dffq_1_249 vdd gf180mcu_fd_sc_mcu7t5v0__dffq_1_249/Q gf180mcu_fd_sc_mcu7t5v0__dffq_2_26/CLK
+ vss gf180mcu_fd_sc_mcu7t5v0__dffq_1_249/D vdd vss gf180mcu_fd_sc_mcu7t5v0__dffq_1
Xgf180mcu_fd_sc_mcu7t5v0__nand2_1_620 vdd vss gf180mcu_fd_sc_mcu7t5v0__or2_1_49/A2
+ gf180mcu_fd_sc_mcu7t5v0__inv_8_1/I gf180mcu_fd_sc_mcu7t5v0__mux4_4_15/Z vdd vss
+ gf180mcu_fd_sc_mcu7t5v0__nand2_1
Xgf180mcu_fd_sc_mcu7t5v0__nand2_1_631 vdd vss gf180mcu_fd_sc_mcu7t5v0__oai21_1_294/A2
+ gf180mcu_fd_sc_mcu7t5v0__inv_4_6/I gf180mcu_fd_sc_mcu7t5v0__xor2_1_162/A1 vdd vss
+ gf180mcu_fd_sc_mcu7t5v0__nand2_1
Xgf180mcu_fd_sc_mcu7t5v0__nand2_1_642 vdd vss gf180mcu_fd_sc_mcu7t5v0__nand2_1_642/ZN
+ gf180mcu_fd_sc_mcu7t5v0__nor2_4_42/ZN gf180mcu_fd_sc_mcu7t5v0__xor3_1_149/Z vdd
+ vss gf180mcu_fd_sc_mcu7t5v0__nand2_1
Xgf180mcu_fd_sc_mcu7t5v0__nand2_1_653 vdd vss gf180mcu_fd_sc_mcu7t5v0__aoi21_1_352/B
+ gf180mcu_fd_sc_mcu7t5v0__oai22_1_278/ZN gf180mcu_fd_sc_mcu7t5v0__nand2_1_653/A2
+ vdd vss gf180mcu_fd_sc_mcu7t5v0__nand2_1
Xgf180mcu_fd_sc_mcu7t5v0__nand2_1_664 vdd vss gf180mcu_fd_sc_mcu7t5v0__oai21_1_322/A2
+ gf180mcu_fd_sc_mcu7t5v0__inv_4_6/I gf180mcu_fd_sc_mcu7t5v0__oai31_4_5/ZN vdd vss
+ gf180mcu_fd_sc_mcu7t5v0__nand2_1
Xgf180mcu_fd_sc_mcu7t5v0__nand2_1_675 vdd vss gf180mcu_fd_sc_mcu7t5v0__xor2_1_195/A1
+ gf180mcu_fd_sc_mcu7t5v0__inv_12_1/I gf180mcu_fd_sc_mcu7t5v0__xor2_1_192/A1 vdd vss
+ gf180mcu_fd_sc_mcu7t5v0__nand2_1
Xgf180mcu_fd_sc_mcu7t5v0__nand2_1_686 vdd vss gf180mcu_fd_sc_mcu7t5v0__xor3_1_160/A3
+ gf180mcu_fd_sc_mcu7t5v0__inv_8_1/I gf180mcu_fd_sc_mcu7t5v0__oai31_4_5/ZN vdd vss
+ gf180mcu_fd_sc_mcu7t5v0__nand2_1
Xgf180mcu_fd_sc_mcu7t5v0__nand2_1_697 vdd vss gf180mcu_fd_sc_mcu7t5v0__or3_1_26/A1
+ gf180mcu_fd_sc_mcu7t5v0__inv_8_1/I gf180mcu_fd_sc_mcu7t5v0__xor3_1_162/A2 vdd vss
+ gf180mcu_fd_sc_mcu7t5v0__nand2_1
Xgf180mcu_fd_sc_mcu7t5v0__dffq_1_15 vdd gf180mcu_fd_sc_mcu7t5v0__inv_2_5/I gf180mcu_fd_sc_mcu7t5v0__dffq_4_6/CLK
+ vss gf180mcu_fd_sc_mcu7t5v0__dffq_1_15/D vdd vss gf180mcu_fd_sc_mcu7t5v0__dffq_1
Xgf180mcu_fd_sc_mcu7t5v0__dffq_1_26 vdd gf180mcu_fd_sc_mcu7t5v0__dffq_1_26/Q gf180mcu_fd_sc_mcu7t5v0__dffq_1_99/CLK
+ vss gf180mcu_fd_sc_mcu7t5v0__dffq_1_26/D vdd vss gf180mcu_fd_sc_mcu7t5v0__dffq_1
Xgf180mcu_fd_sc_mcu7t5v0__dffq_1_37 vdd gf180mcu_fd_sc_mcu7t5v0__dffq_1_37/Q gf180mcu_fd_sc_mcu7t5v0__dffq_1_99/CLK
+ vss gf180mcu_fd_sc_mcu7t5v0__dffq_1_37/D vdd vss gf180mcu_fd_sc_mcu7t5v0__dffq_1
Xgf180mcu_fd_sc_mcu7t5v0__dffq_1_48 vdd gf180mcu_fd_sc_mcu7t5v0__dffq_1_48/Q gf180mcu_fd_sc_mcu7t5v0__dffq_1_99/CLK
+ vss gf180mcu_fd_sc_mcu7t5v0__dffq_1_48/D vdd vss gf180mcu_fd_sc_mcu7t5v0__dffq_1
Xgf180mcu_fd_sc_mcu7t5v0__dffq_1_59 vdd gf180mcu_fd_sc_mcu7t5v0__dffq_1_59/Q gf180mcu_fd_sc_mcu7t5v0__dffq_1_95/CLK
+ vss gf180mcu_fd_sc_mcu7t5v0__dffq_1_59/D vdd vss gf180mcu_fd_sc_mcu7t5v0__dffq_1
Xgf180mcu_fd_sc_mcu7t5v0__nand2_2_8 vdd vss gf180mcu_fd_sc_mcu7t5v0__oai31_1_2/B gf180mcu_fd_sc_mcu7t5v0__inv_4_0/I
+ gf180mcu_fd_sc_mcu7t5v0__nor2_1_84/ZN vdd vss gf180mcu_fd_sc_mcu7t5v0__nand2_2
Xgf180mcu_fd_sc_mcu7t5v0__inv_1_20 vss gf180mcu_fd_sc_mcu7t5v0__inv_1_20/ZN gf180mcu_fd_sc_mcu7t5v0__inv_1_20/I
+ vdd vdd vss gf180mcu_fd_sc_mcu7t5v0__inv_1
Xgf180mcu_fd_sc_mcu7t5v0__aoi21_1_150 gf180mcu_fd_sc_mcu7t5v0__aoi21_1_150/B vdd vss
+ gf180mcu_fd_sc_mcu7t5v0__dffq_1_326/D gf180mcu_fd_sc_mcu7t5v0__aoi21_1_150/A1 gf180mcu_fd_sc_mcu7t5v0__nand2_4_40/ZN
+ vdd vss gf180mcu_fd_sc_mcu7t5v0__aoi21_1
Xgf180mcu_fd_sc_mcu7t5v0__aoi21_1_161 gf180mcu_fd_sc_mcu7t5v0__aoi21_1_161/B vdd vss
+ gf180mcu_fd_sc_mcu7t5v0__dffq_1_335/D gf180mcu_fd_sc_mcu7t5v0__aoi21_1_161/A1 gf180mcu_fd_sc_mcu7t5v0__nand2_4_40/ZN
+ vdd vss gf180mcu_fd_sc_mcu7t5v0__aoi21_1
Xgf180mcu_fd_sc_mcu7t5v0__aoi21_1_172 gf180mcu_fd_sc_mcu7t5v0__aoi21_1_172/B vdd vss
+ gf180mcu_fd_sc_mcu7t5v0__dffq_1_373/D gf180mcu_fd_sc_mcu7t5v0__nand4_2_1/A2 gf180mcu_fd_sc_mcu7t5v0__aoi211_4_0/ZN
+ vdd vss gf180mcu_fd_sc_mcu7t5v0__aoi21_1
Xgf180mcu_fd_sc_mcu7t5v0__aoi21_1_183 gf180mcu_fd_sc_mcu7t5v0__aoi21_1_183/B vdd vss
+ gf180mcu_fd_sc_mcu7t5v0__oai31_1_12/A2 gf180mcu_fd_sc_mcu7t5v0__or2_1_57/A1 gf180mcu_fd_sc_mcu7t5v0__or2_1_57/A2
+ vdd vss gf180mcu_fd_sc_mcu7t5v0__aoi21_1
Xgf180mcu_fd_sc_mcu7t5v0__and2_1_150 vdd vss gf180mcu_fd_sc_mcu7t5v0__and2_1_150/Z
+ gf180mcu_fd_sc_mcu7t5v0__inv_8_0/I gf180mcu_fd_sc_mcu7t5v0__xnor2_1_66/A1 vdd vss
+ gf180mcu_fd_sc_mcu7t5v0__and2_1
Xgf180mcu_fd_sc_mcu7t5v0__aoi21_1_194 gf180mcu_fd_sc_mcu7t5v0__xor2_1_101/A2 vdd vss
+ gf180mcu_fd_sc_mcu7t5v0__nor2_1_215/A2 gf180mcu_fd_sc_mcu7t5v0__nand2_1_387/A1 gf180mcu_fd_sc_mcu7t5v0__nand2_1_387/A2
+ vdd vss gf180mcu_fd_sc_mcu7t5v0__aoi21_1
Xgf180mcu_fd_sc_mcu7t5v0__aoi22_1_9 gf180mcu_fd_sc_mcu7t5v0__xor2_1_58/A1 gf180mcu_fd_sc_mcu7t5v0__inv_12_1/I
+ vdd vss gf180mcu_fd_sc_mcu7t5v0__aoi22_1_9/ZN gf180mcu_fd_sc_mcu7t5v0__inv_8_2/I
+ gf180mcu_fd_sc_mcu7t5v0__or4_1_1/A2 vdd vss gf180mcu_fd_sc_mcu7t5v0__aoi22_1
Xgf180mcu_fd_sc_mcu7t5v0__buf_8_5 gf180mcu_fd_sc_mcu7t5v0__buf_8_5/Z gf180mcu_fd_sc_mcu7t5v0__buf_8_5/I
+ vdd vss vdd vss gf180mcu_fd_sc_mcu7t5v0__buf_8
Xgf180mcu_fd_sc_mcu7t5v0__oai22_1_104 gf180mcu_fd_sc_mcu7t5v0__nand2_4_15/ZN gf180mcu_fd_sc_mcu7t5v0__nand2_2_21/ZN
+ gf180mcu_fd_sc_mcu7t5v0__oai22_1_104/B2 vdd vss gf180mcu_fd_sc_mcu7t5v0__dffq_1_102/D
+ gf180mcu_fd_sc_mcu7t5v0__aoi21_4_3/ZN vdd vss gf180mcu_fd_sc_mcu7t5v0__oai22_1
Xgf180mcu_fd_sc_mcu7t5v0__oai22_1_115 gf180mcu_fd_sc_mcu7t5v0__oai22_1_97/A2 gf180mcu_fd_sc_mcu7t5v0__oai22_1_97/B1
+ gf180mcu_fd_sc_mcu7t5v0__oai22_1_115/B2 vdd vss gf180mcu_fd_sc_mcu7t5v0__dffq_1_109/D
+ gf180mcu_fd_sc_mcu7t5v0__aoi21_4_1/ZN vdd vss gf180mcu_fd_sc_mcu7t5v0__oai22_1
Xgf180mcu_fd_sc_mcu7t5v0__oai22_1_126 gf180mcu_fd_sc_mcu7t5v0__oai22_1_55/A2 gf180mcu_fd_sc_mcu7t5v0__oai22_1_55/B1
+ gf180mcu_fd_sc_mcu7t5v0__oai22_1_126/B2 vdd vss gf180mcu_fd_sc_mcu7t5v0__dffq_1_117/D
+ gf180mcu_fd_sc_mcu7t5v0__oai21_4_9/ZN vdd vss gf180mcu_fd_sc_mcu7t5v0__oai22_1
Xgf180mcu_fd_sc_mcu7t5v0__oai22_1_137 gf180mcu_fd_sc_mcu7t5v0__nand2_4_17/ZN gf180mcu_fd_sc_mcu7t5v0__nand2_2_23/ZN
+ gf180mcu_fd_sc_mcu7t5v0__oai22_1_137/B2 vdd vss gf180mcu_fd_sc_mcu7t5v0__dffq_1_135/D
+ gf180mcu_fd_sc_mcu7t5v0__oai22_1_98/A1 vdd vss gf180mcu_fd_sc_mcu7t5v0__oai22_1
Xgf180mcu_fd_sc_mcu7t5v0__oai22_1_148 gf180mcu_fd_sc_mcu7t5v0__nand2_4_21/ZN gf180mcu_fd_sc_mcu7t5v0__nand2_2_28/ZN
+ gf180mcu_fd_sc_mcu7t5v0__oai22_1_148/B2 vdd vss gf180mcu_fd_sc_mcu7t5v0__dffq_1_157/D
+ gf180mcu_fd_sc_mcu7t5v0__aoi21_4_2/ZN vdd vss gf180mcu_fd_sc_mcu7t5v0__oai22_1
Xgf180mcu_fd_sc_mcu7t5v0__oai22_1_159 gf180mcu_fd_sc_mcu7t5v0__nand2_4_20/ZN gf180mcu_fd_sc_mcu7t5v0__nand2_2_27/ZN
+ gf180mcu_fd_sc_mcu7t5v0__oai22_1_159/B2 vdd vss gf180mcu_fd_sc_mcu7t5v0__dffq_1_159/D
+ gf180mcu_fd_sc_mcu7t5v0__oai22_1_88/A1 vdd vss gf180mcu_fd_sc_mcu7t5v0__oai22_1
Xgf180mcu_fd_sc_mcu7t5v0__oai221_1_9 gf180mcu_fd_sc_mcu7t5v0__oai221_1_9/B1 gf180mcu_fd_sc_mcu7t5v0__oai221_1_9/C
+ vdd vss gf180mcu_fd_sc_mcu7t5v0__oai221_1_9/ZN gf180mcu_fd_sc_mcu7t5v0__and3_2_3/A2
+ gf180mcu_fd_sc_mcu7t5v0__xor3_1_86/A1 gf180mcu_fd_sc_mcu7t5v0__oai221_1_9/B2 vdd
+ vss gf180mcu_fd_sc_mcu7t5v0__oai221_1
Xgf180mcu_fd_sc_mcu7t5v0__nor2_1_13 vdd vss gf180mcu_fd_sc_mcu7t5v0__xor3_1_7/A2 gf180mcu_fd_sc_mcu7t5v0__or2_1_1/Z
+ gf180mcu_fd_sc_mcu7t5v0__xor3_1_60/Z vdd vss gf180mcu_fd_sc_mcu7t5v0__nor2_1
Xgf180mcu_fd_sc_mcu7t5v0__nor2_1_24 vdd vss gf180mcu_fd_sc_mcu7t5v0__nor2_1_24/ZN
+ gf180mcu_fd_sc_mcu7t5v0__or3_1_24/A1 gf180mcu_fd_sc_mcu7t5v0__nor2_1_24/A2 vdd vss
+ gf180mcu_fd_sc_mcu7t5v0__nor2_1
Xgf180mcu_fd_sc_mcu7t5v0__nor2_1_35 vdd vss gf180mcu_fd_sc_mcu7t5v0__nor2_1_35/ZN
+ gf180mcu_fd_sc_mcu7t5v0__mux4_4_3/I2 gf180mcu_fd_sc_mcu7t5v0__xor3_2_0/Z vdd vss
+ gf180mcu_fd_sc_mcu7t5v0__nor2_1
Xgf180mcu_fd_sc_mcu7t5v0__nor2_1_46 vdd vss gf180mcu_fd_sc_mcu7t5v0__dffq_2_14/D gf180mcu_fd_sc_mcu7t5v0__aoi21_1_7/B
+ gf180mcu_fd_sc_mcu7t5v0__nor2_1_46/A2 vdd vss gf180mcu_fd_sc_mcu7t5v0__nor2_1
Xgf180mcu_fd_sc_mcu7t5v0__nor2_1_57 vdd vss gf180mcu_fd_sc_mcu7t5v0__aoi21_2_2/B gf180mcu_fd_sc_mcu7t5v0__nor2_1_57/A1
+ gf180mcu_fd_sc_mcu7t5v0__xor3_1_39/Z vdd vss gf180mcu_fd_sc_mcu7t5v0__nor2_1
Xgf180mcu_fd_sc_mcu7t5v0__nor2_1_68 vdd vss gf180mcu_fd_sc_mcu7t5v0__or3_1_4/A3 gf180mcu_fd_sc_mcu7t5v0__or2_1_14/A1
+ gf180mcu_fd_sc_mcu7t5v0__or2_1_14/A2 vdd vss gf180mcu_fd_sc_mcu7t5v0__nor2_1
Xgf180mcu_fd_sc_mcu7t5v0__nor2_1_79 vdd vss gf180mcu_fd_sc_mcu7t5v0__nor2_1_79/ZN
+ gf180mcu_fd_sc_mcu7t5v0__oai31_1_14/B gf180mcu_fd_sc_mcu7t5v0__nor2_1_79/A2 vdd
+ vss gf180mcu_fd_sc_mcu7t5v0__nor2_1
Xgf180mcu_fd_sc_mcu7t5v0__nor2_1_202 vdd vss gf180mcu_fd_sc_mcu7t5v0__dffq_1_358/D
+ gf180mcu_fd_sc_mcu7t5v0__dffq_1_358/Q gf180mcu_fd_sc_mcu7t5v0__oai31_4_2/ZN vdd
+ vss gf180mcu_fd_sc_mcu7t5v0__nor2_1
Xgf180mcu_fd_sc_mcu7t5v0__nor2_1_213 vdd vss gf180mcu_fd_sc_mcu7t5v0__nor2_1_213/ZN
+ gf180mcu_fd_sc_mcu7t5v0__dffq_2_42/Q gf180mcu_fd_sc_mcu7t5v0__nor2_4_30/A2 vdd vss
+ gf180mcu_fd_sc_mcu7t5v0__nor2_1
Xgf180mcu_fd_sc_mcu7t5v0__nor2_1_224 vdd vss gf180mcu_fd_sc_mcu7t5v0__nor2_1_224/ZN
+ gf180mcu_fd_sc_mcu7t5v0__or2_4_3/Z gf180mcu_fd_sc_mcu7t5v0__nor2_1_224/A2 vdd vss
+ gf180mcu_fd_sc_mcu7t5v0__nor2_1
Xgf180mcu_fd_sc_mcu7t5v0__nor2_1_235 vdd vss gf180mcu_fd_sc_mcu7t5v0__nor2_1_235/ZN
+ gf180mcu_fd_sc_mcu7t5v0__nor2_1_411/A1 gf180mcu_fd_sc_mcu7t5v0__inv_2_8/I vdd vss
+ gf180mcu_fd_sc_mcu7t5v0__nor2_1
Xgf180mcu_fd_sc_mcu7t5v0__nor2_1_246 vdd vss gf180mcu_fd_sc_mcu7t5v0__nor2_1_252/A1
+ gf180mcu_fd_sc_mcu7t5v0__xnor3_1_26/A2 gf180mcu_fd_sc_mcu7t5v0__xor3_1_86/A2 vdd
+ vss gf180mcu_fd_sc_mcu7t5v0__nor2_1
Xgf180mcu_fd_sc_mcu7t5v0__nor2_1_257 vdd vss gf180mcu_fd_sc_mcu7t5v0__aoi21_2_8/B
+ gf180mcu_fd_sc_mcu7t5v0__xnor2_1_82/A2 gf180mcu_fd_sc_mcu7t5v0__xnor2_1_43/A1 vdd
+ vss gf180mcu_fd_sc_mcu7t5v0__nor2_1
Xgf180mcu_fd_sc_mcu7t5v0__nor2_1_268 vdd vss gf180mcu_fd_sc_mcu7t5v0__nor2_1_268/ZN
+ gf180mcu_fd_sc_mcu7t5v0__mux2_1_9/I1 gf180mcu_fd_sc_mcu7t5v0__xor3_1_100/A1 vdd
+ vss gf180mcu_fd_sc_mcu7t5v0__nor2_1
Xgf180mcu_fd_sc_mcu7t5v0__nor2_1_279 vdd vss gf180mcu_fd_sc_mcu7t5v0__xor2_1_131/A1
+ gf180mcu_fd_sc_mcu7t5v0__nor2_1_279/A1 gf180mcu_fd_sc_mcu7t5v0__aoi21_2_9/ZN vdd
+ vss gf180mcu_fd_sc_mcu7t5v0__nor2_1
Xgf180mcu_fd_sc_mcu7t5v0__xor3_1_8 gf180mcu_fd_sc_mcu7t5v0__xor3_1_8/A3 vdd vss gf180mcu_fd_sc_mcu7t5v0__xor3_1_8/Z
+ gf180mcu_fd_sc_mcu7t5v0__xor3_1_8/A1 gf180mcu_fd_sc_mcu7t5v0__xor3_1_4/Z vdd vss
+ gf180mcu_fd_sc_mcu7t5v0__xor3_1
Xgf180mcu_fd_sc_mcu7t5v0__nand2_1_450 vdd vss gf180mcu_fd_sc_mcu7t5v0__oai21_1_210/B
+ gf180mcu_fd_sc_mcu7t5v0__inv_8_0/I gf180mcu_fd_sc_mcu7t5v0__xor2_1_119/Z vdd vss
+ gf180mcu_fd_sc_mcu7t5v0__nand2_1
Xgf180mcu_fd_sc_mcu7t5v0__nand2_1_461 vdd vss gf180mcu_fd_sc_mcu7t5v0__oai21_1_208/A2
+ gf180mcu_fd_sc_mcu7t5v0__dffq_4_37/Q gf180mcu_fd_sc_mcu7t5v0__mux4_4_7/Z vdd vss
+ gf180mcu_fd_sc_mcu7t5v0__nand2_1
Xgf180mcu_fd_sc_mcu7t5v0__nand2_1_472 vdd vss gf180mcu_fd_sc_mcu7t5v0__nor2_4_34/A2
+ gf180mcu_fd_sc_mcu7t5v0__dffq_4_40/Q gf180mcu_fd_sc_mcu7t5v0__nor2_2_33/A1 vdd vss
+ gf180mcu_fd_sc_mcu7t5v0__nand2_1
Xgf180mcu_fd_sc_mcu7t5v0__nand2_1_483 vdd vss gf180mcu_fd_sc_mcu7t5v0__nand3_1_70/A1
+ gf180mcu_fd_sc_mcu7t5v0__inv_4_6/I gf180mcu_fd_sc_mcu7t5v0__xor2_1_130/Z vdd vss
+ gf180mcu_fd_sc_mcu7t5v0__nand2_1
Xgf180mcu_fd_sc_mcu7t5v0__nand2_1_494 vdd vss gf180mcu_fd_sc_mcu7t5v0__oai211_1_33/B
+ gf180mcu_fd_sc_mcu7t5v0__xnor3_1_28/A2 gf180mcu_fd_sc_mcu7t5v0__xnor3_1_28/A3 vdd
+ vss gf180mcu_fd_sc_mcu7t5v0__nand2_1
Xgf180mcu_fd_sc_mcu7t5v0__oai21_1_306 vdd gf180mcu_fd_sc_mcu7t5v0__oai21_1_306/B gf180mcu_fd_sc_mcu7t5v0__nor2_1_379/ZN
+ gf180mcu_fd_sc_mcu7t5v0__xnor3_1_41/A2 gf180mcu_fd_sc_mcu7t5v0__xor3_1_138/A3 vss
+ vdd vss gf180mcu_fd_sc_mcu7t5v0__oai21_1
Xgf180mcu_fd_sc_mcu7t5v0__oai21_1_317 vdd gf180mcu_fd_sc_mcu7t5v0__or3_1_25/A3 gf180mcu_fd_sc_mcu7t5v0__or3_1_25/A2
+ gf180mcu_fd_sc_mcu7t5v0__nand3_1_97/A2 gf180mcu_fd_sc_mcu7t5v0__or3_1_25/A1 vss
+ vdd vss gf180mcu_fd_sc_mcu7t5v0__oai21_1
Xgf180mcu_fd_sc_mcu7t5v0__oai21_1_328 vdd gf180mcu_fd_sc_mcu7t5v0__oai21_1_328/B gf180mcu_fd_sc_mcu7t5v0__oai21_1_328/A2
+ gf180mcu_fd_sc_mcu7t5v0__xnor3_1_48/A1 gf180mcu_fd_sc_mcu7t5v0__xor3_1_148/A2 vss
+ vdd vss gf180mcu_fd_sc_mcu7t5v0__oai21_1
Xgf180mcu_fd_sc_mcu7t5v0__oai21_1_339 vdd gf180mcu_fd_sc_mcu7t5v0__oai31_1_1/B gf180mcu_fd_sc_mcu7t5v0__oai31_1_1/A2
+ gf180mcu_fd_sc_mcu7t5v0__xnor2_1_6/A2 gf180mcu_fd_sc_mcu7t5v0__mux4_4_0/Z vss vdd
+ vss gf180mcu_fd_sc_mcu7t5v0__oai21_1
Xgf180mcu_fd_sc_mcu7t5v0__aoi22_1_15 gf180mcu_fd_sc_mcu7t5v0__nor2_4_11/ZN gf180mcu_fd_sc_mcu7t5v0__dffq_1_31/Q
+ vdd vss gf180mcu_fd_sc_mcu7t5v0__aoi22_1_15/ZN gf180mcu_fd_sc_mcu7t5v0__dffq_1_17/Q
+ gf180mcu_fd_sc_mcu7t5v0__nor2_4_10/ZN vdd vss gf180mcu_fd_sc_mcu7t5v0__aoi22_1
Xgf180mcu_fd_sc_mcu7t5v0__aoi22_1_26 gf180mcu_fd_sc_mcu7t5v0__nor2_4_9/ZN gf180mcu_fd_sc_mcu7t5v0__dffq_1_37/Q
+ vdd vss gf180mcu_fd_sc_mcu7t5v0__aoi22_1_26/ZN gf180mcu_fd_sc_mcu7t5v0__dffq_1_41/Q
+ gf180mcu_fd_sc_mcu7t5v0__nor2_4_8/ZN vdd vss gf180mcu_fd_sc_mcu7t5v0__aoi22_1
Xgf180mcu_fd_sc_mcu7t5v0__aoi22_1_37 gf180mcu_fd_sc_mcu7t5v0__nor2_4_11/ZN gf180mcu_fd_sc_mcu7t5v0__dffq_1_65/Q
+ vdd vss gf180mcu_fd_sc_mcu7t5v0__aoi22_1_37/ZN gf180mcu_fd_sc_mcu7t5v0__dffq_1_63/Q
+ gf180mcu_fd_sc_mcu7t5v0__nor2_4_10/ZN vdd vss gf180mcu_fd_sc_mcu7t5v0__aoi22_1
Xgf180mcu_fd_sc_mcu7t5v0__aoi22_1_48 gf180mcu_fd_sc_mcu7t5v0__nor2_4_11/ZN gf180mcu_fd_sc_mcu7t5v0__dffq_1_89/Q
+ vdd vss gf180mcu_fd_sc_mcu7t5v0__aoi22_1_48/ZN gf180mcu_fd_sc_mcu7t5v0__dffq_1_74/Q
+ gf180mcu_fd_sc_mcu7t5v0__nor2_4_10/ZN vdd vss gf180mcu_fd_sc_mcu7t5v0__aoi22_1
Xgf180mcu_fd_sc_mcu7t5v0__aoi22_1_59 gf180mcu_fd_sc_mcu7t5v0__nor3_4_6/ZN gf180mcu_fd_sc_mcu7t5v0__aoi22_1_59/B2
+ vdd vss gf180mcu_fd_sc_mcu7t5v0__nand3_1_39/A1 gf180mcu_fd_sc_mcu7t5v0__nor2_4_7/ZN
+ gf180mcu_fd_sc_mcu7t5v0__aoi22_1_59/A2 vdd vss gf180mcu_fd_sc_mcu7t5v0__aoi22_1
Xgf180mcu_fd_sc_mcu7t5v0__xnor2_1_20 vdd vss gf180mcu_fd_sc_mcu7t5v0__xnor3_1_12/A2
+ gf180mcu_fd_sc_mcu7t5v0__xnor2_1_20/A1 gf180mcu_fd_sc_mcu7t5v0__oai22_1_6/ZN vdd
+ vss gf180mcu_fd_sc_mcu7t5v0__xnor2_1
Xgf180mcu_fd_sc_mcu7t5v0__xnor2_1_31 vdd vss gf180mcu_fd_sc_mcu7t5v0__xor2_1_87/A2
+ gf180mcu_fd_sc_mcu7t5v0__xnor2_1_31/A1 gf180mcu_fd_sc_mcu7t5v0__xnor2_1_85/ZN vdd
+ vss gf180mcu_fd_sc_mcu7t5v0__xnor2_1
Xgf180mcu_fd_sc_mcu7t5v0__xnor2_1_42 vdd vss gf180mcu_fd_sc_mcu7t5v0__xnor2_1_42/ZN
+ gf180mcu_fd_sc_mcu7t5v0__xnor2_1_42/A1 gf180mcu_fd_sc_mcu7t5v0__xnor2_1_43/ZN vdd
+ vss gf180mcu_fd_sc_mcu7t5v0__xnor2_1
Xgf180mcu_fd_sc_mcu7t5v0__xnor2_1_53 vdd vss gf180mcu_fd_sc_mcu7t5v0__xor2_1_157/A2
+ gf180mcu_fd_sc_mcu7t5v0__or2_1_32/A1 gf180mcu_fd_sc_mcu7t5v0__or2_1_32/A2 vdd vss
+ gf180mcu_fd_sc_mcu7t5v0__xnor2_1
Xgf180mcu_fd_sc_mcu7t5v0__or3_1_8 gf180mcu_fd_sc_mcu7t5v0__or3_1_8/A3 vdd vss gf180mcu_fd_sc_mcu7t5v0__or3_1_8/Z
+ gf180mcu_fd_sc_mcu7t5v0__or3_1_8/A1 gf180mcu_fd_sc_mcu7t5v0__or3_1_8/A2 vdd vss
+ gf180mcu_fd_sc_mcu7t5v0__or3_1
Xgf180mcu_fd_sc_mcu7t5v0__xnor2_1_64 vdd vss gf180mcu_fd_sc_mcu7t5v0__xnor2_1_64/ZN
+ gf180mcu_fd_sc_mcu7t5v0__xnor2_1_64/A1 gf180mcu_fd_sc_mcu7t5v0__xnor2_1_64/A2 vdd
+ vss gf180mcu_fd_sc_mcu7t5v0__xnor2_1
Xgf180mcu_fd_sc_mcu7t5v0__xnor2_1_75 vdd vss gf180mcu_fd_sc_mcu7t5v0__xor2_1_202/A2
+ gf180mcu_fd_sc_mcu7t5v0__xnor2_1_75/A1 gf180mcu_fd_sc_mcu7t5v0__xnor2_1_75/A2 vdd
+ vss gf180mcu_fd_sc_mcu7t5v0__xnor2_1
Xgf180mcu_fd_sc_mcu7t5v0__xnor2_1_86 vdd vss gf180mcu_fd_sc_mcu7t5v0__xor2_2_2/A2
+ gf180mcu_fd_sc_mcu7t5v0__xnor2_1_86/A1 gf180mcu_fd_sc_mcu7t5v0__xor2_1_168/Z vdd
+ vss gf180mcu_fd_sc_mcu7t5v0__xnor2_1
Xgf180mcu_fd_sc_mcu7t5v0__nor3_2_12 gf180mcu_fd_sc_mcu7t5v0__xor3_1_130/Z vdd vss
+ gf180mcu_fd_sc_mcu7t5v0__nor3_2_12/ZN gf180mcu_fd_sc_mcu7t5v0__xor3_2_2/A2 gf180mcu_fd_sc_mcu7t5v0__xor2_1_171/Z
+ vdd vss gf180mcu_fd_sc_mcu7t5v0__nor3_2
Xgf180mcu_fd_sc_mcu7t5v0__dffq_2_80 gf180mcu_fd_sc_mcu7t5v0__dffq_2_80/D vdd vss gf180mcu_fd_sc_mcu7t5v0__dffq_4_44/CLK
+ gf180mcu_fd_sc_mcu7t5v0__dffq_2_80/Q vdd vss gf180mcu_fd_sc_mcu7t5v0__dffq_2
Xgf180mcu_fd_sc_mcu7t5v0__dffq_2_91 gf180mcu_fd_sc_mcu7t5v0__dffq_2_91/D vdd vss gf180mcu_fd_sc_mcu7t5v0__dffq_4_1/CLK
+ gf180mcu_fd_sc_mcu7t5v0__dffq_2_91/Q vdd vss gf180mcu_fd_sc_mcu7t5v0__dffq_2
Xgf180mcu_fd_sc_mcu7t5v0__oai21_1_1 vdd gf180mcu_fd_sc_mcu7t5v0__xor2_1_2/Z gf180mcu_fd_sc_mcu7t5v0__xor3_1_5/A1
+ gf180mcu_fd_sc_mcu7t5v0__xor3_1_3/A1 gf180mcu_fd_sc_mcu7t5v0__xor3_1_2/A1 vss vdd
+ vss gf180mcu_fd_sc_mcu7t5v0__oai21_1
Xgf180mcu_fd_sc_mcu7t5v0__nand2_1_280 vdd vss gf180mcu_fd_sc_mcu7t5v0__xor3_1_170/A2
+ gf180mcu_fd_sc_mcu7t5v0__inv_8_2/I gf180mcu_fd_sc_mcu7t5v0__mux4_4_3/Z vdd vss gf180mcu_fd_sc_mcu7t5v0__nand2_1
Xgf180mcu_fd_sc_mcu7t5v0__nand2_1_291 vdd vss gf180mcu_fd_sc_mcu7t5v0__xor3_1_169/A2
+ gf180mcu_fd_sc_mcu7t5v0__dffq_4_37/Q gf180mcu_fd_sc_mcu7t5v0__inv_1_5/I vdd vss
+ gf180mcu_fd_sc_mcu7t5v0__nand2_1
Xgf180mcu_fd_sc_mcu7t5v0__mux4_4_7 gf180mcu_fd_sc_mcu7t5v0__mux4_4_7/I0 vss vdd gf180mcu_fd_sc_mcu7t5v0__dffq_2_4/Q
+ gf180mcu_fd_sc_mcu7t5v0__mux4_4_7/I1 gf180mcu_fd_sc_mcu7t5v0__mux4_4_9/S0 gf180mcu_fd_sc_mcu7t5v0__or2_1_55/A1
+ gf180mcu_fd_sc_mcu7t5v0__inv_1_16/I gf180mcu_fd_sc_mcu7t5v0__mux4_4_7/Z vdd vss
+ gf180mcu_fd_sc_mcu7t5v0__mux4_4
Xgf180mcu_fd_sc_mcu7t5v0__aoi21_1_70 gf180mcu_fd_sc_mcu7t5v0__aoi21_1_70/B vdd vss
+ gf180mcu_fd_sc_mcu7t5v0__dffq_2_16/D gf180mcu_fd_sc_mcu7t5v0__nor3_4_4/A1 gf180mcu_fd_sc_mcu7t5v0__buf_20_0/Z
+ vdd vss gf180mcu_fd_sc_mcu7t5v0__aoi21_1
Xgf180mcu_fd_sc_mcu7t5v0__aoi21_1_81 gf180mcu_fd_sc_mcu7t5v0__nor3_4_3/ZN vdd vss
+ gf180mcu_fd_sc_mcu7t5v0__oai221_1_4/B2 gf180mcu_fd_sc_mcu7t5v0__mux2_1_6/I1 gf180mcu_fd_sc_mcu7t5v0__xor3_1_32/A1
+ vdd vss gf180mcu_fd_sc_mcu7t5v0__aoi21_1
Xgf180mcu_fd_sc_mcu7t5v0__aoi21_1_92 gf180mcu_fd_sc_mcu7t5v0__xor2_1_69/Z vdd vss
+ gf180mcu_fd_sc_mcu7t5v0__nor3_1_7/A2 gf180mcu_fd_sc_mcu7t5v0__nand3_1_40/A1 gf180mcu_fd_sc_mcu7t5v0__oai21_1_80/ZN
+ vdd vss gf180mcu_fd_sc_mcu7t5v0__aoi21_1
Xgf180mcu_fd_sc_mcu7t5v0__aoi221_2_7 gf180mcu_fd_sc_mcu7t5v0__nor2_4_14/ZN gf180mcu_fd_sc_mcu7t5v0__dffq_1_448/Q
+ vdd vss gf180mcu_fd_sc_mcu7t5v0__aoi221_2_7/ZN gf180mcu_fd_sc_mcu7t5v0__dffq_1_241/Q
+ gf180mcu_fd_sc_mcu7t5v0__nor2_4_14/A2 gf180mcu_fd_sc_mcu7t5v0__and2_1_41/Z vdd vss
+ gf180mcu_fd_sc_mcu7t5v0__aoi221_2
Xgf180mcu_fd_sc_mcu7t5v0__oai21_1_103 vdd gf180mcu_fd_sc_mcu7t5v0__buf_8_7/Z gf180mcu_fd_sc_mcu7t5v0__nor3_4_14/ZN
+ gf180mcu_fd_sc_mcu7t5v0__aoi21_1_168/B gf180mcu_fd_sc_mcu7t5v0__dffq_1_401/Q vss
+ vdd vss gf180mcu_fd_sc_mcu7t5v0__oai21_1
Xgf180mcu_fd_sc_mcu7t5v0__oai21_1_114 vdd gf180mcu_fd_sc_mcu7t5v0__buf_8_6/Z gf180mcu_fd_sc_mcu7t5v0__nor3_4_14/ZN
+ gf180mcu_fd_sc_mcu7t5v0__aoi21_1_123/B gf180mcu_fd_sc_mcu7t5v0__dffq_1_296/Q vss
+ vdd vss gf180mcu_fd_sc_mcu7t5v0__oai21_1
Xgf180mcu_fd_sc_mcu7t5v0__oai21_1_125 vdd gf180mcu_fd_sc_mcu7t5v0__oai21_1_125/B gf180mcu_fd_sc_mcu7t5v0__nor2_4_30/A1
+ gf180mcu_fd_sc_mcu7t5v0__oai21_1_125/ZN gf180mcu_fd_sc_mcu7t5v0__inv_12_1/I vss
+ vdd vss gf180mcu_fd_sc_mcu7t5v0__oai21_1
Xgf180mcu_fd_sc_mcu7t5v0__nor2_2_9 vdd vss gf180mcu_fd_sc_mcu7t5v0__nor2_2_9/ZN gf180mcu_fd_sc_mcu7t5v0__nor3_4_3/A1
+ gf180mcu_fd_sc_mcu7t5v0__nor2_4_3/A2 vdd vss gf180mcu_fd_sc_mcu7t5v0__nor2_2
Xgf180mcu_fd_sc_mcu7t5v0__oai21_1_136 vdd gf180mcu_fd_sc_mcu7t5v0__buf_8_6/Z gf180mcu_fd_sc_mcu7t5v0__nand2_4_40/ZN
+ gf180mcu_fd_sc_mcu7t5v0__aoi21_1_146/B gf180mcu_fd_sc_mcu7t5v0__dffq_1_324/Q vss
+ vdd vss gf180mcu_fd_sc_mcu7t5v0__oai21_1
Xgf180mcu_fd_sc_mcu7t5v0__oai21_1_147 vdd gf180mcu_fd_sc_mcu7t5v0__buf_8_8/I gf180mcu_fd_sc_mcu7t5v0__nor3_1_44/A1
+ gf180mcu_fd_sc_mcu7t5v0__aoi221_1_28/C gf180mcu_fd_sc_mcu7t5v0__nand4_2_5/A2 vss
+ vdd vss gf180mcu_fd_sc_mcu7t5v0__oai21_1
Xgf180mcu_fd_sc_mcu7t5v0__oai21_1_158 vdd gf180mcu_fd_sc_mcu7t5v0__oai21_1_163/B gf180mcu_fd_sc_mcu7t5v0__and2_1_69/Z
+ gf180mcu_fd_sc_mcu7t5v0__nor2_1_197/A2 gf180mcu_fd_sc_mcu7t5v0__nor4_1_2/A3 vss
+ vdd vss gf180mcu_fd_sc_mcu7t5v0__oai21_1
Xgf180mcu_fd_sc_mcu7t5v0__oai21_1_169 vdd gf180mcu_fd_sc_mcu7t5v0__buf_8_8/Z gf180mcu_fd_sc_mcu7t5v0__nor3_4_15/ZN
+ gf180mcu_fd_sc_mcu7t5v0__aoi21_1_179/B gf180mcu_fd_sc_mcu7t5v0__dffq_1_406/Q vss
+ vdd vss gf180mcu_fd_sc_mcu7t5v0__oai21_1
Xgf180mcu_fd_sc_mcu7t5v0__nand2_2_10 vdd vss gf180mcu_fd_sc_mcu7t5v0__xnor2_1_25/A1
+ gf180mcu_fd_sc_mcu7t5v0__nand3_2_17/ZN gf180mcu_fd_sc_mcu7t5v0__aoi22_2_4/ZN vdd
+ vss gf180mcu_fd_sc_mcu7t5v0__nand2_2
Xgf180mcu_fd_sc_mcu7t5v0__nand2_2_21 vdd vss gf180mcu_fd_sc_mcu7t5v0__nand2_2_21/ZN
+ gf180mcu_fd_sc_mcu7t5v0__buf_8_2/Z gf180mcu_fd_sc_mcu7t5v0__nand2_4_15/ZN vdd vss
+ gf180mcu_fd_sc_mcu7t5v0__nand2_2
Xgf180mcu_fd_sc_mcu7t5v0__nand2_2_32 vdd vss gf180mcu_fd_sc_mcu7t5v0__nand2_2_32/ZN
+ rst_n gf180mcu_fd_sc_mcu7t5v0__nand2_4_14/ZN vdd vss gf180mcu_fd_sc_mcu7t5v0__nand2_2
Xgf180mcu_fd_sc_mcu7t5v0__nand2_2_43 vdd vss gf180mcu_fd_sc_mcu7t5v0__nand2_2_43/ZN
+ gf180mcu_fd_sc_mcu7t5v0__buf_8_5/Z gf180mcu_fd_sc_mcu7t5v0__nand2_4_27/ZN vdd vss
+ gf180mcu_fd_sc_mcu7t5v0__nand2_2
Xgf180mcu_fd_sc_mcu7t5v0__nand2_2_54 vdd vss gf180mcu_fd_sc_mcu7t5v0__aoi22_4_8/B2
+ gf180mcu_fd_sc_mcu7t5v0__inv_2_8/I gf180mcu_fd_sc_mcu7t5v0__and4_2_0/Z vdd vss gf180mcu_fd_sc_mcu7t5v0__nand2_2
Xgf180mcu_fd_sc_mcu7t5v0__clkinv_1_18 vdd vss gf180mcu_fd_sc_mcu7t5v0__xor3_1_32/A1
+ gf180mcu_fd_sc_mcu7t5v0__clkinv_1_18/ZN vdd vss gf180mcu_fd_sc_mcu7t5v0__clkinv_1
Xgf180mcu_fd_sc_mcu7t5v0__nand2_2_65 vdd vss gf180mcu_fd_sc_mcu7t5v0__or3_1_19/A1
+ gf180mcu_fd_sc_mcu7t5v0__inv_8_0/I gf180mcu_fd_sc_mcu7t5v0__nor4_2_5/A3 vdd vss
+ gf180mcu_fd_sc_mcu7t5v0__nand2_2
Xgf180mcu_fd_sc_mcu7t5v0__nand2_2_76 vdd vss gf180mcu_fd_sc_mcu7t5v0__nor2_2_55/A2
+ gf180mcu_fd_sc_mcu7t5v0__dffq_2_93/Q gf180mcu_fd_sc_mcu7t5v0__nor3_1_41/A1 vdd vss
+ gf180mcu_fd_sc_mcu7t5v0__nand2_2
Xgf180mcu_fd_sc_mcu7t5v0__clkinv_1_29 vdd vss gf180mcu_fd_sc_mcu7t5v0__dffq_1_265/Q
+ gf180mcu_fd_sc_mcu7t5v0__oai22_1_259/B2 vdd vss gf180mcu_fd_sc_mcu7t5v0__clkinv_1
Xgf180mcu_fd_sc_mcu7t5v0__xor2_1_202 vdd vss gf180mcu_fd_sc_mcu7t5v0__xor2_1_202/Z
+ gf180mcu_fd_sc_mcu7t5v0__xor2_1_202/A1 gf180mcu_fd_sc_mcu7t5v0__xor2_1_202/A2 vdd
+ vss gf180mcu_fd_sc_mcu7t5v0__xor2_1
Xgf180mcu_fd_sc_mcu7t5v0__xor2_1_213 vdd vss gf180mcu_fd_sc_mcu7t5v0__xor2_1_213/Z
+ gf180mcu_fd_sc_mcu7t5v0__dffq_4_37/Q gf180mcu_fd_sc_mcu7t5v0__and2_1_9/A2 vdd vss
+ gf180mcu_fd_sc_mcu7t5v0__xor2_1
Xgf180mcu_fd_sc_mcu7t5v0__xor2_1_224 vdd vss gf180mcu_fd_sc_mcu7t5v0__xor2_1_224/Z
+ gf180mcu_fd_sc_mcu7t5v0__xor2_1_224/A1 gf180mcu_fd_sc_mcu7t5v0__xor2_1_224/A2 vdd
+ vss gf180mcu_fd_sc_mcu7t5v0__xor2_1
Xgf180mcu_fd_sc_mcu7t5v0__clkinv_1_260 vdd vss gf180mcu_fd_sc_mcu7t5v0__dffq_1_226/Q
+ gf180mcu_fd_sc_mcu7t5v0__oai22_1_237/B2 vdd vss gf180mcu_fd_sc_mcu7t5v0__clkinv_1
Xgf180mcu_fd_sc_mcu7t5v0__clkinv_1_271 vdd vss gf180mcu_fd_sc_mcu7t5v0__dffq_1_266/Q
+ gf180mcu_fd_sc_mcu7t5v0__oai22_1_260/B2 vdd vss gf180mcu_fd_sc_mcu7t5v0__clkinv_1
Xgf180mcu_fd_sc_mcu7t5v0__clkinv_1_282 vdd vss gf180mcu_fd_sc_mcu7t5v0__mux4_2_0/I0
+ gf180mcu_fd_sc_mcu7t5v0__nand2_1_334/A1 vdd vss gf180mcu_fd_sc_mcu7t5v0__clkinv_1
Xgf180mcu_fd_sc_mcu7t5v0__clkinv_1_293 vdd vss gf180mcu_fd_sc_mcu7t5v0__dffq_1_334/Q
+ gf180mcu_fd_sc_mcu7t5v0__aoi21_1_160/A1 vdd vss gf180mcu_fd_sc_mcu7t5v0__clkinv_1
Xgf180mcu_fd_sc_mcu7t5v0__nand3_1_0 gf180mcu_fd_sc_mcu7t5v0__nand3_1_0/A3 vdd vss
+ gf180mcu_fd_sc_mcu7t5v0__nand3_1_0/ZN gf180mcu_fd_sc_mcu7t5v0__or2_1_34/A2 gf180mcu_fd_sc_mcu7t5v0__nand3_1_0/A2
+ vdd vss gf180mcu_fd_sc_mcu7t5v0__nand3_1
Xgf180mcu_fd_sc_mcu7t5v0__dffq_4_15 gf180mcu_fd_sc_mcu7t5v0__dffq_4_15/D gf180mcu_fd_sc_mcu7t5v0__inv_2_8/I
+ vdd vss gf180mcu_fd_sc_mcu7t5v0__dffq_4_15/CLK vdd vss gf180mcu_fd_sc_mcu7t5v0__dffq_4
Xgf180mcu_fd_sc_mcu7t5v0__dffq_4_26 gf180mcu_fd_sc_mcu7t5v0__dffq_4_26/D gf180mcu_fd_sc_mcu7t5v0__inv_1_16/I
+ vdd vss gf180mcu_fd_sc_mcu7t5v0__dffq_4_1/CLK vdd vss gf180mcu_fd_sc_mcu7t5v0__dffq_4
Xgf180mcu_fd_sc_mcu7t5v0__dffq_4_37 gf180mcu_fd_sc_mcu7t5v0__dffq_4_37/D gf180mcu_fd_sc_mcu7t5v0__dffq_4_37/Q
+ vdd vss gf180mcu_fd_sc_mcu7t5v0__dffq_4_1/CLK vdd vss gf180mcu_fd_sc_mcu7t5v0__dffq_4
Xgf180mcu_fd_sc_mcu7t5v0__and2_2_8 vdd vss gf180mcu_fd_sc_mcu7t5v0__and2_2_8/Z gf180mcu_fd_sc_mcu7t5v0__and2_2_8/A1
+ gf180mcu_fd_sc_mcu7t5v0__and2_2_8/A2 vdd vss gf180mcu_fd_sc_mcu7t5v0__and2_2
Xgf180mcu_fd_sc_mcu7t5v0__oai21_2_14 gf180mcu_fd_sc_mcu7t5v0__dffq_2_80/Q gf180mcu_fd_sc_mcu7t5v0__oai21_2_14/ZN
+ gf180mcu_fd_sc_mcu7t5v0__inv_4_7/ZN vss gf180mcu_fd_sc_mcu7t5v0__dffq_4_35/Q vdd
+ vdd vss gf180mcu_fd_sc_mcu7t5v0__oai21_2
Xgf180mcu_fd_sc_mcu7t5v0__dffq_1_409 vdd gf180mcu_fd_sc_mcu7t5v0__dffq_1_409/Q gf180mcu_fd_sc_mcu7t5v0__dffq_2_58/CLK
+ vss gf180mcu_fd_sc_mcu7t5v0__dffq_1_409/D vdd vss gf180mcu_fd_sc_mcu7t5v0__dffq_1
Xgf180mcu_fd_sc_mcu7t5v0__aoi22_1_130 gf180mcu_fd_sc_mcu7t5v0__nor2_4_11/ZN gf180mcu_fd_sc_mcu7t5v0__dffq_1_264/Q
+ vdd vss gf180mcu_fd_sc_mcu7t5v0__nand2_1_274/A2 gf180mcu_fd_sc_mcu7t5v0__dffq_1_226/Q
+ gf180mcu_fd_sc_mcu7t5v0__nor2_4_10/ZN vdd vss gf180mcu_fd_sc_mcu7t5v0__aoi22_1
Xgf180mcu_fd_sc_mcu7t5v0__or2_1_13 vdd vss gf180mcu_fd_sc_mcu7t5v0__or2_1_13/Z gf180mcu_fd_sc_mcu7t5v0__or2_1_13/A1
+ gf180mcu_fd_sc_mcu7t5v0__xor2_1_62/Z vdd vss gf180mcu_fd_sc_mcu7t5v0__or2_1
Xgf180mcu_fd_sc_mcu7t5v0__aoi22_1_141 gf180mcu_fd_sc_mcu7t5v0__nor2_4_9/ZN gf180mcu_fd_sc_mcu7t5v0__dffq_1_106/Q
+ vdd vss gf180mcu_fd_sc_mcu7t5v0__nand2_1_295/A1 gf180mcu_fd_sc_mcu7t5v0__dffq_1_259/Q
+ gf180mcu_fd_sc_mcu7t5v0__nor2_4_8/ZN vdd vss gf180mcu_fd_sc_mcu7t5v0__aoi22_1
Xgf180mcu_fd_sc_mcu7t5v0__aoi22_1_152 gf180mcu_fd_sc_mcu7t5v0__nor2_4_26/ZN gf180mcu_fd_sc_mcu7t5v0__or2_4_2/A1
+ vdd vss gf180mcu_fd_sc_mcu7t5v0__nor2_1_147/A2 gf180mcu_fd_sc_mcu7t5v0__dffq_1_289/Q
+ gf180mcu_fd_sc_mcu7t5v0__or3_2_4/Z vdd vss gf180mcu_fd_sc_mcu7t5v0__aoi22_1
Xgf180mcu_fd_sc_mcu7t5v0__or2_1_24 vdd vss gf180mcu_fd_sc_mcu7t5v0__or2_1_24/Z gf180mcu_fd_sc_mcu7t5v0__inv_8_2/ZN
+ gf180mcu_fd_sc_mcu7t5v0__or2_1_24/A2 vdd vss gf180mcu_fd_sc_mcu7t5v0__or2_1
Xgf180mcu_fd_sc_mcu7t5v0__aoi22_1_163 gf180mcu_fd_sc_mcu7t5v0__nor2_2_36/ZN gf180mcu_fd_sc_mcu7t5v0__dffq_2_91/Q
+ vdd vss gf180mcu_fd_sc_mcu7t5v0__nand2_2_61/A2 gf180mcu_fd_sc_mcu7t5v0__or2_1_33/A1
+ gf180mcu_fd_sc_mcu7t5v0__and2_1_104/Z vdd vss gf180mcu_fd_sc_mcu7t5v0__aoi22_1
Xgf180mcu_fd_sc_mcu7t5v0__aoi22_1_174 gf180mcu_fd_sc_mcu7t5v0__and4_1_3/A4 gf180mcu_fd_sc_mcu7t5v0__inv_8_2/I
+ vdd vss gf180mcu_fd_sc_mcu7t5v0__oai22_1_281/B1 gf180mcu_fd_sc_mcu7t5v0__dffq_4_37/Q
+ gf180mcu_fd_sc_mcu7t5v0__and4_1_3/A3 vdd vss gf180mcu_fd_sc_mcu7t5v0__aoi22_1
Xgf180mcu_fd_sc_mcu7t5v0__or2_1_35 vdd vss gf180mcu_fd_sc_mcu7t5v0__or2_1_35/Z gf180mcu_fd_sc_mcu7t5v0__or3_1_18/A1
+ gf180mcu_fd_sc_mcu7t5v0__or2_1_35/A2 vdd vss gf180mcu_fd_sc_mcu7t5v0__or2_1
Xgf180mcu_fd_sc_mcu7t5v0__or2_1_46 vdd vss gf180mcu_fd_sc_mcu7t5v0__or2_1_46/Z gf180mcu_fd_sc_mcu7t5v0__or2_1_46/A1
+ gf180mcu_fd_sc_mcu7t5v0__or2_1_46/A2 vdd vss gf180mcu_fd_sc_mcu7t5v0__or2_1
Xgf180mcu_fd_sc_mcu7t5v0__or2_1_57 vdd vss gf180mcu_fd_sc_mcu7t5v0__or2_1_57/Z gf180mcu_fd_sc_mcu7t5v0__or2_1_57/A1
+ gf180mcu_fd_sc_mcu7t5v0__or2_1_57/A2 vdd vss gf180mcu_fd_sc_mcu7t5v0__or2_1
Xgf180mcu_fd_sc_mcu7t5v0__nor2_4_13 vdd vss gf180mcu_fd_sc_mcu7t5v0__nor2_4_13/ZN
+ gf180mcu_fd_sc_mcu7t5v0__mux2_4_3/Z gf180mcu_fd_sc_mcu7t5v0__or2_2_0/Z vdd vss gf180mcu_fd_sc_mcu7t5v0__nor2_4
Xgf180mcu_fd_sc_mcu7t5v0__nor2_4_24 vdd vss gf180mcu_fd_sc_mcu7t5v0__nor2_4_24/ZN
+ gf180mcu_fd_sc_mcu7t5v0__nor2_4_24/A1 gf180mcu_fd_sc_mcu7t5v0__or2_4_1/Z vdd vss
+ gf180mcu_fd_sc_mcu7t5v0__nor2_4
Xgf180mcu_fd_sc_mcu7t5v0__nor2_4_35 vdd vss gf180mcu_fd_sc_mcu7t5v0__oai32_1_8/A1
+ gf180mcu_fd_sc_mcu7t5v0__dffq_2_97/Q gf180mcu_fd_sc_mcu7t5v0__oai32_1_6/A3 vdd vss
+ gf180mcu_fd_sc_mcu7t5v0__nor2_4
Xgf180mcu_fd_sc_mcu7t5v0__aoi21_1_310 gf180mcu_fd_sc_mcu7t5v0__aoi21_1_310/B vdd vss
+ gf180mcu_fd_sc_mcu7t5v0__dffq_4_36/D gf180mcu_fd_sc_mcu7t5v0__inv_4_6/ZN gf180mcu_fd_sc_mcu7t5v0__buf_20_0/Z
+ vdd vss gf180mcu_fd_sc_mcu7t5v0__aoi21_1
Xgf180mcu_fd_sc_mcu7t5v0__aoi21_1_321 gf180mcu_fd_sc_mcu7t5v0__xor3_1_159/A1 vdd vss
+ gf180mcu_fd_sc_mcu7t5v0__aoi22_1_171/A2 gf180mcu_fd_sc_mcu7t5v0__nand3_2_28/ZN gf180mcu_fd_sc_mcu7t5v0__nand3_1_89/A3
+ vdd vss gf180mcu_fd_sc_mcu7t5v0__aoi21_1
Xgf180mcu_fd_sc_mcu7t5v0__aoi21_1_332 gf180mcu_fd_sc_mcu7t5v0__nor2_1_357/A2 vdd vss
+ gf180mcu_fd_sc_mcu7t5v0__xor2_1_165/A1 gf180mcu_fd_sc_mcu7t5v0__inv_4_6/I gf180mcu_fd_sc_mcu7t5v0__xor2_1_162/Z
+ vdd vss gf180mcu_fd_sc_mcu7t5v0__aoi21_1
Xgf180mcu_fd_sc_mcu7t5v0__aoi21_1_343 gf180mcu_fd_sc_mcu7t5v0__aoi21_1_7/B vdd vss
+ gf180mcu_fd_sc_mcu7t5v0__dffq_2_90/D gf180mcu_fd_sc_mcu7t5v0__nand2_1_641/ZN gf180mcu_fd_sc_mcu7t5v0__oai211_1_48/ZN
+ vdd vss gf180mcu_fd_sc_mcu7t5v0__aoi21_1
Xgf180mcu_fd_sc_mcu7t5v0__aoi21_1_354 gf180mcu_fd_sc_mcu7t5v0__or2_4_4/Z vdd vss gf180mcu_fd_sc_mcu7t5v0__aoi221_1_63/B2
+ gf180mcu_fd_sc_mcu7t5v0__oai211_1_53/C gf180mcu_fd_sc_mcu7t5v0__oai211_1_51/ZN vdd
+ vss gf180mcu_fd_sc_mcu7t5v0__aoi21_1
Xgf180mcu_fd_sc_mcu7t5v0__aoi21_1_365 gf180mcu_fd_sc_mcu7t5v0__nor3_1_34/ZN vdd vss
+ gf180mcu_fd_sc_mcu7t5v0__xor3_1_155/A2 gf180mcu_fd_sc_mcu7t5v0__xor3_1_157/A2 gf180mcu_fd_sc_mcu7t5v0__oai21_1_268/ZN
+ vdd vss gf180mcu_fd_sc_mcu7t5v0__aoi21_1
Xgf180mcu_fd_sc_mcu7t5v0__aoi21_1_376 gf180mcu_fd_sc_mcu7t5v0__or2_4_4/Z vdd vss gf180mcu_fd_sc_mcu7t5v0__aoi221_1_65/B2
+ gf180mcu_fd_sc_mcu7t5v0__and3_1_5/A2 gf180mcu_fd_sc_mcu7t5v0__nor2_1_79/ZN vdd vss
+ gf180mcu_fd_sc_mcu7t5v0__aoi21_1
Xgf180mcu_fd_sc_mcu7t5v0__nand2_1_109 vdd vss gf180mcu_fd_sc_mcu7t5v0__nor2_2_7/A2
+ gf180mcu_fd_sc_mcu7t5v0__dffq_4_37/Q gf180mcu_fd_sc_mcu7t5v0__or4_1_1/A1 vdd vss
+ gf180mcu_fd_sc_mcu7t5v0__nand2_1
Xgf180mcu_fd_sc_mcu7t5v0__xor3_1_20 gf180mcu_fd_sc_mcu7t5v0__xor3_1_20/A3 vdd vss
+ gf180mcu_fd_sc_mcu7t5v0__xor3_1_20/Z gf180mcu_fd_sc_mcu7t5v0__or2_1_7/A1 gf180mcu_fd_sc_mcu7t5v0__xor3_1_20/A2
+ vdd vss gf180mcu_fd_sc_mcu7t5v0__xor3_1
Xgf180mcu_fd_sc_mcu7t5v0__xor3_1_31 gf180mcu_fd_sc_mcu7t5v0__or3_1_3/A3 vdd vss gf180mcu_fd_sc_mcu7t5v0__xor3_1_31/Z
+ gf180mcu_fd_sc_mcu7t5v0__or2_1_11/A2 gf180mcu_fd_sc_mcu7t5v0__xor3_1_31/A2 vdd vss
+ gf180mcu_fd_sc_mcu7t5v0__xor3_1
Xgf180mcu_fd_sc_mcu7t5v0__xor3_1_42 gf180mcu_fd_sc_mcu7t5v0__xor3_1_44/Z vdd vss gf180mcu_fd_sc_mcu7t5v0__xor3_1_42/Z
+ gf180mcu_fd_sc_mcu7t5v0__xor3_1_42/A1 gf180mcu_fd_sc_mcu7t5v0__xor3_1_42/A2 vdd
+ vss gf180mcu_fd_sc_mcu7t5v0__xor3_1
Xgf180mcu_fd_sc_mcu7t5v0__xor3_1_53 gf180mcu_fd_sc_mcu7t5v0__xor3_1_53/A3 vdd vss
+ gf180mcu_fd_sc_mcu7t5v0__xor3_1_53/Z gf180mcu_fd_sc_mcu7t5v0__inv_8_1/I gf180mcu_fd_sc_mcu7t5v0__or4_1_1/A2
+ vdd vss gf180mcu_fd_sc_mcu7t5v0__xor3_1
Xgf180mcu_fd_sc_mcu7t5v0__xor3_1_64 gf180mcu_fd_sc_mcu7t5v0__xor3_1_63/Z vdd vss gf180mcu_fd_sc_mcu7t5v0__xor3_1_64/Z
+ gf180mcu_fd_sc_mcu7t5v0__xor3_1_64/A1 gf180mcu_fd_sc_mcu7t5v0__xor3_1_64/A2 vdd
+ vss gf180mcu_fd_sc_mcu7t5v0__xor3_1
Xgf180mcu_fd_sc_mcu7t5v0__xor3_1_75 gf180mcu_fd_sc_mcu7t5v0__xor3_1_75/A3 vdd vss
+ gf180mcu_fd_sc_mcu7t5v0__xor3_1_75/Z gf180mcu_fd_sc_mcu7t5v0__or3_1_14/A3 gf180mcu_fd_sc_mcu7t5v0__xor3_1_75/A2
+ vdd vss gf180mcu_fd_sc_mcu7t5v0__xor3_1
Xgf180mcu_fd_sc_mcu7t5v0__xor3_1_86 gf180mcu_fd_sc_mcu7t5v0__xor3_1_86/A3 vdd vss
+ gf180mcu_fd_sc_mcu7t5v0__xor3_1_86/Z gf180mcu_fd_sc_mcu7t5v0__xor3_1_86/A1 gf180mcu_fd_sc_mcu7t5v0__xor3_1_86/A2
+ vdd vss gf180mcu_fd_sc_mcu7t5v0__xor3_1
Xgf180mcu_fd_sc_mcu7t5v0__xor3_1_97 gf180mcu_fd_sc_mcu7t5v0__xor3_1_97/A3 vdd vss
+ gf180mcu_fd_sc_mcu7t5v0__xor3_1_97/Z gf180mcu_fd_sc_mcu7t5v0__xor3_1_97/A1 gf180mcu_fd_sc_mcu7t5v0__xor3_1_97/A2
+ vdd vss gf180mcu_fd_sc_mcu7t5v0__xor3_1
Xgf180mcu_fd_sc_mcu7t5v0__nor3_1_1 gf180mcu_fd_sc_mcu7t5v0__nor3_1_1/A3 vdd vss gf180mcu_fd_sc_mcu7t5v0__xor3_1_5/A1
+ gf180mcu_fd_sc_mcu7t5v0__xor3_1_2/A1 gf180mcu_fd_sc_mcu7t5v0__nor3_1_1/A2 vdd vss
+ gf180mcu_fd_sc_mcu7t5v0__nor3_1
Xgf180mcu_fd_sc_mcu7t5v0__dffq_1_206 vdd gf180mcu_fd_sc_mcu7t5v0__dffq_1_206/Q gf180mcu_fd_sc_mcu7t5v0__dffq_4_8/CLK
+ vss gf180mcu_fd_sc_mcu7t5v0__dffq_1_206/D vdd vss gf180mcu_fd_sc_mcu7t5v0__dffq_1
Xgf180mcu_fd_sc_mcu7t5v0__dffq_1_217 vdd gf180mcu_fd_sc_mcu7t5v0__dffq_1_217/Q gf180mcu_fd_sc_mcu7t5v0__dffq_4_8/CLK
+ vss gf180mcu_fd_sc_mcu7t5v0__dffq_1_217/D vdd vss gf180mcu_fd_sc_mcu7t5v0__dffq_1
Xgf180mcu_fd_sc_mcu7t5v0__dffq_1_228 vdd gf180mcu_fd_sc_mcu7t5v0__dffq_1_228/Q gf180mcu_fd_sc_mcu7t5v0__dffq_2_26/CLK
+ vss gf180mcu_fd_sc_mcu7t5v0__dffq_1_228/D vdd vss gf180mcu_fd_sc_mcu7t5v0__dffq_1
Xgf180mcu_fd_sc_mcu7t5v0__nor2_1_406 vdd vss gf180mcu_fd_sc_mcu7t5v0__dffq_1_453/D
+ gf180mcu_fd_sc_mcu7t5v0__oai21_2_8/ZN gf180mcu_fd_sc_mcu7t5v0__xor2_1_92/Z vdd vss
+ gf180mcu_fd_sc_mcu7t5v0__nor2_1
Xgf180mcu_fd_sc_mcu7t5v0__dffq_1_239 vdd gf180mcu_fd_sc_mcu7t5v0__dffq_1_239/Q gf180mcu_fd_sc_mcu7t5v0__dffq_4_8/CLK
+ vss gf180mcu_fd_sc_mcu7t5v0__dffq_1_239/D vdd vss gf180mcu_fd_sc_mcu7t5v0__dffq_1
Xgf180mcu_fd_sc_mcu7t5v0__nand2_1_610 vdd vss gf180mcu_fd_sc_mcu7t5v0__xnor3_1_42/A2
+ gf180mcu_fd_sc_mcu7t5v0__inv_8_1/I gf180mcu_fd_sc_mcu7t5v0__mux4_4_12/Z vdd vss
+ gf180mcu_fd_sc_mcu7t5v0__nand2_1
Xgf180mcu_fd_sc_mcu7t5v0__nand2_1_621 vdd vss gf180mcu_fd_sc_mcu7t5v0__xnor2_1_59/A2
+ gf180mcu_fd_sc_mcu7t5v0__inv_12_1/I gf180mcu_fd_sc_mcu7t5v0__mux4_4_15/Z vdd vss
+ gf180mcu_fd_sc_mcu7t5v0__nand2_1
Xgf180mcu_fd_sc_mcu7t5v0__nand2_1_632 vdd vss gf180mcu_fd_sc_mcu7t5v0__nand2_1_632/ZN
+ gf180mcu_fd_sc_mcu7t5v0__oai21_1_298/B gf180mcu_fd_sc_mcu7t5v0__mux4_4_14/Z vdd
+ vss gf180mcu_fd_sc_mcu7t5v0__nand2_1
Xgf180mcu_fd_sc_mcu7t5v0__nand2_1_643 vdd vss gf180mcu_fd_sc_mcu7t5v0__oai21_1_320/B
+ gf180mcu_fd_sc_mcu7t5v0__dffq_2_91/Q gf180mcu_fd_sc_mcu7t5v0__xor3_1_148/Z vdd vss
+ gf180mcu_fd_sc_mcu7t5v0__nand2_1
Xgf180mcu_fd_sc_mcu7t5v0__nand2_1_654 vdd vss gf180mcu_fd_sc_mcu7t5v0__nand4_1_23/A3
+ gf180mcu_fd_sc_mcu7t5v0__nor2_2_56/ZN gf180mcu_fd_sc_mcu7t5v0__xor3_1_150/Z vdd
+ vss gf180mcu_fd_sc_mcu7t5v0__nand2_1
Xgf180mcu_fd_sc_mcu7t5v0__nand2_1_665 vdd vss gf180mcu_fd_sc_mcu7t5v0__nand4_1_23/A2
+ gf180mcu_fd_sc_mcu7t5v0__nor2_2_53/ZN gf180mcu_fd_sc_mcu7t5v0__xor3_1_148/Z vdd
+ vss gf180mcu_fd_sc_mcu7t5v0__nand2_1
Xgf180mcu_fd_sc_mcu7t5v0__nand2_1_676 vdd vss gf180mcu_fd_sc_mcu7t5v0__xnor2_1_74/A1
+ gf180mcu_fd_sc_mcu7t5v0__inv_12_1/I gf180mcu_fd_sc_mcu7t5v0__and3_1_23/A2 vdd vss
+ gf180mcu_fd_sc_mcu7t5v0__nand2_1
Xgf180mcu_fd_sc_mcu7t5v0__nand2_1_687 vdd vss gf180mcu_fd_sc_mcu7t5v0__xor3_1_161/A3
+ gf180mcu_fd_sc_mcu7t5v0__or2_1_7/A1 gf180mcu_fd_sc_mcu7t5v0__and4_1_3/A3 vdd vss
+ gf180mcu_fd_sc_mcu7t5v0__nand2_1
Xgf180mcu_fd_sc_mcu7t5v0__nand2_1_698 vdd vss gf180mcu_fd_sc_mcu7t5v0__mux2_1_14/I1
+ gf180mcu_fd_sc_mcu7t5v0__xor2_1_201/A1 gf180mcu_fd_sc_mcu7t5v0__xor2_1_202/Z vdd
+ vss gf180mcu_fd_sc_mcu7t5v0__nand2_1
Xgf180mcu_fd_sc_mcu7t5v0__nand4_1_20 gf180mcu_fd_sc_mcu7t5v0__or4_1_3/Z gf180mcu_fd_sc_mcu7t5v0__nand4_1_20/A4
+ vdd vss gf180mcu_fd_sc_mcu7t5v0__oai211_1_41/B gf180mcu_fd_sc_mcu7t5v0__oai211_1_43/C
+ gf180mcu_fd_sc_mcu7t5v0__nand4_1_20/A2 vdd vss gf180mcu_fd_sc_mcu7t5v0__nand4_1
Xgf180mcu_fd_sc_mcu7t5v0__dffq_1_16 vdd gf180mcu_fd_sc_mcu7t5v0__dffq_1_16/Q gf180mcu_fd_sc_mcu7t5v0__dffq_4_6/CLK
+ vss gf180mcu_fd_sc_mcu7t5v0__dffq_1_16/D vdd vss gf180mcu_fd_sc_mcu7t5v0__dffq_1
Xgf180mcu_fd_sc_mcu7t5v0__dffq_1_27 vdd gf180mcu_fd_sc_mcu7t5v0__dffq_1_27/Q gf180mcu_fd_sc_mcu7t5v0__dffq_4_8/CLK
+ vss gf180mcu_fd_sc_mcu7t5v0__dffq_1_27/D vdd vss gf180mcu_fd_sc_mcu7t5v0__dffq_1
Xgf180mcu_fd_sc_mcu7t5v0__dffq_1_38 vdd gf180mcu_fd_sc_mcu7t5v0__dffq_1_38/Q gf180mcu_fd_sc_mcu7t5v0__dffq_1_99/CLK
+ vss gf180mcu_fd_sc_mcu7t5v0__dffq_1_38/D vdd vss gf180mcu_fd_sc_mcu7t5v0__dffq_1
Xgf180mcu_fd_sc_mcu7t5v0__dffq_1_49 vdd gf180mcu_fd_sc_mcu7t5v0__dffq_1_49/Q gf180mcu_fd_sc_mcu7t5v0__dffq_4_8/CLK
+ vss gf180mcu_fd_sc_mcu7t5v0__dffq_1_49/D vdd vss gf180mcu_fd_sc_mcu7t5v0__dffq_1
Xgf180mcu_fd_sc_mcu7t5v0__nand2_2_9 vdd vss gf180mcu_fd_sc_mcu7t5v0__xor2_1_64/A1
+ gf180mcu_fd_sc_mcu7t5v0__nand2_2_9/A1 gf180mcu_fd_sc_mcu7t5v0__nand2_2_9/A2 vdd
+ vss gf180mcu_fd_sc_mcu7t5v0__nand2_2
Xgf180mcu_fd_sc_mcu7t5v0__inv_1_10 vss gf180mcu_fd_sc_mcu7t5v0__inv_1_10/ZN gf180mcu_fd_sc_mcu7t5v0__inv_1_10/I
+ vdd vdd vss gf180mcu_fd_sc_mcu7t5v0__inv_1
Xgf180mcu_fd_sc_mcu7t5v0__inv_1_21 vss gf180mcu_fd_sc_mcu7t5v0__inv_1_21/ZN gf180mcu_fd_sc_mcu7t5v0__inv_1_21/I
+ vdd vdd vss gf180mcu_fd_sc_mcu7t5v0__inv_1
Xgf180mcu_fd_sc_mcu7t5v0__aoi21_1_140 gf180mcu_fd_sc_mcu7t5v0__aoi21_1_140/B vdd vss
+ gf180mcu_fd_sc_mcu7t5v0__dffq_2_39/D gf180mcu_fd_sc_mcu7t5v0__inv_1_7/ZN gf180mcu_fd_sc_mcu7t5v0__buf_20_0/I
+ vdd vss gf180mcu_fd_sc_mcu7t5v0__aoi21_1
Xgf180mcu_fd_sc_mcu7t5v0__aoi21_1_151 gf180mcu_fd_sc_mcu7t5v0__aoi21_1_151/B vdd vss
+ gf180mcu_fd_sc_mcu7t5v0__dffq_1_382/D gf180mcu_fd_sc_mcu7t5v0__aoi21_1_151/A1 gf180mcu_fd_sc_mcu7t5v0__nand3_1_55/A2
+ vdd vss gf180mcu_fd_sc_mcu7t5v0__aoi21_1
Xgf180mcu_fd_sc_mcu7t5v0__aoi21_1_162 gf180mcu_fd_sc_mcu7t5v0__aoi21_1_162/B vdd vss
+ gf180mcu_fd_sc_mcu7t5v0__dffq_1_336/D gf180mcu_fd_sc_mcu7t5v0__aoi21_1_162/A1 gf180mcu_fd_sc_mcu7t5v0__nand2_4_40/ZN
+ vdd vss gf180mcu_fd_sc_mcu7t5v0__aoi21_1
Xgf180mcu_fd_sc_mcu7t5v0__aoi21_1_173 gf180mcu_fd_sc_mcu7t5v0__aoi21_1_173/B vdd vss
+ gf180mcu_fd_sc_mcu7t5v0__dffq_1_366/D gf180mcu_fd_sc_mcu7t5v0__nand4_4_2/ZN gf180mcu_fd_sc_mcu7t5v0__nor2_1_205/ZN
+ vdd vss gf180mcu_fd_sc_mcu7t5v0__aoi21_1
Xgf180mcu_fd_sc_mcu7t5v0__aoi21_1_184 gf180mcu_fd_sc_mcu7t5v0__nor2_2_20/ZN vdd vss
+ gf180mcu_fd_sc_mcu7t5v0__aoi21_1_195/B gf180mcu_fd_sc_mcu7t5v0__oai31_1_9/A2 gf180mcu_fd_sc_mcu7t5v0__xnor3_1_22/A1
+ vdd vss gf180mcu_fd_sc_mcu7t5v0__aoi21_1
Xgf180mcu_fd_sc_mcu7t5v0__aoi21_1_195 gf180mcu_fd_sc_mcu7t5v0__aoi21_1_195/B vdd vss
+ gf180mcu_fd_sc_mcu7t5v0__oai221_1_8/B1 gf180mcu_fd_sc_mcu7t5v0__inv_8_0/ZN gf180mcu_fd_sc_mcu7t5v0__inv_1_14/ZN
+ vdd vss gf180mcu_fd_sc_mcu7t5v0__aoi21_1
Xgf180mcu_fd_sc_mcu7t5v0__and2_1_140 vdd vss gf180mcu_fd_sc_mcu7t5v0__and2_1_140/Z
+ gf180mcu_fd_sc_mcu7t5v0__dffq_2_94/Q gf180mcu_fd_sc_mcu7t5v0__and2_1_141/Z vdd vss
+ gf180mcu_fd_sc_mcu7t5v0__and2_1
Xgf180mcu_fd_sc_mcu7t5v0__and2_1_151 vdd vss gf180mcu_fd_sc_mcu7t5v0__and2_1_151/Z
+ gf180mcu_fd_sc_mcu7t5v0__inv_8_1/I gf180mcu_fd_sc_mcu7t5v0__xnor2_1_66/A1 vdd vss
+ gf180mcu_fd_sc_mcu7t5v0__and2_1
Xgf180mcu_fd_sc_mcu7t5v0__buf_8_6 gf180mcu_fd_sc_mcu7t5v0__buf_8_6/Z gf180mcu_fd_sc_mcu7t5v0__buf_8_8/Z
+ vdd vss vdd vss gf180mcu_fd_sc_mcu7t5v0__buf_8
Xgf180mcu_fd_sc_mcu7t5v0__oai22_1_105 gf180mcu_fd_sc_mcu7t5v0__nand2_4_14/ZN gf180mcu_fd_sc_mcu7t5v0__nand2_2_32/ZN
+ gf180mcu_fd_sc_mcu7t5v0__oai22_1_105/B2 vdd vss gf180mcu_fd_sc_mcu7t5v0__dffq_1_261/D
+ gf180mcu_fd_sc_mcu7t5v0__oai21_4_9/ZN vdd vss gf180mcu_fd_sc_mcu7t5v0__oai22_1
Xgf180mcu_fd_sc_mcu7t5v0__oai22_1_116 gf180mcu_fd_sc_mcu7t5v0__oai22_1_97/A2 gf180mcu_fd_sc_mcu7t5v0__oai22_1_97/B1
+ gf180mcu_fd_sc_mcu7t5v0__oai22_1_116/B2 vdd vss gf180mcu_fd_sc_mcu7t5v0__dffq_1_110/D
+ gf180mcu_fd_sc_mcu7t5v0__oai22_1_88/A1 vdd vss gf180mcu_fd_sc_mcu7t5v0__oai22_1
Xgf180mcu_fd_sc_mcu7t5v0__oai22_1_127 gf180mcu_fd_sc_mcu7t5v0__nand2_4_17/ZN gf180mcu_fd_sc_mcu7t5v0__nand2_2_23/ZN
+ gf180mcu_fd_sc_mcu7t5v0__oai22_1_127/B2 vdd vss gf180mcu_fd_sc_mcu7t5v0__dffq_1_121/D
+ gf180mcu_fd_sc_mcu7t5v0__aoi21_4_3/ZN vdd vss gf180mcu_fd_sc_mcu7t5v0__oai22_1
Xgf180mcu_fd_sc_mcu7t5v0__oai22_1_138 gf180mcu_fd_sc_mcu7t5v0__nand2_4_19/ZN gf180mcu_fd_sc_mcu7t5v0__nand2_2_26/ZN
+ gf180mcu_fd_sc_mcu7t5v0__oai22_1_138/B2 vdd vss gf180mcu_fd_sc_mcu7t5v0__dffq_1_129/D
+ gf180mcu_fd_sc_mcu7t5v0__aoi21_4_4/ZN vdd vss gf180mcu_fd_sc_mcu7t5v0__oai22_1
Xgf180mcu_fd_sc_mcu7t5v0__oai22_1_149 gf180mcu_fd_sc_mcu7t5v0__nand2_4_21/ZN gf180mcu_fd_sc_mcu7t5v0__nand2_2_28/ZN
+ gf180mcu_fd_sc_mcu7t5v0__oai22_1_149/B2 vdd vss gf180mcu_fd_sc_mcu7t5v0__dffq_1_146/D
+ gf180mcu_fd_sc_mcu7t5v0__aoi21_4_1/ZN vdd vss gf180mcu_fd_sc_mcu7t5v0__oai22_1
Xgf180mcu_fd_sc_mcu7t5v0__nor2_1_14 vdd vss gf180mcu_fd_sc_mcu7t5v0__aoi21_1_8/B gf180mcu_fd_sc_mcu7t5v0__xor2_1_32/A1
+ gf180mcu_fd_sc_mcu7t5v0__xor3_1_25/Z vdd vss gf180mcu_fd_sc_mcu7t5v0__nor2_1
Xgf180mcu_fd_sc_mcu7t5v0__nor2_1_25 vdd vss gf180mcu_fd_sc_mcu7t5v0__nor2_1_25/ZN
+ gf180mcu_fd_sc_mcu7t5v0__dffq_2_7/Q gf180mcu_fd_sc_mcu7t5v0__xor2_1_7/Z vdd vss
+ gf180mcu_fd_sc_mcu7t5v0__nor2_1
Xgf180mcu_fd_sc_mcu7t5v0__nor2_1_36 vdd vss gf180mcu_fd_sc_mcu7t5v0__nor2_1_36/ZN
+ gf180mcu_fd_sc_mcu7t5v0__and3_1_3/Z gf180mcu_fd_sc_mcu7t5v0__nor2_1_36/A2 vdd vss
+ gf180mcu_fd_sc_mcu7t5v0__nor2_1
Xgf180mcu_fd_sc_mcu7t5v0__nor2_1_47 vdd vss gf180mcu_fd_sc_mcu7t5v0__nor2_1_47/ZN
+ gf180mcu_fd_sc_mcu7t5v0__dffq_1_3/Q gf180mcu_fd_sc_mcu7t5v0__nor2_4_15/ZN vdd vss
+ gf180mcu_fd_sc_mcu7t5v0__nor2_1
Xgf180mcu_fd_sc_mcu7t5v0__nor2_1_58 vdd vss gf180mcu_fd_sc_mcu7t5v0__xor2_1_35/A1
+ gf180mcu_fd_sc_mcu7t5v0__xor3_1_57/A2 gf180mcu_fd_sc_mcu7t5v0__or2_1_9/A2 vdd vss
+ gf180mcu_fd_sc_mcu7t5v0__nor2_1
Xgf180mcu_fd_sc_mcu7t5v0__nor2_1_69 vdd vss gf180mcu_fd_sc_mcu7t5v0__nor2_1_69/ZN
+ gf180mcu_fd_sc_mcu7t5v0__or4_1_0/A1 gf180mcu_fd_sc_mcu7t5v0__nor4_2_2/A4 vdd vss
+ gf180mcu_fd_sc_mcu7t5v0__nor2_1
Xgf180mcu_fd_sc_mcu7t5v0__nor2_1_203 vdd vss gf180mcu_fd_sc_mcu7t5v0__dffq_1_365/D
+ gf180mcu_fd_sc_mcu7t5v0__nor2_1_203/A1 gf180mcu_fd_sc_mcu7t5v0__nor2_1_203/A2 vdd
+ vss gf180mcu_fd_sc_mcu7t5v0__nor2_1
Xgf180mcu_fd_sc_mcu7t5v0__nor2_1_214 vdd vss gf180mcu_fd_sc_mcu7t5v0__xnor3_1_21/A2
+ gf180mcu_fd_sc_mcu7t5v0__xor3_1_73/A2 gf180mcu_fd_sc_mcu7t5v0__xor2_1_99/Z vdd vss
+ gf180mcu_fd_sc_mcu7t5v0__nor2_1
Xgf180mcu_fd_sc_mcu7t5v0__nor2_1_225 vdd vss gf180mcu_fd_sc_mcu7t5v0__nor2_1_225/ZN
+ gf180mcu_fd_sc_mcu7t5v0__or2_4_3/Z gf180mcu_fd_sc_mcu7t5v0__nor2_1_225/A2 vdd vss
+ gf180mcu_fd_sc_mcu7t5v0__nor2_1
Xgf180mcu_fd_sc_mcu7t5v0__nor2_1_236 vdd vss gf180mcu_fd_sc_mcu7t5v0__nor2_1_236/ZN
+ gf180mcu_fd_sc_mcu7t5v0__nor2_1_236/A1 gf180mcu_fd_sc_mcu7t5v0__inv_2_8/I vdd vss
+ gf180mcu_fd_sc_mcu7t5v0__nor2_1
Xgf180mcu_fd_sc_mcu7t5v0__nor2_1_247 vdd vss gf180mcu_fd_sc_mcu7t5v0__xor2_1_111/A1
+ gf180mcu_fd_sc_mcu7t5v0__xor2_1_219/A1 gf180mcu_fd_sc_mcu7t5v0__xor2_1_219/A2 vdd
+ vss gf180mcu_fd_sc_mcu7t5v0__nor2_1
Xgf180mcu_fd_sc_mcu7t5v0__nor2_1_258 vdd vss gf180mcu_fd_sc_mcu7t5v0__dffq_4_45/D
+ gf180mcu_fd_sc_mcu7t5v0__aoi21_1_7/B gf180mcu_fd_sc_mcu7t5v0__nor2_1_258/A2 vdd
+ vss gf180mcu_fd_sc_mcu7t5v0__nor2_1
Xgf180mcu_fd_sc_mcu7t5v0__nor2_1_269 vdd vss gf180mcu_fd_sc_mcu7t5v0__oai22_4_2/B1
+ gf180mcu_fd_sc_mcu7t5v0__or2_1_36/A2 gf180mcu_fd_sc_mcu7t5v0__dffq_2_102/Q vdd vss
+ gf180mcu_fd_sc_mcu7t5v0__nor2_1
Xgf180mcu_fd_sc_mcu7t5v0__xor3_1_9 gf180mcu_fd_sc_mcu7t5v0__or2_1_0/Z vdd vss gf180mcu_fd_sc_mcu7t5v0__xor3_1_9/Z
+ gf180mcu_fd_sc_mcu7t5v0__inv_1_0/I gf180mcu_fd_sc_mcu7t5v0__xor3_1_9/A2 vdd vss
+ gf180mcu_fd_sc_mcu7t5v0__xor3_1
Xgf180mcu_fd_sc_mcu7t5v0__nand2_1_440 vdd vss gf180mcu_fd_sc_mcu7t5v0__xnor2_1_42/A1
+ gf180mcu_fd_sc_mcu7t5v0__or4_1_0/A1 gf180mcu_fd_sc_mcu7t5v0__mux4_4_9/Z vdd vss
+ gf180mcu_fd_sc_mcu7t5v0__nand2_1
Xgf180mcu_fd_sc_mcu7t5v0__nand2_1_451 vdd vss gf180mcu_fd_sc_mcu7t5v0__nor2_2_31/A2
+ gf180mcu_fd_sc_mcu7t5v0__oai31_2_1/A2 gf180mcu_fd_sc_mcu7t5v0__inv_2_9/ZN vdd vss
+ gf180mcu_fd_sc_mcu7t5v0__nand2_1
Xgf180mcu_fd_sc_mcu7t5v0__nand2_1_462 vdd vss gf180mcu_fd_sc_mcu7t5v0__nand2_1_462/ZN
+ gf180mcu_fd_sc_mcu7t5v0__mux4_4_4/I1 gf180mcu_fd_sc_mcu7t5v0__or2_4_4/Z vdd vss
+ gf180mcu_fd_sc_mcu7t5v0__nand2_1
Xgf180mcu_fd_sc_mcu7t5v0__nand2_1_473 vdd vss gf180mcu_fd_sc_mcu7t5v0__oai221_1_11/B2
+ gf180mcu_fd_sc_mcu7t5v0__dffq_2_61/Q gf180mcu_fd_sc_mcu7t5v0__nor2_1_272/ZN vdd
+ vss gf180mcu_fd_sc_mcu7t5v0__nand2_1
Xgf180mcu_fd_sc_mcu7t5v0__nand2_1_484 vdd vss gf180mcu_fd_sc_mcu7t5v0__oai21_1_222/B
+ gf180mcu_fd_sc_mcu7t5v0__mux4_4_7/I1 gf180mcu_fd_sc_mcu7t5v0__xor2_2_4/Z vdd vss
+ gf180mcu_fd_sc_mcu7t5v0__nand2_1
Xgf180mcu_fd_sc_mcu7t5v0__nand2_1_495 vdd vss gf180mcu_fd_sc_mcu7t5v0__xnor3_1_28/A3
+ gf180mcu_fd_sc_mcu7t5v0__inv_12_1/I gf180mcu_fd_sc_mcu7t5v0__oai32_1_7/B1 vdd vss
+ gf180mcu_fd_sc_mcu7t5v0__nand2_1
Xgf180mcu_fd_sc_mcu7t5v0__oai21_1_307 vdd gf180mcu_fd_sc_mcu7t5v0__or3_1_23/A3 gf180mcu_fd_sc_mcu7t5v0__or3_1_23/A2
+ gf180mcu_fd_sc_mcu7t5v0__and3_1_20/A2 gf180mcu_fd_sc_mcu7t5v0__or3_1_23/A1 vss vdd
+ vss gf180mcu_fd_sc_mcu7t5v0__oai21_1
Xgf180mcu_fd_sc_mcu7t5v0__oai21_1_318 vdd gf180mcu_fd_sc_mcu7t5v0__oai21_1_318/B gf180mcu_fd_sc_mcu7t5v0__and3_1_23/A2
+ gf180mcu_fd_sc_mcu7t5v0__nand4_1_22/A4 gf180mcu_fd_sc_mcu7t5v0__dffq_4_37/Q vss
+ vdd vss gf180mcu_fd_sc_mcu7t5v0__oai21_1
Xgf180mcu_fd_sc_mcu7t5v0__mux2_1_10 gf180mcu_fd_sc_mcu7t5v0__mux2_1_10/S vdd vss gf180mcu_fd_sc_mcu7t5v0__mux2_1_10/Z
+ gf180mcu_fd_sc_mcu7t5v0__nor2_2_40/ZN gf180mcu_fd_sc_mcu7t5v0__nor3_4_17/ZN vdd
+ vss gf180mcu_fd_sc_mcu7t5v0__mux2_1
Xgf180mcu_fd_sc_mcu7t5v0__oai21_1_329 vdd gf180mcu_fd_sc_mcu7t5v0__mux2_1_14/I1 gf180mcu_fd_sc_mcu7t5v0__xor2_1_202/A2
+ gf180mcu_fd_sc_mcu7t5v0__mux2_1_14/I0 gf180mcu_fd_sc_mcu7t5v0__xor2_1_202/A1 vss
+ vdd vss gf180mcu_fd_sc_mcu7t5v0__oai21_1
Xgf180mcu_fd_sc_mcu7t5v0__aoi22_1_16 gf180mcu_fd_sc_mcu7t5v0__nor2_4_11/ZN gf180mcu_fd_sc_mcu7t5v0__dffq_1_48/Q
+ vdd vss gf180mcu_fd_sc_mcu7t5v0__aoi22_1_16/ZN gf180mcu_fd_sc_mcu7t5v0__dffq_1_18/Q
+ gf180mcu_fd_sc_mcu7t5v0__nor2_4_10/ZN vdd vss gf180mcu_fd_sc_mcu7t5v0__aoi22_1
Xgf180mcu_fd_sc_mcu7t5v0__aoi22_1_27 gf180mcu_fd_sc_mcu7t5v0__nor2_4_9/ZN gf180mcu_fd_sc_mcu7t5v0__dffq_1_38/Q
+ vdd vss gf180mcu_fd_sc_mcu7t5v0__aoi22_1_27/ZN gf180mcu_fd_sc_mcu7t5v0__dffq_1_36/Q
+ gf180mcu_fd_sc_mcu7t5v0__nor2_4_8/ZN vdd vss gf180mcu_fd_sc_mcu7t5v0__aoi22_1
Xgf180mcu_fd_sc_mcu7t5v0__aoi22_1_38 gf180mcu_fd_sc_mcu7t5v0__nor2_4_11/ZN gf180mcu_fd_sc_mcu7t5v0__dffq_1_68/Q
+ vdd vss gf180mcu_fd_sc_mcu7t5v0__aoi22_1_38/ZN gf180mcu_fd_sc_mcu7t5v0__dffq_1_71/Q
+ gf180mcu_fd_sc_mcu7t5v0__nor2_4_10/ZN vdd vss gf180mcu_fd_sc_mcu7t5v0__aoi22_1
Xgf180mcu_fd_sc_mcu7t5v0__aoi22_1_49 gf180mcu_fd_sc_mcu7t5v0__nor2_4_11/ZN gf180mcu_fd_sc_mcu7t5v0__dffq_1_82/Q
+ vdd vss gf180mcu_fd_sc_mcu7t5v0__aoi22_1_49/ZN gf180mcu_fd_sc_mcu7t5v0__dffq_1_266/Q
+ gf180mcu_fd_sc_mcu7t5v0__nor2_4_10/ZN vdd vss gf180mcu_fd_sc_mcu7t5v0__aoi22_1
Xgf180mcu_fd_sc_mcu7t5v0__xnor2_1_10 vdd vss gf180mcu_fd_sc_mcu7t5v0__xor3_1_39/A2
+ gf180mcu_fd_sc_mcu7t5v0__or2_1_9/A1 gf180mcu_fd_sc_mcu7t5v0__or2_1_9/A2 vdd vss
+ gf180mcu_fd_sc_mcu7t5v0__xnor2_1
Xgf180mcu_fd_sc_mcu7t5v0__xnor2_1_21 vdd vss gf180mcu_fd_sc_mcu7t5v0__xor2_1_55/A2
+ gf180mcu_fd_sc_mcu7t5v0__oai22_1_8/A2 gf180mcu_fd_sc_mcu7t5v0__xnor2_1_21/A2 vdd
+ vss gf180mcu_fd_sc_mcu7t5v0__xnor2_1
Xgf180mcu_fd_sc_mcu7t5v0__xnor2_1_32 vdd vss gf180mcu_fd_sc_mcu7t5v0__xnor3_1_20/A3
+ gf180mcu_fd_sc_mcu7t5v0__xnor2_1_32/A1 gf180mcu_fd_sc_mcu7t5v0__xnor2_1_32/A2 vdd
+ vss gf180mcu_fd_sc_mcu7t5v0__xnor2_1
Xgf180mcu_fd_sc_mcu7t5v0__xnor2_1_43 vdd vss gf180mcu_fd_sc_mcu7t5v0__xnor2_1_43/ZN
+ gf180mcu_fd_sc_mcu7t5v0__xnor2_1_43/A1 gf180mcu_fd_sc_mcu7t5v0__xnor2_1_43/A2 vdd
+ vss gf180mcu_fd_sc_mcu7t5v0__xnor2_1
Xgf180mcu_fd_sc_mcu7t5v0__or3_1_9 gf180mcu_fd_sc_mcu7t5v0__or3_1_9/A3 vdd vss gf180mcu_fd_sc_mcu7t5v0__or3_1_9/Z
+ gf180mcu_fd_sc_mcu7t5v0__or3_1_9/A1 gf180mcu_fd_sc_mcu7t5v0__or3_1_9/A2 vdd vss
+ gf180mcu_fd_sc_mcu7t5v0__or3_1
Xgf180mcu_fd_sc_mcu7t5v0__xnor2_1_54 vdd vss gf180mcu_fd_sc_mcu7t5v0__xnor2_1_54/ZN
+ gf180mcu_fd_sc_mcu7t5v0__xnor2_1_54/A1 gf180mcu_fd_sc_mcu7t5v0__xor3_1_175/Z vdd
+ vss gf180mcu_fd_sc_mcu7t5v0__xnor2_1
Xgf180mcu_fd_sc_mcu7t5v0__xnor2_1_65 vdd vss gf180mcu_fd_sc_mcu7t5v0__xnor2_1_65/ZN
+ gf180mcu_fd_sc_mcu7t5v0__xnor2_1_65/A1 gf180mcu_fd_sc_mcu7t5v0__xor3_1_140/Z vdd
+ vss gf180mcu_fd_sc_mcu7t5v0__xnor2_1
Xgf180mcu_fd_sc_mcu7t5v0__xnor2_1_76 vdd vss gf180mcu_fd_sc_mcu7t5v0__xor3_1_153/A3
+ gf180mcu_fd_sc_mcu7t5v0__or2_1_54/A1 gf180mcu_fd_sc_mcu7t5v0__or2_1_54/A2 vdd vss
+ gf180mcu_fd_sc_mcu7t5v0__xnor2_1
Xgf180mcu_fd_sc_mcu7t5v0__xnor2_1_87 vdd vss gf180mcu_fd_sc_mcu7t5v0__xor2_1_228/A2
+ gf180mcu_fd_sc_mcu7t5v0__or2_1_24/A2 gf180mcu_fd_sc_mcu7t5v0__xnor2_1_87/A2 vdd
+ vss gf180mcu_fd_sc_mcu7t5v0__xnor2_1
Xgf180mcu_fd_sc_mcu7t5v0__nor3_2_13 gf180mcu_fd_sc_mcu7t5v0__nor3_2_13/A3 vdd vss
+ gf180mcu_fd_sc_mcu7t5v0__nor3_2_13/ZN gf180mcu_fd_sc_mcu7t5v0__nor3_2_13/A1 gf180mcu_fd_sc_mcu7t5v0__xor2_1_195/Z
+ vdd vss gf180mcu_fd_sc_mcu7t5v0__nor3_2
Xgf180mcu_fd_sc_mcu7t5v0__and3_1_0 gf180mcu_fd_sc_mcu7t5v0__and3_1_0/A3 vdd vss gf180mcu_fd_sc_mcu7t5v0__and3_1_0/Z
+ gf180mcu_fd_sc_mcu7t5v0__dffq_2_6/Q gf180mcu_fd_sc_mcu7t5v0__or3_1_0/Z vdd vss gf180mcu_fd_sc_mcu7t5v0__and3_1
Xgf180mcu_fd_sc_mcu7t5v0__dffq_2_70 gf180mcu_fd_sc_mcu7t5v0__dffq_2_70/D vdd vss gf180mcu_fd_sc_mcu7t5v0__dffq_4_44/CLK
+ gf180mcu_fd_sc_mcu7t5v0__dffq_2_70/Q vdd vss gf180mcu_fd_sc_mcu7t5v0__dffq_2
Xgf180mcu_fd_sc_mcu7t5v0__dffq_2_81 gf180mcu_fd_sc_mcu7t5v0__dffq_2_81/D vdd vss gf180mcu_fd_sc_mcu7t5v0__dffq_4_44/CLK
+ gf180mcu_fd_sc_mcu7t5v0__dffq_2_81/Q vdd vss gf180mcu_fd_sc_mcu7t5v0__dffq_2
Xgf180mcu_fd_sc_mcu7t5v0__dffq_2_92 gf180mcu_fd_sc_mcu7t5v0__dffq_2_92/D vdd vss gf180mcu_fd_sc_mcu7t5v0__dffq_4_44/CLK
+ gf180mcu_fd_sc_mcu7t5v0__mux4_4_7/I1 vdd vss gf180mcu_fd_sc_mcu7t5v0__dffq_2
Xgf180mcu_fd_sc_mcu7t5v0__oai21_1_2 vdd gf180mcu_fd_sc_mcu7t5v0__xor2_1_8/Z gf180mcu_fd_sc_mcu7t5v0__or3_1_0/A2
+ gf180mcu_fd_sc_mcu7t5v0__and3_1_0/A3 gf180mcu_fd_sc_mcu7t5v0__or3_1_0/A1 vss vdd
+ vss gf180mcu_fd_sc_mcu7t5v0__oai21_1
Xgf180mcu_fd_sc_mcu7t5v0__aoi211_4_0 gf180mcu_fd_sc_mcu7t5v0__aoi22_4_8/B2 gf180mcu_fd_sc_mcu7t5v0__aoi21_2_6/ZN
+ gf180mcu_fd_sc_mcu7t5v0__inv_1_9/ZN vdd vss gf180mcu_fd_sc_mcu7t5v0__aoi211_4_0/ZN
+ gf180mcu_fd_sc_mcu7t5v0__aoi22_4_8/B1 vdd vss gf180mcu_fd_sc_mcu7t5v0__aoi211_4
Xgf180mcu_fd_sc_mcu7t5v0__nand2_1_270 vdd vss gf180mcu_fd_sc_mcu7t5v0__nand2_1_270/ZN
+ gf180mcu_fd_sc_mcu7t5v0__nand2_1_270/A1 gf180mcu_fd_sc_mcu7t5v0__nand2_1_270/A2
+ vdd vss gf180mcu_fd_sc_mcu7t5v0__nand2_1
Xgf180mcu_fd_sc_mcu7t5v0__nand2_1_281 vdd vss gf180mcu_fd_sc_mcu7t5v0__oai21_1_85/B
+ gf180mcu_fd_sc_mcu7t5v0__xnor2_1_26/A1 gf180mcu_fd_sc_mcu7t5v0__xor3_1_66/Z vdd
+ vss gf180mcu_fd_sc_mcu7t5v0__nand2_1
Xgf180mcu_fd_sc_mcu7t5v0__nand2_1_292 vdd vss gf180mcu_fd_sc_mcu7t5v0__xor3_1_66/A1
+ gf180mcu_fd_sc_mcu7t5v0__xor3_1_67/Z gf180mcu_fd_sc_mcu7t5v0__xor2_1_79/Z vdd vss
+ gf180mcu_fd_sc_mcu7t5v0__nand2_1
Xgf180mcu_fd_sc_mcu7t5v0__mux4_4_8 gf180mcu_fd_sc_mcu7t5v0__mux4_4_8/I0 vss vdd gf180mcu_fd_sc_mcu7t5v0__or3_2_0/A1
+ gf180mcu_fd_sc_mcu7t5v0__inv_2_13/I gf180mcu_fd_sc_mcu7t5v0__mux4_4_9/S0 gf180mcu_fd_sc_mcu7t5v0__or2_1_41/A1
+ gf180mcu_fd_sc_mcu7t5v0__inv_1_16/I gf180mcu_fd_sc_mcu7t5v0__mux4_4_8/Z vdd vss
+ gf180mcu_fd_sc_mcu7t5v0__mux4_4
Xgf180mcu_fd_sc_mcu7t5v0__aoi21_1_60 gf180mcu_fd_sc_mcu7t5v0__xor3_1_47/A2 vdd vss
+ gf180mcu_fd_sc_mcu7t5v0__aoi21_1_59/B gf180mcu_fd_sc_mcu7t5v0__or2_1_14/Z gf180mcu_fd_sc_mcu7t5v0__or3_1_4/Z
+ vdd vss gf180mcu_fd_sc_mcu7t5v0__aoi21_1
Xgf180mcu_fd_sc_mcu7t5v0__aoi21_1_71 gf180mcu_fd_sc_mcu7t5v0__aoi21_1_71/B vdd vss
+ gf180mcu_fd_sc_mcu7t5v0__dffq_4_6/D gf180mcu_fd_sc_mcu7t5v0__inv_4_1/ZN gf180mcu_fd_sc_mcu7t5v0__buf_20_0/Z
+ vdd vss gf180mcu_fd_sc_mcu7t5v0__aoi21_1
Xgf180mcu_fd_sc_mcu7t5v0__aoi21_1_82 gf180mcu_fd_sc_mcu7t5v0__nor2_1_89/A1 vdd vss
+ gf180mcu_fd_sc_mcu7t5v0__oai32_1_2/A3 gf180mcu_fd_sc_mcu7t5v0__inv_8_2/I gf180mcu_fd_sc_mcu7t5v0__and4_1_0/A4
+ vdd vss gf180mcu_fd_sc_mcu7t5v0__aoi21_1
Xgf180mcu_fd_sc_mcu7t5v0__aoi21_1_93 gf180mcu_fd_sc_mcu7t5v0__aoi21_1_93/B vdd vss
+ gf180mcu_fd_sc_mcu7t5v0__or3_1_2/A2 gf180mcu_fd_sc_mcu7t5v0__aoi21_1_93/A1 gf180mcu_fd_sc_mcu7t5v0__oai21_1_75/ZN
+ vdd vss gf180mcu_fd_sc_mcu7t5v0__aoi21_1
Xgf180mcu_fd_sc_mcu7t5v0__oai21_1_104 vdd gf180mcu_fd_sc_mcu7t5v0__buf_8_7/Z gf180mcu_fd_sc_mcu7t5v0__nor3_4_14/ZN
+ gf180mcu_fd_sc_mcu7t5v0__aoi21_1_122/B gf180mcu_fd_sc_mcu7t5v0__dffq_1_295/Q vss
+ vdd vss gf180mcu_fd_sc_mcu7t5v0__oai21_1
Xgf180mcu_fd_sc_mcu7t5v0__oai21_1_115 vdd gf180mcu_fd_sc_mcu7t5v0__buf_8_6/Z gf180mcu_fd_sc_mcu7t5v0__nor3_4_14/ZN
+ gf180mcu_fd_sc_mcu7t5v0__aoi21_1_125/B gf180mcu_fd_sc_mcu7t5v0__dffq_1_305/Q vss
+ vdd vss gf180mcu_fd_sc_mcu7t5v0__oai21_1
Xgf180mcu_fd_sc_mcu7t5v0__oai21_1_126 vdd gf180mcu_fd_sc_mcu7t5v0__oai21_1_126/B gf180mcu_fd_sc_mcu7t5v0__xor2_1_224/A1
+ gf180mcu_fd_sc_mcu7t5v0__oai221_1_7/C gf180mcu_fd_sc_mcu7t5v0__inv_4_6/I vss vdd
+ vss gf180mcu_fd_sc_mcu7t5v0__oai21_1
Xgf180mcu_fd_sc_mcu7t5v0__oai21_1_137 vdd gf180mcu_fd_sc_mcu7t5v0__buf_8_8/Z gf180mcu_fd_sc_mcu7t5v0__nand3_1_55/A2
+ gf180mcu_fd_sc_mcu7t5v0__aoi21_1_175/B gf180mcu_fd_sc_mcu7t5v0__dffq_1_383/Q vss
+ vdd vss gf180mcu_fd_sc_mcu7t5v0__oai21_1
Xgf180mcu_fd_sc_mcu7t5v0__oai21_1_148 vdd gf180mcu_fd_sc_mcu7t5v0__oai21_1_148/B gf180mcu_fd_sc_mcu7t5v0__oai21_1_148/A2
+ gf180mcu_fd_sc_mcu7t5v0__dffq_2_47/D gf180mcu_fd_sc_mcu7t5v0__or3_1_11/Z vss vdd
+ vss gf180mcu_fd_sc_mcu7t5v0__oai21_1
Xgf180mcu_fd_sc_mcu7t5v0__oai21_1_159 vdd gf180mcu_fd_sc_mcu7t5v0__oai21_1_163/B gf180mcu_fd_sc_mcu7t5v0__and2_1_68/Z
+ gf180mcu_fd_sc_mcu7t5v0__nor2_1_196/A2 gf180mcu_fd_sc_mcu7t5v0__nor4_1_2/A4 vss
+ vdd vss gf180mcu_fd_sc_mcu7t5v0__oai21_1
Xgf180mcu_fd_sc_mcu7t5v0__oai31_4_0 gf180mcu_fd_sc_mcu7t5v0__inv_2_0/I gf180mcu_fd_sc_mcu7t5v0__oai31_4_0/B
+ vdd vss gf180mcu_fd_sc_mcu7t5v0__xor2_1_20/A1 gf180mcu_fd_sc_mcu7t5v0__xor3_1_43/A1
+ gf180mcu_fd_sc_mcu7t5v0__or3_2_2/A2 vdd vss gf180mcu_fd_sc_mcu7t5v0__oai31_4
Xgf180mcu_fd_sc_mcu7t5v0__oai22_1_90 gf180mcu_fd_sc_mcu7t5v0__oai22_1_90/A2 gf180mcu_fd_sc_mcu7t5v0__oai22_1_90/B1
+ gf180mcu_fd_sc_mcu7t5v0__oai22_1_90/B2 vdd vss gf180mcu_fd_sc_mcu7t5v0__dffq_1_74/D
+ gf180mcu_fd_sc_mcu7t5v0__aoi21_4_2/ZN vdd vss gf180mcu_fd_sc_mcu7t5v0__oai22_1
Xgf180mcu_fd_sc_mcu7t5v0__nand2_2_11 vdd vss gf180mcu_fd_sc_mcu7t5v0__nor2_4_3/A2
+ gf180mcu_fd_sc_mcu7t5v0__inv_2_4/I gf180mcu_fd_sc_mcu7t5v0__inv_4_0/ZN vdd vss gf180mcu_fd_sc_mcu7t5v0__nand2_2
Xgf180mcu_fd_sc_mcu7t5v0__nand2_2_22 vdd vss gf180mcu_fd_sc_mcu7t5v0__oai22_1_99/B1
+ gf180mcu_fd_sc_mcu7t5v0__buf_8_2/Z gf180mcu_fd_sc_mcu7t5v0__oai22_1_99/A2 vdd vss
+ gf180mcu_fd_sc_mcu7t5v0__nand2_2
Xgf180mcu_fd_sc_mcu7t5v0__nand2_2_33 vdd vss gf180mcu_fd_sc_mcu7t5v0__nand2_2_33/ZN
+ gf180mcu_fd_sc_mcu7t5v0__buf_8_2/Z gf180mcu_fd_sc_mcu7t5v0__nand2_4_32/ZN vdd vss
+ gf180mcu_fd_sc_mcu7t5v0__nand2_2
Xgf180mcu_fd_sc_mcu7t5v0__nand2_2_44 vdd vss gf180mcu_fd_sc_mcu7t5v0__nand2_2_44/ZN
+ gf180mcu_fd_sc_mcu7t5v0__buf_8_5/Z gf180mcu_fd_sc_mcu7t5v0__nand2_4_28/ZN vdd vss
+ gf180mcu_fd_sc_mcu7t5v0__nand2_2
Xgf180mcu_fd_sc_mcu7t5v0__nand2_2_55 vdd vss gf180mcu_fd_sc_mcu7t5v0__or3_1_13/A3
+ gf180mcu_fd_sc_mcu7t5v0__inv_8_1/I gf180mcu_fd_sc_mcu7t5v0__or3_1_12/A2 vdd vss
+ gf180mcu_fd_sc_mcu7t5v0__nand2_2
Xgf180mcu_fd_sc_mcu7t5v0__clkinv_1_19 vdd vss gf180mcu_fd_sc_mcu7t5v0__xor3_1_1/A1
+ gf180mcu_fd_sc_mcu7t5v0__oai32_1_1/A1 vdd vss gf180mcu_fd_sc_mcu7t5v0__clkinv_1
Xgf180mcu_fd_sc_mcu7t5v0__nand2_2_66 vdd vss gf180mcu_fd_sc_mcu7t5v0__nor2_2_33/A2
+ gf180mcu_fd_sc_mcu7t5v0__dffq_2_97/Q gf180mcu_fd_sc_mcu7t5v0__nand2_2_66/A2 vdd
+ vss gf180mcu_fd_sc_mcu7t5v0__nand2_2
Xgf180mcu_fd_sc_mcu7t5v0__xor2_1_203 vdd vss gf180mcu_fd_sc_mcu7t5v0__xor2_1_203/Z
+ gf180mcu_fd_sc_mcu7t5v0__and3_1_23/A2 gf180mcu_fd_sc_mcu7t5v0__xor2_1_203/A2 vdd
+ vss gf180mcu_fd_sc_mcu7t5v0__xor2_1
Xgf180mcu_fd_sc_mcu7t5v0__nand2_2_77 vdd vss gf180mcu_fd_sc_mcu7t5v0__oai31_1_19/B
+ gf180mcu_fd_sc_mcu7t5v0__nor3_1_41/A1 gf180mcu_fd_sc_mcu7t5v0__nor2_1_386/ZN vdd
+ vss gf180mcu_fd_sc_mcu7t5v0__nand2_2
Xgf180mcu_fd_sc_mcu7t5v0__xor2_1_214 vdd vss gf180mcu_fd_sc_mcu7t5v0__xor2_1_71/A2
+ gf180mcu_fd_sc_mcu7t5v0__nor2_1_24/A2 gf180mcu_fd_sc_mcu7t5v0__xor2_1_214/A2 vdd
+ vss gf180mcu_fd_sc_mcu7t5v0__xor2_1
Xgf180mcu_fd_sc_mcu7t5v0__xor2_1_225 vdd vss gf180mcu_fd_sc_mcu7t5v0__or2_1_57/A2
+ gf180mcu_fd_sc_mcu7t5v0__or3_1_9/A1 gf180mcu_fd_sc_mcu7t5v0__xor2_1_226/Z vdd vss
+ gf180mcu_fd_sc_mcu7t5v0__xor2_1
Xgf180mcu_fd_sc_mcu7t5v0__clkinv_1_250 vdd vss gf180mcu_fd_sc_mcu7t5v0__dffq_1_233/Q
+ gf180mcu_fd_sc_mcu7t5v0__oai22_1_230/B2 vdd vss gf180mcu_fd_sc_mcu7t5v0__clkinv_1
Xgf180mcu_fd_sc_mcu7t5v0__clkinv_1_261 vdd vss gf180mcu_fd_sc_mcu7t5v0__dffq_1_232/Q
+ gf180mcu_fd_sc_mcu7t5v0__oai22_1_242/B2 vdd vss gf180mcu_fd_sc_mcu7t5v0__clkinv_1
Xgf180mcu_fd_sc_mcu7t5v0__clkinv_1_272 vdd vss gf180mcu_fd_sc_mcu7t5v0__dffq_1_259/Q
+ gf180mcu_fd_sc_mcu7t5v0__oai22_1_114/B2 vdd vss gf180mcu_fd_sc_mcu7t5v0__clkinv_1
Xgf180mcu_fd_sc_mcu7t5v0__clkinv_1_283 vdd vss gf180mcu_fd_sc_mcu7t5v0__or3_4_0/A1
+ gf180mcu_fd_sc_mcu7t5v0__nand3_4_10/A1 vdd vss gf180mcu_fd_sc_mcu7t5v0__clkinv_1
Xgf180mcu_fd_sc_mcu7t5v0__clkinv_1_294 vdd vss gf180mcu_fd_sc_mcu7t5v0__dffq_1_321/Q
+ gf180mcu_fd_sc_mcu7t5v0__aoi21_1_145/A1 vdd vss gf180mcu_fd_sc_mcu7t5v0__clkinv_1
Xgf180mcu_fd_sc_mcu7t5v0__oai22_4_0 gf180mcu_fd_sc_mcu7t5v0__nor2_2_8/ZN vdd vss gf180mcu_fd_sc_mcu7t5v0__and2_2_0/A2
+ gf180mcu_fd_sc_mcu7t5v0__inv_3_0/ZN gf180mcu_fd_sc_mcu7t5v0__oai22_4_0/A2 gf180mcu_fd_sc_mcu7t5v0__inv_4_1/I
+ vdd vss gf180mcu_fd_sc_mcu7t5v0__oai22_4
Xgf180mcu_fd_sc_mcu7t5v0__inv_4_0 vss gf180mcu_fd_sc_mcu7t5v0__inv_4_0/ZN gf180mcu_fd_sc_mcu7t5v0__inv_4_0/I
+ vdd vdd vss gf180mcu_fd_sc_mcu7t5v0__inv_4
Xgf180mcu_fd_sc_mcu7t5v0__nand3_1_1 gf180mcu_fd_sc_mcu7t5v0__nand3_1_1/A3 vdd vss
+ gf180mcu_fd_sc_mcu7t5v0__xor2_1_32/A1 gf180mcu_fd_sc_mcu7t5v0__inv_12_1/I gf180mcu_fd_sc_mcu7t5v0__xnor3_1_7/ZN
+ vdd vss gf180mcu_fd_sc_mcu7t5v0__nand3_1
Xgf180mcu_fd_sc_mcu7t5v0__dffq_4_16 gf180mcu_fd_sc_mcu7t5v0__dffq_4_16/D gf180mcu_fd_sc_mcu7t5v0__mux4_4_4/I0
+ vdd vss gf180mcu_fd_sc_mcu7t5v0__dffq_4_21/CLK vdd vss gf180mcu_fd_sc_mcu7t5v0__dffq_4
Xgf180mcu_fd_sc_mcu7t5v0__dffq_4_27 gf180mcu_fd_sc_mcu7t5v0__dffq_4_27/D gf180mcu_fd_sc_mcu7t5v0__mux4_4_9/S0
+ vdd vss gf180mcu_fd_sc_mcu7t5v0__dffq_4_1/CLK vdd vss gf180mcu_fd_sc_mcu7t5v0__dffq_4
Xgf180mcu_fd_sc_mcu7t5v0__dffq_4_38 gf180mcu_fd_sc_mcu7t5v0__dffq_4_38/D gf180mcu_fd_sc_mcu7t5v0__inv_8_1/I
+ vdd vss gf180mcu_fd_sc_mcu7t5v0__dffq_4_44/CLK vdd vss gf180mcu_fd_sc_mcu7t5v0__dffq_4
Xgf180mcu_fd_sc_mcu7t5v0__and2_2_9 vdd vss gf180mcu_fd_sc_mcu7t5v0__and2_2_9/Z gf180mcu_fd_sc_mcu7t5v0__and2_2_9/A1
+ gf180mcu_fd_sc_mcu7t5v0__and2_2_9/A2 vdd vss gf180mcu_fd_sc_mcu7t5v0__and2_2
Xgf180mcu_fd_sc_mcu7t5v0__oai21_2_15 gf180mcu_fd_sc_mcu7t5v0__aoi22_2_8/A2 gf180mcu_fd_sc_mcu7t5v0__oai21_2_15/ZN
+ gf180mcu_fd_sc_mcu7t5v0__dffq_2_95/Q vss gf180mcu_fd_sc_mcu7t5v0__inv_1_20/ZN vdd
+ vdd vss gf180mcu_fd_sc_mcu7t5v0__oai21_2
Xgf180mcu_fd_sc_mcu7t5v0__aoi22_1_120 gf180mcu_fd_sc_mcu7t5v0__nor2_4_11/ZN gf180mcu_fd_sc_mcu7t5v0__dffq_1_214/Q
+ vdd vss gf180mcu_fd_sc_mcu7t5v0__nand2_1_269/A2 gf180mcu_fd_sc_mcu7t5v0__dffq_1_216/Q
+ gf180mcu_fd_sc_mcu7t5v0__nor2_4_10/ZN vdd vss gf180mcu_fd_sc_mcu7t5v0__aoi22_1
Xgf180mcu_fd_sc_mcu7t5v0__aoi22_1_131 gf180mcu_fd_sc_mcu7t5v0__nor2_4_11/ZN gf180mcu_fd_sc_mcu7t5v0__dffq_1_228/Q
+ vdd vss gf180mcu_fd_sc_mcu7t5v0__nand2_1_275/A2 gf180mcu_fd_sc_mcu7t5v0__dffq_1_235/Q
+ gf180mcu_fd_sc_mcu7t5v0__nor2_4_10/ZN vdd vss gf180mcu_fd_sc_mcu7t5v0__aoi22_1
Xgf180mcu_fd_sc_mcu7t5v0__aoi22_1_142 gf180mcu_fd_sc_mcu7t5v0__nor2_4_9/ZN gf180mcu_fd_sc_mcu7t5v0__dffq_1_269/Q
+ vdd vss gf180mcu_fd_sc_mcu7t5v0__nand2_1_296/A1 gf180mcu_fd_sc_mcu7t5v0__dffq_1_122/Q
+ gf180mcu_fd_sc_mcu7t5v0__nor2_4_8/ZN vdd vss gf180mcu_fd_sc_mcu7t5v0__aoi22_1
Xgf180mcu_fd_sc_mcu7t5v0__or2_1_14 vdd vss gf180mcu_fd_sc_mcu7t5v0__or2_1_14/Z gf180mcu_fd_sc_mcu7t5v0__or2_1_14/A1
+ gf180mcu_fd_sc_mcu7t5v0__or2_1_14/A2 vdd vss gf180mcu_fd_sc_mcu7t5v0__or2_1
Xgf180mcu_fd_sc_mcu7t5v0__or2_1_25 vdd vss gf180mcu_fd_sc_mcu7t5v0__or2_1_25/Z gf180mcu_fd_sc_mcu7t5v0__or2_1_25/A1
+ gf180mcu_fd_sc_mcu7t5v0__or2_1_25/A2 vdd vss gf180mcu_fd_sc_mcu7t5v0__or2_1
Xgf180mcu_fd_sc_mcu7t5v0__aoi22_1_153 gf180mcu_fd_sc_mcu7t5v0__nor2_4_26/ZN gf180mcu_fd_sc_mcu7t5v0__or2_4_2/A2
+ vdd vss gf180mcu_fd_sc_mcu7t5v0__nor2_1_145/A2 gf180mcu_fd_sc_mcu7t5v0__dffq_1_285/Q
+ gf180mcu_fd_sc_mcu7t5v0__or3_2_4/Z vdd vss gf180mcu_fd_sc_mcu7t5v0__aoi22_1
Xgf180mcu_fd_sc_mcu7t5v0__aoi22_1_164 gf180mcu_fd_sc_mcu7t5v0__and2_2_9/Z gf180mcu_fd_sc_mcu7t5v0__inv_8_0/I
+ vdd vss gf180mcu_fd_sc_mcu7t5v0__nor3_1_29/A2 gf180mcu_fd_sc_mcu7t5v0__or4_1_0/A1
+ gf180mcu_fd_sc_mcu7t5v0__nor4_2_5/A1 vdd vss gf180mcu_fd_sc_mcu7t5v0__aoi22_1
Xgf180mcu_fd_sc_mcu7t5v0__aoi22_1_175 gf180mcu_fd_sc_mcu7t5v0__and4_1_3/A4 gf180mcu_fd_sc_mcu7t5v0__inv_8_0/I
+ vdd vss gf180mcu_fd_sc_mcu7t5v0__or3_1_26/A3 gf180mcu_fd_sc_mcu7t5v0__or4_1_0/A1
+ gf180mcu_fd_sc_mcu7t5v0__and4_1_3/A3 vdd vss gf180mcu_fd_sc_mcu7t5v0__aoi22_1
Xgf180mcu_fd_sc_mcu7t5v0__or2_1_36 vdd vss gf180mcu_fd_sc_mcu7t5v0__or2_1_36/Z gf180mcu_fd_sc_mcu7t5v0__inv_4_4/I
+ gf180mcu_fd_sc_mcu7t5v0__or2_1_36/A2 vdd vss gf180mcu_fd_sc_mcu7t5v0__or2_1
Xgf180mcu_fd_sc_mcu7t5v0__or2_1_47 vdd vss gf180mcu_fd_sc_mcu7t5v0__or2_1_47/Z gf180mcu_fd_sc_mcu7t5v0__or3_1_9/A1
+ gf180mcu_fd_sc_mcu7t5v0__inv_1_13/I vdd vss gf180mcu_fd_sc_mcu7t5v0__or2_1
Xgf180mcu_fd_sc_mcu7t5v0__nor2_4_14 vdd vss gf180mcu_fd_sc_mcu7t5v0__nor2_4_14/ZN
+ gf180mcu_fd_sc_mcu7t5v0__or2_1_34/A2 gf180mcu_fd_sc_mcu7t5v0__nor2_4_14/A2 vdd vss
+ gf180mcu_fd_sc_mcu7t5v0__nor2_4
Xgf180mcu_fd_sc_mcu7t5v0__nor2_4_25 vdd vss gf180mcu_fd_sc_mcu7t5v0__and3_2_2/A2 gf180mcu_fd_sc_mcu7t5v0__nor4_4_0/A1
+ gf180mcu_fd_sc_mcu7t5v0__inv_2_7/ZN vdd vss gf180mcu_fd_sc_mcu7t5v0__nor2_4
Xgf180mcu_fd_sc_mcu7t5v0__nor2_4_36 vdd vss gf180mcu_fd_sc_mcu7t5v0__xor3_2_1/A1 gf180mcu_fd_sc_mcu7t5v0__oai32_1_6/B1
+ gf180mcu_fd_sc_mcu7t5v0__nor3_4_16/A3 vdd vss gf180mcu_fd_sc_mcu7t5v0__nor2_4
Xgf180mcu_fd_sc_mcu7t5v0__aoi21_1_300 gf180mcu_fd_sc_mcu7t5v0__aoi21_1_300/B vdd vss
+ gf180mcu_fd_sc_mcu7t5v0__aoi211_1_86/B gf180mcu_fd_sc_mcu7t5v0__inv_1_24/I gf180mcu_fd_sc_mcu7t5v0__nor2_2_32/ZN
+ vdd vss gf180mcu_fd_sc_mcu7t5v0__aoi21_1
Xgf180mcu_fd_sc_mcu7t5v0__aoi21_1_311 gf180mcu_fd_sc_mcu7t5v0__aoi21_1_311/B vdd vss
+ gf180mcu_fd_sc_mcu7t5v0__dffq_4_37/D gf180mcu_fd_sc_mcu7t5v0__or3_1_9/A1 gf180mcu_fd_sc_mcu7t5v0__buf_20_0/Z
+ vdd vss gf180mcu_fd_sc_mcu7t5v0__aoi21_1
Xgf180mcu_fd_sc_mcu7t5v0__aoi21_1_322 gf180mcu_fd_sc_mcu7t5v0__nor2_2_46/A2 vdd vss
+ gf180mcu_fd_sc_mcu7t5v0__oai22_1_277/B2 gf180mcu_fd_sc_mcu7t5v0__or4_1_0/A2 gf180mcu_fd_sc_mcu7t5v0__inv_3_4/I
+ vdd vss gf180mcu_fd_sc_mcu7t5v0__aoi21_1
Xgf180mcu_fd_sc_mcu7t5v0__aoi21_1_333 gf180mcu_fd_sc_mcu7t5v0__nor2_1_353/ZN vdd vss
+ gf180mcu_fd_sc_mcu7t5v0__xor3_1_141/A2 gf180mcu_fd_sc_mcu7t5v0__xor3_1_125/A1 gf180mcu_fd_sc_mcu7t5v0__nand2_1_637/ZN
+ vdd vss gf180mcu_fd_sc_mcu7t5v0__aoi21_1
Xgf180mcu_fd_sc_mcu7t5v0__aoi21_1_344 gf180mcu_fd_sc_mcu7t5v0__aoi21_1_7/B vdd vss
+ gf180mcu_fd_sc_mcu7t5v0__dffq_2_91/D gf180mcu_fd_sc_mcu7t5v0__nand2_1_644/ZN gf180mcu_fd_sc_mcu7t5v0__oai211_1_47/ZN
+ vdd vss gf180mcu_fd_sc_mcu7t5v0__aoi21_1
Xgf180mcu_fd_sc_mcu7t5v0__aoi21_1_355 gf180mcu_fd_sc_mcu7t5v0__nor2_2_54/ZN vdd vss
+ gf180mcu_fd_sc_mcu7t5v0__oai22_1_279/B1 gf180mcu_fd_sc_mcu7t5v0__nor2_2_57/ZN gf180mcu_fd_sc_mcu7t5v0__xor3_1_147/A1
+ vdd vss gf180mcu_fd_sc_mcu7t5v0__aoi21_1
Xgf180mcu_fd_sc_mcu7t5v0__aoi21_1_366 gf180mcu_fd_sc_mcu7t5v0__aoi21_1_366/B vdd vss
+ gf180mcu_fd_sc_mcu7t5v0__aoi21_1_301/B gf180mcu_fd_sc_mcu7t5v0__nor2_4_34/ZN gf180mcu_fd_sc_mcu7t5v0__xor3_1_157/Z
+ vdd vss gf180mcu_fd_sc_mcu7t5v0__aoi21_1
Xgf180mcu_fd_sc_mcu7t5v0__aoi21_1_377 gf180mcu_fd_sc_mcu7t5v0__oai21_1_90/ZN vdd vss
+ gf180mcu_fd_sc_mcu7t5v0__dffq_2_106/D gf180mcu_fd_sc_mcu7t5v0__nor2_4_37/A1 gf180mcu_fd_sc_mcu7t5v0__buf_20_0/Z
+ vdd vss gf180mcu_fd_sc_mcu7t5v0__aoi21_1
Xgf180mcu_fd_sc_mcu7t5v0__xor3_1_10 gf180mcu_fd_sc_mcu7t5v0__xor3_1_11/Z vdd vss gf180mcu_fd_sc_mcu7t5v0__xor3_1_10/Z
+ gf180mcu_fd_sc_mcu7t5v0__xor3_1_10/A1 gf180mcu_fd_sc_mcu7t5v0__xor3_1_10/A2 vdd
+ vss gf180mcu_fd_sc_mcu7t5v0__xor3_1
Xgf180mcu_fd_sc_mcu7t5v0__xor3_1_21 gf180mcu_fd_sc_mcu7t5v0__xor2_1_64/Z vdd vss gf180mcu_fd_sc_mcu7t5v0__xor3_1_21/Z
+ gf180mcu_fd_sc_mcu7t5v0__inv_4_6/ZN gf180mcu_fd_sc_mcu7t5v0__xor3_1_21/A2 vdd vss
+ gf180mcu_fd_sc_mcu7t5v0__xor3_1
Xgf180mcu_fd_sc_mcu7t5v0__xor3_1_32 gf180mcu_fd_sc_mcu7t5v0__xor3_1_32/A3 vdd vss
+ gf180mcu_fd_sc_mcu7t5v0__xor3_1_32/Z gf180mcu_fd_sc_mcu7t5v0__xor3_1_32/A1 gf180mcu_fd_sc_mcu7t5v0__xor3_1_32/A2
+ vdd vss gf180mcu_fd_sc_mcu7t5v0__xor3_1
Xgf180mcu_fd_sc_mcu7t5v0__aoi222_1_0 vss vdd gf180mcu_fd_sc_mcu7t5v0__aoi222_1_0/C2
+ gf180mcu_fd_sc_mcu7t5v0__nor2_4_7/ZN gf180mcu_fd_sc_mcu7t5v0__nor2_4_5/ZN gf180mcu_fd_sc_mcu7t5v0__aoi222_1_0/B1
+ gf180mcu_fd_sc_mcu7t5v0__aoi222_1_0/A2 gf180mcu_fd_sc_mcu7t5v0__nor2_4_6/ZN gf180mcu_fd_sc_mcu7t5v0__nand3_1_38/A2
+ vdd vss gf180mcu_fd_sc_mcu7t5v0__aoi222_1
Xgf180mcu_fd_sc_mcu7t5v0__xor3_1_43 gf180mcu_fd_sc_mcu7t5v0__or3_1_5/A3 vdd vss gf180mcu_fd_sc_mcu7t5v0__xor3_1_43/Z
+ gf180mcu_fd_sc_mcu7t5v0__xor3_1_43/A1 gf180mcu_fd_sc_mcu7t5v0__xor3_1_43/A2 vdd
+ vss gf180mcu_fd_sc_mcu7t5v0__xor3_1
Xgf180mcu_fd_sc_mcu7t5v0__xor3_1_54 gf180mcu_fd_sc_mcu7t5v0__xor3_1_54/A3 vdd vss
+ gf180mcu_fd_sc_mcu7t5v0__xor3_1_54/Z gf180mcu_fd_sc_mcu7t5v0__xor3_1_54/A1 gf180mcu_fd_sc_mcu7t5v0__xor3_1_54/A2
+ vdd vss gf180mcu_fd_sc_mcu7t5v0__xor3_1
Xgf180mcu_fd_sc_mcu7t5v0__xor3_1_65 gf180mcu_fd_sc_mcu7t5v0__xor2_1_80/Z vdd vss gf180mcu_fd_sc_mcu7t5v0__xor3_1_65/Z
+ gf180mcu_fd_sc_mcu7t5v0__xor3_1_65/A1 gf180mcu_fd_sc_mcu7t5v0__xor3_1_65/A2 vdd
+ vss gf180mcu_fd_sc_mcu7t5v0__xor3_1
Xgf180mcu_fd_sc_mcu7t5v0__xor3_1_76 gf180mcu_fd_sc_mcu7t5v0__or2_1_27/A2 vdd vss gf180mcu_fd_sc_mcu7t5v0__xor3_1_76/Z
+ gf180mcu_fd_sc_mcu7t5v0__or2_1_27/A1 gf180mcu_fd_sc_mcu7t5v0__xor3_1_76/A2 vdd vss
+ gf180mcu_fd_sc_mcu7t5v0__xor3_1
Xgf180mcu_fd_sc_mcu7t5v0__xor3_1_87 gf180mcu_fd_sc_mcu7t5v0__xor3_1_87/A3 vdd vss
+ gf180mcu_fd_sc_mcu7t5v0__xor3_1_87/Z gf180mcu_fd_sc_mcu7t5v0__inv_1_2/I gf180mcu_fd_sc_mcu7t5v0__xor3_1_87/A2
+ vdd vss gf180mcu_fd_sc_mcu7t5v0__xor3_1
Xgf180mcu_fd_sc_mcu7t5v0__xor3_1_98 gf180mcu_fd_sc_mcu7t5v0__xor3_1_94/Z vdd vss gf180mcu_fd_sc_mcu7t5v0__xor3_1_98/Z
+ gf180mcu_fd_sc_mcu7t5v0__xor3_1_98/A1 gf180mcu_fd_sc_mcu7t5v0__xor3_1_98/A2 vdd
+ vss gf180mcu_fd_sc_mcu7t5v0__xor3_1
Xgf180mcu_fd_sc_mcu7t5v0__nor3_1_2 gf180mcu_fd_sc_mcu7t5v0__or2_1_0/A2 vdd vss gf180mcu_fd_sc_mcu7t5v0__nor3_1_2/ZN
+ gf180mcu_fd_sc_mcu7t5v0__inv_1_0/ZN gf180mcu_fd_sc_mcu7t5v0__or2_1_0/A1 vdd vss
+ gf180mcu_fd_sc_mcu7t5v0__nor3_1
Xgf180mcu_fd_sc_mcu7t5v0__dffq_1_207 vdd gf180mcu_fd_sc_mcu7t5v0__dffq_1_207/Q gf180mcu_fd_sc_mcu7t5v0__dffq_4_8/CLK
+ vss gf180mcu_fd_sc_mcu7t5v0__dffq_1_207/D vdd vss gf180mcu_fd_sc_mcu7t5v0__dffq_1
Xgf180mcu_fd_sc_mcu7t5v0__dffq_1_218 vdd gf180mcu_fd_sc_mcu7t5v0__dffq_1_218/Q gf180mcu_fd_sc_mcu7t5v0__dffq_4_8/CLK
+ vss gf180mcu_fd_sc_mcu7t5v0__dffq_1_218/D vdd vss gf180mcu_fd_sc_mcu7t5v0__dffq_1
Xgf180mcu_fd_sc_mcu7t5v0__nor2_1_407 vdd vss gf180mcu_fd_sc_mcu7t5v0__dffq_1_158/D
+ gf180mcu_fd_sc_mcu7t5v0__dffq_1_158/Q gf180mcu_fd_sc_mcu7t5v0__oai21_2_8/ZN vdd
+ vss gf180mcu_fd_sc_mcu7t5v0__nor2_1
Xgf180mcu_fd_sc_mcu7t5v0__dffq_1_229 vdd gf180mcu_fd_sc_mcu7t5v0__dffq_1_229/Q gf180mcu_fd_sc_mcu7t5v0__dffq_2_26/CLK
+ vss gf180mcu_fd_sc_mcu7t5v0__dffq_1_229/D vdd vss gf180mcu_fd_sc_mcu7t5v0__dffq_1
Xgf180mcu_fd_sc_mcu7t5v0__nand2_1_600 vdd vss gf180mcu_fd_sc_mcu7t5v0__xor3_1_123/A1
+ gf180mcu_fd_sc_mcu7t5v0__or2_1_7/A1 gf180mcu_fd_sc_mcu7t5v0__inv_1_23/I vdd vss
+ gf180mcu_fd_sc_mcu7t5v0__nand2_1
Xgf180mcu_fd_sc_mcu7t5v0__nand2_1_611 vdd vss gf180mcu_fd_sc_mcu7t5v0__nor3_1_40/A2
+ gf180mcu_fd_sc_mcu7t5v0__inv_12_1/I gf180mcu_fd_sc_mcu7t5v0__mux4_4_12/Z vdd vss
+ gf180mcu_fd_sc_mcu7t5v0__nand2_1
Xgf180mcu_fd_sc_mcu7t5v0__nand2_1_622 vdd vss gf180mcu_fd_sc_mcu7t5v0__xnor2_1_59/A1
+ gf180mcu_fd_sc_mcu7t5v0__inv_8_1/I gf180mcu_fd_sc_mcu7t5v0__mux4_4_13/Z vdd vss
+ gf180mcu_fd_sc_mcu7t5v0__nand2_1
Xgf180mcu_fd_sc_mcu7t5v0__nand2_1_633 vdd vss gf180mcu_fd_sc_mcu7t5v0__xor2_1_163/A1
+ gf180mcu_fd_sc_mcu7t5v0__nand2_1_633/A1 gf180mcu_fd_sc_mcu7t5v0__and3_1_20/A2 vdd
+ vss gf180mcu_fd_sc_mcu7t5v0__nand2_1
Xgf180mcu_fd_sc_mcu7t5v0__nand2_1_644 vdd vss gf180mcu_fd_sc_mcu7t5v0__nand2_1_644/ZN
+ gf180mcu_fd_sc_mcu7t5v0__dffq_2_91/Q gf180mcu_fd_sc_mcu7t5v0__or2_4_4/Z vdd vss
+ gf180mcu_fd_sc_mcu7t5v0__nand2_1
Xgf180mcu_fd_sc_mcu7t5v0__nand2_1_655 vdd vss gf180mcu_fd_sc_mcu7t5v0__nand3_1_95/A1
+ gf180mcu_fd_sc_mcu7t5v0__inv_8_0/I gf180mcu_fd_sc_mcu7t5v0__xor2_1_211/Z vdd vss
+ gf180mcu_fd_sc_mcu7t5v0__nand2_1
Xgf180mcu_fd_sc_mcu7t5v0__nand2_1_666 vdd vss gf180mcu_fd_sc_mcu7t5v0__xnor3_1_43/A1
+ gf180mcu_fd_sc_mcu7t5v0__inv_8_1/I gf180mcu_fd_sc_mcu7t5v0__and4_1_3/A4 vdd vss
+ gf180mcu_fd_sc_mcu7t5v0__nand2_1
Xgf180mcu_fd_sc_mcu7t5v0__nand2_1_677 vdd vss gf180mcu_fd_sc_mcu7t5v0__xor3_1_153/A1
+ gf180mcu_fd_sc_mcu7t5v0__aoi21_2_23/A1 gf180mcu_fd_sc_mcu7t5v0__and2_1_151/Z vdd
+ vss gf180mcu_fd_sc_mcu7t5v0__nand2_1
Xgf180mcu_fd_sc_mcu7t5v0__nand2_1_688 vdd vss gf180mcu_fd_sc_mcu7t5v0__xor3_1_160/A2
+ gf180mcu_fd_sc_mcu7t5v0__inv_12_1/I gf180mcu_fd_sc_mcu7t5v0__xor2_1_209/A2 vdd vss
+ gf180mcu_fd_sc_mcu7t5v0__nand2_1
Xgf180mcu_fd_sc_mcu7t5v0__nand2_1_699 vdd vss gf180mcu_fd_sc_mcu7t5v0__xor3_1_148/A2
+ gf180mcu_fd_sc_mcu7t5v0__nor3_2_13/ZN gf180mcu_fd_sc_mcu7t5v0__xor3_1_153/Z vdd
+ vss gf180mcu_fd_sc_mcu7t5v0__nand2_1
Xgf180mcu_fd_sc_mcu7t5v0__nand4_1_10 gf180mcu_fd_sc_mcu7t5v0__inv_1_14/ZN gf180mcu_fd_sc_mcu7t5v0__nor2_2_49/A2
+ vdd vss gf180mcu_fd_sc_mcu7t5v0__nand4_1_10/ZN gf180mcu_fd_sc_mcu7t5v0__inv_1_13/I
+ gf180mcu_fd_sc_mcu7t5v0__xor3_1_74/A2 vdd vss gf180mcu_fd_sc_mcu7t5v0__nand4_1
Xgf180mcu_fd_sc_mcu7t5v0__nand4_1_21 gf180mcu_fd_sc_mcu7t5v0__nand4_1_21/A3 gf180mcu_fd_sc_mcu7t5v0__nand4_1_21/A4
+ vdd vss gf180mcu_fd_sc_mcu7t5v0__oai21_1_331/B gf180mcu_fd_sc_mcu7t5v0__oai211_1_43/C
+ gf180mcu_fd_sc_mcu7t5v0__nand4_1_21/A2 vdd vss gf180mcu_fd_sc_mcu7t5v0__nand4_1
Xgf180mcu_fd_sc_mcu7t5v0__dffq_1_17 vdd gf180mcu_fd_sc_mcu7t5v0__dffq_1_17/Q gf180mcu_fd_sc_mcu7t5v0__dffq_1_99/CLK
+ vss gf180mcu_fd_sc_mcu7t5v0__dffq_1_17/D vdd vss gf180mcu_fd_sc_mcu7t5v0__dffq_1
Xgf180mcu_fd_sc_mcu7t5v0__dffq_1_28 vdd gf180mcu_fd_sc_mcu7t5v0__dffq_1_28/Q gf180mcu_fd_sc_mcu7t5v0__dffq_1_99/CLK
+ vss gf180mcu_fd_sc_mcu7t5v0__dffq_1_28/D vdd vss gf180mcu_fd_sc_mcu7t5v0__dffq_1
Xgf180mcu_fd_sc_mcu7t5v0__dffq_1_39 vdd gf180mcu_fd_sc_mcu7t5v0__dffq_1_39/Q gf180mcu_fd_sc_mcu7t5v0__dffq_4_8/CLK
+ vss gf180mcu_fd_sc_mcu7t5v0__dffq_1_39/D vdd vss gf180mcu_fd_sc_mcu7t5v0__dffq_1
Xgf180mcu_fd_sc_mcu7t5v0__inv_1_11 vss gf180mcu_fd_sc_mcu7t5v0__inv_1_11/ZN gf180mcu_fd_sc_mcu7t5v0__inv_1_11/I
+ vdd vdd vss gf180mcu_fd_sc_mcu7t5v0__inv_1
Xgf180mcu_fd_sc_mcu7t5v0__inv_1_22 vss gf180mcu_fd_sc_mcu7t5v0__inv_1_22/ZN gf180mcu_fd_sc_mcu7t5v0__inv_1_22/I
+ vdd vdd vss gf180mcu_fd_sc_mcu7t5v0__inv_1
Xgf180mcu_fd_sc_mcu7t5v0__aoi21_1_130 gf180mcu_fd_sc_mcu7t5v0__aoi21_1_130/B vdd vss
+ gf180mcu_fd_sc_mcu7t5v0__dffq_1_316/D gf180mcu_fd_sc_mcu7t5v0__dffq_4_20/Q gf180mcu_fd_sc_mcu7t5v0__and3_1_13/A3
+ vdd vss gf180mcu_fd_sc_mcu7t5v0__aoi21_1
Xgf180mcu_fd_sc_mcu7t5v0__aoi21_1_141 gf180mcu_fd_sc_mcu7t5v0__aoi21_1_141/B vdd vss
+ gf180mcu_fd_sc_mcu7t5v0__dffq_2_109/D gf180mcu_fd_sc_mcu7t5v0__or2_1_34/A2 gf180mcu_fd_sc_mcu7t5v0__oai21_1_124/ZN
+ vdd vss gf180mcu_fd_sc_mcu7t5v0__aoi21_1
Xgf180mcu_fd_sc_mcu7t5v0__aoi21_1_152 gf180mcu_fd_sc_mcu7t5v0__aoi21_1_152/B vdd vss
+ gf180mcu_fd_sc_mcu7t5v0__dffq_1_330/D gf180mcu_fd_sc_mcu7t5v0__aoi22_4_8/ZN gf180mcu_fd_sc_mcu7t5v0__aoi21_1_152/A2
+ vdd vss gf180mcu_fd_sc_mcu7t5v0__aoi21_1
Xgf180mcu_fd_sc_mcu7t5v0__aoi21_1_163 gf180mcu_fd_sc_mcu7t5v0__nand4_2_5/A3 vdd vss
+ gf180mcu_fd_sc_mcu7t5v0__nor3_1_12/A3 gf180mcu_fd_sc_mcu7t5v0__nor4_4_3/A1 gf180mcu_fd_sc_mcu7t5v0__xor2_1_91/A2
+ vdd vss gf180mcu_fd_sc_mcu7t5v0__aoi21_1
Xgf180mcu_fd_sc_mcu7t5v0__and2_1_130 vdd vss gf180mcu_fd_sc_mcu7t5v0__or3_1_22/A1
+ gf180mcu_fd_sc_mcu7t5v0__inv_8_2/I gf180mcu_fd_sc_mcu7t5v0__xor2_1_181/Z vdd vss
+ gf180mcu_fd_sc_mcu7t5v0__and2_1
Xgf180mcu_fd_sc_mcu7t5v0__aoi21_1_174 gf180mcu_fd_sc_mcu7t5v0__dffq_1_380/Q vdd vss
+ gf180mcu_fd_sc_mcu7t5v0__nor3_1_21/A2 gf180mcu_fd_sc_mcu7t5v0__dffq_1_358/Q gf180mcu_fd_sc_mcu7t5v0__and4_2_0/A1
+ vdd vss gf180mcu_fd_sc_mcu7t5v0__aoi21_1
Xgf180mcu_fd_sc_mcu7t5v0__and2_1_141 vdd vss gf180mcu_fd_sc_mcu7t5v0__and2_1_141/Z
+ gf180mcu_fd_sc_mcu7t5v0__inv_12_1/I gf180mcu_fd_sc_mcu7t5v0__and4_1_3/A3 vdd vss
+ gf180mcu_fd_sc_mcu7t5v0__and2_1
Xgf180mcu_fd_sc_mcu7t5v0__aoi21_1_185 gf180mcu_fd_sc_mcu7t5v0__aoi21_1_7/B vdd vss
+ gf180mcu_fd_sc_mcu7t5v0__dffq_4_16/D gf180mcu_fd_sc_mcu7t5v0__nand2_1_382/ZN gf180mcu_fd_sc_mcu7t5v0__oai31_1_12/ZN
+ vdd vss gf180mcu_fd_sc_mcu7t5v0__aoi21_1
Xgf180mcu_fd_sc_mcu7t5v0__aoi21_1_196 gf180mcu_fd_sc_mcu7t5v0__aoi21_1_196/B vdd vss
+ gf180mcu_fd_sc_mcu7t5v0__nor2_1_222/A2 gf180mcu_fd_sc_mcu7t5v0__mux4_4_3/I0 gf180mcu_fd_sc_mcu7t5v0__or2_4_4/Z
+ vdd vss gf180mcu_fd_sc_mcu7t5v0__aoi21_1
Xgf180mcu_fd_sc_mcu7t5v0__and2_1_152 vdd vss gf180mcu_fd_sc_mcu7t5v0__nor3_2_14/A2
+ gf180mcu_fd_sc_mcu7t5v0__oai32_1_3/B1 gf180mcu_fd_sc_mcu7t5v0__nor3_4_1/A3 vdd vss
+ gf180mcu_fd_sc_mcu7t5v0__and2_1
Xgf180mcu_fd_sc_mcu7t5v0__buf_8_7 gf180mcu_fd_sc_mcu7t5v0__buf_8_7/Z gf180mcu_fd_sc_mcu7t5v0__buf_8_8/Z
+ vdd vss vdd vss gf180mcu_fd_sc_mcu7t5v0__buf_8
Xgf180mcu_fd_sc_mcu7t5v0__oai22_1_106 gf180mcu_fd_sc_mcu7t5v0__nand2_4_14/ZN gf180mcu_fd_sc_mcu7t5v0__nand2_2_32/ZN
+ gf180mcu_fd_sc_mcu7t5v0__oai22_1_106/B2 vdd vss gf180mcu_fd_sc_mcu7t5v0__dffq_1_180/D
+ gf180mcu_fd_sc_mcu7t5v0__aoi21_4_5/ZN vdd vss gf180mcu_fd_sc_mcu7t5v0__oai22_1
Xgf180mcu_fd_sc_mcu7t5v0__oai22_1_117 gf180mcu_fd_sc_mcu7t5v0__oai22_1_99/A2 gf180mcu_fd_sc_mcu7t5v0__oai22_1_99/B1
+ gf180mcu_fd_sc_mcu7t5v0__oai22_1_117/B2 vdd vss gf180mcu_fd_sc_mcu7t5v0__dffq_1_106/D
+ gf180mcu_fd_sc_mcu7t5v0__aoi21_4_4/ZN vdd vss gf180mcu_fd_sc_mcu7t5v0__oai22_1
Xgf180mcu_fd_sc_mcu7t5v0__oai22_1_128 gf180mcu_fd_sc_mcu7t5v0__oai22_1_55/A2 gf180mcu_fd_sc_mcu7t5v0__oai22_1_55/B1
+ gf180mcu_fd_sc_mcu7t5v0__oai22_1_128/B2 vdd vss gf180mcu_fd_sc_mcu7t5v0__dffq_1_120/D
+ gf180mcu_fd_sc_mcu7t5v0__aoi21_4_3/ZN vdd vss gf180mcu_fd_sc_mcu7t5v0__oai22_1
Xgf180mcu_fd_sc_mcu7t5v0__oai22_1_139 gf180mcu_fd_sc_mcu7t5v0__nand2_4_18/ZN gf180mcu_fd_sc_mcu7t5v0__nand2_2_25/ZN
+ gf180mcu_fd_sc_mcu7t5v0__oai22_1_139/B2 vdd vss gf180mcu_fd_sc_mcu7t5v0__dffq_1_127/D
+ gf180mcu_fd_sc_mcu7t5v0__aoi21_4_4/ZN vdd vss gf180mcu_fd_sc_mcu7t5v0__oai22_1
Xgf180mcu_fd_sc_mcu7t5v0__nor4_4_0 gf180mcu_fd_sc_mcu7t5v0__or2_4_2/Z gf180mcu_fd_sc_mcu7t5v0__or3_1_10/A3
+ vdd vss gf180mcu_fd_sc_mcu7t5v0__nor4_4_0/ZN gf180mcu_fd_sc_mcu7t5v0__nor4_4_0/A1
+ gf180mcu_fd_sc_mcu7t5v0__inv_2_7/ZN vdd vss gf180mcu_fd_sc_mcu7t5v0__nor4_4
Xgf180mcu_fd_sc_mcu7t5v0__nor2_1_15 vdd vss gf180mcu_fd_sc_mcu7t5v0__dffq_2_4/D gf180mcu_fd_sc_mcu7t5v0__aoi21_1_7/B
+ gf180mcu_fd_sc_mcu7t5v0__nor2_1_15/A2 vdd vss gf180mcu_fd_sc_mcu7t5v0__nor2_1
Xgf180mcu_fd_sc_mcu7t5v0__nor2_1_26 vdd vss gf180mcu_fd_sc_mcu7t5v0__nor2_1_26/ZN
+ gf180mcu_fd_sc_mcu7t5v0__or2_4_4/Z gf180mcu_fd_sc_mcu7t5v0__nor2_1_26/A2 vdd vss
+ gf180mcu_fd_sc_mcu7t5v0__nor2_1
Xgf180mcu_fd_sc_mcu7t5v0__nor2_1_37 vdd vss gf180mcu_fd_sc_mcu7t5v0__nor2_1_37/ZN
+ gf180mcu_fd_sc_mcu7t5v0__mux2_1_1/S gf180mcu_fd_sc_mcu7t5v0__nor3_1_6/A3 vdd vss
+ gf180mcu_fd_sc_mcu7t5v0__nor2_1
Xgf180mcu_fd_sc_mcu7t5v0__nor2_1_48 vdd vss gf180mcu_fd_sc_mcu7t5v0__nor2_1_48/ZN
+ gf180mcu_fd_sc_mcu7t5v0__dffq_1_4/Q gf180mcu_fd_sc_mcu7t5v0__nor2_4_16/ZN vdd vss
+ gf180mcu_fd_sc_mcu7t5v0__nor2_1
Xgf180mcu_fd_sc_mcu7t5v0__nor2_1_59 vdd vss gf180mcu_fd_sc_mcu7t5v0__nor2_1_59/ZN
+ gf180mcu_fd_sc_mcu7t5v0__or2_1_13/Z gf180mcu_fd_sc_mcu7t5v0__xor2_1_35/Z vdd vss
+ gf180mcu_fd_sc_mcu7t5v0__nor2_1
Xgf180mcu_fd_sc_mcu7t5v0__nor2_1_204 vdd vss gf180mcu_fd_sc_mcu7t5v0__dffq_1_407/D
+ gf180mcu_fd_sc_mcu7t5v0__or2_1_23/A1 gf180mcu_fd_sc_mcu7t5v0__nor4_1_3/ZN vdd vss
+ gf180mcu_fd_sc_mcu7t5v0__nor2_1
Xgf180mcu_fd_sc_mcu7t5v0__nor2_1_215 vdd vss gf180mcu_fd_sc_mcu7t5v0__xor2_1_98/A1
+ gf180mcu_fd_sc_mcu7t5v0__and2_1_81/Z gf180mcu_fd_sc_mcu7t5v0__nor2_1_215/A2 vdd
+ vss gf180mcu_fd_sc_mcu7t5v0__nor2_1
Xgf180mcu_fd_sc_mcu7t5v0__nor2_1_226 vdd vss gf180mcu_fd_sc_mcu7t5v0__nor2_1_226/ZN
+ gf180mcu_fd_sc_mcu7t5v0__or2_4_3/Z gf180mcu_fd_sc_mcu7t5v0__nor2_1_226/A2 vdd vss
+ gf180mcu_fd_sc_mcu7t5v0__nor2_1
Xgf180mcu_fd_sc_mcu7t5v0__aoi21_1_0 gf180mcu_fd_sc_mcu7t5v0__aoi21_1_0/B vdd vss gf180mcu_fd_sc_mcu7t5v0__or2_1_3/A2
+ gf180mcu_fd_sc_mcu7t5v0__xor3_2_0/A2 gf180mcu_fd_sc_mcu7t5v0__xor2_1_3/Z vdd vss
+ gf180mcu_fd_sc_mcu7t5v0__aoi21_1
Xgf180mcu_fd_sc_mcu7t5v0__nor2_1_237 vdd vss gf180mcu_fd_sc_mcu7t5v0__and2_1_79/A2
+ gf180mcu_fd_sc_mcu7t5v0__dffq_2_42/Q gf180mcu_fd_sc_mcu7t5v0__inv_1_7/I vdd vss
+ gf180mcu_fd_sc_mcu7t5v0__nor2_1
Xgf180mcu_fd_sc_mcu7t5v0__nor2_1_248 vdd vss gf180mcu_fd_sc_mcu7t5v0__nor2_1_248/ZN
+ gf180mcu_fd_sc_mcu7t5v0__xor2_1_112/A1 gf180mcu_fd_sc_mcu7t5v0__xor2_1_116/Z vdd
+ vss gf180mcu_fd_sc_mcu7t5v0__nor2_1
Xgf180mcu_fd_sc_mcu7t5v0__nor2_1_259 vdd vss gf180mcu_fd_sc_mcu7t5v0__oai221_1_9/B2
+ gf180mcu_fd_sc_mcu7t5v0__or4_1_0/A1 gf180mcu_fd_sc_mcu7t5v0__mux4_4_8/Z vdd vss
+ gf180mcu_fd_sc_mcu7t5v0__nor2_1
Xgf180mcu_fd_sc_mcu7t5v0__nand2_1_430 vdd vss gf180mcu_fd_sc_mcu7t5v0__xor2_1_113/A1
+ gf180mcu_fd_sc_mcu7t5v0__dffq_4_37/Q gf180mcu_fd_sc_mcu7t5v0__mux4_4_9/Z vdd vss
+ gf180mcu_fd_sc_mcu7t5v0__nand2_1
Xgf180mcu_fd_sc_mcu7t5v0__nand2_1_441 vdd vss gf180mcu_fd_sc_mcu7t5v0__nand2_1_441/ZN
+ gf180mcu_fd_sc_mcu7t5v0__dffq_4_37/Q gf180mcu_fd_sc_mcu7t5v0__mux4_4_6/Z vdd vss
+ gf180mcu_fd_sc_mcu7t5v0__nand2_1
Xgf180mcu_fd_sc_mcu7t5v0__nand2_1_452 vdd vss gf180mcu_fd_sc_mcu7t5v0__nand3_1_66/A1
+ gf180mcu_fd_sc_mcu7t5v0__or4_1_0/A1 gf180mcu_fd_sc_mcu7t5v0__xor2_1_120/A2 vdd vss
+ gf180mcu_fd_sc_mcu7t5v0__nand2_1
Xgf180mcu_fd_sc_mcu7t5v0__nand2_1_463 vdd vss gf180mcu_fd_sc_mcu7t5v0__oai21_1_214/A2
+ gf180mcu_fd_sc_mcu7t5v0__inv_4_6/I gf180mcu_fd_sc_mcu7t5v0__nor2_2_30/ZN vdd vss
+ gf180mcu_fd_sc_mcu7t5v0__nand2_1
Xgf180mcu_fd_sc_mcu7t5v0__nand2_1_474 vdd vss gf180mcu_fd_sc_mcu7t5v0__nand4_1_14/A2
+ gf180mcu_fd_sc_mcu7t5v0__nor2_2_33/ZN gf180mcu_fd_sc_mcu7t5v0__xnor2_1_45/ZN vdd
+ vss gf180mcu_fd_sc_mcu7t5v0__nand2_1
Xgf180mcu_fd_sc_mcu7t5v0__nand2_1_485 vdd vss gf180mcu_fd_sc_mcu7t5v0__nand2_1_485/ZN
+ gf180mcu_fd_sc_mcu7t5v0__or4_1_0/A1 gf180mcu_fd_sc_mcu7t5v0__xor2_1_133/Z vdd vss
+ gf180mcu_fd_sc_mcu7t5v0__nand2_1
Xgf180mcu_fd_sc_mcu7t5v0__nand2_1_496 vdd vss gf180mcu_fd_sc_mcu7t5v0__xnor3_1_28/A2
+ gf180mcu_fd_sc_mcu7t5v0__inv_8_1/I gf180mcu_fd_sc_mcu7t5v0__xnor2_1_47/A1 vdd vss
+ gf180mcu_fd_sc_mcu7t5v0__nand2_1
Xgf180mcu_fd_sc_mcu7t5v0__oai21_1_308 vdd gf180mcu_fd_sc_mcu7t5v0__nor2_2_52/ZN gf180mcu_fd_sc_mcu7t5v0__nor3_4_22/ZN
+ gf180mcu_fd_sc_mcu7t5v0__nand3_1_86/A3 gf180mcu_fd_sc_mcu7t5v0__or4_1_3/A2 vss vdd
+ vss gf180mcu_fd_sc_mcu7t5v0__oai21_1
Xgf180mcu_fd_sc_mcu7t5v0__oai21_1_319 vdd gf180mcu_fd_sc_mcu7t5v0__oai21_1_319/B gf180mcu_fd_sc_mcu7t5v0__oai21_1_319/A2
+ gf180mcu_fd_sc_mcu7t5v0__oai21_1_318/B gf180mcu_fd_sc_mcu7t5v0__nor2_1_389/A1 vss
+ vdd vss gf180mcu_fd_sc_mcu7t5v0__oai21_1
Xgf180mcu_fd_sc_mcu7t5v0__mux2_1_11 gf180mcu_fd_sc_mcu7t5v0__or2_1_43/Z vdd vss gf180mcu_fd_sc_mcu7t5v0__mux2_1_11/Z
+ gf180mcu_fd_sc_mcu7t5v0__or4_1_3/A2 gf180mcu_fd_sc_mcu7t5v0__nor3_4_21/ZN vdd vss
+ gf180mcu_fd_sc_mcu7t5v0__mux2_1
Xgf180mcu_fd_sc_mcu7t5v0__aoi22_1_17 gf180mcu_fd_sc_mcu7t5v0__nor2_4_11/ZN gf180mcu_fd_sc_mcu7t5v0__dffq_1_20/Q
+ vdd vss gf180mcu_fd_sc_mcu7t5v0__aoi22_1_17/ZN gf180mcu_fd_sc_mcu7t5v0__dffq_1_22/Q
+ gf180mcu_fd_sc_mcu7t5v0__nor2_4_10/ZN vdd vss gf180mcu_fd_sc_mcu7t5v0__aoi22_1
Xgf180mcu_fd_sc_mcu7t5v0__aoi22_1_28 gf180mcu_fd_sc_mcu7t5v0__nor2_4_9/ZN gf180mcu_fd_sc_mcu7t5v0__dffq_1_46/Q
+ vdd vss gf180mcu_fd_sc_mcu7t5v0__aoi22_1_28/ZN gf180mcu_fd_sc_mcu7t5v0__dffq_1_42/Q
+ gf180mcu_fd_sc_mcu7t5v0__nor2_4_8/ZN vdd vss gf180mcu_fd_sc_mcu7t5v0__aoi22_1
Xgf180mcu_fd_sc_mcu7t5v0__aoi22_1_39 gf180mcu_fd_sc_mcu7t5v0__nor2_4_11/ZN gf180mcu_fd_sc_mcu7t5v0__dffq_1_64/Q
+ vdd vss gf180mcu_fd_sc_mcu7t5v0__aoi22_1_39/ZN gf180mcu_fd_sc_mcu7t5v0__dffq_1_69/Q
+ gf180mcu_fd_sc_mcu7t5v0__nor2_4_10/ZN vdd vss gf180mcu_fd_sc_mcu7t5v0__aoi22_1
Xgf180mcu_fd_sc_mcu7t5v0__oai211_1_0 gf180mcu_fd_sc_mcu7t5v0__oai211_1_0/B gf180mcu_fd_sc_mcu7t5v0__or2_1_34/A2
+ vdd vss gf180mcu_fd_sc_mcu7t5v0__oai211_1_0/ZN gf180mcu_fd_sc_mcu7t5v0__nor3_1_9/A1
+ gf180mcu_fd_sc_mcu7t5v0__xor2_1_23/Z vdd vss gf180mcu_fd_sc_mcu7t5v0__oai211_1
Xgf180mcu_fd_sc_mcu7t5v0__mux2_1_0 gf180mcu_fd_sc_mcu7t5v0__mux2_1_0/S vdd vss gf180mcu_fd_sc_mcu7t5v0__mux2_1_0/Z
+ gf180mcu_fd_sc_mcu7t5v0__mux2_1_0/I0 gf180mcu_fd_sc_mcu7t5v0__inv_8_0/I vdd vss
+ gf180mcu_fd_sc_mcu7t5v0__mux2_1
Xgf180mcu_fd_sc_mcu7t5v0__xnor2_1_11 vdd vss gf180mcu_fd_sc_mcu7t5v0__xor2_1_61/A2
+ gf180mcu_fd_sc_mcu7t5v0__nor2_1_59/ZN gf180mcu_fd_sc_mcu7t5v0__xor3_1_30/Z vdd vss
+ gf180mcu_fd_sc_mcu7t5v0__xnor2_1
Xgf180mcu_fd_sc_mcu7t5v0__xnor2_1_22 vdd vss gf180mcu_fd_sc_mcu7t5v0__xor2_1_35/A2
+ gf180mcu_fd_sc_mcu7t5v0__nor2_1_57/A1 gf180mcu_fd_sc_mcu7t5v0__xor3_1_39/Z vdd vss
+ gf180mcu_fd_sc_mcu7t5v0__xnor2_1
Xgf180mcu_fd_sc_mcu7t5v0__xnor2_1_33 vdd vss gf180mcu_fd_sc_mcu7t5v0__xnor2_1_33/ZN
+ gf180mcu_fd_sc_mcu7t5v0__xnor3_1_21/A2 gf180mcu_fd_sc_mcu7t5v0__nor3_1_25/A3 vdd
+ vss gf180mcu_fd_sc_mcu7t5v0__xnor2_1
Xgf180mcu_fd_sc_mcu7t5v0__xnor2_1_44 vdd vss gf180mcu_fd_sc_mcu7t5v0__xor2_1_120/A2
+ gf180mcu_fd_sc_mcu7t5v0__mux4_4_8/Z gf180mcu_fd_sc_mcu7t5v0__xnor2_1_44/A2 vdd vss
+ gf180mcu_fd_sc_mcu7t5v0__xnor2_1
Xgf180mcu_fd_sc_mcu7t5v0__xnor2_1_55 vdd vss gf180mcu_fd_sc_mcu7t5v0__xor2_1_148/A2
+ gf180mcu_fd_sc_mcu7t5v0__xnor2_1_55/A1 gf180mcu_fd_sc_mcu7t5v0__xnor2_1_55/A2 vdd
+ vss gf180mcu_fd_sc_mcu7t5v0__xnor2_1
Xgf180mcu_fd_sc_mcu7t5v0__xnor2_1_66 vdd vss gf180mcu_fd_sc_mcu7t5v0__xor2_1_190/A2
+ gf180mcu_fd_sc_mcu7t5v0__xnor2_1_66/A1 gf180mcu_fd_sc_mcu7t5v0__xnor2_1_66/A2 vdd
+ vss gf180mcu_fd_sc_mcu7t5v0__xnor2_1
Xgf180mcu_fd_sc_mcu7t5v0__xnor2_1_77 vdd vss gf180mcu_fd_sc_mcu7t5v0__xor3_1_154/A3
+ gf180mcu_fd_sc_mcu7t5v0__xnor2_1_77/A1 gf180mcu_fd_sc_mcu7t5v0__nor3_2_13/A3 vdd
+ vss gf180mcu_fd_sc_mcu7t5v0__xnor2_1
Xgf180mcu_fd_sc_mcu7t5v0__xnor2_1_88 vdd vss gf180mcu_fd_sc_mcu7t5v0__xor2_1_229/A2
+ gf180mcu_fd_sc_mcu7t5v0__nor2_2_49/A2 gf180mcu_fd_sc_mcu7t5v0__xnor2_1_88/A2 vdd
+ vss gf180mcu_fd_sc_mcu7t5v0__xnor2_1
Xgf180mcu_fd_sc_mcu7t5v0__nor3_2_14 gf180mcu_fd_sc_mcu7t5v0__nor3_2_14/A3 vdd vss
+ gf180mcu_fd_sc_mcu7t5v0__xor2_1_4/A1 gf180mcu_fd_sc_mcu7t5v0__xor3_2_0/A1 gf180mcu_fd_sc_mcu7t5v0__nor3_2_14/A2
+ vdd vss gf180mcu_fd_sc_mcu7t5v0__nor3_2
Xgf180mcu_fd_sc_mcu7t5v0__and3_1_1 gf180mcu_fd_sc_mcu7t5v0__and3_1_1/A3 vdd vss gf180mcu_fd_sc_mcu7t5v0__and3_1_1/Z
+ gf180mcu_fd_sc_mcu7t5v0__inv_8_2/I gf180mcu_fd_sc_mcu7t5v0__or3_2_1/Z vdd vss gf180mcu_fd_sc_mcu7t5v0__and3_1
Xgf180mcu_fd_sc_mcu7t5v0__dffq_2_60 gf180mcu_fd_sc_mcu7t5v0__dffq_2_60/D vdd vss gf180mcu_fd_sc_mcu7t5v0__dffq_4_1/CLK
+ gf180mcu_fd_sc_mcu7t5v0__inv_1_3/I vdd vss gf180mcu_fd_sc_mcu7t5v0__dffq_2
Xgf180mcu_fd_sc_mcu7t5v0__dffq_2_71 gf180mcu_fd_sc_mcu7t5v0__dffq_2_71/D vdd vss gf180mcu_fd_sc_mcu7t5v0__dffq_4_9/CLK
+ gf180mcu_fd_sc_mcu7t5v0__mux4_4_2/I3 vdd vss gf180mcu_fd_sc_mcu7t5v0__dffq_2
Xgf180mcu_fd_sc_mcu7t5v0__dffq_2_82 gf180mcu_fd_sc_mcu7t5v0__dffq_2_82/D vdd vss gf180mcu_fd_sc_mcu7t5v0__dffq_4_44/CLK
+ gf180mcu_fd_sc_mcu7t5v0__or2_1_42/A1 vdd vss gf180mcu_fd_sc_mcu7t5v0__dffq_2
Xgf180mcu_fd_sc_mcu7t5v0__dffq_2_93 gf180mcu_fd_sc_mcu7t5v0__dffq_2_93/D vdd vss gf180mcu_fd_sc_mcu7t5v0__dffq_4_44/CLK
+ gf180mcu_fd_sc_mcu7t5v0__dffq_2_93/Q vdd vss gf180mcu_fd_sc_mcu7t5v0__dffq_2
Xgf180mcu_fd_sc_mcu7t5v0__oai21_1_3 vdd gf180mcu_fd_sc_mcu7t5v0__oai21_1_3/B gf180mcu_fd_sc_mcu7t5v0__oai21_1_3/A2
+ gf180mcu_fd_sc_mcu7t5v0__xor3_1_9/A2 gf180mcu_fd_sc_mcu7t5v0__and2_1_5/Z vss vdd
+ vss gf180mcu_fd_sc_mcu7t5v0__oai21_1
Xgf180mcu_fd_sc_mcu7t5v0__aoi211_4_1 gf180mcu_fd_sc_mcu7t5v0__aoi21_4_7/A2 gf180mcu_fd_sc_mcu7t5v0__aoi21_4_7/B
+ gf180mcu_fd_sc_mcu7t5v0__or3_1_24/A1 vdd vss gf180mcu_fd_sc_mcu7t5v0__xor3_1_100/A1
+ gf180mcu_fd_sc_mcu7t5v0__aoi21_4_7/A1 vdd vss gf180mcu_fd_sc_mcu7t5v0__aoi211_4
Xgf180mcu_fd_sc_mcu7t5v0__nand2_1_260 vdd vss gf180mcu_fd_sc_mcu7t5v0__oai21_1_79/A2
+ gf180mcu_fd_sc_mcu7t5v0__inv_8_2/I gf180mcu_fd_sc_mcu7t5v0__and2_2_3/Z vdd vss gf180mcu_fd_sc_mcu7t5v0__nand2_1
Xgf180mcu_fd_sc_mcu7t5v0__nand2_1_271 vdd vss gf180mcu_fd_sc_mcu7t5v0__aoi222_1_6/A2
+ gf180mcu_fd_sc_mcu7t5v0__nand2_1_271/A1 gf180mcu_fd_sc_mcu7t5v0__nand2_1_271/A2
+ vdd vss gf180mcu_fd_sc_mcu7t5v0__nand2_1
Xgf180mcu_fd_sc_mcu7t5v0__nand2_1_282 vdd vss gf180mcu_fd_sc_mcu7t5v0__xor3_1_171/A3
+ gf180mcu_fd_sc_mcu7t5v0__inv_8_2/I gf180mcu_fd_sc_mcu7t5v0__inv_1_5/I vdd vss gf180mcu_fd_sc_mcu7t5v0__nand2_1
Xgf180mcu_fd_sc_mcu7t5v0__nand2_1_293 vdd vss gf180mcu_fd_sc_mcu7t5v0__aoi222_1_3/A2
+ gf180mcu_fd_sc_mcu7t5v0__nand2_1_293/A1 gf180mcu_fd_sc_mcu7t5v0__nand2_1_293/A2
+ vdd vss gf180mcu_fd_sc_mcu7t5v0__nand2_1
Xgf180mcu_fd_sc_mcu7t5v0__mux4_4_9 gf180mcu_fd_sc_mcu7t5v0__or2_1_42/A1 vss vdd gf180mcu_fd_sc_mcu7t5v0__or3_2_1/A1
+ gf180mcu_fd_sc_mcu7t5v0__inv_2_11/I gf180mcu_fd_sc_mcu7t5v0__mux4_4_9/S0 gf180mcu_fd_sc_mcu7t5v0__mux4_4_9/I3
+ gf180mcu_fd_sc_mcu7t5v0__inv_1_16/I gf180mcu_fd_sc_mcu7t5v0__mux4_4_9/Z vdd vss
+ gf180mcu_fd_sc_mcu7t5v0__mux4_4
Xgf180mcu_fd_sc_mcu7t5v0__aoi21_1_50 gf180mcu_fd_sc_mcu7t5v0__nor2_1_60/ZN vdd vss
+ gf180mcu_fd_sc_mcu7t5v0__or2_1_13/A1 gf180mcu_fd_sc_mcu7t5v0__and2_1_17/Z gf180mcu_fd_sc_mcu7t5v0__aoi21_1_50/A2
+ vdd vss gf180mcu_fd_sc_mcu7t5v0__aoi21_1
Xgf180mcu_fd_sc_mcu7t5v0__aoi21_1_61 gf180mcu_fd_sc_mcu7t5v0__or4_1_0/A2 vdd vss gf180mcu_fd_sc_mcu7t5v0__xor2_1_48/A1
+ gf180mcu_fd_sc_mcu7t5v0__nand3_2_17/ZN gf180mcu_fd_sc_mcu7t5v0__aoi22_2_4/ZN vdd
+ vss gf180mcu_fd_sc_mcu7t5v0__aoi21_1
Xgf180mcu_fd_sc_mcu7t5v0__aoi21_1_72 gf180mcu_fd_sc_mcu7t5v0__xor2_1_47/Z vdd vss
+ gf180mcu_fd_sc_mcu7t5v0__nor2_1_79/A2 gf180mcu_fd_sc_mcu7t5v0__inv_1_15/I gf180mcu_fd_sc_mcu7t5v0__and2_2_12/Z
+ vdd vss gf180mcu_fd_sc_mcu7t5v0__aoi21_1
Xgf180mcu_fd_sc_mcu7t5v0__aoi21_1_83 gf180mcu_fd_sc_mcu7t5v0__aoi21_1_7/B vdd vss
+ gf180mcu_fd_sc_mcu7t5v0__dffq_2_21/D gf180mcu_fd_sc_mcu7t5v0__aoi21_1_83/A1 gf180mcu_fd_sc_mcu7t5v0__aoi21_1_83/A2
+ vdd vss gf180mcu_fd_sc_mcu7t5v0__aoi21_1
Xgf180mcu_fd_sc_mcu7t5v0__aoi21_1_94 gf180mcu_fd_sc_mcu7t5v0__and2_1_38/Z vdd vss
+ gf180mcu_fd_sc_mcu7t5v0__aoi21_1_20/B gf180mcu_fd_sc_mcu7t5v0__xor2_1_68/A1 gf180mcu_fd_sc_mcu7t5v0__nor4_2_3/ZN
+ vdd vss gf180mcu_fd_sc_mcu7t5v0__aoi21_1
Xgf180mcu_fd_sc_mcu7t5v0__oai21_1_105 vdd gf180mcu_fd_sc_mcu7t5v0__buf_8_6/Z gf180mcu_fd_sc_mcu7t5v0__nor3_4_14/ZN
+ gf180mcu_fd_sc_mcu7t5v0__aoi21_1_124/B gf180mcu_fd_sc_mcu7t5v0__dffq_1_297/Q vss
+ vdd vss gf180mcu_fd_sc_mcu7t5v0__oai21_1
Xgf180mcu_fd_sc_mcu7t5v0__oai21_1_116 vdd gf180mcu_fd_sc_mcu7t5v0__buf_8_4/Z gf180mcu_fd_sc_mcu7t5v0__buf_20_0/I
+ gf180mcu_fd_sc_mcu7t5v0__aoi21_1_135/B gf180mcu_fd_sc_mcu7t5v0__mux4_4_5/I3 vss
+ vdd vss gf180mcu_fd_sc_mcu7t5v0__oai21_1
Xgf180mcu_fd_sc_mcu7t5v0__oai21_1_127 vdd gf180mcu_fd_sc_mcu7t5v0__oai32_1_5/B1 gf180mcu_fd_sc_mcu7t5v0__oai32_4_0/ZN
+ gf180mcu_fd_sc_mcu7t5v0__oai21_1_127/ZN gf180mcu_fd_sc_mcu7t5v0__oai32_1_4/B2 vss
+ vdd vss gf180mcu_fd_sc_mcu7t5v0__oai21_1
Xgf180mcu_fd_sc_mcu7t5v0__oai21_1_138 vdd gf180mcu_fd_sc_mcu7t5v0__buf_8_8/Z gf180mcu_fd_sc_mcu7t5v0__nand3_1_55/A2
+ gf180mcu_fd_sc_mcu7t5v0__aoi21_1_148/B gf180mcu_fd_sc_mcu7t5v0__dffq_1_326/Q vss
+ vdd vss gf180mcu_fd_sc_mcu7t5v0__oai21_1
Xgf180mcu_fd_sc_mcu7t5v0__oai21_1_149 vdd gf180mcu_fd_sc_mcu7t5v0__oai21_1_157/B gf180mcu_fd_sc_mcu7t5v0__and2_1_55/Z
+ gf180mcu_fd_sc_mcu7t5v0__nor2_1_184/A2 gf180mcu_fd_sc_mcu7t5v0__nor4_1_1/A2 vss
+ vdd vss gf180mcu_fd_sc_mcu7t5v0__oai21_1
Xgf180mcu_fd_sc_mcu7t5v0__dffq_1_390 vdd gf180mcu_fd_sc_mcu7t5v0__nor3_1_24/A1 gf180mcu_fd_sc_mcu7t5v0__dffq_4_21/CLK
+ vss gf180mcu_fd_sc_mcu7t5v0__dffq_1_390/D vdd vss gf180mcu_fd_sc_mcu7t5v0__dffq_1
Xgf180mcu_fd_sc_mcu7t5v0__oai31_4_1 gf180mcu_fd_sc_mcu7t5v0__or3_2_3/A2 gf180mcu_fd_sc_mcu7t5v0__oai31_4_1/B
+ vdd vss gf180mcu_fd_sc_mcu7t5v0__oai31_4_1/ZN gf180mcu_fd_sc_mcu7t5v0__oai31_4_1/A1
+ gf180mcu_fd_sc_mcu7t5v0__inv_1_6/ZN vdd vss gf180mcu_fd_sc_mcu7t5v0__oai31_4
Xgf180mcu_fd_sc_mcu7t5v0__oai22_1_80 gf180mcu_fd_sc_mcu7t5v0__nand2_4_7/ZN gf180mcu_fd_sc_mcu7t5v0__oai22_1_94/B1
+ gf180mcu_fd_sc_mcu7t5v0__oai22_1_80/B2 vdd vss gf180mcu_fd_sc_mcu7t5v0__dffq_1_92/D
+ gf180mcu_fd_sc_mcu7t5v0__aoi21_4_4/ZN vdd vss gf180mcu_fd_sc_mcu7t5v0__oai22_1
Xgf180mcu_fd_sc_mcu7t5v0__oai22_1_91 gf180mcu_fd_sc_mcu7t5v0__nand2_4_9/ZN gf180mcu_fd_sc_mcu7t5v0__oai22_1_95/B1
+ gf180mcu_fd_sc_mcu7t5v0__oai22_1_91/B2 vdd vss gf180mcu_fd_sc_mcu7t5v0__dffq_1_89/D
+ gf180mcu_fd_sc_mcu7t5v0__aoi21_4_2/ZN vdd vss gf180mcu_fd_sc_mcu7t5v0__oai22_1
Xgf180mcu_fd_sc_mcu7t5v0__nand2_2_12 vdd vss gf180mcu_fd_sc_mcu7t5v0__oai22_1_29/B1
+ gf180mcu_fd_sc_mcu7t5v0__buf_8_2/Z gf180mcu_fd_sc_mcu7t5v0__nand2_4_2/ZN vdd vss
+ gf180mcu_fd_sc_mcu7t5v0__nand2_2
Xgf180mcu_fd_sc_mcu7t5v0__nand2_2_23 vdd vss gf180mcu_fd_sc_mcu7t5v0__nand2_2_23/ZN
+ rst_n gf180mcu_fd_sc_mcu7t5v0__nand2_4_17/ZN vdd vss gf180mcu_fd_sc_mcu7t5v0__nand2_2
Xgf180mcu_fd_sc_mcu7t5v0__nand2_2_34 vdd vss gf180mcu_fd_sc_mcu7t5v0__oai31_1_5/B
+ gf180mcu_fd_sc_mcu7t5v0__dffq_4_7/Q gf180mcu_fd_sc_mcu7t5v0__and2_1_38/A2 vdd vss
+ gf180mcu_fd_sc_mcu7t5v0__nand2_2
Xgf180mcu_fd_sc_mcu7t5v0__nand2_2_45 vdd vss gf180mcu_fd_sc_mcu7t5v0__oai22_1_90/B1
+ gf180mcu_fd_sc_mcu7t5v0__buf_8_2/Z gf180mcu_fd_sc_mcu7t5v0__oai22_1_90/A2 vdd vss
+ gf180mcu_fd_sc_mcu7t5v0__nand2_2
Xgf180mcu_fd_sc_mcu7t5v0__nand2_2_56 vdd vss gf180mcu_fd_sc_mcu7t5v0__and3_2_3/A3
+ gf180mcu_fd_sc_mcu7t5v0__dffq_2_98/Q gf180mcu_fd_sc_mcu7t5v0__nor2_2_29/A1 vdd vss
+ gf180mcu_fd_sc_mcu7t5v0__nand2_2
Xgf180mcu_fd_sc_mcu7t5v0__nand2_2_67 vdd vss gf180mcu_fd_sc_mcu7t5v0__nor2_4_38/A2
+ gf180mcu_fd_sc_mcu7t5v0__nor3_4_18/A2 gf180mcu_fd_sc_mcu7t5v0__inv_2_12/ZN vdd vss
+ gf180mcu_fd_sc_mcu7t5v0__nand2_2
Xgf180mcu_fd_sc_mcu7t5v0__nand2_2_78 vdd vss gf180mcu_fd_sc_mcu7t5v0__xor3_1_147/A1
+ gf180mcu_fd_sc_mcu7t5v0__inv_8_0/I gf180mcu_fd_sc_mcu7t5v0__xor3_1_162/A2 vdd vss
+ gf180mcu_fd_sc_mcu7t5v0__nand2_2
Xgf180mcu_fd_sc_mcu7t5v0__xor2_1_204 vdd vss gf180mcu_fd_sc_mcu7t5v0__xor2_1_204/Z
+ gf180mcu_fd_sc_mcu7t5v0__xor3_1_153/A1 gf180mcu_fd_sc_mcu7t5v0__xor3_1_153/A3 vdd
+ vss gf180mcu_fd_sc_mcu7t5v0__xor2_1
Xgf180mcu_fd_sc_mcu7t5v0__xor2_1_215 vdd vss gf180mcu_fd_sc_mcu7t5v0__and3_1_2/A3
+ gf180mcu_fd_sc_mcu7t5v0__oai22_4_0/A2 gf180mcu_fd_sc_mcu7t5v0__nor2_1_34/A2 vdd
+ vss gf180mcu_fd_sc_mcu7t5v0__xor2_1
Xgf180mcu_fd_sc_mcu7t5v0__xor2_1_226 vdd vss gf180mcu_fd_sc_mcu7t5v0__xor2_1_226/Z
+ gf180mcu_fd_sc_mcu7t5v0__mux4_4_16/Z gf180mcu_fd_sc_mcu7t5v0__xor2_1_226/A2 vdd
+ vss gf180mcu_fd_sc_mcu7t5v0__xor2_1
Xgf180mcu_fd_sc_mcu7t5v0__clkinv_1_240 vdd vss gf180mcu_fd_sc_mcu7t5v0__dffq_1_211/Q
+ gf180mcu_fd_sc_mcu7t5v0__oai22_1_222/B2 vdd vss gf180mcu_fd_sc_mcu7t5v0__clkinv_1
Xgf180mcu_fd_sc_mcu7t5v0__clkinv_1_251 vdd vss gf180mcu_fd_sc_mcu7t5v0__dffq_1_231/Q
+ gf180mcu_fd_sc_mcu7t5v0__oai22_1_232/B2 vdd vss gf180mcu_fd_sc_mcu7t5v0__clkinv_1
Xgf180mcu_fd_sc_mcu7t5v0__clkinv_1_262 vdd vss gf180mcu_fd_sc_mcu7t5v0__dffq_1_240/Q
+ gf180mcu_fd_sc_mcu7t5v0__oai22_1_248/B2 vdd vss gf180mcu_fd_sc_mcu7t5v0__clkinv_1
Xgf180mcu_fd_sc_mcu7t5v0__clkinv_1_273 vdd vss gf180mcu_fd_sc_mcu7t5v0__dffq_1_39/Q
+ gf180mcu_fd_sc_mcu7t5v0__oai22_1_42/B2 vdd vss gf180mcu_fd_sc_mcu7t5v0__clkinv_1
Xgf180mcu_fd_sc_mcu7t5v0__clkinv_1_284 vdd vss gf180mcu_fd_sc_mcu7t5v0__mux4_4_1/I0
+ gf180mcu_fd_sc_mcu7t5v0__nor2_1_161/A1 vdd vss gf180mcu_fd_sc_mcu7t5v0__clkinv_1
Xgf180mcu_fd_sc_mcu7t5v0__clkinv_1_295 vdd vss gf180mcu_fd_sc_mcu7t5v0__dffq_1_323/Q
+ gf180mcu_fd_sc_mcu7t5v0__oai22_1_288/B2 vdd vss gf180mcu_fd_sc_mcu7t5v0__clkinv_1
Xgf180mcu_fd_sc_mcu7t5v0__oai22_4_1 gf180mcu_fd_sc_mcu7t5v0__oai22_4_1/B1 vdd vss
+ gf180mcu_fd_sc_mcu7t5v0__and2_4_0/A2 gf180mcu_fd_sc_mcu7t5v0__inv_3_0/ZN gf180mcu_fd_sc_mcu7t5v0__oai22_4_1/A2
+ gf180mcu_fd_sc_mcu7t5v0__inv_4_1/I vdd vss gf180mcu_fd_sc_mcu7t5v0__oai22_4
Xgf180mcu_fd_sc_mcu7t5v0__inv_4_1 vss gf180mcu_fd_sc_mcu7t5v0__inv_4_1/ZN gf180mcu_fd_sc_mcu7t5v0__inv_4_1/I
+ vdd vdd vss gf180mcu_fd_sc_mcu7t5v0__inv_4
Xgf180mcu_fd_sc_mcu7t5v0__dffq_2_110 gf180mcu_fd_sc_mcu7t5v0__dffq_2_110/D vdd vss
+ gf180mcu_fd_sc_mcu7t5v0__dffq_4_44/CLK gf180mcu_fd_sc_mcu7t5v0__mux4_4_2/I0 vdd
+ vss gf180mcu_fd_sc_mcu7t5v0__dffq_2
Xgf180mcu_fd_sc_mcu7t5v0__nand3_1_2 gf180mcu_fd_sc_mcu7t5v0__and2_2_0/A2 vdd vss gf180mcu_fd_sc_mcu7t5v0__or2_1_1/A2
+ gf180mcu_fd_sc_mcu7t5v0__inv_12_1/I gf180mcu_fd_sc_mcu7t5v0__and2_2_0/A1 vdd vss
+ gf180mcu_fd_sc_mcu7t5v0__nand3_1
Xgf180mcu_fd_sc_mcu7t5v0__dffq_4_17 gf180mcu_fd_sc_mcu7t5v0__dffq_4_17/D gf180mcu_fd_sc_mcu7t5v0__mux4_4_0/I0
+ vdd vss gf180mcu_fd_sc_mcu7t5v0__dffq_4_21/CLK vdd vss gf180mcu_fd_sc_mcu7t5v0__dffq_4
Xgf180mcu_fd_sc_mcu7t5v0__dffq_4_28 gf180mcu_fd_sc_mcu7t5v0__dffq_4_28/D gf180mcu_fd_sc_mcu7t5v0__dffq_4_28/Q
+ vdd vss gf180mcu_fd_sc_mcu7t5v0__dffq_4_9/CLK vdd vss gf180mcu_fd_sc_mcu7t5v0__dffq_4
Xgf180mcu_fd_sc_mcu7t5v0__dffq_4_39 gf180mcu_fd_sc_mcu7t5v0__dffq_4_39/D gf180mcu_fd_sc_mcu7t5v0__inv_3_4/I
+ vdd vss gf180mcu_fd_sc_mcu7t5v0__dffq_4_44/CLK vdd vss gf180mcu_fd_sc_mcu7t5v0__dffq_4
Xgf180mcu_fd_sc_mcu7t5v0__oai21_2_16 gf180mcu_fd_sc_mcu7t5v0__and4_1_1/Z gf180mcu_fd_sc_mcu7t5v0__oai33_2_4/A1
+ gf180mcu_fd_sc_mcu7t5v0__xor3_2_2/A1 vss gf180mcu_fd_sc_mcu7t5v0__xor3_1_139/Z vdd
+ vdd vss gf180mcu_fd_sc_mcu7t5v0__oai21_2
Xgf180mcu_fd_sc_mcu7t5v0__nand4_4_0 gf180mcu_fd_sc_mcu7t5v0__nor2_4_23/ZN gf180mcu_fd_sc_mcu7t5v0__and3_2_1/A3
+ vdd vss gf180mcu_fd_sc_mcu7t5v0__nor2_4_28/A2 gf180mcu_fd_sc_mcu7t5v0__nor4_4_1/A2
+ gf180mcu_fd_sc_mcu7t5v0__dffq_2_44/Q vdd vss gf180mcu_fd_sc_mcu7t5v0__nand4_4
Xgf180mcu_fd_sc_mcu7t5v0__aoi22_1_110 gf180mcu_fd_sc_mcu7t5v0__nor2_4_9/ZN gf180mcu_fd_sc_mcu7t5v0__dffq_1_203/Q
+ vdd vss gf180mcu_fd_sc_mcu7t5v0__nand2_1_271/A1 gf180mcu_fd_sc_mcu7t5v0__dffq_1_201/Q
+ gf180mcu_fd_sc_mcu7t5v0__nor2_4_8/ZN vdd vss gf180mcu_fd_sc_mcu7t5v0__aoi22_1
Xgf180mcu_fd_sc_mcu7t5v0__aoi22_1_121 gf180mcu_fd_sc_mcu7t5v0__nor2_4_9/ZN gf180mcu_fd_sc_mcu7t5v0__dffq_1_212/Q
+ vdd vss gf180mcu_fd_sc_mcu7t5v0__nand2_1_269/A1 gf180mcu_fd_sc_mcu7t5v0__dffq_1_253/Q
+ gf180mcu_fd_sc_mcu7t5v0__nor2_4_8/ZN vdd vss gf180mcu_fd_sc_mcu7t5v0__aoi22_1
Xgf180mcu_fd_sc_mcu7t5v0__aoi22_1_132 gf180mcu_fd_sc_mcu7t5v0__nor2_4_9/ZN gf180mcu_fd_sc_mcu7t5v0__dffq_1_239/Q
+ vdd vss gf180mcu_fd_sc_mcu7t5v0__nand2_1_273/A1 gf180mcu_fd_sc_mcu7t5v0__dffq_1_240/Q
+ gf180mcu_fd_sc_mcu7t5v0__nor2_4_8/ZN vdd vss gf180mcu_fd_sc_mcu7t5v0__aoi22_1
Xgf180mcu_fd_sc_mcu7t5v0__aoi22_1_143 gf180mcu_fd_sc_mcu7t5v0__nor2_4_11/ZN gf180mcu_fd_sc_mcu7t5v0__dffq_1_98/Q
+ vdd vss gf180mcu_fd_sc_mcu7t5v0__nand2_1_225/A2 gf180mcu_fd_sc_mcu7t5v0__dffq_1_267/Q
+ gf180mcu_fd_sc_mcu7t5v0__nor2_4_10/ZN vdd vss gf180mcu_fd_sc_mcu7t5v0__aoi22_1
Xgf180mcu_fd_sc_mcu7t5v0__aoi22_1_154 gf180mcu_fd_sc_mcu7t5v0__nor2_4_26/ZN gf180mcu_fd_sc_mcu7t5v0__inv_1_8/I
+ vdd vss gf180mcu_fd_sc_mcu7t5v0__nor2_1_151/A2 gf180mcu_fd_sc_mcu7t5v0__dffq_1_296/Q
+ gf180mcu_fd_sc_mcu7t5v0__or3_2_4/Z vdd vss gf180mcu_fd_sc_mcu7t5v0__aoi22_1
Xgf180mcu_fd_sc_mcu7t5v0__or2_1_15 vdd vss gf180mcu_fd_sc_mcu7t5v0__or2_1_15/Z gf180mcu_fd_sc_mcu7t5v0__or2_1_15/A1
+ gf180mcu_fd_sc_mcu7t5v0__or2_1_15/A2 vdd vss gf180mcu_fd_sc_mcu7t5v0__or2_1
Xgf180mcu_fd_sc_mcu7t5v0__or2_1_26 vdd vss gf180mcu_fd_sc_mcu7t5v0__or2_1_26/Z gf180mcu_fd_sc_mcu7t5v0__inv_8_2/ZN
+ gf180mcu_fd_sc_mcu7t5v0__inv_1_13/I vdd vss gf180mcu_fd_sc_mcu7t5v0__or2_1
Xgf180mcu_fd_sc_mcu7t5v0__aoi22_1_165 gf180mcu_fd_sc_mcu7t5v0__oai32_1_8/B1 gf180mcu_fd_sc_mcu7t5v0__inv_12_1/I
+ vdd vss gf180mcu_fd_sc_mcu7t5v0__or3_1_19/A2 gf180mcu_fd_sc_mcu7t5v0__inv_8_1/I
+ gf180mcu_fd_sc_mcu7t5v0__nor4_2_5/A4 vdd vss gf180mcu_fd_sc_mcu7t5v0__aoi22_1
Xgf180mcu_fd_sc_mcu7t5v0__or2_1_37 vdd vss gf180mcu_fd_sc_mcu7t5v0__or2_1_37/Z gf180mcu_fd_sc_mcu7t5v0__or2_1_37/A1
+ gf180mcu_fd_sc_mcu7t5v0__or2_1_37/A2 vdd vss gf180mcu_fd_sc_mcu7t5v0__or2_1
Xgf180mcu_fd_sc_mcu7t5v0__or2_1_48 vdd vss gf180mcu_fd_sc_mcu7t5v0__or2_1_48/Z gf180mcu_fd_sc_mcu7t5v0__or2_1_48/A1
+ gf180mcu_fd_sc_mcu7t5v0__or2_1_48/A2 vdd vss gf180mcu_fd_sc_mcu7t5v0__or2_1
Xgf180mcu_fd_sc_mcu7t5v0__aoi22_1_176 gf180mcu_fd_sc_mcu7t5v0__and4_1_3/A4 gf180mcu_fd_sc_mcu7t5v0__inv_8_1/I
+ vdd vss gf180mcu_fd_sc_mcu7t5v0__oai22_1_283/B1 gf180mcu_fd_sc_mcu7t5v0__inv_8_0/I
+ gf180mcu_fd_sc_mcu7t5v0__and4_1_3/A3 vdd vss gf180mcu_fd_sc_mcu7t5v0__aoi22_1
Xgf180mcu_fd_sc_mcu7t5v0__nor2_4_15 vdd vss gf180mcu_fd_sc_mcu7t5v0__nor2_4_15/ZN
+ gf180mcu_fd_sc_mcu7t5v0__nor2_4_21/A2 gf180mcu_fd_sc_mcu7t5v0__or2_4_1/Z vdd vss
+ gf180mcu_fd_sc_mcu7t5v0__nor2_4
Xgf180mcu_fd_sc_mcu7t5v0__nor2_4_26 vdd vss gf180mcu_fd_sc_mcu7t5v0__nor2_4_26/ZN
+ gf180mcu_fd_sc_mcu7t5v0__nor4_1_3/A1 gf180mcu_fd_sc_mcu7t5v0__nor2_4_26/A2 vdd vss
+ gf180mcu_fd_sc_mcu7t5v0__nor2_4
Xgf180mcu_fd_sc_mcu7t5v0__nor2_4_37 vdd vss gf180mcu_fd_sc_mcu7t5v0__nor2_4_37/ZN
+ gf180mcu_fd_sc_mcu7t5v0__nor2_4_37/A1 gf180mcu_fd_sc_mcu7t5v0__inv_2_12/ZN vdd vss
+ gf180mcu_fd_sc_mcu7t5v0__nor2_4
Xgf180mcu_fd_sc_mcu7t5v0__aoi21_1_301 gf180mcu_fd_sc_mcu7t5v0__aoi21_1_301/B vdd vss
+ gf180mcu_fd_sc_mcu7t5v0__nor2_1_325/A2 gf180mcu_fd_sc_mcu7t5v0__mux4_4_18/I1 gf180mcu_fd_sc_mcu7t5v0__or2_4_4/Z
+ vdd vss gf180mcu_fd_sc_mcu7t5v0__aoi21_1
Xgf180mcu_fd_sc_mcu7t5v0__aoi21_1_312 gf180mcu_fd_sc_mcu7t5v0__aoi21_1_312/B vdd vss
+ gf180mcu_fd_sc_mcu7t5v0__dffq_2_97/D gf180mcu_fd_sc_mcu7t5v0__oai32_1_6/A2 gf180mcu_fd_sc_mcu7t5v0__buf_20_0/Z
+ vdd vss gf180mcu_fd_sc_mcu7t5v0__aoi21_1
Xgf180mcu_fd_sc_mcu7t5v0__aoi21_1_323 gf180mcu_fd_sc_mcu7t5v0__aoi21_1_323/B vdd vss
+ gf180mcu_fd_sc_mcu7t5v0__dffq_4_39/D gf180mcu_fd_sc_mcu7t5v0__inv_3_4/ZN gf180mcu_fd_sc_mcu7t5v0__buf_20_0/I
+ vdd vss gf180mcu_fd_sc_mcu7t5v0__aoi21_1
Xgf180mcu_fd_sc_mcu7t5v0__aoi21_1_334 gf180mcu_fd_sc_mcu7t5v0__xnor3_1_42/A3 vdd vss
+ gf180mcu_fd_sc_mcu7t5v0__nor3_1_37/A3 gf180mcu_fd_sc_mcu7t5v0__inv_8_1/I gf180mcu_fd_sc_mcu7t5v0__mux4_4_12/Z
+ vdd vss gf180mcu_fd_sc_mcu7t5v0__aoi21_1
Xgf180mcu_fd_sc_mcu7t5v0__aoi21_1_345 gf180mcu_fd_sc_mcu7t5v0__aoi21_1_345/B vdd vss
+ gf180mcu_fd_sc_mcu7t5v0__dffq_2_102/D gf180mcu_fd_sc_mcu7t5v0__or2_1_34/A2 gf180mcu_fd_sc_mcu7t5v0__oai21_1_312/ZN
+ vdd vss gf180mcu_fd_sc_mcu7t5v0__aoi21_1
Xgf180mcu_fd_sc_mcu7t5v0__aoi21_1_356 gf180mcu_fd_sc_mcu7t5v0__aoi21_1_356/B vdd vss
+ gf180mcu_fd_sc_mcu7t5v0__or2_1_54/A1 gf180mcu_fd_sc_mcu7t5v0__xnor2_1_69/A1 gf180mcu_fd_sc_mcu7t5v0__xnor2_1_70/ZN
+ vdd vss gf180mcu_fd_sc_mcu7t5v0__aoi21_1
Xgf180mcu_fd_sc_mcu7t5v0__aoi21_1_367 gf180mcu_fd_sc_mcu7t5v0__or2_4_4/Z vdd vss gf180mcu_fd_sc_mcu7t5v0__aoi22_1_178/B2
+ gf180mcu_fd_sc_mcu7t5v0__nor2_4_34/ZN gf180mcu_fd_sc_mcu7t5v0__xor3_1_109/Z vdd
+ vss gf180mcu_fd_sc_mcu7t5v0__aoi21_1
Xgf180mcu_fd_sc_mcu7t5v0__aoi21_1_378 gf180mcu_fd_sc_mcu7t5v0__nor2_1_409/A1 vdd vss
+ gf180mcu_fd_sc_mcu7t5v0__xor2_2_1/A1 gf180mcu_fd_sc_mcu7t5v0__xor2_1_82/A1 gf180mcu_fd_sc_mcu7t5v0__xor2_1_82/A2
+ vdd vss gf180mcu_fd_sc_mcu7t5v0__aoi21_1
Xgf180mcu_fd_sc_mcu7t5v0__xor3_1_11 gf180mcu_fd_sc_mcu7t5v0__xor3_1_15/Z vdd vss gf180mcu_fd_sc_mcu7t5v0__xor3_1_11/Z
+ gf180mcu_fd_sc_mcu7t5v0__nor3_1_4/ZN gf180mcu_fd_sc_mcu7t5v0__xor3_1_24/Z vdd vss
+ gf180mcu_fd_sc_mcu7t5v0__xor3_1
Xgf180mcu_fd_sc_mcu7t5v0__xor3_1_22 gf180mcu_fd_sc_mcu7t5v0__xor3_1_64/Z vdd vss gf180mcu_fd_sc_mcu7t5v0__xor3_1_22/Z
+ gf180mcu_fd_sc_mcu7t5v0__xor3_1_22/A1 gf180mcu_fd_sc_mcu7t5v0__xor3_1_22/A2 vdd
+ vss gf180mcu_fd_sc_mcu7t5v0__xor3_1
Xgf180mcu_fd_sc_mcu7t5v0__xor3_1_33 gf180mcu_fd_sc_mcu7t5v0__nor2_2_7/A2 vdd vss gf180mcu_fd_sc_mcu7t5v0__xor3_1_33/Z
+ gf180mcu_fd_sc_mcu7t5v0__or3_1_3/Z gf180mcu_fd_sc_mcu7t5v0__xor3_1_34/Z vdd vss
+ gf180mcu_fd_sc_mcu7t5v0__xor3_1
Xgf180mcu_fd_sc_mcu7t5v0__aoi222_1_1 vss vdd gf180mcu_fd_sc_mcu7t5v0__nor3_4_11/ZN
+ gf180mcu_fd_sc_mcu7t5v0__aoi222_1_1/C1 gf180mcu_fd_sc_mcu7t5v0__aoi222_1_1/B2 gf180mcu_fd_sc_mcu7t5v0__nor2_4_12/ZN
+ gf180mcu_fd_sc_mcu7t5v0__aoi222_1_1/A2 gf180mcu_fd_sc_mcu7t5v0__nor2_4_13/ZN gf180mcu_fd_sc_mcu7t5v0__nand3_1_39/A3
+ vdd vss gf180mcu_fd_sc_mcu7t5v0__aoi222_1
Xgf180mcu_fd_sc_mcu7t5v0__xor3_1_44 gf180mcu_fd_sc_mcu7t5v0__xor3_1_45/Z vdd vss gf180mcu_fd_sc_mcu7t5v0__xor3_1_44/Z
+ gf180mcu_fd_sc_mcu7t5v0__xor3_1_44/A1 gf180mcu_fd_sc_mcu7t5v0__xor3_1_49/Z vdd vss
+ gf180mcu_fd_sc_mcu7t5v0__xor3_1
Xgf180mcu_fd_sc_mcu7t5v0__xor3_1_55 gf180mcu_fd_sc_mcu7t5v0__xor3_1_55/A3 vdd vss
+ gf180mcu_fd_sc_mcu7t5v0__xor3_1_55/Z gf180mcu_fd_sc_mcu7t5v0__xor3_1_55/A1 gf180mcu_fd_sc_mcu7t5v0__xor3_1_55/A2
+ vdd vss gf180mcu_fd_sc_mcu7t5v0__xor3_1
Xgf180mcu_fd_sc_mcu7t5v0__xor3_1_66 gf180mcu_fd_sc_mcu7t5v0__xor2_1_78/Z vdd vss gf180mcu_fd_sc_mcu7t5v0__xor3_1_66/Z
+ gf180mcu_fd_sc_mcu7t5v0__xor3_1_66/A1 gf180mcu_fd_sc_mcu7t5v0__xor3_1_66/A2 vdd
+ vss gf180mcu_fd_sc_mcu7t5v0__xor3_1
Xgf180mcu_fd_sc_mcu7t5v0__xor3_1_77 gf180mcu_fd_sc_mcu7t5v0__xor3_1_82/Z vdd vss gf180mcu_fd_sc_mcu7t5v0__xor3_1_77/Z
+ gf180mcu_fd_sc_mcu7t5v0__or2_1_33/A1 gf180mcu_fd_sc_mcu7t5v0__xor3_1_77/A2 vdd vss
+ gf180mcu_fd_sc_mcu7t5v0__xor3_1
Xgf180mcu_fd_sc_mcu7t5v0__xor3_1_88 gf180mcu_fd_sc_mcu7t5v0__xor3_1_88/A3 vdd vss
+ gf180mcu_fd_sc_mcu7t5v0__xor3_1_88/Z gf180mcu_fd_sc_mcu7t5v0__or4_1_0/A2 gf180mcu_fd_sc_mcu7t5v0__xor3_1_88/A2
+ vdd vss gf180mcu_fd_sc_mcu7t5v0__xor3_1
Xgf180mcu_fd_sc_mcu7t5v0__xor3_1_99 gf180mcu_fd_sc_mcu7t5v0__xor3_1_99/A3 vdd vss
+ gf180mcu_fd_sc_mcu7t5v0__xor3_1_99/Z gf180mcu_fd_sc_mcu7t5v0__xor3_1_99/A1 gf180mcu_fd_sc_mcu7t5v0__xor3_1_99/A2
+ vdd vss gf180mcu_fd_sc_mcu7t5v0__xor3_1
Xgf180mcu_fd_sc_mcu7t5v0__nor3_1_3 gf180mcu_fd_sc_mcu7t5v0__xor2_1_15/Z vdd vss gf180mcu_fd_sc_mcu7t5v0__nor3_1_3/ZN
+ gf180mcu_fd_sc_mcu7t5v0__and2_1_7/Z gf180mcu_fd_sc_mcu7t5v0__nor3_1_3/A2 vdd vss
+ gf180mcu_fd_sc_mcu7t5v0__nor3_1
Xgf180mcu_fd_sc_mcu7t5v0__dffq_1_208 vdd gf180mcu_fd_sc_mcu7t5v0__dffq_1_208/Q gf180mcu_fd_sc_mcu7t5v0__dffq_4_8/CLK
+ vss gf180mcu_fd_sc_mcu7t5v0__dffq_1_208/D vdd vss gf180mcu_fd_sc_mcu7t5v0__dffq_1
Xgf180mcu_fd_sc_mcu7t5v0__dffq_1_219 vdd gf180mcu_fd_sc_mcu7t5v0__dffq_1_219/Q gf180mcu_fd_sc_mcu7t5v0__dffq_4_8/CLK
+ vss gf180mcu_fd_sc_mcu7t5v0__dffq_1_219/D vdd vss gf180mcu_fd_sc_mcu7t5v0__dffq_1
Xgf180mcu_fd_sc_mcu7t5v0__nor2_1_408 vdd vss gf180mcu_fd_sc_mcu7t5v0__or3_1_27/A1
+ gf180mcu_fd_sc_mcu7t5v0__and2_1_88/A1 gf180mcu_fd_sc_mcu7t5v0__or2_1_28/A1 vdd vss
+ gf180mcu_fd_sc_mcu7t5v0__nor2_1
Xgf180mcu_fd_sc_mcu7t5v0__nand2_1_601 vdd vss gf180mcu_fd_sc_mcu7t5v0__nand2_1_633/A1
+ gf180mcu_fd_sc_mcu7t5v0__or4_1_0/A1 gf180mcu_fd_sc_mcu7t5v0__xor2_1_167/Z vdd vss
+ gf180mcu_fd_sc_mcu7t5v0__nand2_1
Xgf180mcu_fd_sc_mcu7t5v0__nand2_1_612 vdd vss gf180mcu_fd_sc_mcu7t5v0__mux2_1_12/I0
+ gf180mcu_fd_sc_mcu7t5v0__inv_8_0/I gf180mcu_fd_sc_mcu7t5v0__mux4_4_12/Z vdd vss
+ gf180mcu_fd_sc_mcu7t5v0__nand2_1
Xgf180mcu_fd_sc_mcu7t5v0__nand2_1_623 vdd vss gf180mcu_fd_sc_mcu7t5v0__aoi21_2_22/A2
+ gf180mcu_fd_sc_mcu7t5v0__or2_1_49/A2 gf180mcu_fd_sc_mcu7t5v0__xor3_1_133/A3 vdd
+ vss gf180mcu_fd_sc_mcu7t5v0__nand2_1
Xgf180mcu_fd_sc_mcu7t5v0__nand2_1_634 vdd vss gf180mcu_fd_sc_mcu7t5v0__xnor2_1_64/A1
+ gf180mcu_fd_sc_mcu7t5v0__inv_8_1/I gf180mcu_fd_sc_mcu7t5v0__mux4_4_14/Z vdd vss
+ gf180mcu_fd_sc_mcu7t5v0__nand2_1
Xgf180mcu_fd_sc_mcu7t5v0__nand2_1_645 vdd vss gf180mcu_fd_sc_mcu7t5v0__nand2_1_645/ZN
+ gf180mcu_fd_sc_mcu7t5v0__dffq_2_96/Q gf180mcu_fd_sc_mcu7t5v0__or2_4_4/Z vdd vss
+ gf180mcu_fd_sc_mcu7t5v0__nand2_1
Xgf180mcu_fd_sc_mcu7t5v0__nand2_1_656 vdd vss gf180mcu_fd_sc_mcu7t5v0__oai21_1_314/A2
+ gf180mcu_fd_sc_mcu7t5v0__nor2_2_56/ZN gf180mcu_fd_sc_mcu7t5v0__nand3_1_95/ZN vdd
+ vss gf180mcu_fd_sc_mcu7t5v0__nand2_1
Xgf180mcu_fd_sc_mcu7t5v0__nand2_1_667 vdd vss gf180mcu_fd_sc_mcu7t5v0__and2_1_142/A1
+ gf180mcu_fd_sc_mcu7t5v0__nor3_2_5/A1 gf180mcu_fd_sc_mcu7t5v0__and4_1_3/A3 vdd vss
+ gf180mcu_fd_sc_mcu7t5v0__nand2_1
Xgf180mcu_fd_sc_mcu7t5v0__nand2_1_678 vdd vss gf180mcu_fd_sc_mcu7t5v0__xnor2_1_73/A1
+ gf180mcu_fd_sc_mcu7t5v0__inv_12_1/I gf180mcu_fd_sc_mcu7t5v0__oai31_4_5/ZN vdd vss
+ gf180mcu_fd_sc_mcu7t5v0__nand2_1
Xgf180mcu_fd_sc_mcu7t5v0__nand2_1_689 vdd vss gf180mcu_fd_sc_mcu7t5v0__xor3_1_147/A2
+ gf180mcu_fd_sc_mcu7t5v0__or4_1_0/A1 gf180mcu_fd_sc_mcu7t5v0__and4_1_3/A4 vdd vss
+ gf180mcu_fd_sc_mcu7t5v0__nand2_1
Xgf180mcu_fd_sc_mcu7t5v0__nand4_1_11 gf180mcu_fd_sc_mcu7t5v0__nand4_1_11/A3 gf180mcu_fd_sc_mcu7t5v0__nand4_1_11/A4
+ vdd vss gf180mcu_fd_sc_mcu7t5v0__oai211_1_55/B gf180mcu_fd_sc_mcu7t5v0__nand4_1_11/A1
+ gf180mcu_fd_sc_mcu7t5v0__nand4_1_11/A2 vdd vss gf180mcu_fd_sc_mcu7t5v0__nand4_1
Xgf180mcu_fd_sc_mcu7t5v0__nand4_1_22 gf180mcu_fd_sc_mcu7t5v0__or2_1_52/Z gf180mcu_fd_sc_mcu7t5v0__nand4_1_22/A4
+ vdd vss gf180mcu_fd_sc_mcu7t5v0__oai211_1_48/B gf180mcu_fd_sc_mcu7t5v0__oai211_1_53/C
+ gf180mcu_fd_sc_mcu7t5v0__nand4_1_22/A2 vdd vss gf180mcu_fd_sc_mcu7t5v0__nand4_1
Xgf180mcu_fd_sc_mcu7t5v0__dffq_1_18 vdd gf180mcu_fd_sc_mcu7t5v0__dffq_1_18/Q gf180mcu_fd_sc_mcu7t5v0__dffq_1_99/CLK
+ vss gf180mcu_fd_sc_mcu7t5v0__dffq_1_18/D vdd vss gf180mcu_fd_sc_mcu7t5v0__dffq_1
Xgf180mcu_fd_sc_mcu7t5v0__dffq_1_29 vdd gf180mcu_fd_sc_mcu7t5v0__dffq_1_29/Q gf180mcu_fd_sc_mcu7t5v0__dffq_1_99/CLK
+ vss gf180mcu_fd_sc_mcu7t5v0__dffq_1_29/D vdd vss gf180mcu_fd_sc_mcu7t5v0__dffq_1
Xgf180mcu_fd_sc_mcu7t5v0__inv_1_12 vss gf180mcu_fd_sc_mcu7t5v0__inv_1_12/ZN gf180mcu_fd_sc_mcu7t5v0__inv_1_12/I
+ vdd vdd vss gf180mcu_fd_sc_mcu7t5v0__inv_1
Xgf180mcu_fd_sc_mcu7t5v0__inv_1_23 vss gf180mcu_fd_sc_mcu7t5v0__inv_1_23/ZN gf180mcu_fd_sc_mcu7t5v0__inv_1_23/I
+ vdd vdd vss gf180mcu_fd_sc_mcu7t5v0__inv_1
Xgf180mcu_fd_sc_mcu7t5v0__aoi21_1_120 gf180mcu_fd_sc_mcu7t5v0__aoi21_1_120/B vdd vss
+ gf180mcu_fd_sc_mcu7t5v0__dffq_1_294/D gf180mcu_fd_sc_mcu7t5v0__aoi22_4_6/ZN gf180mcu_fd_sc_mcu7t5v0__nor2_4_31/ZN
+ vdd vss gf180mcu_fd_sc_mcu7t5v0__aoi21_1
Xgf180mcu_fd_sc_mcu7t5v0__aoi21_1_131 gf180mcu_fd_sc_mcu7t5v0__aoi21_1_131/B vdd vss
+ gf180mcu_fd_sc_mcu7t5v0__dffq_1_304/D gf180mcu_fd_sc_mcu7t5v0__aoi22_4_3/ZN gf180mcu_fd_sc_mcu7t5v0__nor2_4_31/ZN
+ vdd vss gf180mcu_fd_sc_mcu7t5v0__aoi21_1
Xgf180mcu_fd_sc_mcu7t5v0__aoi21_1_142 gf180mcu_fd_sc_mcu7t5v0__or2_4_4/Z vdd vss gf180mcu_fd_sc_mcu7t5v0__aoi221_1_22/B2
+ gf180mcu_fd_sc_mcu7t5v0__oai221_1_8/A1 gf180mcu_fd_sc_mcu7t5v0__oai221_1_6/ZN vdd
+ vss gf180mcu_fd_sc_mcu7t5v0__aoi21_1
Xgf180mcu_fd_sc_mcu7t5v0__aoi21_1_153 gf180mcu_fd_sc_mcu7t5v0__nor2_1_236/ZN vdd vss
+ gf180mcu_fd_sc_mcu7t5v0__aoi21_1_170/A2 gf180mcu_fd_sc_mcu7t5v0__dffq_1_330/Q gf180mcu_fd_sc_mcu7t5v0__inv_2_8/I
+ vdd vss gf180mcu_fd_sc_mcu7t5v0__aoi21_1
Xgf180mcu_fd_sc_mcu7t5v0__and2_1_120 vdd vss gf180mcu_fd_sc_mcu7t5v0__oai32_4_2/A2
+ gf180mcu_fd_sc_mcu7t5v0__dffq_2_102/Q gf180mcu_fd_sc_mcu7t5v0__inv_1_20/ZN vdd vss
+ gf180mcu_fd_sc_mcu7t5v0__and2_1
Xgf180mcu_fd_sc_mcu7t5v0__aoi21_1_164 gf180mcu_fd_sc_mcu7t5v0__aoi21_1_164/B vdd vss
+ gf180mcu_fd_sc_mcu7t5v0__dffq_1_349/D gf180mcu_fd_sc_mcu7t5v0__nor4_1_1/A4 gf180mcu_fd_sc_mcu7t5v0__and2_1_58/Z
+ vdd vss gf180mcu_fd_sc_mcu7t5v0__aoi21_1
Xgf180mcu_fd_sc_mcu7t5v0__aoi21_1_175 gf180mcu_fd_sc_mcu7t5v0__aoi21_1_175/B vdd vss
+ gf180mcu_fd_sc_mcu7t5v0__dffq_1_327/D gf180mcu_fd_sc_mcu7t5v0__aoi21_1_175/A1 gf180mcu_fd_sc_mcu7t5v0__nand3_1_55/A2
+ vdd vss gf180mcu_fd_sc_mcu7t5v0__aoi21_1
Xgf180mcu_fd_sc_mcu7t5v0__and2_1_131 vdd vss gf180mcu_fd_sc_mcu7t5v0__and2_1_131/Z
+ gf180mcu_fd_sc_mcu7t5v0__xor3_1_124/A1 gf180mcu_fd_sc_mcu7t5v0__xor3_1_124/A2 vdd
+ vss gf180mcu_fd_sc_mcu7t5v0__and2_1
Xgf180mcu_fd_sc_mcu7t5v0__aoi21_1_186 gf180mcu_fd_sc_mcu7t5v0__or2_4_4/Z vdd vss gf180mcu_fd_sc_mcu7t5v0__oai31_1_12/B
+ gf180mcu_fd_sc_mcu7t5v0__nor2_4_30/ZN gf180mcu_fd_sc_mcu7t5v0__xor3_1_71/Z vdd vss
+ gf180mcu_fd_sc_mcu7t5v0__aoi21_1
Xgf180mcu_fd_sc_mcu7t5v0__and2_1_142 vdd vss gf180mcu_fd_sc_mcu7t5v0__and2_1_142/Z
+ gf180mcu_fd_sc_mcu7t5v0__and2_1_142/A1 gf180mcu_fd_sc_mcu7t5v0__xor3_1_163/Z vdd
+ vss gf180mcu_fd_sc_mcu7t5v0__and2_1
Xgf180mcu_fd_sc_mcu7t5v0__aoi21_1_197 gf180mcu_fd_sc_mcu7t5v0__aoi21_1_197/B vdd vss
+ gf180mcu_fd_sc_mcu7t5v0__dffq_1_395/D gf180mcu_fd_sc_mcu7t5v0__dffq_4_20/Q gf180mcu_fd_sc_mcu7t5v0__aoi22_4_7/ZN
+ vdd vss gf180mcu_fd_sc_mcu7t5v0__aoi21_1
Xgf180mcu_fd_sc_mcu7t5v0__and2_1_153 vdd vss gf180mcu_fd_sc_mcu7t5v0__and2_1_153/Z
+ gf180mcu_fd_sc_mcu7t5v0__and2_1_153/A1 gf180mcu_fd_sc_mcu7t5v0__nand3_1_67/A2 vdd
+ vss gf180mcu_fd_sc_mcu7t5v0__and2_1
Xgf180mcu_fd_sc_mcu7t5v0__buf_8_8 gf180mcu_fd_sc_mcu7t5v0__buf_8_8/Z gf180mcu_fd_sc_mcu7t5v0__buf_8_8/I
+ vdd vss vdd vss gf180mcu_fd_sc_mcu7t5v0__buf_8
Xgf180mcu_fd_sc_mcu7t5v0__oai22_1_107 gf180mcu_fd_sc_mcu7t5v0__nand2_4_14/ZN gf180mcu_fd_sc_mcu7t5v0__nand2_2_32/ZN
+ gf180mcu_fd_sc_mcu7t5v0__oai22_1_107/B2 vdd vss gf180mcu_fd_sc_mcu7t5v0__dffq_1_262/D
+ gf180mcu_fd_sc_mcu7t5v0__aoi21_4_2/ZN vdd vss gf180mcu_fd_sc_mcu7t5v0__oai22_1
Xgf180mcu_fd_sc_mcu7t5v0__oai22_1_118 gf180mcu_fd_sc_mcu7t5v0__nand2_4_15/ZN gf180mcu_fd_sc_mcu7t5v0__nand2_2_21/ZN
+ gf180mcu_fd_sc_mcu7t5v0__oai22_1_118/B2 vdd vss gf180mcu_fd_sc_mcu7t5v0__dffq_1_101/D
+ gf180mcu_fd_sc_mcu7t5v0__oai22_1_98/A1 vdd vss gf180mcu_fd_sc_mcu7t5v0__oai22_1
Xgf180mcu_fd_sc_mcu7t5v0__oai22_1_129 gf180mcu_fd_sc_mcu7t5v0__nand2_4_17/ZN gf180mcu_fd_sc_mcu7t5v0__nand2_2_23/ZN
+ gf180mcu_fd_sc_mcu7t5v0__oai22_1_129/B2 vdd vss gf180mcu_fd_sc_mcu7t5v0__dffq_1_122/D
+ gf180mcu_fd_sc_mcu7t5v0__aoi21_4_1/ZN vdd vss gf180mcu_fd_sc_mcu7t5v0__oai22_1
Xgf180mcu_fd_sc_mcu7t5v0__nor4_4_1 gf180mcu_fd_sc_mcu7t5v0__or2_4_2/Z gf180mcu_fd_sc_mcu7t5v0__nor4_4_1/A4
+ vdd vss gf180mcu_fd_sc_mcu7t5v0__nor4_4_1/ZN gf180mcu_fd_sc_mcu7t5v0__nor4_4_1/A1
+ gf180mcu_fd_sc_mcu7t5v0__nor4_4_1/A2 vdd vss gf180mcu_fd_sc_mcu7t5v0__nor4_4
Xgf180mcu_fd_sc_mcu7t5v0__nor2_1_16 vdd vss gf180mcu_fd_sc_mcu7t5v0__dffq_2_1/D gf180mcu_fd_sc_mcu7t5v0__aoi21_1_7/B
+ gf180mcu_fd_sc_mcu7t5v0__nor2_1_16/A2 vdd vss gf180mcu_fd_sc_mcu7t5v0__nor2_1
Xgf180mcu_fd_sc_mcu7t5v0__nor2_1_27 vdd vss gf180mcu_fd_sc_mcu7t5v0__dffq_2_9/D gf180mcu_fd_sc_mcu7t5v0__aoi21_1_7/B
+ gf180mcu_fd_sc_mcu7t5v0__nor2_1_27/A2 vdd vss gf180mcu_fd_sc_mcu7t5v0__nor2_1
Xgf180mcu_fd_sc_mcu7t5v0__nor2_1_38 vdd vss gf180mcu_fd_sc_mcu7t5v0__mux2_1_1/S gf180mcu_fd_sc_mcu7t5v0__xor2_1_79/A2
+ gf180mcu_fd_sc_mcu7t5v0__xor2_1_27/A1 vdd vss gf180mcu_fd_sc_mcu7t5v0__nor2_1
Xgf180mcu_fd_sc_mcu7t5v0__nor2_1_49 vdd vss gf180mcu_fd_sc_mcu7t5v0__nor2_1_49/ZN
+ gf180mcu_fd_sc_mcu7t5v0__dffq_1_6/Q gf180mcu_fd_sc_mcu7t5v0__nor2_4_16/ZN vdd vss
+ gf180mcu_fd_sc_mcu7t5v0__nor2_1
Xgf180mcu_fd_sc_mcu7t5v0__nor2_1_205 vdd vss gf180mcu_fd_sc_mcu7t5v0__nor2_1_205/ZN
+ gf180mcu_fd_sc_mcu7t5v0__dffq_2_50/Q gf180mcu_fd_sc_mcu7t5v0__oai31_1_10/A2 vdd
+ vss gf180mcu_fd_sc_mcu7t5v0__nor2_1
Xgf180mcu_fd_sc_mcu7t5v0__nor2_1_216 vdd vss gf180mcu_fd_sc_mcu7t5v0__dffq_4_17/D
+ gf180mcu_fd_sc_mcu7t5v0__aoi21_1_7/B gf180mcu_fd_sc_mcu7t5v0__nor2_1_216/A2 vdd
+ vss gf180mcu_fd_sc_mcu7t5v0__nor2_1
Xgf180mcu_fd_sc_mcu7t5v0__aoi21_1_1 gf180mcu_fd_sc_mcu7t5v0__and3_1_7/Z vdd vss gf180mcu_fd_sc_mcu7t5v0__xnor3_1_5/A2
+ gf180mcu_fd_sc_mcu7t5v0__aoi21_1_1/A1 gf180mcu_fd_sc_mcu7t5v0__aoi21_1_1/A2 vdd
+ vss gf180mcu_fd_sc_mcu7t5v0__aoi21_1
Xgf180mcu_fd_sc_mcu7t5v0__nor2_1_227 vdd vss gf180mcu_fd_sc_mcu7t5v0__dffq_2_55/D
+ gf180mcu_fd_sc_mcu7t5v0__or2_1_23/A1 gf180mcu_fd_sc_mcu7t5v0__nor2_1_227/A2 vdd
+ vss gf180mcu_fd_sc_mcu7t5v0__nor2_1
Xgf180mcu_fd_sc_mcu7t5v0__nor2_1_238 vdd vss gf180mcu_fd_sc_mcu7t5v0__nor2_1_238/ZN
+ gf180mcu_fd_sc_mcu7t5v0__xor3_1_83/A2 gf180mcu_fd_sc_mcu7t5v0__xor3_1_83/A3 vdd
+ vss gf180mcu_fd_sc_mcu7t5v0__nor2_1
Xgf180mcu_fd_sc_mcu7t5v0__nor2_1_249 vdd vss gf180mcu_fd_sc_mcu7t5v0__mux2_1_7/S gf180mcu_fd_sc_mcu7t5v0__xnor2_1_41/A2
+ gf180mcu_fd_sc_mcu7t5v0__xnor3_1_27/A1 vdd vss gf180mcu_fd_sc_mcu7t5v0__nor2_1
Xgf180mcu_fd_sc_mcu7t5v0__nand2_1_420 vdd vss gf180mcu_fd_sc_mcu7t5v0__xor2_1_219/A1
+ gf180mcu_fd_sc_mcu7t5v0__and2_2_12/Z gf180mcu_fd_sc_mcu7t5v0__and2_1_91/Z vdd vss
+ gf180mcu_fd_sc_mcu7t5v0__nand2_1
Xgf180mcu_fd_sc_mcu7t5v0__nand2_1_431 vdd vss gf180mcu_fd_sc_mcu7t5v0__xnor3_1_27/A3
+ gf180mcu_fd_sc_mcu7t5v0__inv_12_1/I gf180mcu_fd_sc_mcu7t5v0__nor2_2_39/ZN vdd vss
+ gf180mcu_fd_sc_mcu7t5v0__nand2_1
Xgf180mcu_fd_sc_mcu7t5v0__nand2_1_442 vdd vss gf180mcu_fd_sc_mcu7t5v0__xor3_1_85/A3
+ gf180mcu_fd_sc_mcu7t5v0__inv_4_6/I gf180mcu_fd_sc_mcu7t5v0__mux4_4_19/Z vdd vss
+ gf180mcu_fd_sc_mcu7t5v0__nand2_1
Xgf180mcu_fd_sc_mcu7t5v0__nand2_1_453 vdd vss gf180mcu_fd_sc_mcu7t5v0__and3_2_3/A1
+ gf180mcu_fd_sc_mcu7t5v0__oai31_2_1/A2 gf180mcu_fd_sc_mcu7t5v0__inv_2_9/I vdd vss
+ gf180mcu_fd_sc_mcu7t5v0__nand2_1
Xgf180mcu_fd_sc_mcu7t5v0__nand2_1_464 vdd vss gf180mcu_fd_sc_mcu7t5v0__nand2_1_464/ZN
+ gf180mcu_fd_sc_mcu7t5v0__inv_4_6/ZN gf180mcu_fd_sc_mcu7t5v0__oai32_2_2/ZN vdd vss
+ gf180mcu_fd_sc_mcu7t5v0__nand2_1
Xgf180mcu_fd_sc_mcu7t5v0__nand2_1_475 vdd vss gf180mcu_fd_sc_mcu7t5v0__nand2_1_475/ZN
+ gf180mcu_fd_sc_mcu7t5v0__nor2_2_33/ZN gf180mcu_fd_sc_mcu7t5v0__xor3_2_1/Z vdd vss
+ gf180mcu_fd_sc_mcu7t5v0__nand2_1
Xgf180mcu_fd_sc_mcu7t5v0__nand2_1_486 vdd vss gf180mcu_fd_sc_mcu7t5v0__and3_1_15/A1
+ gf180mcu_fd_sc_mcu7t5v0__inv_8_2/I gf180mcu_fd_sc_mcu7t5v0__xor2_1_137/Z vdd vss
+ gf180mcu_fd_sc_mcu7t5v0__nand2_1
Xgf180mcu_fd_sc_mcu7t5v0__nand2_1_497 vdd vss gf180mcu_fd_sc_mcu7t5v0__xor3_1_93/A1
+ gf180mcu_fd_sc_mcu7t5v0__or4_1_0/A1 gf180mcu_fd_sc_mcu7t5v0__oai32_1_8/B1 vdd vss
+ gf180mcu_fd_sc_mcu7t5v0__nand2_1
Xgf180mcu_fd_sc_mcu7t5v0__oai21_1_309 vdd gf180mcu_fd_sc_mcu7t5v0__xor2_1_143/Z gf180mcu_fd_sc_mcu7t5v0__xor3_1_96/A1
+ gf180mcu_fd_sc_mcu7t5v0__xor3_1_142/A1 gf180mcu_fd_sc_mcu7t5v0__nor3_4_16/ZN vss
+ vdd vss gf180mcu_fd_sc_mcu7t5v0__oai21_1
Xgf180mcu_fd_sc_mcu7t5v0__mux2_1_12 gf180mcu_fd_sc_mcu7t5v0__mux2_1_12/S vdd vss gf180mcu_fd_sc_mcu7t5v0__mux2_1_12/Z
+ gf180mcu_fd_sc_mcu7t5v0__mux2_1_12/I0 gf180mcu_fd_sc_mcu7t5v0__inv_8_0/I vdd vss
+ gf180mcu_fd_sc_mcu7t5v0__mux2_1
Xgf180mcu_fd_sc_mcu7t5v0__xor2_1_0 vdd vss gf180mcu_fd_sc_mcu7t5v0__xor2_1_0/Z gf180mcu_fd_sc_mcu7t5v0__xor3_1_0/A2
+ gf180mcu_fd_sc_mcu7t5v0__xor3_1_48/Z vdd vss gf180mcu_fd_sc_mcu7t5v0__xor2_1
Xgf180mcu_fd_sc_mcu7t5v0__aoi22_1_18 gf180mcu_fd_sc_mcu7t5v0__nor2_4_11/ZN gf180mcu_fd_sc_mcu7t5v0__dffq_1_21/Q
+ vdd vss gf180mcu_fd_sc_mcu7t5v0__aoi22_1_18/ZN gf180mcu_fd_sc_mcu7t5v0__dffq_1_23/Q
+ gf180mcu_fd_sc_mcu7t5v0__nor2_4_10/ZN vdd vss gf180mcu_fd_sc_mcu7t5v0__aoi22_1
Xgf180mcu_fd_sc_mcu7t5v0__aoi22_1_29 gf180mcu_fd_sc_mcu7t5v0__nor2_4_9/ZN gf180mcu_fd_sc_mcu7t5v0__dffq_1_47/Q
+ vdd vss gf180mcu_fd_sc_mcu7t5v0__aoi22_1_29/ZN gf180mcu_fd_sc_mcu7t5v0__dffq_1_43/Q
+ gf180mcu_fd_sc_mcu7t5v0__nor2_4_8/ZN vdd vss gf180mcu_fd_sc_mcu7t5v0__aoi22_1
Xgf180mcu_fd_sc_mcu7t5v0__oai211_1_1 gf180mcu_fd_sc_mcu7t5v0__or2_1_2/Z gf180mcu_fd_sc_mcu7t5v0__xor3_1_4/A2
+ vdd vss gf180mcu_fd_sc_mcu7t5v0__aoi21_1_1/A2 gf180mcu_fd_sc_mcu7t5v0__xor3_1_62/A1
+ gf180mcu_fd_sc_mcu7t5v0__aoi22_1_4/ZN vdd vss gf180mcu_fd_sc_mcu7t5v0__oai211_1
Xgf180mcu_fd_sc_mcu7t5v0__mux2_1_1 gf180mcu_fd_sc_mcu7t5v0__mux2_1_1/S vdd vss gf180mcu_fd_sc_mcu7t5v0__mux2_1_1/Z
+ gf180mcu_fd_sc_mcu7t5v0__mux2_1_1/I0 gf180mcu_fd_sc_mcu7t5v0__inv_8_0/I vdd vss
+ gf180mcu_fd_sc_mcu7t5v0__mux2_1
Xgf180mcu_fd_sc_mcu7t5v0__xnor2_1_12 vdd vss gf180mcu_fd_sc_mcu7t5v0__oai32_2_0/B1
+ gf180mcu_fd_sc_mcu7t5v0__or2_1_9/Z gf180mcu_fd_sc_mcu7t5v0__or2_1_10/A2 vdd vss
+ gf180mcu_fd_sc_mcu7t5v0__xnor2_1
Xgf180mcu_fd_sc_mcu7t5v0__xnor2_1_23 vdd vss gf180mcu_fd_sc_mcu7t5v0__xor3_1_57/A3
+ gf180mcu_fd_sc_mcu7t5v0__mux2_1_6/S gf180mcu_fd_sc_mcu7t5v0__or2_1_11/A1 vdd vss
+ gf180mcu_fd_sc_mcu7t5v0__xnor2_1
Xgf180mcu_fd_sc_mcu7t5v0__xnor2_1_34 vdd vss gf180mcu_fd_sc_mcu7t5v0__xor2_1_101/A2
+ gf180mcu_fd_sc_mcu7t5v0__mux4_4_3/I0 gf180mcu_fd_sc_mcu7t5v0__xor3_1_73/Z vdd vss
+ gf180mcu_fd_sc_mcu7t5v0__xnor2_1
Xgf180mcu_fd_sc_mcu7t5v0__xnor2_1_45 vdd vss gf180mcu_fd_sc_mcu7t5v0__xnor2_1_45/ZN
+ gf180mcu_fd_sc_mcu7t5v0__xor3_1_92/A2 gf180mcu_fd_sc_mcu7t5v0__xor2_2_3/Z vdd vss
+ gf180mcu_fd_sc_mcu7t5v0__xnor2_1
Xgf180mcu_fd_sc_mcu7t5v0__xnor2_1_56 vdd vss gf180mcu_fd_sc_mcu7t5v0__xnor2_1_56/ZN
+ gf180mcu_fd_sc_mcu7t5v0__xnor2_1_56/A1 gf180mcu_fd_sc_mcu7t5v0__xnor3_1_49/ZN vdd
+ vss gf180mcu_fd_sc_mcu7t5v0__xnor2_1
Xgf180mcu_fd_sc_mcu7t5v0__xnor2_1_67 vdd vss gf180mcu_fd_sc_mcu7t5v0__xor3_1_143/A3
+ gf180mcu_fd_sc_mcu7t5v0__xnor2_1_67/A1 gf180mcu_fd_sc_mcu7t5v0__xnor3_1_43/ZN vdd
+ vss gf180mcu_fd_sc_mcu7t5v0__xnor2_1
Xgf180mcu_fd_sc_mcu7t5v0__xnor2_1_78 vdd vss gf180mcu_fd_sc_mcu7t5v0__nor3_2_13/A3
+ gf180mcu_fd_sc_mcu7t5v0__nor2_2_58/A1 gf180mcu_fd_sc_mcu7t5v0__nor2_2_58/A2 vdd
+ vss gf180mcu_fd_sc_mcu7t5v0__xnor2_1
Xgf180mcu_fd_sc_mcu7t5v0__and3_1_2 gf180mcu_fd_sc_mcu7t5v0__and3_1_2/A3 vdd vss gf180mcu_fd_sc_mcu7t5v0__or2_1_6/A2
+ gf180mcu_fd_sc_mcu7t5v0__mux4_4_2/I2 gf180mcu_fd_sc_mcu7t5v0__nor2_2_3/ZN vdd vss
+ gf180mcu_fd_sc_mcu7t5v0__and3_1
Xgf180mcu_fd_sc_mcu7t5v0__dffq_2_50 gf180mcu_fd_sc_mcu7t5v0__dffq_2_50/D vdd vss gf180mcu_fd_sc_mcu7t5v0__dffq_4_15/CLK
+ gf180mcu_fd_sc_mcu7t5v0__dffq_2_50/Q vdd vss gf180mcu_fd_sc_mcu7t5v0__dffq_2
Xgf180mcu_fd_sc_mcu7t5v0__dffq_2_61 gf180mcu_fd_sc_mcu7t5v0__dffq_2_61/D vdd vss gf180mcu_fd_sc_mcu7t5v0__dffq_4_1/CLK
+ gf180mcu_fd_sc_mcu7t5v0__dffq_2_61/Q vdd vss gf180mcu_fd_sc_mcu7t5v0__dffq_2
Xgf180mcu_fd_sc_mcu7t5v0__dffq_2_72 gf180mcu_fd_sc_mcu7t5v0__dffq_2_72/D vdd vss gf180mcu_fd_sc_mcu7t5v0__dffq_4_44/CLK
+ gf180mcu_fd_sc_mcu7t5v0__inv_1_19/I vdd vss gf180mcu_fd_sc_mcu7t5v0__dffq_2
Xgf180mcu_fd_sc_mcu7t5v0__dffq_2_83 gf180mcu_fd_sc_mcu7t5v0__dffq_2_83/D vdd vss gf180mcu_fd_sc_mcu7t5v0__dffq_4_1/CLK
+ gf180mcu_fd_sc_mcu7t5v0__inv_1_21/I vdd vss gf180mcu_fd_sc_mcu7t5v0__dffq_2
Xgf180mcu_fd_sc_mcu7t5v0__dffq_2_94 gf180mcu_fd_sc_mcu7t5v0__dffq_2_94/D vdd vss gf180mcu_fd_sc_mcu7t5v0__dffq_4_1/CLK
+ gf180mcu_fd_sc_mcu7t5v0__dffq_2_94/Q vdd vss gf180mcu_fd_sc_mcu7t5v0__dffq_2
Xgf180mcu_fd_sc_mcu7t5v0__oai21_1_4 vdd gf180mcu_fd_sc_mcu7t5v0__oai21_1_4/B gf180mcu_fd_sc_mcu7t5v0__xor2_1_16/Z
+ gf180mcu_fd_sc_mcu7t5v0__xor2_1_17/A1 gf180mcu_fd_sc_mcu7t5v0__or4_1_0/A2 vss vdd
+ vss gf180mcu_fd_sc_mcu7t5v0__oai21_1
Xgf180mcu_fd_sc_mcu7t5v0__or2_1_0 vdd vss gf180mcu_fd_sc_mcu7t5v0__or2_1_0/Z gf180mcu_fd_sc_mcu7t5v0__or2_1_0/A1
+ gf180mcu_fd_sc_mcu7t5v0__or2_1_0/A2 vdd vss gf180mcu_fd_sc_mcu7t5v0__or2_1
Xgf180mcu_fd_sc_mcu7t5v0__aoi211_4_2 gf180mcu_fd_sc_mcu7t5v0__nor2_4_37/A1 gf180mcu_fd_sc_mcu7t5v0__nor2_4_37/ZN
+ gf180mcu_fd_sc_mcu7t5v0__nor2_2_40/ZN vdd vss gf180mcu_fd_sc_mcu7t5v0__nor2_1_315/A2
+ gf180mcu_fd_sc_mcu7t5v0__dffq_4_28/Q vdd vss gf180mcu_fd_sc_mcu7t5v0__aoi211_4
Xgf180mcu_fd_sc_mcu7t5v0__nand2_1_250 vdd vss gf180mcu_fd_sc_mcu7t5v0__aoi222_2_2/C1
+ gf180mcu_fd_sc_mcu7t5v0__aoi22_1_95/ZN gf180mcu_fd_sc_mcu7t5v0__aoi22_1_92/ZN vdd
+ vss gf180mcu_fd_sc_mcu7t5v0__nand2_1
Xgf180mcu_fd_sc_mcu7t5v0__nand2_1_261 vdd vss gf180mcu_fd_sc_mcu7t5v0__nand2_1_261/ZN
+ gf180mcu_fd_sc_mcu7t5v0__nand2_1_261/A1 gf180mcu_fd_sc_mcu7t5v0__nand2_1_261/A2
+ vdd vss gf180mcu_fd_sc_mcu7t5v0__nand2_1
Xgf180mcu_fd_sc_mcu7t5v0__nand2_1_272 vdd vss gf180mcu_fd_sc_mcu7t5v0__aoi222_1_3/B1
+ gf180mcu_fd_sc_mcu7t5v0__nand2_1_272/A1 gf180mcu_fd_sc_mcu7t5v0__aoi22_1_89/ZN vdd
+ vss gf180mcu_fd_sc_mcu7t5v0__nand2_1
Xgf180mcu_fd_sc_mcu7t5v0__nand2_1_283 vdd vss gf180mcu_fd_sc_mcu7t5v0__nand2_1_283/ZN
+ gf180mcu_fd_sc_mcu7t5v0__xnor3_1_18/A1 gf180mcu_fd_sc_mcu7t5v0__xnor3_1_18/A3 vdd
+ vss gf180mcu_fd_sc_mcu7t5v0__nand2_1
Xgf180mcu_fd_sc_mcu7t5v0__nand2_1_294 vdd vss gf180mcu_fd_sc_mcu7t5v0__aoi222_2_6/C1
+ gf180mcu_fd_sc_mcu7t5v0__aoi22_1_99/ZN gf180mcu_fd_sc_mcu7t5v0__aoi22_1_98/ZN vdd
+ vss gf180mcu_fd_sc_mcu7t5v0__nand2_1
Xgf180mcu_fd_sc_mcu7t5v0__aoi21_1_40 gf180mcu_fd_sc_mcu7t5v0__aoi21_1_40/B vdd vss
+ gf180mcu_fd_sc_mcu7t5v0__dffq_2_12/D gf180mcu_fd_sc_mcu7t5v0__inv_2_1/ZN gf180mcu_fd_sc_mcu7t5v0__buf_20_0/Z
+ vdd vss gf180mcu_fd_sc_mcu7t5v0__aoi21_1
Xgf180mcu_fd_sc_mcu7t5v0__aoi21_1_51 gf180mcu_fd_sc_mcu7t5v0__aoi21_1_51/B vdd vss
+ gf180mcu_fd_sc_mcu7t5v0__nor2_1_61/A2 gf180mcu_fd_sc_mcu7t5v0__inv_2_2/I gf180mcu_fd_sc_mcu7t5v0__or2_4_4/Z
+ vdd vss gf180mcu_fd_sc_mcu7t5v0__aoi21_1
Xgf180mcu_fd_sc_mcu7t5v0__aoi21_1_62 gf180mcu_fd_sc_mcu7t5v0__aoi21_1_62/B vdd vss
+ gf180mcu_fd_sc_mcu7t5v0__dffq_1_15/D gf180mcu_fd_sc_mcu7t5v0__or2_1_34/A2 gf180mcu_fd_sc_mcu7t5v0__oai22_1_11/ZN
+ vdd vss gf180mcu_fd_sc_mcu7t5v0__aoi21_1
Xgf180mcu_fd_sc_mcu7t5v0__aoi21_1_73 gf180mcu_fd_sc_mcu7t5v0__and3_1_5/A3 vdd vss
+ gf180mcu_fd_sc_mcu7t5v0__nor2_1_80/A2 gf180mcu_fd_sc_mcu7t5v0__and3_1_5/A1 gf180mcu_fd_sc_mcu7t5v0__and3_1_5/A2
+ vdd vss gf180mcu_fd_sc_mcu7t5v0__aoi21_1
Xgf180mcu_fd_sc_mcu7t5v0__aoi21_1_84 gf180mcu_fd_sc_mcu7t5v0__aoi21_1_84/B vdd vss
+ gf180mcu_fd_sc_mcu7t5v0__oai21_1_65/B gf180mcu_fd_sc_mcu7t5v0__oai21_1_65/A1 gf180mcu_fd_sc_mcu7t5v0__xor2_1_55/Z
+ vdd vss gf180mcu_fd_sc_mcu7t5v0__aoi21_1
Xgf180mcu_fd_sc_mcu7t5v0__aoi21_1_95 gf180mcu_fd_sc_mcu7t5v0__aoi21_1_95/B vdd vss
+ gf180mcu_fd_sc_mcu7t5v0__dffq_2_24/D gf180mcu_fd_sc_mcu7t5v0__inv_2_6/ZN gf180mcu_fd_sc_mcu7t5v0__buf_20_0/Z
+ vdd vss gf180mcu_fd_sc_mcu7t5v0__aoi21_1
Xgf180mcu_fd_sc_mcu7t5v0__oai21_1_106 vdd gf180mcu_fd_sc_mcu7t5v0__oai21_1_106/B gf180mcu_fd_sc_mcu7t5v0__oai21_1_106/A2
+ gf180mcu_fd_sc_mcu7t5v0__dffq_1_414/D gf180mcu_fd_sc_mcu7t5v0__and3_1_13/A3 vss
+ vdd vss gf180mcu_fd_sc_mcu7t5v0__oai21_1
Xgf180mcu_fd_sc_mcu7t5v0__oai21_1_117 vdd gf180mcu_fd_sc_mcu7t5v0__buf_8_4/Z gf180mcu_fd_sc_mcu7t5v0__buf_20_0/I
+ gf180mcu_fd_sc_mcu7t5v0__aoi21_1_136/B gf180mcu_fd_sc_mcu7t5v0__mux4_4_3/I3 vss
+ vdd vss gf180mcu_fd_sc_mcu7t5v0__oai21_1
Xgf180mcu_fd_sc_mcu7t5v0__oai21_1_128 vdd gf180mcu_fd_sc_mcu7t5v0__buf_8_4/Z gf180mcu_fd_sc_mcu7t5v0__buf_20_0/I
+ gf180mcu_fd_sc_mcu7t5v0__aoi21_1_288/B gf180mcu_fd_sc_mcu7t5v0__dffq_1_308/Q vss
+ vdd vss gf180mcu_fd_sc_mcu7t5v0__oai21_1
Xgf180mcu_fd_sc_mcu7t5v0__oai21_1_139 vdd gf180mcu_fd_sc_mcu7t5v0__buf_8_8/Z gf180mcu_fd_sc_mcu7t5v0__nand2_4_40/ZN
+ gf180mcu_fd_sc_mcu7t5v0__aoi21_1_150/B gf180mcu_fd_sc_mcu7t5v0__dffq_1_383/Q vss
+ vdd vss gf180mcu_fd_sc_mcu7t5v0__oai21_1
Xgf180mcu_fd_sc_mcu7t5v0__dffq_1_380 vdd gf180mcu_fd_sc_mcu7t5v0__dffq_1_380/Q gf180mcu_fd_sc_mcu7t5v0__dffq_4_15/CLK
+ vss gf180mcu_fd_sc_mcu7t5v0__nor3_1_21/ZN vdd vss gf180mcu_fd_sc_mcu7t5v0__dffq_1
Xgf180mcu_fd_sc_mcu7t5v0__dffq_1_391 vdd gf180mcu_fd_sc_mcu7t5v0__inv_1_12/I gf180mcu_fd_sc_mcu7t5v0__dffq_4_21/CLK
+ vss gf180mcu_fd_sc_mcu7t5v0__dffq_1_391/D vdd vss gf180mcu_fd_sc_mcu7t5v0__dffq_1
Xgf180mcu_fd_sc_mcu7t5v0__oai31_4_2 gf180mcu_fd_sc_mcu7t5v0__oai31_4_2/A3 gf180mcu_fd_sc_mcu7t5v0__oai31_4_2/B
+ vdd vss gf180mcu_fd_sc_mcu7t5v0__oai31_4_2/ZN gf180mcu_fd_sc_mcu7t5v0__dffq_2_50/Q
+ gf180mcu_fd_sc_mcu7t5v0__inv_2_8/I vdd vss gf180mcu_fd_sc_mcu7t5v0__oai31_4
Xgf180mcu_fd_sc_mcu7t5v0__oai22_1_70 gf180mcu_fd_sc_mcu7t5v0__nand2_4_8/ZN gf180mcu_fd_sc_mcu7t5v0__oai22_1_89/B1
+ gf180mcu_fd_sc_mcu7t5v0__oai22_1_70/B2 vdd vss gf180mcu_fd_sc_mcu7t5v0__dffq_1_94/D
+ gf180mcu_fd_sc_mcu7t5v0__oai21_4_9/ZN vdd vss gf180mcu_fd_sc_mcu7t5v0__oai22_1
Xgf180mcu_fd_sc_mcu7t5v0__oai22_1_81 gf180mcu_fd_sc_mcu7t5v0__nand2_4_9/ZN gf180mcu_fd_sc_mcu7t5v0__oai22_1_95/B1
+ gf180mcu_fd_sc_mcu7t5v0__oai22_1_81/B2 vdd vss gf180mcu_fd_sc_mcu7t5v0__dffq_1_88/D
+ gf180mcu_fd_sc_mcu7t5v0__oai22_1_98/A1 vdd vss gf180mcu_fd_sc_mcu7t5v0__oai22_1
Xgf180mcu_fd_sc_mcu7t5v0__oai22_1_92 gf180mcu_fd_sc_mcu7t5v0__nand2_4_7/ZN gf180mcu_fd_sc_mcu7t5v0__oai22_1_94/B1
+ gf180mcu_fd_sc_mcu7t5v0__oai22_1_92/B2 vdd vss gf180mcu_fd_sc_mcu7t5v0__dffq_1_90/D
+ gf180mcu_fd_sc_mcu7t5v0__oai21_4_9/ZN vdd vss gf180mcu_fd_sc_mcu7t5v0__oai22_1
Xgf180mcu_fd_sc_mcu7t5v0__nand2_2_13 vdd vss gf180mcu_fd_sc_mcu7t5v0__oai22_1_33/B1
+ gf180mcu_fd_sc_mcu7t5v0__buf_8_2/Z gf180mcu_fd_sc_mcu7t5v0__nand2_4_4/ZN vdd vss
+ gf180mcu_fd_sc_mcu7t5v0__nand2_2
Xgf180mcu_fd_sc_mcu7t5v0__nand2_2_24 vdd vss gf180mcu_fd_sc_mcu7t5v0__oai22_1_55/B1
+ rst_n gf180mcu_fd_sc_mcu7t5v0__oai22_1_55/A2 vdd vss gf180mcu_fd_sc_mcu7t5v0__nand2_2
Xgf180mcu_fd_sc_mcu7t5v0__nand2_2_35 vdd vss gf180mcu_fd_sc_mcu7t5v0__nor2_2_15/A2
+ gf180mcu_fd_sc_mcu7t5v0__dffq_4_8/Q gf180mcu_fd_sc_mcu7t5v0__inv_2_6/ZN vdd vss
+ gf180mcu_fd_sc_mcu7t5v0__nand2_2
Xgf180mcu_fd_sc_mcu7t5v0__nand2_2_46 vdd vss gf180mcu_fd_sc_mcu7t5v0__nor2_4_24/A1
+ gf180mcu_fd_sc_mcu7t5v0__and3_2_2/A2 gf180mcu_fd_sc_mcu7t5v0__and3_2_1/Z vdd vss
+ gf180mcu_fd_sc_mcu7t5v0__nand2_2
Xgf180mcu_fd_sc_mcu7t5v0__nand2_2_57 vdd vss gf180mcu_fd_sc_mcu7t5v0__and3_2_3/A2
+ gf180mcu_fd_sc_mcu7t5v0__nor2_2_31/A1 gf180mcu_fd_sc_mcu7t5v0__nor2_2_29/ZN vdd
+ vss gf180mcu_fd_sc_mcu7t5v0__nand2_2
Xgf180mcu_fd_sc_mcu7t5v0__nand2_2_68 vdd vss gf180mcu_fd_sc_mcu7t5v0__nand4_1_1/A1
+ gf180mcu_fd_sc_mcu7t5v0__dffq_4_28/Q gf180mcu_fd_sc_mcu7t5v0__nor2_2_41/ZN vdd vss
+ gf180mcu_fd_sc_mcu7t5v0__nand2_2
Xgf180mcu_fd_sc_mcu7t5v0__xor2_1_205 vdd vss gf180mcu_fd_sc_mcu7t5v0__xor2_1_205/Z
+ gf180mcu_fd_sc_mcu7t5v0__or2_1_39/A1 gf180mcu_fd_sc_mcu7t5v0__xor2_1_194/Z vdd vss
+ gf180mcu_fd_sc_mcu7t5v0__xor2_1
Xgf180mcu_fd_sc_mcu7t5v0__xor2_1_216 vdd vss gf180mcu_fd_sc_mcu7t5v0__xor2_1_216/Z
+ gf180mcu_fd_sc_mcu7t5v0__xor2_1_216/A1 gf180mcu_fd_sc_mcu7t5v0__xor2_1_216/A2 vdd
+ vss gf180mcu_fd_sc_mcu7t5v0__xor2_1
Xgf180mcu_fd_sc_mcu7t5v0__xor2_1_227 vdd vss gf180mcu_fd_sc_mcu7t5v0__xor2_1_227/Z
+ gf180mcu_fd_sc_mcu7t5v0__xor2_1_227/A1 gf180mcu_fd_sc_mcu7t5v0__xor2_1_228/Z vdd
+ vss gf180mcu_fd_sc_mcu7t5v0__xor2_1
Xgf180mcu_fd_sc_mcu7t5v0__clkinv_1_230 vdd vss gf180mcu_fd_sc_mcu7t5v0__dffq_1_276/Q
+ gf180mcu_fd_sc_mcu7t5v0__oai22_1_216/B2 vdd vss gf180mcu_fd_sc_mcu7t5v0__clkinv_1
Xgf180mcu_fd_sc_mcu7t5v0__clkinv_1_241 vdd vss gf180mcu_fd_sc_mcu7t5v0__dffq_1_253/Q
+ gf180mcu_fd_sc_mcu7t5v0__oai22_1_252/B2 vdd vss gf180mcu_fd_sc_mcu7t5v0__clkinv_1
Xgf180mcu_fd_sc_mcu7t5v0__clkinv_1_252 vdd vss gf180mcu_fd_sc_mcu7t5v0__dffq_1_234/Q
+ gf180mcu_fd_sc_mcu7t5v0__oai22_1_244/B2 vdd vss gf180mcu_fd_sc_mcu7t5v0__clkinv_1
Xgf180mcu_fd_sc_mcu7t5v0__clkinv_1_263 vdd vss gf180mcu_fd_sc_mcu7t5v0__dffq_1_239/Q
+ gf180mcu_fd_sc_mcu7t5v0__oai22_1_246/B2 vdd vss gf180mcu_fd_sc_mcu7t5v0__clkinv_1
Xgf180mcu_fd_sc_mcu7t5v0__clkinv_1_274 vdd vss gf180mcu_fd_sc_mcu7t5v0__dffq_1_204/Q
+ gf180mcu_fd_sc_mcu7t5v0__oai22_1_200/B2 vdd vss gf180mcu_fd_sc_mcu7t5v0__clkinv_1
Xgf180mcu_fd_sc_mcu7t5v0__clkinv_1_285 vdd vss gf180mcu_fd_sc_mcu7t5v0__nor4_4_1/A2
+ gf180mcu_fd_sc_mcu7t5v0__nand4_4_1/A4 vdd vss gf180mcu_fd_sc_mcu7t5v0__clkinv_1
Xgf180mcu_fd_sc_mcu7t5v0__clkinv_1_296 vdd vss gf180mcu_fd_sc_mcu7t5v0__dffq_1_325/Q
+ gf180mcu_fd_sc_mcu7t5v0__aoi21_1_146/A1 vdd vss gf180mcu_fd_sc_mcu7t5v0__clkinv_1
Xgf180mcu_fd_sc_mcu7t5v0__oai22_4_2 gf180mcu_fd_sc_mcu7t5v0__oai22_4_2/B1 vdd vss
+ gf180mcu_fd_sc_mcu7t5v0__and2_2_9/A2 gf180mcu_fd_sc_mcu7t5v0__oai22_4_3/A1 gf180mcu_fd_sc_mcu7t5v0__oai31_4_1/A1
+ gf180mcu_fd_sc_mcu7t5v0__inv_4_4/I vdd vss gf180mcu_fd_sc_mcu7t5v0__oai22_4
Xgf180mcu_fd_sc_mcu7t5v0__inv_4_2 vss gf180mcu_fd_sc_mcu7t5v0__inv_4_2/ZN gf180mcu_fd_sc_mcu7t5v0__inv_4_2/I
+ vdd vdd vss gf180mcu_fd_sc_mcu7t5v0__inv_4
Xgf180mcu_fd_sc_mcu7t5v0__dffq_2_100 gf180mcu_fd_sc_mcu7t5v0__dffq_2_100/D vdd vss
+ gf180mcu_fd_sc_mcu7t5v0__dffq_4_44/CLK gf180mcu_fd_sc_mcu7t5v0__nor2_2_54/A1 vdd
+ vss gf180mcu_fd_sc_mcu7t5v0__dffq_2
Xgf180mcu_fd_sc_mcu7t5v0__dffq_2_111 gf180mcu_fd_sc_mcu7t5v0__dffq_2_111/D vdd vss
+ gf180mcu_fd_sc_mcu7t5v0__dffq_2_58/CLK gf180mcu_fd_sc_mcu7t5v0__dffq_2_111/Q vdd
+ vss gf180mcu_fd_sc_mcu7t5v0__dffq_2
Xgf180mcu_fd_sc_mcu7t5v0__nand3_1_3 gf180mcu_fd_sc_mcu7t5v0__and2_4_0/A2 vdd vss gf180mcu_fd_sc_mcu7t5v0__or2_1_1/A1
+ gf180mcu_fd_sc_mcu7t5v0__inv_8_1/I gf180mcu_fd_sc_mcu7t5v0__and2_4_0/A1 vdd vss
+ gf180mcu_fd_sc_mcu7t5v0__nand3_1
Xgf180mcu_fd_sc_mcu7t5v0__dffq_4_18 gf180mcu_fd_sc_mcu7t5v0__dffq_4_18/D gf180mcu_fd_sc_mcu7t5v0__mux4_4_3/I0
+ vdd vss gf180mcu_fd_sc_mcu7t5v0__dffq_4_21/CLK vdd vss gf180mcu_fd_sc_mcu7t5v0__dffq_4
Xgf180mcu_fd_sc_mcu7t5v0__dffq_4_29 gf180mcu_fd_sc_mcu7t5v0__dffq_4_29/D gf180mcu_fd_sc_mcu7t5v0__inv_8_2/I
+ vdd vss gf180mcu_fd_sc_mcu7t5v0__dffq_4_44/CLK vdd vss gf180mcu_fd_sc_mcu7t5v0__dffq_4
Xgf180mcu_fd_sc_mcu7t5v0__nand4_4_1 gf180mcu_fd_sc_mcu7t5v0__nor4_4_1/A1 gf180mcu_fd_sc_mcu7t5v0__nand4_4_1/A4
+ vdd vss gf180mcu_fd_sc_mcu7t5v0__or3_1_10/A3 gf180mcu_fd_sc_mcu7t5v0__dffq_2_34/Q
+ gf180mcu_fd_sc_mcu7t5v0__inv_1_8/ZN vdd vss gf180mcu_fd_sc_mcu7t5v0__nand4_4
Xgf180mcu_fd_sc_mcu7t5v0__aoi22_1_100 gf180mcu_fd_sc_mcu7t5v0__nor2_4_9/ZN gf180mcu_fd_sc_mcu7t5v0__dffq_1_165/Q
+ vdd vss gf180mcu_fd_sc_mcu7t5v0__nand2_1_249/A1 gf180mcu_fd_sc_mcu7t5v0__dffq_1_171/Q
+ gf180mcu_fd_sc_mcu7t5v0__nor2_4_8/ZN vdd vss gf180mcu_fd_sc_mcu7t5v0__aoi22_1
Xgf180mcu_fd_sc_mcu7t5v0__aoi22_1_111 gf180mcu_fd_sc_mcu7t5v0__nand2_1_261/ZN gf180mcu_fd_sc_mcu7t5v0__nor2_4_6/ZN
+ vdd vss gf180mcu_fd_sc_mcu7t5v0__nand3_1_43/A1 gf180mcu_fd_sc_mcu7t5v0__nor3_4_11/ZN
+ gf180mcu_fd_sc_mcu7t5v0__nand2_1_212/ZN vdd vss gf180mcu_fd_sc_mcu7t5v0__aoi22_1
Xgf180mcu_fd_sc_mcu7t5v0__aoi22_1_122 gf180mcu_fd_sc_mcu7t5v0__nand2_1_270/ZN gf180mcu_fd_sc_mcu7t5v0__nor2_4_4/ZN
+ vdd vss gf180mcu_fd_sc_mcu7t5v0__nand3_1_45/A1 gf180mcu_fd_sc_mcu7t5v0__nor3_4_11/ZN
+ gf180mcu_fd_sc_mcu7t5v0__nand2_1_221/ZN vdd vss gf180mcu_fd_sc_mcu7t5v0__aoi22_1
Xgf180mcu_fd_sc_mcu7t5v0__aoi22_1_133 gf180mcu_fd_sc_mcu7t5v0__nor2_4_9/ZN gf180mcu_fd_sc_mcu7t5v0__dffq_1_237/Q
+ vdd vss gf180mcu_fd_sc_mcu7t5v0__nand2_1_275/A1 gf180mcu_fd_sc_mcu7t5v0__dffq_1_245/Q
+ gf180mcu_fd_sc_mcu7t5v0__nor2_4_8/ZN vdd vss gf180mcu_fd_sc_mcu7t5v0__aoi22_1
Xgf180mcu_fd_sc_mcu7t5v0__or2_1_16 vdd vss gf180mcu_fd_sc_mcu7t5v0__or2_1_16/Z gf180mcu_fd_sc_mcu7t5v0__or2_1_7/A1
+ gf180mcu_fd_sc_mcu7t5v0__or2_1_16/A2 vdd vss gf180mcu_fd_sc_mcu7t5v0__or2_1
Xgf180mcu_fd_sc_mcu7t5v0__aoi22_1_144 gf180mcu_fd_sc_mcu7t5v0__nor2_4_9/ZN gf180mcu_fd_sc_mcu7t5v0__dffq_1_194/Q
+ vdd vss gf180mcu_fd_sc_mcu7t5v0__nand2_1_262/A1 gf180mcu_fd_sc_mcu7t5v0__dffq_1_39/Q
+ gf180mcu_fd_sc_mcu7t5v0__nor2_4_8/ZN vdd vss gf180mcu_fd_sc_mcu7t5v0__aoi22_1
Xgf180mcu_fd_sc_mcu7t5v0__aoi22_1_155 gf180mcu_fd_sc_mcu7t5v0__nor2_4_26/ZN gf180mcu_fd_sc_mcu7t5v0__nor4_4_1/A2
+ vdd vss gf180mcu_fd_sc_mcu7t5v0__nor2_1_153/A2 gf180mcu_fd_sc_mcu7t5v0__dffq_1_297/Q
+ gf180mcu_fd_sc_mcu7t5v0__or3_2_4/Z vdd vss gf180mcu_fd_sc_mcu7t5v0__aoi22_1
Xgf180mcu_fd_sc_mcu7t5v0__or2_1_27 vdd vss gf180mcu_fd_sc_mcu7t5v0__or2_1_27/Z gf180mcu_fd_sc_mcu7t5v0__or2_1_27/A1
+ gf180mcu_fd_sc_mcu7t5v0__or2_1_27/A2 vdd vss gf180mcu_fd_sc_mcu7t5v0__or2_1
Xgf180mcu_fd_sc_mcu7t5v0__aoi22_1_166 gf180mcu_fd_sc_mcu7t5v0__nand4_1_17/ZN gf180mcu_fd_sc_mcu7t5v0__aoi22_1_166/B2
+ vdd vss gf180mcu_fd_sc_mcu7t5v0__nor2_1_301/A2 gf180mcu_fd_sc_mcu7t5v0__dffq_2_65/Q
+ gf180mcu_fd_sc_mcu7t5v0__or2_4_4/Z vdd vss gf180mcu_fd_sc_mcu7t5v0__aoi22_1
Xgf180mcu_fd_sc_mcu7t5v0__aoi22_1_177 gf180mcu_fd_sc_mcu7t5v0__nand4_1_13/ZN gf180mcu_fd_sc_mcu7t5v0__aoi22_1_177/B2
+ vdd vss gf180mcu_fd_sc_mcu7t5v0__nor2_1_402/A2 gf180mcu_fd_sc_mcu7t5v0__mux4_4_7/I1
+ gf180mcu_fd_sc_mcu7t5v0__or2_4_4/Z vdd vss gf180mcu_fd_sc_mcu7t5v0__aoi22_1
Xgf180mcu_fd_sc_mcu7t5v0__or2_1_38 vdd vss gf180mcu_fd_sc_mcu7t5v0__or2_1_38/Z gf180mcu_fd_sc_mcu7t5v0__or2_1_38/A1
+ gf180mcu_fd_sc_mcu7t5v0__or2_1_38/A2 vdd vss gf180mcu_fd_sc_mcu7t5v0__or2_1
Xgf180mcu_fd_sc_mcu7t5v0__or2_1_49 vdd vss gf180mcu_fd_sc_mcu7t5v0__or2_1_49/Z gf180mcu_fd_sc_mcu7t5v0__or2_1_49/A1
+ gf180mcu_fd_sc_mcu7t5v0__or2_1_49/A2 vdd vss gf180mcu_fd_sc_mcu7t5v0__or2_1
Xgf180mcu_fd_sc_mcu7t5v0__nor2_4_16 vdd vss gf180mcu_fd_sc_mcu7t5v0__nor2_4_16/ZN
+ gf180mcu_fd_sc_mcu7t5v0__nor2_4_22/A1 gf180mcu_fd_sc_mcu7t5v0__nor2_4_28/A2 vdd
+ vss gf180mcu_fd_sc_mcu7t5v0__nor2_4
Xgf180mcu_fd_sc_mcu7t5v0__nor2_4_27 vdd vss gf180mcu_fd_sc_mcu7t5v0__nor2_4_27/ZN
+ gf180mcu_fd_sc_mcu7t5v0__or2_4_2/Z gf180mcu_fd_sc_mcu7t5v0__nor2_4_27/A2 vdd vss
+ gf180mcu_fd_sc_mcu7t5v0__nor2_4
Xgf180mcu_fd_sc_mcu7t5v0__nor2_4_38 vdd vss gf180mcu_fd_sc_mcu7t5v0__nor2_4_38/ZN
+ gf180mcu_fd_sc_mcu7t5v0__nor3_4_18/A1 gf180mcu_fd_sc_mcu7t5v0__nor2_4_38/A2 vdd
+ vss gf180mcu_fd_sc_mcu7t5v0__nor2_4
Xgf180mcu_fd_sc_mcu7t5v0__aoi21_1_302 gf180mcu_fd_sc_mcu7t5v0__nor2_1_321/ZN vdd vss
+ gf180mcu_fd_sc_mcu7t5v0__nor2_1_330/A2 gf180mcu_fd_sc_mcu7t5v0__inv_2_11/I gf180mcu_fd_sc_mcu7t5v0__or2_4_4/Z
+ vdd vss gf180mcu_fd_sc_mcu7t5v0__aoi21_1
Xgf180mcu_fd_sc_mcu7t5v0__aoi21_1_313 gf180mcu_fd_sc_mcu7t5v0__aoi21_1_313/B vdd vss
+ gf180mcu_fd_sc_mcu7t5v0__dffq_2_101/D gf180mcu_fd_sc_mcu7t5v0__nor2_2_53/A1 gf180mcu_fd_sc_mcu7t5v0__buf_20_0/I
+ vdd vss gf180mcu_fd_sc_mcu7t5v0__aoi21_1
Xgf180mcu_fd_sc_mcu7t5v0__aoi21_1_324 gf180mcu_fd_sc_mcu7t5v0__aoi21_1_324/B vdd vss
+ gf180mcu_fd_sc_mcu7t5v0__dffq_2_86/D gf180mcu_fd_sc_mcu7t5v0__nor2_4_41/A1 gf180mcu_fd_sc_mcu7t5v0__buf_20_0/I
+ vdd vss gf180mcu_fd_sc_mcu7t5v0__aoi21_1
Xgf180mcu_fd_sc_mcu7t5v0__aoi21_1_335 gf180mcu_fd_sc_mcu7t5v0__nor2_1_378/ZN vdd vss
+ gf180mcu_fd_sc_mcu7t5v0__or2_1_50/A1 gf180mcu_fd_sc_mcu7t5v0__oai33_2_4/ZN gf180mcu_fd_sc_mcu7t5v0__xor2_1_174/Z
+ vdd vss gf180mcu_fd_sc_mcu7t5v0__aoi21_1
Xgf180mcu_fd_sc_mcu7t5v0__aoi21_1_346 gf180mcu_fd_sc_mcu7t5v0__nor2_2_54/ZN vdd vss
+ gf180mcu_fd_sc_mcu7t5v0__nand2_1_646/A2 gf180mcu_fd_sc_mcu7t5v0__inv_12_1/I gf180mcu_fd_sc_mcu7t5v0__nor2_2_55/ZN
+ vdd vss gf180mcu_fd_sc_mcu7t5v0__aoi21_1
Xgf180mcu_fd_sc_mcu7t5v0__aoi21_1_357 gf180mcu_fd_sc_mcu7t5v0__xor3_1_147/Z vdd vss
+ gf180mcu_fd_sc_mcu7t5v0__aoi21_1_356/B gf180mcu_fd_sc_mcu7t5v0__oai21_1_324/B gf180mcu_fd_sc_mcu7t5v0__or3_1_26/Z
+ vdd vss gf180mcu_fd_sc_mcu7t5v0__aoi21_1
Xgf180mcu_fd_sc_mcu7t5v0__aoi21_1_368 gf180mcu_fd_sc_mcu7t5v0__aoi21_1_368/B vdd vss
+ gf180mcu_fd_sc_mcu7t5v0__dffq_2_100/D gf180mcu_fd_sc_mcu7t5v0__nor2_4_42/A1 gf180mcu_fd_sc_mcu7t5v0__buf_20_0/I
+ vdd vss gf180mcu_fd_sc_mcu7t5v0__aoi21_1
Xgf180mcu_fd_sc_mcu7t5v0__aoi21_1_379 gf180mcu_fd_sc_mcu7t5v0__nor2_1_134/ZN vdd vss
+ gf180mcu_fd_sc_mcu7t5v0__xor3_1_65/A2 gf180mcu_fd_sc_mcu7t5v0__xor3_1_68/A3 gf180mcu_fd_sc_mcu7t5v0__nand2_1_304/ZN
+ vdd vss gf180mcu_fd_sc_mcu7t5v0__aoi21_1
Xgf180mcu_fd_sc_mcu7t5v0__xor3_1_12 gf180mcu_fd_sc_mcu7t5v0__xor3_1_12/A3 vdd vss
+ gf180mcu_fd_sc_mcu7t5v0__xor3_1_12/Z gf180mcu_fd_sc_mcu7t5v0__or4_1_0/A2 gf180mcu_fd_sc_mcu7t5v0__nor3_4_0/A2
+ vdd vss gf180mcu_fd_sc_mcu7t5v0__xor3_1
Xgf180mcu_fd_sc_mcu7t5v0__xor3_1_23 gf180mcu_fd_sc_mcu7t5v0__xor2_2_1/Z vdd vss gf180mcu_fd_sc_mcu7t5v0__xor3_1_23/Z
+ gf180mcu_fd_sc_mcu7t5v0__dffq_2_14/Q gf180mcu_fd_sc_mcu7t5v0__xor3_1_23/A2 vdd vss
+ gf180mcu_fd_sc_mcu7t5v0__xor3_1
Xgf180mcu_fd_sc_mcu7t5v0__aoi222_1_2 vss vdd gf180mcu_fd_sc_mcu7t5v0__nor2_4_13/ZN
+ gf180mcu_fd_sc_mcu7t5v0__aoi222_1_2/C1 gf180mcu_fd_sc_mcu7t5v0__nor2_4_12/ZN gf180mcu_fd_sc_mcu7t5v0__aoi222_1_2/B1
+ gf180mcu_fd_sc_mcu7t5v0__aoi222_1_2/A2 gf180mcu_fd_sc_mcu7t5v0__nor3_4_11/ZN gf180mcu_fd_sc_mcu7t5v0__nand3_1_37/A3
+ vdd vss gf180mcu_fd_sc_mcu7t5v0__aoi222_1
Xgf180mcu_fd_sc_mcu7t5v0__xor3_1_34 gf180mcu_fd_sc_mcu7t5v0__xor3_1_34/A3 vdd vss
+ gf180mcu_fd_sc_mcu7t5v0__xor3_1_34/Z gf180mcu_fd_sc_mcu7t5v0__xor3_1_34/A1 gf180mcu_fd_sc_mcu7t5v0__xor3_1_34/A2
+ vdd vss gf180mcu_fd_sc_mcu7t5v0__xor3_1
Xgf180mcu_fd_sc_mcu7t5v0__xor3_1_45 gf180mcu_fd_sc_mcu7t5v0__xor2_1_43/Z vdd vss gf180mcu_fd_sc_mcu7t5v0__xor3_1_45/Z
+ gf180mcu_fd_sc_mcu7t5v0__xor3_1_45/A1 gf180mcu_fd_sc_mcu7t5v0__xor3_1_45/A2 vdd
+ vss gf180mcu_fd_sc_mcu7t5v0__xor3_1
Xgf180mcu_fd_sc_mcu7t5v0__xor3_1_56 gf180mcu_fd_sc_mcu7t5v0__xor3_1_56/A3 vdd vss
+ gf180mcu_fd_sc_mcu7t5v0__xor3_1_56/Z gf180mcu_fd_sc_mcu7t5v0__inv_3_3/I gf180mcu_fd_sc_mcu7t5v0__xor3_1_56/A2
+ vdd vss gf180mcu_fd_sc_mcu7t5v0__xor3_1
Xgf180mcu_fd_sc_mcu7t5v0__xor3_1_67 gf180mcu_fd_sc_mcu7t5v0__nor3_1_8/A3 vdd vss gf180mcu_fd_sc_mcu7t5v0__xor3_1_67/Z
+ gf180mcu_fd_sc_mcu7t5v0__xor3_1_67/A1 gf180mcu_fd_sc_mcu7t5v0__xor3_1_67/A2 vdd
+ vss gf180mcu_fd_sc_mcu7t5v0__xor3_1
Xgf180mcu_fd_sc_mcu7t5v0__xor3_1_78 gf180mcu_fd_sc_mcu7t5v0__xor3_1_78/A3 vdd vss
+ gf180mcu_fd_sc_mcu7t5v0__xor3_1_78/Z gf180mcu_fd_sc_mcu7t5v0__xor3_1_78/A1 gf180mcu_fd_sc_mcu7t5v0__xor3_1_78/A2
+ vdd vss gf180mcu_fd_sc_mcu7t5v0__xor3_1
Xgf180mcu_fd_sc_mcu7t5v0__xor3_1_89 gf180mcu_fd_sc_mcu7t5v0__xor3_1_89/A3 vdd vss
+ gf180mcu_fd_sc_mcu7t5v0__xor3_1_89/Z gf180mcu_fd_sc_mcu7t5v0__inv_8_0/ZN gf180mcu_fd_sc_mcu7t5v0__nor4_2_5/A3
+ vdd vss gf180mcu_fd_sc_mcu7t5v0__xor3_1
Xgf180mcu_fd_sc_mcu7t5v0__nor3_1_4 gf180mcu_fd_sc_mcu7t5v0__and2_1_6/Z vdd vss gf180mcu_fd_sc_mcu7t5v0__nor3_1_4/ZN
+ gf180mcu_fd_sc_mcu7t5v0__nor3_1_4/A1 gf180mcu_fd_sc_mcu7t5v0__mux2_1_0/S vdd vss
+ gf180mcu_fd_sc_mcu7t5v0__nor3_1
Xgf180mcu_fd_sc_mcu7t5v0__dffq_1_209 vdd gf180mcu_fd_sc_mcu7t5v0__dffq_1_209/Q gf180mcu_fd_sc_mcu7t5v0__dffq_2_26/CLK
+ vss gf180mcu_fd_sc_mcu7t5v0__dffq_1_209/D vdd vss gf180mcu_fd_sc_mcu7t5v0__dffq_1
Xgf180mcu_fd_sc_mcu7t5v0__nor2_1_409 vdd vss gf180mcu_fd_sc_mcu7t5v0__xor2_1_82/A2
+ gf180mcu_fd_sc_mcu7t5v0__nor2_1_409/A1 gf180mcu_fd_sc_mcu7t5v0__and3_1_8/Z vdd vss
+ gf180mcu_fd_sc_mcu7t5v0__nor2_1
Xgf180mcu_fd_sc_mcu7t5v0__nand2_1_602 vdd vss gf180mcu_fd_sc_mcu7t5v0__xor3_1_129/A3
+ gf180mcu_fd_sc_mcu7t5v0__oai21_1_298/B gf180mcu_fd_sc_mcu7t5v0__nand3_1_93/ZN vdd
+ vss gf180mcu_fd_sc_mcu7t5v0__nand2_1
Xgf180mcu_fd_sc_mcu7t5v0__nand2_1_613 vdd vss gf180mcu_fd_sc_mcu7t5v0__xor2_1_166/A2
+ gf180mcu_fd_sc_mcu7t5v0__inv_8_2/I gf180mcu_fd_sc_mcu7t5v0__mux4_4_15/Z vdd vss
+ gf180mcu_fd_sc_mcu7t5v0__nand2_1
Xgf180mcu_fd_sc_mcu7t5v0__nand2_1_624 vdd vss gf180mcu_fd_sc_mcu7t5v0__xor3_1_133/A3
+ gf180mcu_fd_sc_mcu7t5v0__inv_12_1/I gf180mcu_fd_sc_mcu7t5v0__mux4_4_14/Z vdd vss
+ gf180mcu_fd_sc_mcu7t5v0__nand2_1
Xgf180mcu_fd_sc_mcu7t5v0__nand2_1_635 vdd vss gf180mcu_fd_sc_mcu7t5v0__nand2_1_635/ZN
+ gf180mcu_fd_sc_mcu7t5v0__inv_8_1/I gf180mcu_fd_sc_mcu7t5v0__xor2_1_183/Z vdd vss
+ gf180mcu_fd_sc_mcu7t5v0__nand2_1
Xgf180mcu_fd_sc_mcu7t5v0__nand2_1_646 vdd vss gf180mcu_fd_sc_mcu7t5v0__oai211_1_53/B
+ gf180mcu_fd_sc_mcu7t5v0__oai31_1_20/ZN gf180mcu_fd_sc_mcu7t5v0__nand2_1_646/A2 vdd
+ vss gf180mcu_fd_sc_mcu7t5v0__nand2_1
Xgf180mcu_fd_sc_mcu7t5v0__nand2_1_657 vdd vss gf180mcu_fd_sc_mcu7t5v0__nand3_1_97/A1
+ gf180mcu_fd_sc_mcu7t5v0__inv_8_2/I gf180mcu_fd_sc_mcu7t5v0__xor2_1_190/A2 vdd vss
+ gf180mcu_fd_sc_mcu7t5v0__nand2_1
Xgf180mcu_fd_sc_mcu7t5v0__nand2_1_668 vdd vss gf180mcu_fd_sc_mcu7t5v0__nand3_1_96/A3
+ gf180mcu_fd_sc_mcu7t5v0__nor3_1_41/A1 gf180mcu_fd_sc_mcu7t5v0__nor2_2_56/A1 vdd
+ vss gf180mcu_fd_sc_mcu7t5v0__nand2_1
Xgf180mcu_fd_sc_mcu7t5v0__nand2_1_679 vdd vss gf180mcu_fd_sc_mcu7t5v0__xor3_1_147/A3
+ gf180mcu_fd_sc_mcu7t5v0__inv_8_2/I gf180mcu_fd_sc_mcu7t5v0__and4_1_3/A3 vdd vss
+ gf180mcu_fd_sc_mcu7t5v0__nand2_1
Xgf180mcu_fd_sc_mcu7t5v0__nand4_1_12 gf180mcu_fd_sc_mcu7t5v0__nand4_1_12/A3 gf180mcu_fd_sc_mcu7t5v0__nand4_1_12/A4
+ vdd vss gf180mcu_fd_sc_mcu7t5v0__oai211_1_34/B gf180mcu_fd_sc_mcu7t5v0__oai31_1_14/B
+ gf180mcu_fd_sc_mcu7t5v0__nand4_1_12/A2 vdd vss gf180mcu_fd_sc_mcu7t5v0__nand4_1
Xgf180mcu_fd_sc_mcu7t5v0__nand4_1_23 gf180mcu_fd_sc_mcu7t5v0__nand4_1_23/A3 gf180mcu_fd_sc_mcu7t5v0__nand4_1_23/A4
+ vdd vss gf180mcu_fd_sc_mcu7t5v0__oai211_1_47/B gf180mcu_fd_sc_mcu7t5v0__oai211_1_53/C
+ gf180mcu_fd_sc_mcu7t5v0__nand4_1_23/A2 vdd vss gf180mcu_fd_sc_mcu7t5v0__nand4_1
Xgf180mcu_fd_sc_mcu7t5v0__buf_20_0 vdd vss gf180mcu_fd_sc_mcu7t5v0__buf_20_0/Z gf180mcu_fd_sc_mcu7t5v0__buf_20_0/I
+ vdd vss gf180mcu_fd_sc_mcu7t5v0__buf_20
Xgf180mcu_fd_sc_mcu7t5v0__dffq_1_19 vdd gf180mcu_fd_sc_mcu7t5v0__dffq_1_19/Q gf180mcu_fd_sc_mcu7t5v0__dffq_1_99/CLK
+ vss gf180mcu_fd_sc_mcu7t5v0__dffq_1_19/D vdd vss gf180mcu_fd_sc_mcu7t5v0__dffq_1
Xgf180mcu_fd_sc_mcu7t5v0__inv_1_13 vss gf180mcu_fd_sc_mcu7t5v0__inv_1_13/ZN gf180mcu_fd_sc_mcu7t5v0__inv_1_13/I
+ vdd vdd vss gf180mcu_fd_sc_mcu7t5v0__inv_1
Xgf180mcu_fd_sc_mcu7t5v0__inv_1_24 vss gf180mcu_fd_sc_mcu7t5v0__inv_1_24/ZN gf180mcu_fd_sc_mcu7t5v0__inv_1_24/I
+ vdd vdd vss gf180mcu_fd_sc_mcu7t5v0__inv_1
Xgf180mcu_fd_sc_mcu7t5v0__aoi21_1_110 gf180mcu_fd_sc_mcu7t5v0__aoi21_1_110/B vdd vss
+ gf180mcu_fd_sc_mcu7t5v0__dffq_1_290/D gf180mcu_fd_sc_mcu7t5v0__oai21_1_94/A2 gf180mcu_fd_sc_mcu7t5v0__aoi221_2_3/ZN
+ vdd vss gf180mcu_fd_sc_mcu7t5v0__aoi21_1
Xgf180mcu_fd_sc_mcu7t5v0__aoi21_1_121 gf180mcu_fd_sc_mcu7t5v0__or2_1_23/A1 vdd vss
+ gf180mcu_fd_sc_mcu7t5v0__dffq_4_11/D gf180mcu_fd_sc_mcu7t5v0__nand2_1_311/ZN gf180mcu_fd_sc_mcu7t5v0__aoi21_1_121/A2
+ vdd vss gf180mcu_fd_sc_mcu7t5v0__aoi21_1
Xgf180mcu_fd_sc_mcu7t5v0__aoi21_1_132 gf180mcu_fd_sc_mcu7t5v0__aoi21_1_132/B vdd vss
+ gf180mcu_fd_sc_mcu7t5v0__dffq_1_303/D gf180mcu_fd_sc_mcu7t5v0__dffq_4_20/Q gf180mcu_fd_sc_mcu7t5v0__aoi22_4_3/ZN
+ vdd vss gf180mcu_fd_sc_mcu7t5v0__aoi21_1
Xgf180mcu_fd_sc_mcu7t5v0__aoi21_1_143 gf180mcu_fd_sc_mcu7t5v0__nor2_1_161/ZN vdd vss
+ gf180mcu_fd_sc_mcu7t5v0__xor3_1_69/A2 gf180mcu_fd_sc_mcu7t5v0__xor3_1_70/A2 gf180mcu_fd_sc_mcu7t5v0__nand2_1_327/ZN
+ vdd vss gf180mcu_fd_sc_mcu7t5v0__aoi21_1
Xgf180mcu_fd_sc_mcu7t5v0__aoi21_1_154 gf180mcu_fd_sc_mcu7t5v0__aoi21_1_154/B vdd vss
+ gf180mcu_fd_sc_mcu7t5v0__dffq_1_329/D gf180mcu_fd_sc_mcu7t5v0__aoi21_1_154/A1 gf180mcu_fd_sc_mcu7t5v0__nand3_1_55/A2
+ vdd vss gf180mcu_fd_sc_mcu7t5v0__aoi21_1
Xgf180mcu_fd_sc_mcu7t5v0__and2_1_110 vdd vss gf180mcu_fd_sc_mcu7t5v0__and2_1_110/Z
+ gf180mcu_fd_sc_mcu7t5v0__xor2_2_4/A1 gf180mcu_fd_sc_mcu7t5v0__xor2_2_4/A2 vdd vss
+ gf180mcu_fd_sc_mcu7t5v0__and2_1
Xgf180mcu_fd_sc_mcu7t5v0__and2_1_121 vdd vss gf180mcu_fd_sc_mcu7t5v0__oai32_4_2/A1
+ gf180mcu_fd_sc_mcu7t5v0__or3_2_3/A3 gf180mcu_fd_sc_mcu7t5v0__aoi22_2_8/B2 vdd vss
+ gf180mcu_fd_sc_mcu7t5v0__and2_1
Xgf180mcu_fd_sc_mcu7t5v0__aoi21_1_165 gf180mcu_fd_sc_mcu7t5v0__aoi21_1_165/B vdd vss
+ gf180mcu_fd_sc_mcu7t5v0__dffq_1_345/D gf180mcu_fd_sc_mcu7t5v0__aoi21_1_165/A1 gf180mcu_fd_sc_mcu7t5v0__nand2_4_40/ZN
+ vdd vss gf180mcu_fd_sc_mcu7t5v0__aoi21_1
Xgf180mcu_fd_sc_mcu7t5v0__and2_1_132 vdd vss gf180mcu_fd_sc_mcu7t5v0__oai33_2_4/A2
+ gf180mcu_fd_sc_mcu7t5v0__or3_1_24/Z gf180mcu_fd_sc_mcu7t5v0__xor3_1_131/A3 vdd vss
+ gf180mcu_fd_sc_mcu7t5v0__and2_1
Xgf180mcu_fd_sc_mcu7t5v0__aoi21_1_176 gf180mcu_fd_sc_mcu7t5v0__aoi21_1_176/B vdd vss
+ gf180mcu_fd_sc_mcu7t5v0__dffq_1_383/D gf180mcu_fd_sc_mcu7t5v0__aoi21_1_176/A1 gf180mcu_fd_sc_mcu7t5v0__nand2_4_40/ZN
+ vdd vss gf180mcu_fd_sc_mcu7t5v0__aoi21_1
Xgf180mcu_fd_sc_mcu7t5v0__and2_1_143 vdd vss gf180mcu_fd_sc_mcu7t5v0__and2_1_143/Z
+ gf180mcu_fd_sc_mcu7t5v0__inv_8_1/I gf180mcu_fd_sc_mcu7t5v0__and4_1_3/A3 vdd vss
+ gf180mcu_fd_sc_mcu7t5v0__and2_1
Xgf180mcu_fd_sc_mcu7t5v0__aoi21_1_187 gf180mcu_fd_sc_mcu7t5v0__aoi21_1_187/B vdd vss
+ gf180mcu_fd_sc_mcu7t5v0__dffq_1_399/D gf180mcu_fd_sc_mcu7t5v0__dffq_4_20/Q gf180mcu_fd_sc_mcu7t5v0__aoi22_4_4/ZN
+ vdd vss gf180mcu_fd_sc_mcu7t5v0__aoi21_1
Xgf180mcu_fd_sc_mcu7t5v0__aoi21_1_198 gf180mcu_fd_sc_mcu7t5v0__aoi21_1_198/B vdd vss
+ gf180mcu_fd_sc_mcu7t5v0__dffq_1_393/D gf180mcu_fd_sc_mcu7t5v0__aoi22_4_7/ZN gf180mcu_fd_sc_mcu7t5v0__nor2_4_31/ZN
+ vdd vss gf180mcu_fd_sc_mcu7t5v0__aoi21_1
Xgf180mcu_fd_sc_mcu7t5v0__and2_1_154 vdd vss gf180mcu_fd_sc_mcu7t5v0__and2_1_154/Z
+ gf180mcu_fd_sc_mcu7t5v0__or2_1_55/A1 gf180mcu_fd_sc_mcu7t5v0__xor2_1_82/Z vdd vss
+ gf180mcu_fd_sc_mcu7t5v0__and2_1
Xgf180mcu_fd_sc_mcu7t5v0__oai22_1_108 gf180mcu_fd_sc_mcu7t5v0__nand2_4_14/ZN gf180mcu_fd_sc_mcu7t5v0__nand2_2_32/ZN
+ gf180mcu_fd_sc_mcu7t5v0__oai22_1_108/B2 vdd vss gf180mcu_fd_sc_mcu7t5v0__dffq_1_181/D
+ gf180mcu_fd_sc_mcu7t5v0__aoi21_4_4/ZN vdd vss gf180mcu_fd_sc_mcu7t5v0__oai22_1
Xgf180mcu_fd_sc_mcu7t5v0__oai22_1_119 gf180mcu_fd_sc_mcu7t5v0__oai22_1_97/A2 gf180mcu_fd_sc_mcu7t5v0__oai22_1_97/B1
+ gf180mcu_fd_sc_mcu7t5v0__oai22_1_119/B2 vdd vss gf180mcu_fd_sc_mcu7t5v0__dffq_1_108/D
+ gf180mcu_fd_sc_mcu7t5v0__oai22_1_98/A1 vdd vss gf180mcu_fd_sc_mcu7t5v0__oai22_1
Xgf180mcu_fd_sc_mcu7t5v0__nor4_4_2 gf180mcu_fd_sc_mcu7t5v0__nor4_4_2/A3 gf180mcu_fd_sc_mcu7t5v0__or2_4_3/A1
+ vdd vss gf180mcu_fd_sc_mcu7t5v0__nor4_4_2/ZN gf180mcu_fd_sc_mcu7t5v0__nor4_4_2/A1
+ gf180mcu_fd_sc_mcu7t5v0__nor4_4_2/A2 vdd vss gf180mcu_fd_sc_mcu7t5v0__nor4_4
Xgf180mcu_fd_sc_mcu7t5v0__nor2_1_17 vdd vss gf180mcu_fd_sc_mcu7t5v0__or3_1_1/A1 gf180mcu_fd_sc_mcu7t5v0__inv_1_1/ZN
+ gf180mcu_fd_sc_mcu7t5v0__xor2_1_13/A2 vdd vss gf180mcu_fd_sc_mcu7t5v0__nor2_1
Xgf180mcu_fd_sc_mcu7t5v0__nor2_1_28 vdd vss gf180mcu_fd_sc_mcu7t5v0__dffq_2_8/D gf180mcu_fd_sc_mcu7t5v0__nor2_1_28/A1
+ gf180mcu_fd_sc_mcu7t5v0__nor2_1_28/A2 vdd vss gf180mcu_fd_sc_mcu7t5v0__nor2_1
Xgf180mcu_fd_sc_mcu7t5v0__nor2_1_39 vdd vss gf180mcu_fd_sc_mcu7t5v0__nor2_1_39/ZN
+ gf180mcu_fd_sc_mcu7t5v0__dffq_2_14/Q gf180mcu_fd_sc_mcu7t5v0__xor2_2_1/Z vdd vss
+ gf180mcu_fd_sc_mcu7t5v0__nor2_1
Xgf180mcu_fd_sc_mcu7t5v0__nor2_1_206 vdd vss gf180mcu_fd_sc_mcu7t5v0__dffq_1_369/D
+ gf180mcu_fd_sc_mcu7t5v0__nor2_1_206/A1 gf180mcu_fd_sc_mcu7t5v0__nor2_1_206/A2 vdd
+ vss gf180mcu_fd_sc_mcu7t5v0__nor2_1
Xgf180mcu_fd_sc_mcu7t5v0__nor2_1_217 vdd vss gf180mcu_fd_sc_mcu7t5v0__xor3_1_72/A2
+ gf180mcu_fd_sc_mcu7t5v0__inv_8_0/ZN gf180mcu_fd_sc_mcu7t5v0__inv_1_13/I vdd vss
+ gf180mcu_fd_sc_mcu7t5v0__nor2_1
Xgf180mcu_fd_sc_mcu7t5v0__nor2_1_228 vdd vss gf180mcu_fd_sc_mcu7t5v0__nand4_1_9/A4
+ gf180mcu_fd_sc_mcu7t5v0__dffq_1_398/Q gf180mcu_fd_sc_mcu7t5v0__dffq_1_405/Q vdd
+ vss gf180mcu_fd_sc_mcu7t5v0__nor2_1
Xgf180mcu_fd_sc_mcu7t5v0__aoi21_1_2 gf180mcu_fd_sc_mcu7t5v0__or2_4_4/Z vdd vss gf180mcu_fd_sc_mcu7t5v0__aoi22_1_2/B2
+ gf180mcu_fd_sc_mcu7t5v0__nor3_4_2/ZN gf180mcu_fd_sc_mcu7t5v0__xor3_1_58/Z vdd vss
+ gf180mcu_fd_sc_mcu7t5v0__aoi21_1
Xgf180mcu_fd_sc_mcu7t5v0__nor2_1_239 vdd vss gf180mcu_fd_sc_mcu7t5v0__nor3_2_6/A2
+ gf180mcu_fd_sc_mcu7t5v0__and2_1_87/A1 gf180mcu_fd_sc_mcu7t5v0__and2_1_87/A2 vdd
+ vss gf180mcu_fd_sc_mcu7t5v0__nor2_1
Xgf180mcu_fd_sc_mcu7t5v0__nand2_1_410 vdd vss gf180mcu_fd_sc_mcu7t5v0__and2_1_87/A1
+ gf180mcu_fd_sc_mcu7t5v0__inv_8_2/I gf180mcu_fd_sc_mcu7t5v0__mux4_4_6/Z vdd vss gf180mcu_fd_sc_mcu7t5v0__nand2_1
Xgf180mcu_fd_sc_mcu7t5v0__nand2_1_421 vdd vss gf180mcu_fd_sc_mcu7t5v0__xor3_1_86/A2
+ gf180mcu_fd_sc_mcu7t5v0__inv_8_0/I gf180mcu_fd_sc_mcu7t5v0__mux4_4_18/Z vdd vss
+ gf180mcu_fd_sc_mcu7t5v0__nand2_1
Xgf180mcu_fd_sc_mcu7t5v0__nand2_1_432 vdd vss gf180mcu_fd_sc_mcu7t5v0__xnor3_1_27/A1
+ gf180mcu_fd_sc_mcu7t5v0__inv_8_1/I gf180mcu_fd_sc_mcu7t5v0__nor2_2_30/ZN vdd vss
+ gf180mcu_fd_sc_mcu7t5v0__nand2_1
Xgf180mcu_fd_sc_mcu7t5v0__nand2_1_443 vdd vss gf180mcu_fd_sc_mcu7t5v0__nand2_1_443/ZN
+ gf180mcu_fd_sc_mcu7t5v0__xor3_1_82/A2 gf180mcu_fd_sc_mcu7t5v0__xor3_1_82/A3 vdd
+ vss gf180mcu_fd_sc_mcu7t5v0__nand2_1
Xgf180mcu_fd_sc_mcu7t5v0__nand2_1_454 vdd vss gf180mcu_fd_sc_mcu7t5v0__nand3_1_66/A2
+ gf180mcu_fd_sc_mcu7t5v0__or2_1_29/A1 gf180mcu_fd_sc_mcu7t5v0__or2_1_29/A2 vdd vss
+ gf180mcu_fd_sc_mcu7t5v0__nand2_1
Xgf180mcu_fd_sc_mcu7t5v0__nand2_1_465 vdd vss gf180mcu_fd_sc_mcu7t5v0__aoi22_4_9/B1
+ gf180mcu_fd_sc_mcu7t5v0__inv_1_3/I gf180mcu_fd_sc_mcu7t5v0__and2_1_104/Z vdd vss
+ gf180mcu_fd_sc_mcu7t5v0__nand2_1
Xgf180mcu_fd_sc_mcu7t5v0__nand2_1_476 vdd vss gf180mcu_fd_sc_mcu7t5v0__xor3_1_90/A3
+ gf180mcu_fd_sc_mcu7t5v0__xor2_1_130/A2 gf180mcu_fd_sc_mcu7t5v0__nand2_1_477/ZN vdd
+ vss gf180mcu_fd_sc_mcu7t5v0__nand2_1
Xgf180mcu_fd_sc_mcu7t5v0__nand2_1_487 vdd vss gf180mcu_fd_sc_mcu7t5v0__aoi21_2_9/A1
+ gf180mcu_fd_sc_mcu7t5v0__inv_8_0/I gf180mcu_fd_sc_mcu7t5v0__xnor2_1_46/ZN vdd vss
+ gf180mcu_fd_sc_mcu7t5v0__nand2_1
Xgf180mcu_fd_sc_mcu7t5v0__nand2_1_498 vdd vss gf180mcu_fd_sc_mcu7t5v0__xnor3_1_32/A1
+ gf180mcu_fd_sc_mcu7t5v0__inv_4_6/I gf180mcu_fd_sc_mcu7t5v0__nor4_2_5/A1 vdd vss
+ gf180mcu_fd_sc_mcu7t5v0__nand2_1
Xgf180mcu_fd_sc_mcu7t5v0__mux2_1_13 gf180mcu_fd_sc_mcu7t5v0__mux2_1_13/S vdd vss gf180mcu_fd_sc_mcu7t5v0__mux2_1_13/Z
+ gf180mcu_fd_sc_mcu7t5v0__or4_1_3/A2 gf180mcu_fd_sc_mcu7t5v0__nor3_4_21/ZN vdd vss
+ gf180mcu_fd_sc_mcu7t5v0__mux2_1
Xgf180mcu_fd_sc_mcu7t5v0__xor2_1_1 vdd vss gf180mcu_fd_sc_mcu7t5v0__xor2_1_1/Z gf180mcu_fd_sc_mcu7t5v0__xor2_1_1/A1
+ gf180mcu_fd_sc_mcu7t5v0__xor2_1_1/A2 vdd vss gf180mcu_fd_sc_mcu7t5v0__xor2_1
Xgf180mcu_fd_sc_mcu7t5v0__aoi22_1_19 gf180mcu_fd_sc_mcu7t5v0__nor2_4_11/ZN gf180mcu_fd_sc_mcu7t5v0__dffq_1_25/Q
+ vdd vss gf180mcu_fd_sc_mcu7t5v0__aoi22_1_19/ZN gf180mcu_fd_sc_mcu7t5v0__dffq_1_276/Q
+ gf180mcu_fd_sc_mcu7t5v0__nor2_4_10/ZN vdd vss gf180mcu_fd_sc_mcu7t5v0__aoi22_1
Xgf180mcu_fd_sc_mcu7t5v0__oai211_1_2 gf180mcu_fd_sc_mcu7t5v0__oai211_1_2/B gf180mcu_fd_sc_mcu7t5v0__oai211_1_2/C
+ vdd vss gf180mcu_fd_sc_mcu7t5v0__oai211_1_6/A2 gf180mcu_fd_sc_mcu7t5v0__oai21_1_16/A1
+ gf180mcu_fd_sc_mcu7t5v0__xor2_1_212/Z vdd vss gf180mcu_fd_sc_mcu7t5v0__oai211_1
Xgf180mcu_fd_sc_mcu7t5v0__mux2_1_2 gf180mcu_fd_sc_mcu7t5v0__mux2_1_2/S vdd vss gf180mcu_fd_sc_mcu7t5v0__mux2_1_2/Z
+ gf180mcu_fd_sc_mcu7t5v0__mux2_1_2/I0 gf180mcu_fd_sc_mcu7t5v0__mux2_1_2/I1 vdd vss
+ gf180mcu_fd_sc_mcu7t5v0__mux2_1
Xgf180mcu_fd_sc_mcu7t5v0__xnor2_1_13 vdd vss gf180mcu_fd_sc_mcu7t5v0__or2_1_17/A2
+ gf180mcu_fd_sc_mcu7t5v0__or2_1_13/Z gf180mcu_fd_sc_mcu7t5v0__xor2_1_35/Z vdd vss
+ gf180mcu_fd_sc_mcu7t5v0__xnor2_1
Xgf180mcu_fd_sc_mcu7t5v0__xnor2_1_24 vdd vss gf180mcu_fd_sc_mcu7t5v0__xnor2_1_24/ZN
+ gf180mcu_fd_sc_mcu7t5v0__xnor2_1_24/A1 gf180mcu_fd_sc_mcu7t5v0__xor2_1_45/Z vdd
+ vss gf180mcu_fd_sc_mcu7t5v0__xnor2_1
Xgf180mcu_fd_sc_mcu7t5v0__xnor2_1_35 vdd vss gf180mcu_fd_sc_mcu7t5v0__xor3_1_73/A3
+ gf180mcu_fd_sc_mcu7t5v0__nand4_2_2/ZN gf180mcu_fd_sc_mcu7t5v0__xor3_1_75/Z vdd vss
+ gf180mcu_fd_sc_mcu7t5v0__xnor2_1
Xgf180mcu_fd_sc_mcu7t5v0__xnor2_1_46 vdd vss gf180mcu_fd_sc_mcu7t5v0__xnor2_1_46/ZN
+ gf180mcu_fd_sc_mcu7t5v0__nor4_2_5/A3 gf180mcu_fd_sc_mcu7t5v0__xor3_1_89/A3 vdd vss
+ gf180mcu_fd_sc_mcu7t5v0__xnor2_1
Xgf180mcu_fd_sc_mcu7t5v0__xnor2_1_57 vdd vss gf180mcu_fd_sc_mcu7t5v0__xor3_2_2/A3
+ gf180mcu_fd_sc_mcu7t5v0__and4_1_1/Z gf180mcu_fd_sc_mcu7t5v0__xor3_1_139/Z vdd vss
+ gf180mcu_fd_sc_mcu7t5v0__xnor2_1
Xgf180mcu_fd_sc_mcu7t5v0__xnor2_1_68 vdd vss gf180mcu_fd_sc_mcu7t5v0__or2_1_54/A2
+ gf180mcu_fd_sc_mcu7t5v0__xnor2_1_74/ZN gf180mcu_fd_sc_mcu7t5v0__xor2_1_197/Z vdd
+ vss gf180mcu_fd_sc_mcu7t5v0__xnor2_1
Xgf180mcu_fd_sc_mcu7t5v0__xnor2_1_79 vdd vss gf180mcu_fd_sc_mcu7t5v0__and2_1_9/A2
+ gf180mcu_fd_sc_mcu7t5v0__nand3_1_1/A3 gf180mcu_fd_sc_mcu7t5v0__aoi21_1_20/B vdd
+ vss gf180mcu_fd_sc_mcu7t5v0__xnor2_1
Xgf180mcu_fd_sc_mcu7t5v0__dffq_2_40 gf180mcu_fd_sc_mcu7t5v0__dffq_2_40/D vdd vss gf180mcu_fd_sc_mcu7t5v0__dffq_4_21/CLK
+ gf180mcu_fd_sc_mcu7t5v0__dffq_2_40/Q vdd vss gf180mcu_fd_sc_mcu7t5v0__dffq_2
Xgf180mcu_fd_sc_mcu7t5v0__dffq_2_51 gf180mcu_fd_sc_mcu7t5v0__dffq_2_51/D vdd vss gf180mcu_fd_sc_mcu7t5v0__dffq_4_21/CLK
+ gf180mcu_fd_sc_mcu7t5v0__inv_1_11/I vdd vss gf180mcu_fd_sc_mcu7t5v0__dffq_2
Xgf180mcu_fd_sc_mcu7t5v0__and3_1_3 gf180mcu_fd_sc_mcu7t5v0__xor2_1_24/Z vdd vss gf180mcu_fd_sc_mcu7t5v0__and3_1_3/Z
+ gf180mcu_fd_sc_mcu7t5v0__or2_1_8/Z gf180mcu_fd_sc_mcu7t5v0__and3_1_3/A2 vdd vss
+ gf180mcu_fd_sc_mcu7t5v0__and3_1
Xgf180mcu_fd_sc_mcu7t5v0__dffq_2_62 gf180mcu_fd_sc_mcu7t5v0__dffq_2_62/D vdd vss gf180mcu_fd_sc_mcu7t5v0__dffq_4_1/CLK
+ gf180mcu_fd_sc_mcu7t5v0__inv_1_15/I vdd vss gf180mcu_fd_sc_mcu7t5v0__dffq_2
Xgf180mcu_fd_sc_mcu7t5v0__dffq_2_73 gf180mcu_fd_sc_mcu7t5v0__dffq_2_73/D vdd vss gf180mcu_fd_sc_mcu7t5v0__dffq_4_44/CLK
+ gf180mcu_fd_sc_mcu7t5v0__inv_2_13/I vdd vss gf180mcu_fd_sc_mcu7t5v0__dffq_2
Xgf180mcu_fd_sc_mcu7t5v0__dffq_2_84 gf180mcu_fd_sc_mcu7t5v0__dffq_2_84/D vdd vss gf180mcu_fd_sc_mcu7t5v0__dffq_4_44/CLK
+ gf180mcu_fd_sc_mcu7t5v0__mux4_2_1/I2 vdd vss gf180mcu_fd_sc_mcu7t5v0__dffq_2
Xgf180mcu_fd_sc_mcu7t5v0__dffq_2_95 gf180mcu_fd_sc_mcu7t5v0__dffq_2_95/D vdd vss gf180mcu_fd_sc_mcu7t5v0__dffq_4_1/CLK
+ gf180mcu_fd_sc_mcu7t5v0__dffq_2_95/Q vdd vss gf180mcu_fd_sc_mcu7t5v0__dffq_2
Xgf180mcu_fd_sc_mcu7t5v0__oai21_1_5 vdd gf180mcu_fd_sc_mcu7t5v0__inv_1_0/ZN gf180mcu_fd_sc_mcu7t5v0__or2_1_0/A2
+ gf180mcu_fd_sc_mcu7t5v0__oai21_1_5/ZN gf180mcu_fd_sc_mcu7t5v0__or2_1_0/A1 vss vdd
+ vss gf180mcu_fd_sc_mcu7t5v0__oai21_1
Xgf180mcu_fd_sc_mcu7t5v0__or2_1_1 vdd vss gf180mcu_fd_sc_mcu7t5v0__or2_1_1/Z gf180mcu_fd_sc_mcu7t5v0__or2_1_1/A1
+ gf180mcu_fd_sc_mcu7t5v0__or2_1_1/A2 vdd vss gf180mcu_fd_sc_mcu7t5v0__or2_1
Xgf180mcu_fd_sc_mcu7t5v0__aoi22_4_0 gf180mcu_fd_sc_mcu7t5v0__oai21_2_5/ZN gf180mcu_fd_sc_mcu7t5v0__nor2_4_2/ZN
+ gf180mcu_fd_sc_mcu7t5v0__inv_1_2/ZN vdd vss gf180mcu_fd_sc_mcu7t5v0__nor4_2_2/A4
+ gf180mcu_fd_sc_mcu7t5v0__aoi22_4_0/A1 vdd vss gf180mcu_fd_sc_mcu7t5v0__aoi22_4
Xgf180mcu_fd_sc_mcu7t5v0__nand2_1_240 vdd vss gf180mcu_fd_sc_mcu7t5v0__aoi222_1_5/B1
+ gf180mcu_fd_sc_mcu7t5v0__nand2_1_240/A1 gf180mcu_fd_sc_mcu7t5v0__aoi22_1_75/ZN vdd
+ vss gf180mcu_fd_sc_mcu7t5v0__nand2_1
Xgf180mcu_fd_sc_mcu7t5v0__nand2_1_251 vdd vss gf180mcu_fd_sc_mcu7t5v0__aoi222_2_3/A2
+ gf180mcu_fd_sc_mcu7t5v0__aoi22_1_97/ZN gf180mcu_fd_sc_mcu7t5v0__aoi22_1_96/ZN vdd
+ vss gf180mcu_fd_sc_mcu7t5v0__nand2_1
Xgf180mcu_fd_sc_mcu7t5v0__nand2_1_262 vdd vss gf180mcu_fd_sc_mcu7t5v0__aoi222_2_7/A2
+ gf180mcu_fd_sc_mcu7t5v0__nand2_1_262/A1 gf180mcu_fd_sc_mcu7t5v0__aoi22_1_23/ZN vdd
+ vss gf180mcu_fd_sc_mcu7t5v0__nand2_1
Xgf180mcu_fd_sc_mcu7t5v0__nand2_1_273 vdd vss gf180mcu_fd_sc_mcu7t5v0__aoi222_1_7/A2
+ gf180mcu_fd_sc_mcu7t5v0__nand2_1_273/A1 gf180mcu_fd_sc_mcu7t5v0__nand2_1_273/A2
+ vdd vss gf180mcu_fd_sc_mcu7t5v0__nand2_1
Xgf180mcu_fd_sc_mcu7t5v0__nand2_1_284 vdd vss gf180mcu_fd_sc_mcu7t5v0__and2_1_42/A2
+ gf180mcu_fd_sc_mcu7t5v0__inv_8_0/I gf180mcu_fd_sc_mcu7t5v0__mux4_4_0/Z vdd vss gf180mcu_fd_sc_mcu7t5v0__nand2_1
Xgf180mcu_fd_sc_mcu7t5v0__nand2_1_295 vdd vss gf180mcu_fd_sc_mcu7t5v0__nand2_1_295/ZN
+ gf180mcu_fd_sc_mcu7t5v0__nand2_1_295/A1 gf180mcu_fd_sc_mcu7t5v0__aoi22_1_64/ZN vdd
+ vss gf180mcu_fd_sc_mcu7t5v0__nand2_1
Xgf180mcu_fd_sc_mcu7t5v0__aoi21_1_30 gf180mcu_fd_sc_mcu7t5v0__nor3_1_5/ZN vdd vss
+ gf180mcu_fd_sc_mcu7t5v0__xor3_1_16/A2 gf180mcu_fd_sc_mcu7t5v0__xor3_1_17/A2 gf180mcu_fd_sc_mcu7t5v0__oai21_1_13/ZN
+ vdd vss gf180mcu_fd_sc_mcu7t5v0__aoi21_1
Xgf180mcu_fd_sc_mcu7t5v0__aoi21_1_41 gf180mcu_fd_sc_mcu7t5v0__aoi21_1_41/B vdd vss
+ gf180mcu_fd_sc_mcu7t5v0__dffq_4_0/D gf180mcu_fd_sc_mcu7t5v0__nor2_2_6/A1 gf180mcu_fd_sc_mcu7t5v0__buf_20_0/Z
+ vdd vss gf180mcu_fd_sc_mcu7t5v0__aoi21_1
Xgf180mcu_fd_sc_mcu7t5v0__aoi21_1_52 gf180mcu_fd_sc_mcu7t5v0__xor3_1_32/A3 vdd vss
+ gf180mcu_fd_sc_mcu7t5v0__oai21_1_43/A2 gf180mcu_fd_sc_mcu7t5v0__inv_8_2/I gf180mcu_fd_sc_mcu7t5v0__or4_1_1/A3
+ vdd vss gf180mcu_fd_sc_mcu7t5v0__aoi21_1
Xgf180mcu_fd_sc_mcu7t5v0__aoi21_1_63 gf180mcu_fd_sc_mcu7t5v0__aoi21_1_63/B vdd vss
+ gf180mcu_fd_sc_mcu7t5v0__dffq_2_15/D gf180mcu_fd_sc_mcu7t5v0__inv_3_3/ZN gf180mcu_fd_sc_mcu7t5v0__or2_4_4/Z
+ vdd vss gf180mcu_fd_sc_mcu7t5v0__aoi21_1
Xgf180mcu_fd_sc_mcu7t5v0__aoi21_1_74 gf180mcu_fd_sc_mcu7t5v0__aoi21_1_7/B vdd vss
+ gf180mcu_fd_sc_mcu7t5v0__dffq_2_22/D gf180mcu_fd_sc_mcu7t5v0__aoi21_1_74/A1 gf180mcu_fd_sc_mcu7t5v0__aoi21_1_74/A2
+ vdd vss gf180mcu_fd_sc_mcu7t5v0__aoi21_1
Xgf180mcu_fd_sc_mcu7t5v0__aoi21_1_85 gf180mcu_fd_sc_mcu7t5v0__and2_1_31/Z vdd vss
+ gf180mcu_fd_sc_mcu7t5v0__xor3_1_54/A2 gf180mcu_fd_sc_mcu7t5v0__oai21_1_65/A1 gf180mcu_fd_sc_mcu7t5v0__xor2_1_55/Z
+ vdd vss gf180mcu_fd_sc_mcu7t5v0__aoi21_1
Xgf180mcu_fd_sc_mcu7t5v0__aoi21_1_96 gf180mcu_fd_sc_mcu7t5v0__aoi21_1_96/B vdd vss
+ gf180mcu_fd_sc_mcu7t5v0__dffq_4_7/D gf180mcu_fd_sc_mcu7t5v0__nor2_2_14/A1 gf180mcu_fd_sc_mcu7t5v0__buf_20_0/Z
+ vdd vss gf180mcu_fd_sc_mcu7t5v0__aoi21_1
Xgf180mcu_fd_sc_mcu7t5v0__oai21_1_107 vdd gf180mcu_fd_sc_mcu7t5v0__buf_8_7/Z gf180mcu_fd_sc_mcu7t5v0__dffq_4_20/Q
+ gf180mcu_fd_sc_mcu7t5v0__aoi21_1_126/B gf180mcu_fd_sc_mcu7t5v0__dffq_1_298/Q vss
+ vdd vss gf180mcu_fd_sc_mcu7t5v0__oai21_1
Xgf180mcu_fd_sc_mcu7t5v0__oai21_1_118 vdd gf180mcu_fd_sc_mcu7t5v0__buf_8_4/Z gf180mcu_fd_sc_mcu7t5v0__buf_20_0/I
+ gf180mcu_fd_sc_mcu7t5v0__aoi21_1_291/B gf180mcu_fd_sc_mcu7t5v0__dffq_1_307/Q vss
+ vdd vss gf180mcu_fd_sc_mcu7t5v0__oai21_1
Xgf180mcu_fd_sc_mcu7t5v0__oai21_1_129 vdd gf180mcu_fd_sc_mcu7t5v0__and2_4_3/Z gf180mcu_fd_sc_mcu7t5v0__or2_1_34/A2
+ gf180mcu_fd_sc_mcu7t5v0__nor2_1_169/A2 gf180mcu_fd_sc_mcu7t5v0__mux4_4_2/I0 vss
+ vdd vss gf180mcu_fd_sc_mcu7t5v0__oai21_1
Xgf180mcu_fd_sc_mcu7t5v0__dffq_1_370 vdd gf180mcu_fd_sc_mcu7t5v0__nor4_1_4/A2 gf180mcu_fd_sc_mcu7t5v0__dffq_4_21/CLK
+ vss gf180mcu_fd_sc_mcu7t5v0__and2_1_76/Z vdd vss gf180mcu_fd_sc_mcu7t5v0__dffq_1
Xgf180mcu_fd_sc_mcu7t5v0__dffq_1_381 vdd gf180mcu_fd_sc_mcu7t5v0__dffq_1_381/Q gf180mcu_fd_sc_mcu7t5v0__dffq_2_58/CLK
+ vss gf180mcu_fd_sc_mcu7t5v0__dffq_1_381/D vdd vss gf180mcu_fd_sc_mcu7t5v0__dffq_1
Xgf180mcu_fd_sc_mcu7t5v0__dffq_1_392 vdd gf180mcu_fd_sc_mcu7t5v0__dffq_1_392/Q gf180mcu_fd_sc_mcu7t5v0__dffq_4_21/CLK
+ vss gf180mcu_fd_sc_mcu7t5v0__dffq_1_392/D vdd vss gf180mcu_fd_sc_mcu7t5v0__dffq_1
Xgf180mcu_fd_sc_mcu7t5v0__oai31_4_3 gf180mcu_fd_sc_mcu7t5v0__inv_4_5/ZN gf180mcu_fd_sc_mcu7t5v0__oai31_4_3/B
+ vdd vss gf180mcu_fd_sc_mcu7t5v0__oai31_4_3/ZN gf180mcu_fd_sc_mcu7t5v0__oai31_4_3/A1
+ gf180mcu_fd_sc_mcu7t5v0__or2_2_1/A1 vdd vss gf180mcu_fd_sc_mcu7t5v0__oai31_4
Xgf180mcu_fd_sc_mcu7t5v0__oai22_1_60 gf180mcu_fd_sc_mcu7t5v0__nand2_4_6/ZN gf180mcu_fd_sc_mcu7t5v0__oai22_1_96/B1
+ gf180mcu_fd_sc_mcu7t5v0__oai22_1_60/B2 vdd vss gf180mcu_fd_sc_mcu7t5v0__dffq_1_69/D
+ gf180mcu_fd_sc_mcu7t5v0__oai21_4_9/ZN vdd vss gf180mcu_fd_sc_mcu7t5v0__oai22_1
Xgf180mcu_fd_sc_mcu7t5v0__oai22_1_71 gf180mcu_fd_sc_mcu7t5v0__nand2_4_8/ZN gf180mcu_fd_sc_mcu7t5v0__oai22_1_89/B1
+ gf180mcu_fd_sc_mcu7t5v0__oai22_1_71/B2 vdd vss gf180mcu_fd_sc_mcu7t5v0__dffq_1_85/D
+ gf180mcu_fd_sc_mcu7t5v0__aoi21_4_5/ZN vdd vss gf180mcu_fd_sc_mcu7t5v0__oai22_1
Xgf180mcu_fd_sc_mcu7t5v0__oai22_1_82 gf180mcu_fd_sc_mcu7t5v0__oai22_1_97/A2 gf180mcu_fd_sc_mcu7t5v0__oai22_1_97/B1
+ gf180mcu_fd_sc_mcu7t5v0__oai22_1_82/B2 vdd vss gf180mcu_fd_sc_mcu7t5v0__dffq_1_257/D
+ gf180mcu_fd_sc_mcu7t5v0__oai21_4_9/ZN vdd vss gf180mcu_fd_sc_mcu7t5v0__oai22_1
Xgf180mcu_fd_sc_mcu7t5v0__oai22_1_93 gf180mcu_fd_sc_mcu7t5v0__nand2_4_7/ZN gf180mcu_fd_sc_mcu7t5v0__oai22_1_94/B1
+ gf180mcu_fd_sc_mcu7t5v0__oai22_1_93/B2 vdd vss gf180mcu_fd_sc_mcu7t5v0__dffq_1_91/D
+ gf180mcu_fd_sc_mcu7t5v0__aoi21_4_3/ZN vdd vss gf180mcu_fd_sc_mcu7t5v0__oai22_1
Xgf180mcu_fd_sc_mcu7t5v0__nand2_2_14 vdd vss gf180mcu_fd_sc_mcu7t5v0__oai22_1_48/A2
+ gf180mcu_fd_sc_mcu7t5v0__buf_8_2/Z gf180mcu_fd_sc_mcu7t5v0__nand2_4_5/ZN vdd vss
+ gf180mcu_fd_sc_mcu7t5v0__nand2_2
Xgf180mcu_fd_sc_mcu7t5v0__nand2_2_25 vdd vss gf180mcu_fd_sc_mcu7t5v0__nand2_2_25/ZN
+ rst_n gf180mcu_fd_sc_mcu7t5v0__nand2_4_18/ZN vdd vss gf180mcu_fd_sc_mcu7t5v0__nand2_2
Xgf180mcu_fd_sc_mcu7t5v0__nand2_2_36 vdd vss gf180mcu_fd_sc_mcu7t5v0__oai22_1_43/B1
+ gf180mcu_fd_sc_mcu7t5v0__buf_8_2/Z gf180mcu_fd_sc_mcu7t5v0__oai22_1_43/A2 vdd vss
+ gf180mcu_fd_sc_mcu7t5v0__nand2_2
Xgf180mcu_fd_sc_mcu7t5v0__nand2_2_47 vdd vss gf180mcu_fd_sc_mcu7t5v0__nor2_4_26/A2
+ gf180mcu_fd_sc_mcu7t5v0__nor2_1_152/A2 gf180mcu_fd_sc_mcu7t5v0__nor4_4_2/ZN vdd
+ vss gf180mcu_fd_sc_mcu7t5v0__nand2_2
Xgf180mcu_fd_sc_mcu7t5v0__nand2_2_58 vdd vss gf180mcu_fd_sc_mcu7t5v0__xor3_1_88/A2
+ gf180mcu_fd_sc_mcu7t5v0__and2_2_9/A1 gf180mcu_fd_sc_mcu7t5v0__and2_2_9/A2 vdd vss
+ gf180mcu_fd_sc_mcu7t5v0__nand2_2
Xgf180mcu_fd_sc_mcu7t5v0__nand2_2_69 vdd vss gf180mcu_fd_sc_mcu7t5v0__oai31_1_1/B
+ gf180mcu_fd_sc_mcu7t5v0__inv_2_12/I gf180mcu_fd_sc_mcu7t5v0__nor2_2_43/ZN vdd vss
+ gf180mcu_fd_sc_mcu7t5v0__nand2_2
Xgf180mcu_fd_sc_mcu7t5v0__xor2_1_206 vdd vss gf180mcu_fd_sc_mcu7t5v0__xor2_1_206/Z
+ gf180mcu_fd_sc_mcu7t5v0__xor2_1_206/A1 gf180mcu_fd_sc_mcu7t5v0__xor2_1_206/A2 vdd
+ vss gf180mcu_fd_sc_mcu7t5v0__xor2_1
Xgf180mcu_fd_sc_mcu7t5v0__xor2_1_217 vdd vss gf180mcu_fd_sc_mcu7t5v0__xor2_1_217/Z
+ gf180mcu_fd_sc_mcu7t5v0__or3_1_27/A1 gf180mcu_fd_sc_mcu7t5v0__xor2_1_218/Z vdd vss
+ gf180mcu_fd_sc_mcu7t5v0__xor2_1
Xgf180mcu_fd_sc_mcu7t5v0__xor2_1_228 vdd vss gf180mcu_fd_sc_mcu7t5v0__xor2_1_228/Z
+ gf180mcu_fd_sc_mcu7t5v0__inv_8_2/I gf180mcu_fd_sc_mcu7t5v0__xor2_1_228/A2 vdd vss
+ gf180mcu_fd_sc_mcu7t5v0__xor2_1
Xgf180mcu_fd_sc_mcu7t5v0__clkinv_1_220 vdd vss gf180mcu_fd_sc_mcu7t5v0__dffq_1_248/Q
+ gf180mcu_fd_sc_mcu7t5v0__oai22_1_203/B2 vdd vss gf180mcu_fd_sc_mcu7t5v0__clkinv_1
Xgf180mcu_fd_sc_mcu7t5v0__clkinv_1_231 vdd vss gf180mcu_fd_sc_mcu7t5v0__dffq_1_258/Q
+ gf180mcu_fd_sc_mcu7t5v0__oai22_1_97/B2 vdd vss gf180mcu_fd_sc_mcu7t5v0__clkinv_1
Xgf180mcu_fd_sc_mcu7t5v0__clkinv_1_242 vdd vss gf180mcu_fd_sc_mcu7t5v0__dffq_1_216/Q
+ gf180mcu_fd_sc_mcu7t5v0__oai22_1_224/B2 vdd vss gf180mcu_fd_sc_mcu7t5v0__clkinv_1
Xgf180mcu_fd_sc_mcu7t5v0__clkinv_1_253 vdd vss gf180mcu_fd_sc_mcu7t5v0__dffq_1_223/Q
+ gf180mcu_fd_sc_mcu7t5v0__oai22_1_241/B2 vdd vss gf180mcu_fd_sc_mcu7t5v0__clkinv_1
Xgf180mcu_fd_sc_mcu7t5v0__clkinv_1_264 vdd vss gf180mcu_fd_sc_mcu7t5v0__dffq_1_245/Q
+ gf180mcu_fd_sc_mcu7t5v0__oai22_1_247/B2 vdd vss gf180mcu_fd_sc_mcu7t5v0__clkinv_1
Xgf180mcu_fd_sc_mcu7t5v0__clkinv_1_275 vdd vss gf180mcu_fd_sc_mcu7t5v0__xor3_1_68/Z
+ gf180mcu_fd_sc_mcu7t5v0__nor2_1_126/A1 vdd vss gf180mcu_fd_sc_mcu7t5v0__clkinv_1
Xgf180mcu_fd_sc_mcu7t5v0__clkinv_1_286 vdd vss gf180mcu_fd_sc_mcu7t5v0__oai32_4_0/ZN
+ gf180mcu_fd_sc_mcu7t5v0__xor2_1_224/A1 vdd vss gf180mcu_fd_sc_mcu7t5v0__clkinv_1
Xgf180mcu_fd_sc_mcu7t5v0__clkinv_1_297 vdd vss gf180mcu_fd_sc_mcu7t5v0__dffq_1_324/Q
+ gf180mcu_fd_sc_mcu7t5v0__aoi21_1_159/A1 vdd vss gf180mcu_fd_sc_mcu7t5v0__clkinv_1
Xgf180mcu_fd_sc_mcu7t5v0__oai22_4_3 gf180mcu_fd_sc_mcu7t5v0__oai22_4_3/B1 vdd vss
+ gf180mcu_fd_sc_mcu7t5v0__oai22_4_3/ZN gf180mcu_fd_sc_mcu7t5v0__oai22_4_3/A1 gf180mcu_fd_sc_mcu7t5v0__inv_1_15/ZN
+ gf180mcu_fd_sc_mcu7t5v0__inv_4_4/I vdd vss gf180mcu_fd_sc_mcu7t5v0__oai22_4
Xgf180mcu_fd_sc_mcu7t5v0__inv_4_3 vss gf180mcu_fd_sc_mcu7t5v0__inv_4_3/ZN gf180mcu_fd_sc_mcu7t5v0__inv_4_3/I
+ vdd vdd vss gf180mcu_fd_sc_mcu7t5v0__inv_4
Xgf180mcu_fd_sc_mcu7t5v0__dffq_2_101 gf180mcu_fd_sc_mcu7t5v0__dffq_2_101/D vdd vss
+ gf180mcu_fd_sc_mcu7t5v0__dffq_4_44/CLK gf180mcu_fd_sc_mcu7t5v0__nor3_1_41/A1 vdd
+ vss gf180mcu_fd_sc_mcu7t5v0__dffq_2
Xgf180mcu_fd_sc_mcu7t5v0__oai22_1_280 gf180mcu_fd_sc_mcu7t5v0__oai22_1_280/A2 gf180mcu_fd_sc_mcu7t5v0__xnor3_1_47/A1
+ gf180mcu_fd_sc_mcu7t5v0__xnor3_1_44/A3 vdd vss gf180mcu_fd_sc_mcu7t5v0__xor2_1_197/A1
+ gf180mcu_fd_sc_mcu7t5v0__xor3_1_147/A1 vdd vss gf180mcu_fd_sc_mcu7t5v0__oai22_1
Xgf180mcu_fd_sc_mcu7t5v0__oai31_2_0 gf180mcu_fd_sc_mcu7t5v0__oai31_2_0/A2 gf180mcu_fd_sc_mcu7t5v0__dffq_2_53/Q
+ gf180mcu_fd_sc_mcu7t5v0__buf_8_8/I vdd vss gf180mcu_fd_sc_mcu7t5v0__oai31_2_0/ZN
+ gf180mcu_fd_sc_mcu7t5v0__or2_1_20/A1 vdd vss gf180mcu_fd_sc_mcu7t5v0__oai31_2
Xgf180mcu_fd_sc_mcu7t5v0__nand3_1_4 gf180mcu_fd_sc_mcu7t5v0__xor2_1_14/Z vdd vss gf180mcu_fd_sc_mcu7t5v0__nand3_1_4/ZN
+ gf180mcu_fd_sc_mcu7t5v0__nand3_1_4/A1 gf180mcu_fd_sc_mcu7t5v0__nand3_1_4/A2 vdd
+ vss gf180mcu_fd_sc_mcu7t5v0__nand3_1
Xgf180mcu_fd_sc_mcu7t5v0__oai22_2_0 gf180mcu_fd_sc_mcu7t5v0__oai22_2_0/B2 vdd vss
+ gf180mcu_fd_sc_mcu7t5v0__oai22_2_0/ZN gf180mcu_fd_sc_mcu7t5v0__mux2_1_6/S gf180mcu_fd_sc_mcu7t5v0__or2_1_11/A1
+ gf180mcu_fd_sc_mcu7t5v0__nor4_2_0/ZN vdd vss gf180mcu_fd_sc_mcu7t5v0__oai22_2
Xgf180mcu_fd_sc_mcu7t5v0__dffq_4_19 gf180mcu_fd_sc_mcu7t5v0__dffq_4_19/D gf180mcu_fd_sc_mcu7t5v0__mux4_4_5/I0
+ vdd vss gf180mcu_fd_sc_mcu7t5v0__dffq_4_21/CLK vdd vss gf180mcu_fd_sc_mcu7t5v0__dffq_4
Xgf180mcu_fd_sc_mcu7t5v0__clkinv_2_10 vdd vss gf180mcu_fd_sc_mcu7t5v0__dffq_1_443/Q
+ gf180mcu_fd_sc_mcu7t5v0__xor3_1_92/A1 vdd vss gf180mcu_fd_sc_mcu7t5v0__clkinv_2
Xgf180mcu_fd_sc_mcu7t5v0__inv_2_0 vss gf180mcu_fd_sc_mcu7t5v0__inv_2_0/ZN gf180mcu_fd_sc_mcu7t5v0__inv_2_0/I
+ vdd vdd vss gf180mcu_fd_sc_mcu7t5v0__inv_2
Xgf180mcu_fd_sc_mcu7t5v0__nand4_4_2 gf180mcu_fd_sc_mcu7t5v0__nor2_4_23/ZN gf180mcu_fd_sc_mcu7t5v0__nor4_4_1/ZN
+ vdd vss gf180mcu_fd_sc_mcu7t5v0__nand4_4_2/ZN gf180mcu_fd_sc_mcu7t5v0__nand4_4_2/A1
+ gf180mcu_fd_sc_mcu7t5v0__dffq_2_44/Q vdd vss gf180mcu_fd_sc_mcu7t5v0__nand4_4
Xgf180mcu_fd_sc_mcu7t5v0__aoi22_1_101 gf180mcu_fd_sc_mcu7t5v0__nor2_4_11/ZN gf180mcu_fd_sc_mcu7t5v0__dffq_1_164/Q
+ vdd vss gf180mcu_fd_sc_mcu7t5v0__nand2_1_248/A2 gf180mcu_fd_sc_mcu7t5v0__dffq_1_172/Q
+ gf180mcu_fd_sc_mcu7t5v0__nor2_4_10/ZN vdd vss gf180mcu_fd_sc_mcu7t5v0__aoi22_1
Xgf180mcu_fd_sc_mcu7t5v0__aoi22_1_112 gf180mcu_fd_sc_mcu7t5v0__nor2_4_11/ZN gf180mcu_fd_sc_mcu7t5v0__dffq_1_217/Q
+ vdd vss gf180mcu_fd_sc_mcu7t5v0__nand2_1_261/A2 gf180mcu_fd_sc_mcu7t5v0__dffq_1_205/Q
+ gf180mcu_fd_sc_mcu7t5v0__nor2_4_10/ZN vdd vss gf180mcu_fd_sc_mcu7t5v0__aoi22_1
Xgf180mcu_fd_sc_mcu7t5v0__aoi22_1_123 gf180mcu_fd_sc_mcu7t5v0__nor2_4_11/ZN gf180mcu_fd_sc_mcu7t5v0__dffq_1_218/Q
+ vdd vss gf180mcu_fd_sc_mcu7t5v0__nand2_1_271/A2 gf180mcu_fd_sc_mcu7t5v0__dffq_1_220/Q
+ gf180mcu_fd_sc_mcu7t5v0__nor2_4_10/ZN vdd vss gf180mcu_fd_sc_mcu7t5v0__aoi22_1
Xgf180mcu_fd_sc_mcu7t5v0__aoi22_1_134 gf180mcu_fd_sc_mcu7t5v0__nor2_4_9/ZN gf180mcu_fd_sc_mcu7t5v0__dffq_1_238/Q
+ vdd vss gf180mcu_fd_sc_mcu7t5v0__nand2_1_270/A1 gf180mcu_fd_sc_mcu7t5v0__dffq_1_199/Q
+ gf180mcu_fd_sc_mcu7t5v0__nor2_4_8/ZN vdd vss gf180mcu_fd_sc_mcu7t5v0__aoi22_1
Xgf180mcu_fd_sc_mcu7t5v0__aoi22_1_145 gf180mcu_fd_sc_mcu7t5v0__nor2_4_9/ZN gf180mcu_fd_sc_mcu7t5v0__dffq_1_133/Q
+ vdd vss gf180mcu_fd_sc_mcu7t5v0__nand2_1_297/A1 gf180mcu_fd_sc_mcu7t5v0__dffq_1_136/Q
+ gf180mcu_fd_sc_mcu7t5v0__nor2_4_8/ZN vdd vss gf180mcu_fd_sc_mcu7t5v0__aoi22_1
Xgf180mcu_fd_sc_mcu7t5v0__aoi22_1_156 gf180mcu_fd_sc_mcu7t5v0__and2_1_47/Z gf180mcu_fd_sc_mcu7t5v0__dffq_1_331/Q
+ vdd vss gf180mcu_fd_sc_mcu7t5v0__nand2_1_343/A2 gf180mcu_fd_sc_mcu7t5v0__dffq_1_330/Q
+ gf180mcu_fd_sc_mcu7t5v0__nor2_4_23/ZN vdd vss gf180mcu_fd_sc_mcu7t5v0__aoi22_1
Xgf180mcu_fd_sc_mcu7t5v0__or2_1_17 vdd vss gf180mcu_fd_sc_mcu7t5v0__or2_1_17/Z gf180mcu_fd_sc_mcu7t5v0__or2_1_17/A1
+ gf180mcu_fd_sc_mcu7t5v0__or2_1_17/A2 vdd vss gf180mcu_fd_sc_mcu7t5v0__or2_1
Xgf180mcu_fd_sc_mcu7t5v0__or2_1_28 vdd vss gf180mcu_fd_sc_mcu7t5v0__or2_1_28/Z gf180mcu_fd_sc_mcu7t5v0__or2_1_28/A1
+ gf180mcu_fd_sc_mcu7t5v0__or2_1_28/A2 vdd vss gf180mcu_fd_sc_mcu7t5v0__or2_1
Xgf180mcu_fd_sc_mcu7t5v0__aoi22_1_167 gf180mcu_fd_sc_mcu7t5v0__nand4_1_19/ZN gf180mcu_fd_sc_mcu7t5v0__aoi22_1_167/B2
+ vdd vss gf180mcu_fd_sc_mcu7t5v0__nor2_1_340/A2 gf180mcu_fd_sc_mcu7t5v0__mux4_4_7/I0
+ gf180mcu_fd_sc_mcu7t5v0__or2_4_4/Z vdd vss gf180mcu_fd_sc_mcu7t5v0__aoi22_1
Xgf180mcu_fd_sc_mcu7t5v0__or2_1_39 vdd vss gf180mcu_fd_sc_mcu7t5v0__or2_1_39/Z gf180mcu_fd_sc_mcu7t5v0__or2_1_39/A1
+ gf180mcu_fd_sc_mcu7t5v0__or2_1_36/Z vdd vss gf180mcu_fd_sc_mcu7t5v0__or2_1
Xgf180mcu_fd_sc_mcu7t5v0__aoi22_1_178 gf180mcu_fd_sc_mcu7t5v0__nand2_1_469/ZN gf180mcu_fd_sc_mcu7t5v0__aoi22_1_178/B2
+ vdd vss gf180mcu_fd_sc_mcu7t5v0__nor2_1_326/A2 gf180mcu_fd_sc_mcu7t5v0__inv_2_13/I
+ gf180mcu_fd_sc_mcu7t5v0__or2_4_4/Z vdd vss gf180mcu_fd_sc_mcu7t5v0__aoi22_1
Xgf180mcu_fd_sc_mcu7t5v0__nor2_4_17 vdd vss gf180mcu_fd_sc_mcu7t5v0__nor2_4_17/ZN
+ gf180mcu_fd_sc_mcu7t5v0__nor2_4_22/A1 gf180mcu_fd_sc_mcu7t5v0__nor2_4_27/A2 vdd
+ vss gf180mcu_fd_sc_mcu7t5v0__nor2_4
Xgf180mcu_fd_sc_mcu7t5v0__nor2_4_28 vdd vss gf180mcu_fd_sc_mcu7t5v0__nor2_4_28/ZN
+ gf180mcu_fd_sc_mcu7t5v0__or2_4_2/Z gf180mcu_fd_sc_mcu7t5v0__nor2_4_28/A2 vdd vss
+ gf180mcu_fd_sc_mcu7t5v0__nor2_4
Xgf180mcu_fd_sc_mcu7t5v0__nor2_4_39 vdd vss gf180mcu_fd_sc_mcu7t5v0__nor2_4_39/ZN
+ gf180mcu_fd_sc_mcu7t5v0__dffq_4_32/Q gf180mcu_fd_sc_mcu7t5v0__inv_1_20/I vdd vss
+ gf180mcu_fd_sc_mcu7t5v0__nor2_4
Xgf180mcu_fd_sc_mcu7t5v0__oai21_1_290 vdd gf180mcu_fd_sc_mcu7t5v0__buf_8_4/Z gf180mcu_fd_sc_mcu7t5v0__buf_20_0/I
+ gf180mcu_fd_sc_mcu7t5v0__aoi21_1_323/B gf180mcu_fd_sc_mcu7t5v0__dffq_1_428/Q vss
+ vdd vss gf180mcu_fd_sc_mcu7t5v0__oai21_1
Xgf180mcu_fd_sc_mcu7t5v0__aoi21_1_303 gf180mcu_fd_sc_mcu7t5v0__aoi21_1_303/B vdd vss
+ gf180mcu_fd_sc_mcu7t5v0__dffq_1_438/D gf180mcu_fd_sc_mcu7t5v0__aoi21_1_303/A1 gf180mcu_fd_sc_mcu7t5v0__buf_20_0/Z
+ vdd vss gf180mcu_fd_sc_mcu7t5v0__aoi21_1
Xgf180mcu_fd_sc_mcu7t5v0__aoi21_1_314 gf180mcu_fd_sc_mcu7t5v0__aoi21_1_314/B vdd vss
+ gf180mcu_fd_sc_mcu7t5v0__nor2_1_337/A2 gf180mcu_fd_sc_mcu7t5v0__or2_1_42/A1 gf180mcu_fd_sc_mcu7t5v0__or2_4_4/Z
+ vdd vss gf180mcu_fd_sc_mcu7t5v0__aoi21_1
Xgf180mcu_fd_sc_mcu7t5v0__aoi21_1_325 gf180mcu_fd_sc_mcu7t5v0__aoi21_1_325/B vdd vss
+ gf180mcu_fd_sc_mcu7t5v0__dffq_2_87/D gf180mcu_fd_sc_mcu7t5v0__nor3_4_22/A3 gf180mcu_fd_sc_mcu7t5v0__buf_20_0/I
+ vdd vss gf180mcu_fd_sc_mcu7t5v0__aoi21_1
Xgf180mcu_fd_sc_mcu7t5v0__aoi21_1_336 gf180mcu_fd_sc_mcu7t5v0__nor3_1_38/ZN vdd vss
+ gf180mcu_fd_sc_mcu7t5v0__oai32_1_9/B2 gf180mcu_fd_sc_mcu7t5v0__aoi21_1_336/A1 gf180mcu_fd_sc_mcu7t5v0__oai21_1_301/ZN
+ vdd vss gf180mcu_fd_sc_mcu7t5v0__aoi21_1
Xgf180mcu_fd_sc_mcu7t5v0__aoi21_1_347 gf180mcu_fd_sc_mcu7t5v0__and2_1_137/Z vdd vss
+ gf180mcu_fd_sc_mcu7t5v0__xor3_1_143/A2 gf180mcu_fd_sc_mcu7t5v0__and2_1_140/Z gf180mcu_fd_sc_mcu7t5v0__xor2_1_187/Z
+ vdd vss gf180mcu_fd_sc_mcu7t5v0__aoi21_1
Xgf180mcu_fd_sc_mcu7t5v0__aoi21_1_358 gf180mcu_fd_sc_mcu7t5v0__and2_1_145/Z vdd vss
+ gf180mcu_fd_sc_mcu7t5v0__xnor2_1_75/A1 gf180mcu_fd_sc_mcu7t5v0__xnor2_1_74/ZN gf180mcu_fd_sc_mcu7t5v0__xor2_1_197/Z
+ vdd vss gf180mcu_fd_sc_mcu7t5v0__aoi21_1
Xgf180mcu_fd_sc_mcu7t5v0__aoi21_1_369 gf180mcu_fd_sc_mcu7t5v0__xnor2_1_71/A2 vdd vss
+ gf180mcu_fd_sc_mcu7t5v0__xor3_1_144/A3 gf180mcu_fd_sc_mcu7t5v0__oai31_1_19/B gf180mcu_fd_sc_mcu7t5v0__oai31_4_5/ZN
+ vdd vss gf180mcu_fd_sc_mcu7t5v0__aoi21_1
Xgf180mcu_fd_sc_mcu7t5v0__xor3_1_13 gf180mcu_fd_sc_mcu7t5v0__xor3_1_7/Z vdd vss gf180mcu_fd_sc_mcu7t5v0__xor3_1_13/Z
+ gf180mcu_fd_sc_mcu7t5v0__or3_2_0/A1 gf180mcu_fd_sc_mcu7t5v0__and2_1_5/Z vdd vss
+ gf180mcu_fd_sc_mcu7t5v0__xor3_1
Xgf180mcu_fd_sc_mcu7t5v0__xor3_1_24 gf180mcu_fd_sc_mcu7t5v0__xor3_1_24/A3 vdd vss
+ gf180mcu_fd_sc_mcu7t5v0__xor3_1_24/Z gf180mcu_fd_sc_mcu7t5v0__xor2_1_31/Z gf180mcu_fd_sc_mcu7t5v0__mux2_1_0/Z
+ vdd vss gf180mcu_fd_sc_mcu7t5v0__xor3_1
Xgf180mcu_fd_sc_mcu7t5v0__xor3_1_35 gf180mcu_fd_sc_mcu7t5v0__xor3_1_41/Z vdd vss gf180mcu_fd_sc_mcu7t5v0__xor3_1_35/Z
+ gf180mcu_fd_sc_mcu7t5v0__nor2_2_7/ZN gf180mcu_fd_sc_mcu7t5v0__xor3_1_32/Z vdd vss
+ gf180mcu_fd_sc_mcu7t5v0__xor3_1
Xgf180mcu_fd_sc_mcu7t5v0__aoi222_1_3 vss vdd gf180mcu_fd_sc_mcu7t5v0__aoi222_1_3/C2
+ gf180mcu_fd_sc_mcu7t5v0__nor2_4_6/ZN gf180mcu_fd_sc_mcu7t5v0__nor2_4_5/ZN gf180mcu_fd_sc_mcu7t5v0__aoi222_1_3/B1
+ gf180mcu_fd_sc_mcu7t5v0__aoi222_1_3/A2 gf180mcu_fd_sc_mcu7t5v0__nor2_4_4/ZN gf180mcu_fd_sc_mcu7t5v0__nand3_1_37/A2
+ vdd vss gf180mcu_fd_sc_mcu7t5v0__aoi222_1
Xgf180mcu_fd_sc_mcu7t5v0__xor3_1_46 gf180mcu_fd_sc_mcu7t5v0__xor3_1_46/A3 vdd vss
+ gf180mcu_fd_sc_mcu7t5v0__xor3_1_46/Z gf180mcu_fd_sc_mcu7t5v0__xor3_1_46/A1 gf180mcu_fd_sc_mcu7t5v0__xor3_1_46/A2
+ vdd vss gf180mcu_fd_sc_mcu7t5v0__xor3_1
Xgf180mcu_fd_sc_mcu7t5v0__xor3_1_57 gf180mcu_fd_sc_mcu7t5v0__xor3_1_57/A3 vdd vss
+ gf180mcu_fd_sc_mcu7t5v0__xor3_1_57/Z gf180mcu_fd_sc_mcu7t5v0__xor3_1_57/A1 gf180mcu_fd_sc_mcu7t5v0__xor3_1_57/A2
+ vdd vss gf180mcu_fd_sc_mcu7t5v0__xor3_1
Xgf180mcu_fd_sc_mcu7t5v0__xor3_1_68 gf180mcu_fd_sc_mcu7t5v0__xor3_1_68/A3 vdd vss
+ gf180mcu_fd_sc_mcu7t5v0__xor3_1_68/Z gf180mcu_fd_sc_mcu7t5v0__xor3_1_68/A1 gf180mcu_fd_sc_mcu7t5v0__or2_1_56/Z
+ vdd vss gf180mcu_fd_sc_mcu7t5v0__xor3_1
Xgf180mcu_fd_sc_mcu7t5v0__xor3_1_79 gf180mcu_fd_sc_mcu7t5v0__xor3_1_79/A3 vdd vss
+ gf180mcu_fd_sc_mcu7t5v0__xor3_1_79/Z gf180mcu_fd_sc_mcu7t5v0__xor3_1_79/A1 gf180mcu_fd_sc_mcu7t5v0__xor3_1_79/A2
+ vdd vss gf180mcu_fd_sc_mcu7t5v0__xor3_1
Xgf180mcu_fd_sc_mcu7t5v0__nor3_1_5 gf180mcu_fd_sc_mcu7t5v0__or2_1_3/A2 vdd vss gf180mcu_fd_sc_mcu7t5v0__nor3_1_5/ZN
+ gf180mcu_fd_sc_mcu7t5v0__nor3_1_5/A1 gf180mcu_fd_sc_mcu7t5v0__or2_1_3/A1 vdd vss
+ gf180mcu_fd_sc_mcu7t5v0__nor3_1
Xgf180mcu_fd_sc_mcu7t5v0__nand2_1_603 vdd vss gf180mcu_fd_sc_mcu7t5v0__xor2_1_166/A1
+ gf180mcu_fd_sc_mcu7t5v0__or4_1_0/A1 gf180mcu_fd_sc_mcu7t5v0__mux4_4_14/Z vdd vss
+ gf180mcu_fd_sc_mcu7t5v0__nand2_1
Xgf180mcu_fd_sc_mcu7t5v0__nand2_1_614 vdd vss gf180mcu_fd_sc_mcu7t5v0__xor3_1_160/A1
+ gf180mcu_fd_sc_mcu7t5v0__dffq_4_37/Q gf180mcu_fd_sc_mcu7t5v0__xor3_1_162/A2 vdd
+ vss gf180mcu_fd_sc_mcu7t5v0__nand2_1
Xgf180mcu_fd_sc_mcu7t5v0__nand2_1_625 vdd vss gf180mcu_fd_sc_mcu7t5v0__oai21_1_306/B
+ gf180mcu_fd_sc_mcu7t5v0__xor3_1_138/A1 gf180mcu_fd_sc_mcu7t5v0__nor2_1_379/A2 vdd
+ vss gf180mcu_fd_sc_mcu7t5v0__nand2_1
Xgf180mcu_fd_sc_mcu7t5v0__nand2_1_636 vdd vss gf180mcu_fd_sc_mcu7t5v0__nand2_1_636/ZN
+ gf180mcu_fd_sc_mcu7t5v0__nor3_2_11/A1 gf180mcu_fd_sc_mcu7t5v0__oai21_1_288/B vdd
+ vss gf180mcu_fd_sc_mcu7t5v0__nand2_1
Xgf180mcu_fd_sc_mcu7t5v0__nand2_1_647 vdd vss gf180mcu_fd_sc_mcu7t5v0__oai211_1_49/B
+ gf180mcu_fd_sc_mcu7t5v0__nor2_4_42/ZN gf180mcu_fd_sc_mcu7t5v0__xor3_1_143/Z vdd
+ vss gf180mcu_fd_sc_mcu7t5v0__nand2_1
Xgf180mcu_fd_sc_mcu7t5v0__nand2_1_658 vdd vss gf180mcu_fd_sc_mcu7t5v0__nand2_1_658/ZN
+ gf180mcu_fd_sc_mcu7t5v0__or4_1_0/A1 gf180mcu_fd_sc_mcu7t5v0__xor2_1_192/Z vdd vss
+ gf180mcu_fd_sc_mcu7t5v0__nand2_1
Xgf180mcu_fd_sc_mcu7t5v0__nand2_1_669 vdd vss gf180mcu_fd_sc_mcu7t5v0__nor2_2_56/A2
+ gf180mcu_fd_sc_mcu7t5v0__nor2_1_389/A1 gf180mcu_fd_sc_mcu7t5v0__nor2_2_55/A2 vdd
+ vss gf180mcu_fd_sc_mcu7t5v0__nand2_1
Xgf180mcu_fd_sc_mcu7t5v0__nand4_1_13 gf180mcu_fd_sc_mcu7t5v0__or3_1_18/Z gf180mcu_fd_sc_mcu7t5v0__nand4_1_13/A4
+ vdd vss gf180mcu_fd_sc_mcu7t5v0__nand4_1_13/ZN gf180mcu_fd_sc_mcu7t5v0__nor3_1_33/A1
+ gf180mcu_fd_sc_mcu7t5v0__nand4_1_13/A2 vdd vss gf180mcu_fd_sc_mcu7t5v0__nand4_1
Xgf180mcu_fd_sc_mcu7t5v0__nand4_1_24 gf180mcu_fd_sc_mcu7t5v0__and4_1_3/A3 gf180mcu_fd_sc_mcu7t5v0__and4_1_3/A4
+ vdd vss gf180mcu_fd_sc_mcu7t5v0__oai21_1_324/B gf180mcu_fd_sc_mcu7t5v0__or4_1_0/A1
+ gf180mcu_fd_sc_mcu7t5v0__inv_8_0/I vdd vss gf180mcu_fd_sc_mcu7t5v0__nand4_1
Xgf180mcu_fd_sc_mcu7t5v0__inv_1_14 vss gf180mcu_fd_sc_mcu7t5v0__inv_1_14/ZN gf180mcu_fd_sc_mcu7t5v0__inv_1_14/I
+ vdd vdd vss gf180mcu_fd_sc_mcu7t5v0__inv_1
Xgf180mcu_fd_sc_mcu7t5v0__xor2_1_90 vdd vss gf180mcu_fd_sc_mcu7t5v0__xor2_1_90/Z gf180mcu_fd_sc_mcu7t5v0__and3_1_9/A2
+ gf180mcu_fd_sc_mcu7t5v0__xor2_1_90/A2 vdd vss gf180mcu_fd_sc_mcu7t5v0__xor2_1
Xgf180mcu_fd_sc_mcu7t5v0__aoi21_1_100 gf180mcu_fd_sc_mcu7t5v0__xor2_1_78/Z vdd vss
+ gf180mcu_fd_sc_mcu7t5v0__oai21_1_84/A2 gf180mcu_fd_sc_mcu7t5v0__xor3_1_67/Z gf180mcu_fd_sc_mcu7t5v0__xor2_1_79/Z
+ vdd vss gf180mcu_fd_sc_mcu7t5v0__aoi21_1
Xgf180mcu_fd_sc_mcu7t5v0__aoi21_1_111 gf180mcu_fd_sc_mcu7t5v0__nor2_1_146/ZN vdd vss
+ gf180mcu_fd_sc_mcu7t5v0__aoi21_1_114/A2 gf180mcu_fd_sc_mcu7t5v0__dffq_1_409/Q gf180mcu_fd_sc_mcu7t5v0__inv_2_8/I
+ vdd vss gf180mcu_fd_sc_mcu7t5v0__aoi21_1
Xgf180mcu_fd_sc_mcu7t5v0__aoi21_1_122 gf180mcu_fd_sc_mcu7t5v0__aoi21_1_122/B vdd vss
+ gf180mcu_fd_sc_mcu7t5v0__dffq_1_295/D gf180mcu_fd_sc_mcu7t5v0__nor3_4_14/ZN gf180mcu_fd_sc_mcu7t5v0__aoi22_2_6/ZN
+ vdd vss gf180mcu_fd_sc_mcu7t5v0__aoi21_1
Xgf180mcu_fd_sc_mcu7t5v0__aoi21_1_133 gf180mcu_fd_sc_mcu7t5v0__aoi21_1_7/B vdd vss
+ gf180mcu_fd_sc_mcu7t5v0__dffq_2_38/D gf180mcu_fd_sc_mcu7t5v0__nand2_1_320/ZN gf180mcu_fd_sc_mcu7t5v0__oai211_1_19/ZN
+ vdd vss gf180mcu_fd_sc_mcu7t5v0__aoi21_1
Xgf180mcu_fd_sc_mcu7t5v0__and2_1_100 vdd vss gf180mcu_fd_sc_mcu7t5v0__aoi21_2_11/B
+ gf180mcu_fd_sc_mcu7t5v0__dffq_2_61/Q gf180mcu_fd_sc_mcu7t5v0__nor2_1_282/ZN vdd
+ vss gf180mcu_fd_sc_mcu7t5v0__and2_1
Xgf180mcu_fd_sc_mcu7t5v0__aoi21_1_144 gf180mcu_fd_sc_mcu7t5v0__nor2_1_235/ZN vdd vss
+ gf180mcu_fd_sc_mcu7t5v0__aoi21_1_152/A2 gf180mcu_fd_sc_mcu7t5v0__dffq_1_411/Q gf180mcu_fd_sc_mcu7t5v0__inv_2_8/I
+ vdd vss gf180mcu_fd_sc_mcu7t5v0__aoi21_1
Xgf180mcu_fd_sc_mcu7t5v0__and2_1_111 vdd vss gf180mcu_fd_sc_mcu7t5v0__and2_1_111/Z
+ gf180mcu_fd_sc_mcu7t5v0__inv_1_2/I gf180mcu_fd_sc_mcu7t5v0__and2_1_104/Z vdd vss
+ gf180mcu_fd_sc_mcu7t5v0__and2_1
Xgf180mcu_fd_sc_mcu7t5v0__aoi21_1_155 gf180mcu_fd_sc_mcu7t5v0__or2_1_23/A1 vdd vss
+ gf180mcu_fd_sc_mcu7t5v0__dffq_1_331/D gf180mcu_fd_sc_mcu7t5v0__nand3_1_55/A2 gf180mcu_fd_sc_mcu7t5v0__nand2_1_342/ZN
+ vdd vss gf180mcu_fd_sc_mcu7t5v0__aoi21_1
Xgf180mcu_fd_sc_mcu7t5v0__aoi21_1_166 gf180mcu_fd_sc_mcu7t5v0__aoi21_1_166/B vdd vss
+ gf180mcu_fd_sc_mcu7t5v0__dffq_1_360/D gf180mcu_fd_sc_mcu7t5v0__or4_1_2/A4 gf180mcu_fd_sc_mcu7t5v0__and2_1_65/Z
+ vdd vss gf180mcu_fd_sc_mcu7t5v0__aoi21_1
Xgf180mcu_fd_sc_mcu7t5v0__aoi21_1_177 gf180mcu_fd_sc_mcu7t5v0__nor3_4_15/ZN vdd vss
+ gf180mcu_fd_sc_mcu7t5v0__nor2_1_210/A2 gf180mcu_fd_sc_mcu7t5v0__nor3_4_15/A2 gf180mcu_fd_sc_mcu7t5v0__inv_1_12/I
+ vdd vss gf180mcu_fd_sc_mcu7t5v0__aoi21_1
Xgf180mcu_fd_sc_mcu7t5v0__and2_1_122 vdd vss gf180mcu_fd_sc_mcu7t5v0__and2_1_122/Z
+ gf180mcu_fd_sc_mcu7t5v0__and2_1_122/A1 gf180mcu_fd_sc_mcu7t5v0__and2_1_122/A2 vdd
+ vss gf180mcu_fd_sc_mcu7t5v0__and2_1
Xgf180mcu_fd_sc_mcu7t5v0__and2_1_133 vdd vss gf180mcu_fd_sc_mcu7t5v0__or2_1_48/A1
+ gf180mcu_fd_sc_mcu7t5v0__xor3_1_138/Z gf180mcu_fd_sc_mcu7t5v0__xor3_1_133/Z vdd
+ vss gf180mcu_fd_sc_mcu7t5v0__and2_1
Xgf180mcu_fd_sc_mcu7t5v0__and2_1_144 vdd vss gf180mcu_fd_sc_mcu7t5v0__and2_1_144/Z
+ gf180mcu_fd_sc_mcu7t5v0__inv_12_1/I gf180mcu_fd_sc_mcu7t5v0__and4_1_3/A4 vdd vss
+ gf180mcu_fd_sc_mcu7t5v0__and2_1
Xgf180mcu_fd_sc_mcu7t5v0__aoi21_1_188 gf180mcu_fd_sc_mcu7t5v0__aoi21_1_7/B vdd vss
+ gf180mcu_fd_sc_mcu7t5v0__dffq_4_19/D gf180mcu_fd_sc_mcu7t5v0__nand2_1_380/ZN gf180mcu_fd_sc_mcu7t5v0__oai221_1_8/ZN
+ vdd vss gf180mcu_fd_sc_mcu7t5v0__aoi21_1
Xgf180mcu_fd_sc_mcu7t5v0__aoi21_1_199 gf180mcu_fd_sc_mcu7t5v0__aoi21_1_199/B vdd vss
+ gf180mcu_fd_sc_mcu7t5v0__dffq_1_400/D gf180mcu_fd_sc_mcu7t5v0__aoi22_4_4/ZN gf180mcu_fd_sc_mcu7t5v0__nor2_4_31/ZN
+ vdd vss gf180mcu_fd_sc_mcu7t5v0__aoi21_1
Xgf180mcu_fd_sc_mcu7t5v0__and2_1_155 vdd vss gf180mcu_fd_sc_mcu7t5v0__or3_1_28/A1
+ gf180mcu_fd_sc_mcu7t5v0__inv_8_2/I gf180mcu_fd_sc_mcu7t5v0__xor2_1_221/Z vdd vss
+ gf180mcu_fd_sc_mcu7t5v0__and2_1
Xgf180mcu_fd_sc_mcu7t5v0__oai22_1_109 gf180mcu_fd_sc_mcu7t5v0__nand2_4_14/ZN gf180mcu_fd_sc_mcu7t5v0__nand2_2_32/ZN
+ gf180mcu_fd_sc_mcu7t5v0__oai22_1_109/B2 vdd vss gf180mcu_fd_sc_mcu7t5v0__dffq_1_103/D
+ gf180mcu_fd_sc_mcu7t5v0__aoi21_4_1/ZN vdd vss gf180mcu_fd_sc_mcu7t5v0__oai22_1
Xgf180mcu_fd_sc_mcu7t5v0__nand3_1_90 gf180mcu_fd_sc_mcu7t5v0__nand3_1_90/A3 vdd vss
+ gf180mcu_fd_sc_mcu7t5v0__nand4_1_21/A4 gf180mcu_fd_sc_mcu7t5v0__nor3_4_22/ZN gf180mcu_fd_sc_mcu7t5v0__nand3_1_91/ZN
+ vdd vss gf180mcu_fd_sc_mcu7t5v0__nand3_1
Xgf180mcu_fd_sc_mcu7t5v0__nor4_4_3 gf180mcu_fd_sc_mcu7t5v0__nor4_4_3/A3 gf180mcu_fd_sc_mcu7t5v0__nor4_4_3/A4
+ vdd vss gf180mcu_fd_sc_mcu7t5v0__or2_1_21/A1 gf180mcu_fd_sc_mcu7t5v0__nor4_4_3/A1
+ gf180mcu_fd_sc_mcu7t5v0__or3_1_11/A1 vdd vss gf180mcu_fd_sc_mcu7t5v0__nor4_4
Xgf180mcu_fd_sc_mcu7t5v0__nor2_1_18 vdd vss gf180mcu_fd_sc_mcu7t5v0__nor2_1_18/ZN
+ gf180mcu_fd_sc_mcu7t5v0__oai31_1_0/B gf180mcu_fd_sc_mcu7t5v0__or3_1_1/A2 vdd vss
+ gf180mcu_fd_sc_mcu7t5v0__nor2_1
Xgf180mcu_fd_sc_mcu7t5v0__nor2_1_29 vdd vss gf180mcu_fd_sc_mcu7t5v0__nor2_1_29/ZN
+ gf180mcu_fd_sc_mcu7t5v0__dffq_1_0/Q gf180mcu_fd_sc_mcu7t5v0__nor2_4_19/ZN vdd vss
+ gf180mcu_fd_sc_mcu7t5v0__nor2_1
Xgf180mcu_fd_sc_mcu7t5v0__nor2_1_207 vdd vss gf180mcu_fd_sc_mcu7t5v0__nor3_1_20/A2
+ gf180mcu_fd_sc_mcu7t5v0__nor3_1_13/A1 gf180mcu_fd_sc_mcu7t5v0__and3_1_12/Z vdd vss
+ gf180mcu_fd_sc_mcu7t5v0__nor2_1
Xgf180mcu_fd_sc_mcu7t5v0__nor2_1_218 vdd vss gf180mcu_fd_sc_mcu7t5v0__xor3_1_74/A3
+ gf180mcu_fd_sc_mcu7t5v0__inv_1_13/I gf180mcu_fd_sc_mcu7t5v0__or3_1_12/A3 vdd vss
+ gf180mcu_fd_sc_mcu7t5v0__nor2_1
Xgf180mcu_fd_sc_mcu7t5v0__nor2_1_229 vdd vss gf180mcu_fd_sc_mcu7t5v0__nor2_1_229/ZN
+ gf180mcu_fd_sc_mcu7t5v0__or2_4_3/Z gf180mcu_fd_sc_mcu7t5v0__nor2_1_229/A2 vdd vss
+ gf180mcu_fd_sc_mcu7t5v0__nor2_1
Xgf180mcu_fd_sc_mcu7t5v0__aoi21_1_3 gf180mcu_fd_sc_mcu7t5v0__nor3_1_2/ZN vdd vss gf180mcu_fd_sc_mcu7t5v0__xor3_1_58/A2
+ gf180mcu_fd_sc_mcu7t5v0__xor3_1_9/A2 gf180mcu_fd_sc_mcu7t5v0__oai21_1_5/ZN vdd vss
+ gf180mcu_fd_sc_mcu7t5v0__aoi21_1
Xgf180mcu_fd_sc_mcu7t5v0__nand2_1_400 vdd vss gf180mcu_fd_sc_mcu7t5v0__or3_1_14/A3
+ gf180mcu_fd_sc_mcu7t5v0__inv_8_0/I gf180mcu_fd_sc_mcu7t5v0__or3_1_12/A2 vdd vss
+ gf180mcu_fd_sc_mcu7t5v0__nand2_1
Xgf180mcu_fd_sc_mcu7t5v0__nand2_1_411 vdd vss gf180mcu_fd_sc_mcu7t5v0__or2_1_28/A2
+ gf180mcu_fd_sc_mcu7t5v0__or4_1_0/A1 gf180mcu_fd_sc_mcu7t5v0__mux4_4_19/Z vdd vss
+ gf180mcu_fd_sc_mcu7t5v0__nand2_1
Xgf180mcu_fd_sc_mcu7t5v0__nand2_1_422 vdd vss gf180mcu_fd_sc_mcu7t5v0__oai21_1_203/B
+ gf180mcu_fd_sc_mcu7t5v0__inv_1_2/I gf180mcu_fd_sc_mcu7t5v0__xor3_1_87/A3 vdd vss
+ gf180mcu_fd_sc_mcu7t5v0__nand2_1
Xgf180mcu_fd_sc_mcu7t5v0__nand2_1_433 vdd vss gf180mcu_fd_sc_mcu7t5v0__xor2_1_114/A2
+ gf180mcu_fd_sc_mcu7t5v0__inv_8_2/I gf180mcu_fd_sc_mcu7t5v0__mux4_4_8/Z vdd vss gf180mcu_fd_sc_mcu7t5v0__nand2_1
Xgf180mcu_fd_sc_mcu7t5v0__nand2_1_444 vdd vss gf180mcu_fd_sc_mcu7t5v0__xnor2_1_82/A2
+ gf180mcu_fd_sc_mcu7t5v0__inv_12_1/I gf180mcu_fd_sc_mcu7t5v0__mux4_4_8/Z vdd vss
+ gf180mcu_fd_sc_mcu7t5v0__nand2_1
Xgf180mcu_fd_sc_mcu7t5v0__nand2_1_455 vdd vss gf180mcu_fd_sc_mcu7t5v0__or2_1_30/A2
+ gf180mcu_fd_sc_mcu7t5v0__and3_2_3/Z gf180mcu_fd_sc_mcu7t5v0__nand3_1_66/ZN vdd vss
+ gf180mcu_fd_sc_mcu7t5v0__nand2_1
Xgf180mcu_fd_sc_mcu7t5v0__nand2_1_466 vdd vss gf180mcu_fd_sc_mcu7t5v0__nand2_1_466/ZN
+ gf180mcu_fd_sc_mcu7t5v0__nand2_1_466/A1 gf180mcu_fd_sc_mcu7t5v0__oai22_1_271/ZN
+ vdd vss gf180mcu_fd_sc_mcu7t5v0__nand2_1
Xgf180mcu_fd_sc_mcu7t5v0__nand2_1_477 vdd vss gf180mcu_fd_sc_mcu7t5v0__nand2_1_477/ZN
+ gf180mcu_fd_sc_mcu7t5v0__oai31_1_16/B gf180mcu_fd_sc_mcu7t5v0__oai32_1_7/B1 vdd
+ vss gf180mcu_fd_sc_mcu7t5v0__nand2_1
Xgf180mcu_fd_sc_mcu7t5v0__nand2_1_488 vdd vss gf180mcu_fd_sc_mcu7t5v0__xor3_1_102/A1
+ gf180mcu_fd_sc_mcu7t5v0__inv_8_0/I gf180mcu_fd_sc_mcu7t5v0__and2_2_9/Z vdd vss gf180mcu_fd_sc_mcu7t5v0__nand2_1
Xgf180mcu_fd_sc_mcu7t5v0__nand2_1_499 vdd vss gf180mcu_fd_sc_mcu7t5v0__oai21_2_11/B
+ gf180mcu_fd_sc_mcu7t5v0__or2_1_36/A2 gf180mcu_fd_sc_mcu7t5v0__mux4_4_5/I1 vdd vss
+ gf180mcu_fd_sc_mcu7t5v0__nand2_1
Xgf180mcu_fd_sc_mcu7t5v0__mux2_1_14 gf180mcu_fd_sc_mcu7t5v0__mux2_1_14/S vdd vss gf180mcu_fd_sc_mcu7t5v0__mux2_1_14/Z
+ gf180mcu_fd_sc_mcu7t5v0__mux2_1_14/I0 gf180mcu_fd_sc_mcu7t5v0__mux2_1_14/I1 vdd
+ vss gf180mcu_fd_sc_mcu7t5v0__mux2_1
Xgf180mcu_fd_sc_mcu7t5v0__xor2_1_2 vdd vss gf180mcu_fd_sc_mcu7t5v0__xor2_1_2/Z gf180mcu_fd_sc_mcu7t5v0__xor3_1_5/A2
+ gf180mcu_fd_sc_mcu7t5v0__xor3_1_62/Z vdd vss gf180mcu_fd_sc_mcu7t5v0__xor2_1
Xgf180mcu_fd_sc_mcu7t5v0__oai211_1_3 gf180mcu_fd_sc_mcu7t5v0__oai211_1_3/B gf180mcu_fd_sc_mcu7t5v0__oai211_1_3/C
+ vdd vss gf180mcu_fd_sc_mcu7t5v0__oai211_1_3/ZN gf180mcu_fd_sc_mcu7t5v0__oai211_1_3/A1
+ gf180mcu_fd_sc_mcu7t5v0__oai211_1_3/A2 vdd vss gf180mcu_fd_sc_mcu7t5v0__oai211_1
Xgf180mcu_fd_sc_mcu7t5v0__mux2_1_3 gf180mcu_fd_sc_mcu7t5v0__or3_1_3/A1 vdd vss gf180mcu_fd_sc_mcu7t5v0__mux2_1_3/Z
+ gf180mcu_fd_sc_mcu7t5v0__mux2_1_3/I0 gf180mcu_fd_sc_mcu7t5v0__or4_1_1/A3 vdd vss
+ gf180mcu_fd_sc_mcu7t5v0__mux2_1
Xgf180mcu_fd_sc_mcu7t5v0__xnor2_1_14 vdd vss gf180mcu_fd_sc_mcu7t5v0__xnor2_1_14/ZN
+ gf180mcu_fd_sc_mcu7t5v0__xnor2_1_14/A1 gf180mcu_fd_sc_mcu7t5v0__xor2_1_36/Z vdd
+ vss gf180mcu_fd_sc_mcu7t5v0__xnor2_1
Xgf180mcu_fd_sc_mcu7t5v0__xnor2_1_25 vdd vss gf180mcu_fd_sc_mcu7t5v0__xor2_1_28/A2
+ gf180mcu_fd_sc_mcu7t5v0__xnor2_1_25/A1 gf180mcu_fd_sc_mcu7t5v0__aoi21_1_69/B vdd
+ vss gf180mcu_fd_sc_mcu7t5v0__xnor2_1
Xgf180mcu_fd_sc_mcu7t5v0__xnor2_1_36 vdd vss gf180mcu_fd_sc_mcu7t5v0__xor2_1_104/A1
+ gf180mcu_fd_sc_mcu7t5v0__xnor2_1_36/A1 gf180mcu_fd_sc_mcu7t5v0__or2_1_26/Z vdd vss
+ gf180mcu_fd_sc_mcu7t5v0__xnor2_1
Xgf180mcu_fd_sc_mcu7t5v0__xnor2_1_47 vdd vss gf180mcu_fd_sc_mcu7t5v0__xor2_1_138/A2
+ gf180mcu_fd_sc_mcu7t5v0__xnor2_1_47/A1 gf180mcu_fd_sc_mcu7t5v0__xnor2_1_47/A2 vdd
+ vss gf180mcu_fd_sc_mcu7t5v0__xnor2_1
Xgf180mcu_fd_sc_mcu7t5v0__xnor2_1_58 vdd vss gf180mcu_fd_sc_mcu7t5v0__xor2_1_164/A2
+ gf180mcu_fd_sc_mcu7t5v0__mux4_4_12/Z gf180mcu_fd_sc_mcu7t5v0__xnor2_1_58/A2 vdd
+ vss gf180mcu_fd_sc_mcu7t5v0__xnor2_1
Xgf180mcu_fd_sc_mcu7t5v0__xnor2_1_69 vdd vss gf180mcu_fd_sc_mcu7t5v0__nor2_2_58/A2
+ gf180mcu_fd_sc_mcu7t5v0__xnor2_1_69/A1 gf180mcu_fd_sc_mcu7t5v0__xnor2_1_70/ZN vdd
+ vss gf180mcu_fd_sc_mcu7t5v0__xnor2_1
Xgf180mcu_fd_sc_mcu7t5v0__dffq_2_30 gf180mcu_fd_sc_mcu7t5v0__dffq_2_30/D vdd vss gf180mcu_fd_sc_mcu7t5v0__dffq_2_58/CLK
+ gf180mcu_fd_sc_mcu7t5v0__dffq_2_30/Q vdd vss gf180mcu_fd_sc_mcu7t5v0__dffq_2
Xgf180mcu_fd_sc_mcu7t5v0__dffq_2_41 gf180mcu_fd_sc_mcu7t5v0__dffq_2_41/D vdd vss gf180mcu_fd_sc_mcu7t5v0__dffq_4_9/CLK
+ gf180mcu_fd_sc_mcu7t5v0__dffq_2_41/Q vdd vss gf180mcu_fd_sc_mcu7t5v0__dffq_2
Xgf180mcu_fd_sc_mcu7t5v0__dffq_2_52 gf180mcu_fd_sc_mcu7t5v0__dffq_2_52/D vdd vss gf180mcu_fd_sc_mcu7t5v0__dffq_4_15/CLK
+ gf180mcu_fd_sc_mcu7t5v0__dffq_2_52/Q vdd vss gf180mcu_fd_sc_mcu7t5v0__dffq_2
Xgf180mcu_fd_sc_mcu7t5v0__and3_1_4 gf180mcu_fd_sc_mcu7t5v0__and3_1_4/A3 vdd vss gf180mcu_fd_sc_mcu7t5v0__and3_1_4/Z
+ gf180mcu_fd_sc_mcu7t5v0__dffq_1_16/Q gf180mcu_fd_sc_mcu7t5v0__or3_1_5/Z vdd vss
+ gf180mcu_fd_sc_mcu7t5v0__and3_1
Xgf180mcu_fd_sc_mcu7t5v0__dffq_2_63 gf180mcu_fd_sc_mcu7t5v0__dffq_2_63/D vdd vss gf180mcu_fd_sc_mcu7t5v0__dffq_4_1/CLK
+ gf180mcu_fd_sc_mcu7t5v0__or2_1_34/A1 vdd vss gf180mcu_fd_sc_mcu7t5v0__dffq_2
Xgf180mcu_fd_sc_mcu7t5v0__dffq_2_74 gf180mcu_fd_sc_mcu7t5v0__dffq_2_74/D vdd vss gf180mcu_fd_sc_mcu7t5v0__dffq_4_44/CLK
+ gf180mcu_fd_sc_mcu7t5v0__dffq_2_74/Q vdd vss gf180mcu_fd_sc_mcu7t5v0__dffq_2
Xgf180mcu_fd_sc_mcu7t5v0__dffq_2_85 gf180mcu_fd_sc_mcu7t5v0__dffq_2_85/D vdd vss gf180mcu_fd_sc_mcu7t5v0__dffq_4_44/CLK
+ gf180mcu_fd_sc_mcu7t5v0__mux4_4_7/I0 vdd vss gf180mcu_fd_sc_mcu7t5v0__dffq_2
Xgf180mcu_fd_sc_mcu7t5v0__dffq_2_96 gf180mcu_fd_sc_mcu7t5v0__dffq_2_96/D vdd vss gf180mcu_fd_sc_mcu7t5v0__dffq_4_1/CLK
+ gf180mcu_fd_sc_mcu7t5v0__dffq_2_96/Q vdd vss gf180mcu_fd_sc_mcu7t5v0__dffq_2
Xgf180mcu_fd_sc_mcu7t5v0__oai21_1_6 vdd gf180mcu_fd_sc_mcu7t5v0__or2_1_34/A2 gf180mcu_fd_sc_mcu7t5v0__oai21_1_6/A2
+ gf180mcu_fd_sc_mcu7t5v0__aoi21_1_5/B gf180mcu_fd_sc_mcu7t5v0__nor3_4_2/ZN vss vdd
+ vss gf180mcu_fd_sc_mcu7t5v0__oai21_1
Xgf180mcu_fd_sc_mcu7t5v0__or2_1_2 vdd vss gf180mcu_fd_sc_mcu7t5v0__or2_1_2/Z gf180mcu_fd_sc_mcu7t5v0__or2_1_2/A1
+ gf180mcu_fd_sc_mcu7t5v0__or2_1_2/A2 vdd vss gf180mcu_fd_sc_mcu7t5v0__or2_1
Xgf180mcu_fd_sc_mcu7t5v0__nor4_2_0 gf180mcu_fd_sc_mcu7t5v0__or4_1_0/A3 gf180mcu_fd_sc_mcu7t5v0__nor4_2_0/A4
+ vdd vss gf180mcu_fd_sc_mcu7t5v0__nor4_2_0/ZN gf180mcu_fd_sc_mcu7t5v0__or3_1_24/A1
+ gf180mcu_fd_sc_mcu7t5v0__inv_8_0/ZN vdd vss gf180mcu_fd_sc_mcu7t5v0__nor4_2
Xgf180mcu_fd_sc_mcu7t5v0__aoi22_4_1 gf180mcu_fd_sc_mcu7t5v0__nor2_4_2/ZN gf180mcu_fd_sc_mcu7t5v0__aoi22_4_1/B1
+ gf180mcu_fd_sc_mcu7t5v0__oai21_2_7/ZN vdd vss gf180mcu_fd_sc_mcu7t5v0__aoi22_4_1/ZN
+ gf180mcu_fd_sc_mcu7t5v0__inv_1_3/ZN vdd vss gf180mcu_fd_sc_mcu7t5v0__aoi22_4
Xgf180mcu_fd_sc_mcu7t5v0__nand2_1_230 vdd vss gf180mcu_fd_sc_mcu7t5v0__aoi22_1_59/B2
+ gf180mcu_fd_sc_mcu7t5v0__aoi22_1_58/ZN gf180mcu_fd_sc_mcu7t5v0__aoi22_1_61/ZN vdd
+ vss gf180mcu_fd_sc_mcu7t5v0__nand2_1
Xgf180mcu_fd_sc_mcu7t5v0__nand2_1_241 vdd vss gf180mcu_fd_sc_mcu7t5v0__aoi222_1_5/A2
+ gf180mcu_fd_sc_mcu7t5v0__aoi22_1_76/ZN gf180mcu_fd_sc_mcu7t5v0__aoi22_1_37/ZN vdd
+ vss gf180mcu_fd_sc_mcu7t5v0__nand2_1
Xgf180mcu_fd_sc_mcu7t5v0__nand2_1_252 vdd vss gf180mcu_fd_sc_mcu7t5v0__aoi222_1_4/A2
+ gf180mcu_fd_sc_mcu7t5v0__aoi22_1_94/ZN gf180mcu_fd_sc_mcu7t5v0__aoi22_1_93/ZN vdd
+ vss gf180mcu_fd_sc_mcu7t5v0__nand2_1
Xgf180mcu_fd_sc_mcu7t5v0__nand2_1_263 vdd vss gf180mcu_fd_sc_mcu7t5v0__aoi222_1_0/A2
+ gf180mcu_fd_sc_mcu7t5v0__nand2_1_263/A1 gf180mcu_fd_sc_mcu7t5v0__nand2_1_263/A2
+ vdd vss gf180mcu_fd_sc_mcu7t5v0__nand2_1
Xgf180mcu_fd_sc_mcu7t5v0__nand2_1_274 vdd vss gf180mcu_fd_sc_mcu7t5v0__nand2_1_274/ZN
+ gf180mcu_fd_sc_mcu7t5v0__nand2_1_274/A1 gf180mcu_fd_sc_mcu7t5v0__nand2_1_274/A2
+ vdd vss gf180mcu_fd_sc_mcu7t5v0__nand2_1
Xgf180mcu_fd_sc_mcu7t5v0__nand2_1_285 vdd vss gf180mcu_fd_sc_mcu7t5v0__xnor3_1_18/A3
+ gf180mcu_fd_sc_mcu7t5v0__inv_8_0/I gf180mcu_fd_sc_mcu7t5v0__mux4_4_3/Z vdd vss gf180mcu_fd_sc_mcu7t5v0__nand2_1
Xgf180mcu_fd_sc_mcu7t5v0__nand2_1_296 vdd vss gf180mcu_fd_sc_mcu7t5v0__aoi222_2_7/C1
+ gf180mcu_fd_sc_mcu7t5v0__nand2_1_296/A1 gf180mcu_fd_sc_mcu7t5v0__aoi22_1_40/ZN vdd
+ vss gf180mcu_fd_sc_mcu7t5v0__nand2_1
Xgf180mcu_fd_sc_mcu7t5v0__aoi21_1_20 gf180mcu_fd_sc_mcu7t5v0__aoi21_1_20/B vdd vss
+ gf180mcu_fd_sc_mcu7t5v0__xor2_1_20/A2 gf180mcu_fd_sc_mcu7t5v0__oai31_1_5/B gf180mcu_fd_sc_mcu7t5v0__nand3_1_1/A3
+ vdd vss gf180mcu_fd_sc_mcu7t5v0__aoi21_1
Xgf180mcu_fd_sc_mcu7t5v0__aoi21_1_31 gf180mcu_fd_sc_mcu7t5v0__or2_4_4/Z vdd vss gf180mcu_fd_sc_mcu7t5v0__aoi22_1_5/B2
+ gf180mcu_fd_sc_mcu7t5v0__or2_1_4/A1 gf180mcu_fd_sc_mcu7t5v0__xor3_1_17/Z vdd vss
+ gf180mcu_fd_sc_mcu7t5v0__aoi21_1
Xgf180mcu_fd_sc_mcu7t5v0__aoi21_1_42 gf180mcu_fd_sc_mcu7t5v0__aoi21_1_42/B vdd vss
+ gf180mcu_fd_sc_mcu7t5v0__dffq_4_1/D gf180mcu_fd_sc_mcu7t5v0__clkinv_1_7/ZN gf180mcu_fd_sc_mcu7t5v0__buf_20_0/Z
+ vdd vss gf180mcu_fd_sc_mcu7t5v0__aoi21_1
Xgf180mcu_fd_sc_mcu7t5v0__aoi21_1_53 gf180mcu_fd_sc_mcu7t5v0__oai33_2_1/B3 vdd vss
+ gf180mcu_fd_sc_mcu7t5v0__xor2_1_33/A1 gf180mcu_fd_sc_mcu7t5v0__or4_1_1/A3 gf180mcu_fd_sc_mcu7t5v0__or3_1_3/A1
+ vdd vss gf180mcu_fd_sc_mcu7t5v0__aoi21_1
Xgf180mcu_fd_sc_mcu7t5v0__aoi21_1_64 gf180mcu_fd_sc_mcu7t5v0__aoi21_1_64/B vdd vss
+ gf180mcu_fd_sc_mcu7t5v0__nor2_1_82/A2 gf180mcu_fd_sc_mcu7t5v0__inv_2_10/I gf180mcu_fd_sc_mcu7t5v0__or2_4_4/Z
+ vdd vss gf180mcu_fd_sc_mcu7t5v0__aoi21_1
Xgf180mcu_fd_sc_mcu7t5v0__aoi21_1_75 gf180mcu_fd_sc_mcu7t5v0__aoi21_1_75/B vdd vss
+ gf180mcu_fd_sc_mcu7t5v0__dffq_2_18/D gf180mcu_fd_sc_mcu7t5v0__inv_2_4/ZN gf180mcu_fd_sc_mcu7t5v0__buf_20_0/Z
+ vdd vss gf180mcu_fd_sc_mcu7t5v0__aoi21_1
Xgf180mcu_fd_sc_mcu7t5v0__aoi21_1_86 gf180mcu_fd_sc_mcu7t5v0__aoi21_1_86/B vdd vss
+ gf180mcu_fd_sc_mcu7t5v0__aoi21_1_90/B gf180mcu_fd_sc_mcu7t5v0__and2_2_8/Z gf180mcu_fd_sc_mcu7t5v0__xor2_1_50/Z
+ vdd vss gf180mcu_fd_sc_mcu7t5v0__aoi21_1
Xgf180mcu_fd_sc_mcu7t5v0__aoi21_1_97 gf180mcu_fd_sc_mcu7t5v0__aoi21_1_97/B vdd vss
+ gf180mcu_fd_sc_mcu7t5v0__dffq_1_451/D gf180mcu_fd_sc_mcu7t5v0__oai21_1_94/A2 gf180mcu_fd_sc_mcu7t5v0__aoi221_2_7/ZN
+ vdd vss gf180mcu_fd_sc_mcu7t5v0__aoi21_1
Xgf180mcu_fd_sc_mcu7t5v0__oai21_1_108 vdd gf180mcu_fd_sc_mcu7t5v0__buf_8_7/Z gf180mcu_fd_sc_mcu7t5v0__nor2_4_31/ZN
+ gf180mcu_fd_sc_mcu7t5v0__aoi21_1_127/B gf180mcu_fd_sc_mcu7t5v0__dffq_1_299/Q vss
+ vdd vss gf180mcu_fd_sc_mcu7t5v0__oai21_1
Xgf180mcu_fd_sc_mcu7t5v0__nor2_2_50 vdd vss gf180mcu_fd_sc_mcu7t5v0__nor2_2_50/ZN
+ gf180mcu_fd_sc_mcu7t5v0__inv_3_4/I gf180mcu_fd_sc_mcu7t5v0__dffq_2_86/Q vdd vss
+ gf180mcu_fd_sc_mcu7t5v0__nor2_2
Xgf180mcu_fd_sc_mcu7t5v0__oai21_1_119 vdd gf180mcu_fd_sc_mcu7t5v0__buf_8_6/Z gf180mcu_fd_sc_mcu7t5v0__buf_20_0/I
+ gf180mcu_fd_sc_mcu7t5v0__aoi21_1_139/B gf180mcu_fd_sc_mcu7t5v0__dffq_1_309/Q vss
+ vdd vss gf180mcu_fd_sc_mcu7t5v0__oai21_1
Xgf180mcu_fd_sc_mcu7t5v0__dffq_1_360 vdd gf180mcu_fd_sc_mcu7t5v0__or4_1_2/A4 gf180mcu_fd_sc_mcu7t5v0__dffq_4_15/CLK
+ vss gf180mcu_fd_sc_mcu7t5v0__dffq_1_360/D vdd vss gf180mcu_fd_sc_mcu7t5v0__dffq_1
Xgf180mcu_fd_sc_mcu7t5v0__dffq_1_371 vdd gf180mcu_fd_sc_mcu7t5v0__nor4_1_4/A1 gf180mcu_fd_sc_mcu7t5v0__dffq_4_21/CLK
+ vss gf180mcu_fd_sc_mcu7t5v0__and2_1_71/Z vdd vss gf180mcu_fd_sc_mcu7t5v0__dffq_1
Xgf180mcu_fd_sc_mcu7t5v0__dffq_1_382 vdd gf180mcu_fd_sc_mcu7t5v0__dffq_1_382/Q gf180mcu_fd_sc_mcu7t5v0__dffq_4_15/CLK
+ vss gf180mcu_fd_sc_mcu7t5v0__dffq_1_382/D vdd vss gf180mcu_fd_sc_mcu7t5v0__dffq_1
Xgf180mcu_fd_sc_mcu7t5v0__dffq_1_393 vdd gf180mcu_fd_sc_mcu7t5v0__dffq_1_393/Q gf180mcu_fd_sc_mcu7t5v0__dffq_4_21/CLK
+ vss gf180mcu_fd_sc_mcu7t5v0__dffq_1_393/D vdd vss gf180mcu_fd_sc_mcu7t5v0__dffq_1
Xgf180mcu_fd_sc_mcu7t5v0__oai31_4_4 gf180mcu_fd_sc_mcu7t5v0__inv_4_5/ZN gf180mcu_fd_sc_mcu7t5v0__oai31_4_4/B
+ vdd vss gf180mcu_fd_sc_mcu7t5v0__oai31_4_4/ZN gf180mcu_fd_sc_mcu7t5v0__oai31_4_4/A1
+ gf180mcu_fd_sc_mcu7t5v0__or2_2_1/A1 vdd vss gf180mcu_fd_sc_mcu7t5v0__oai31_4
Xgf180mcu_fd_sc_mcu7t5v0__oai22_1_50 gf180mcu_fd_sc_mcu7t5v0__nand2_4_6/ZN gf180mcu_fd_sc_mcu7t5v0__oai22_1_96/B1
+ gf180mcu_fd_sc_mcu7t5v0__oai22_1_50/B2 vdd vss gf180mcu_fd_sc_mcu7t5v0__dffq_1_58/D
+ gf180mcu_fd_sc_mcu7t5v0__aoi21_4_1/ZN vdd vss gf180mcu_fd_sc_mcu7t5v0__oai22_1
Xgf180mcu_fd_sc_mcu7t5v0__oai22_1_61 gf180mcu_fd_sc_mcu7t5v0__oai22_1_62/A2 gf180mcu_fd_sc_mcu7t5v0__oai22_1_62/B1
+ gf180mcu_fd_sc_mcu7t5v0__oai22_1_61/B2 vdd vss gf180mcu_fd_sc_mcu7t5v0__dffq_1_66/D
+ gf180mcu_fd_sc_mcu7t5v0__aoi21_4_1/ZN vdd vss gf180mcu_fd_sc_mcu7t5v0__oai22_1
Xgf180mcu_fd_sc_mcu7t5v0__oai22_1_72 gf180mcu_fd_sc_mcu7t5v0__nand2_4_8/ZN gf180mcu_fd_sc_mcu7t5v0__oai22_1_89/B1
+ gf180mcu_fd_sc_mcu7t5v0__oai22_1_72/B2 vdd vss gf180mcu_fd_sc_mcu7t5v0__dffq_1_95/D
+ gf180mcu_fd_sc_mcu7t5v0__aoi21_4_3/ZN vdd vss gf180mcu_fd_sc_mcu7t5v0__oai22_1
Xgf180mcu_fd_sc_mcu7t5v0__oai22_1_83 gf180mcu_fd_sc_mcu7t5v0__nand2_4_9/ZN gf180mcu_fd_sc_mcu7t5v0__oai22_1_95/B1
+ gf180mcu_fd_sc_mcu7t5v0__oai22_1_83/B2 vdd vss gf180mcu_fd_sc_mcu7t5v0__dffq_1_82/D
+ gf180mcu_fd_sc_mcu7t5v0__aoi21_4_4/ZN vdd vss gf180mcu_fd_sc_mcu7t5v0__oai22_1
Xgf180mcu_fd_sc_mcu7t5v0__oai22_1_94 gf180mcu_fd_sc_mcu7t5v0__nand2_4_7/ZN gf180mcu_fd_sc_mcu7t5v0__oai22_1_94/B1
+ gf180mcu_fd_sc_mcu7t5v0__oai22_1_94/B2 vdd vss gf180mcu_fd_sc_mcu7t5v0__dffq_1_93/D
+ gf180mcu_fd_sc_mcu7t5v0__aoi21_4_2/ZN vdd vss gf180mcu_fd_sc_mcu7t5v0__oai22_1
Xgf180mcu_fd_sc_mcu7t5v0__nand2_2_15 vdd vss gf180mcu_fd_sc_mcu7t5v0__oai22_1_45/B1
+ gf180mcu_fd_sc_mcu7t5v0__buf_8_2/Z gf180mcu_fd_sc_mcu7t5v0__nand2_4_3/ZN vdd vss
+ gf180mcu_fd_sc_mcu7t5v0__nand2_2
Xgf180mcu_fd_sc_mcu7t5v0__nand2_2_26 vdd vss gf180mcu_fd_sc_mcu7t5v0__nand2_2_26/ZN
+ rst_n gf180mcu_fd_sc_mcu7t5v0__nand2_4_19/ZN vdd vss gf180mcu_fd_sc_mcu7t5v0__nand2_2
Xgf180mcu_fd_sc_mcu7t5v0__nand2_2_37 vdd vss gf180mcu_fd_sc_mcu7t5v0__oai22_1_28/B1
+ gf180mcu_fd_sc_mcu7t5v0__buf_8_2/Z gf180mcu_fd_sc_mcu7t5v0__oai22_1_28/A2 vdd vss
+ gf180mcu_fd_sc_mcu7t5v0__nand2_2
Xgf180mcu_fd_sc_mcu7t5v0__nand2_2_48 vdd vss gf180mcu_fd_sc_mcu7t5v0__or2_4_4/A2 gf180mcu_fd_sc_mcu7t5v0__or3_4_0/A1
+ gf180mcu_fd_sc_mcu7t5v0__nor3_4_12/A2 vdd vss gf180mcu_fd_sc_mcu7t5v0__nand2_2
Xgf180mcu_fd_sc_mcu7t5v0__nand2_2_59 vdd vss gf180mcu_fd_sc_mcu7t5v0__nor2_2_32/A2
+ gf180mcu_fd_sc_mcu7t5v0__and2_2_10/A1 gf180mcu_fd_sc_mcu7t5v0__oai22_4_3/ZN vdd
+ vss gf180mcu_fd_sc_mcu7t5v0__nand2_2
Xgf180mcu_fd_sc_mcu7t5v0__xor2_1_207 vdd vss gf180mcu_fd_sc_mcu7t5v0__xor2_1_207/Z
+ gf180mcu_fd_sc_mcu7t5v0__xor2_1_207/A1 gf180mcu_fd_sc_mcu7t5v0__xor3_1_92/Z vdd
+ vss gf180mcu_fd_sc_mcu7t5v0__xor2_1
Xgf180mcu_fd_sc_mcu7t5v0__xor2_1_218 vdd vss gf180mcu_fd_sc_mcu7t5v0__xor2_1_218/Z
+ gf180mcu_fd_sc_mcu7t5v0__or3_1_27/Z gf180mcu_fd_sc_mcu7t5v0__xor2_1_218/A2 vdd vss
+ gf180mcu_fd_sc_mcu7t5v0__xor2_1
Xgf180mcu_fd_sc_mcu7t5v0__xor2_1_229 vdd vss gf180mcu_fd_sc_mcu7t5v0__or2_1_25/A2
+ gf180mcu_fd_sc_mcu7t5v0__or3_1_24/A1 gf180mcu_fd_sc_mcu7t5v0__xor2_1_229/A2 vdd
+ vss gf180mcu_fd_sc_mcu7t5v0__xor2_1
Xgf180mcu_fd_sc_mcu7t5v0__clkinv_1_210 vdd vss gf180mcu_fd_sc_mcu7t5v0__dffq_1_193/Q
+ gf180mcu_fd_sc_mcu7t5v0__oai22_1_202/B2 vdd vss gf180mcu_fd_sc_mcu7t5v0__clkinv_1
Xgf180mcu_fd_sc_mcu7t5v0__clkinv_1_221 vdd vss gf180mcu_fd_sc_mcu7t5v0__dffq_1_195/Q
+ gf180mcu_fd_sc_mcu7t5v0__oai22_1_199/B2 vdd vss gf180mcu_fd_sc_mcu7t5v0__clkinv_1
Xgf180mcu_fd_sc_mcu7t5v0__clkinv_1_232 vdd vss gf180mcu_fd_sc_mcu7t5v0__dffq_1_208/Q
+ gf180mcu_fd_sc_mcu7t5v0__oai22_1_221/B2 vdd vss gf180mcu_fd_sc_mcu7t5v0__clkinv_1
Xgf180mcu_fd_sc_mcu7t5v0__clkinv_1_243 vdd vss gf180mcu_fd_sc_mcu7t5v0__dffq_1_212/Q
+ gf180mcu_fd_sc_mcu7t5v0__oai22_1_223/B2 vdd vss gf180mcu_fd_sc_mcu7t5v0__clkinv_1
Xgf180mcu_fd_sc_mcu7t5v0__clkinv_1_254 vdd vss gf180mcu_fd_sc_mcu7t5v0__dffq_1_227/Q
+ gf180mcu_fd_sc_mcu7t5v0__oai22_1_235/B2 vdd vss gf180mcu_fd_sc_mcu7t5v0__clkinv_1
Xgf180mcu_fd_sc_mcu7t5v0__clkinv_1_265 vdd vss gf180mcu_fd_sc_mcu7t5v0__mux4_4_3/Z
+ gf180mcu_fd_sc_mcu7t5v0__nand4_2_4/A4 vdd vss gf180mcu_fd_sc_mcu7t5v0__clkinv_1
Xgf180mcu_fd_sc_mcu7t5v0__clkinv_1_276 vdd vss gf180mcu_fd_sc_mcu7t5v0__or3_2_3/A2
+ gf180mcu_fd_sc_mcu7t5v0__aoi21_1_105/A1 vdd vss gf180mcu_fd_sc_mcu7t5v0__clkinv_1
Xgf180mcu_fd_sc_mcu7t5v0__clkinv_1_287 vdd vss gf180mcu_fd_sc_mcu7t5v0__clkinv_1_287/I
+ gf180mcu_fd_sc_mcu7t5v0__oai21_1_126/B vdd vss gf180mcu_fd_sc_mcu7t5v0__clkinv_1
Xgf180mcu_fd_sc_mcu7t5v0__clkinv_1_298 vdd vss gf180mcu_fd_sc_mcu7t5v0__xor2_1_90/A2
+ gf180mcu_fd_sc_mcu7t5v0__aoi211_1_50/B vdd vss gf180mcu_fd_sc_mcu7t5v0__clkinv_1
Xgf180mcu_fd_sc_mcu7t5v0__or3_4_0 gf180mcu_fd_sc_mcu7t5v0__or3_4_0/A3 vdd vss gf180mcu_fd_sc_mcu7t5v0__or3_4_0/Z
+ gf180mcu_fd_sc_mcu7t5v0__or3_4_0/A1 gf180mcu_fd_sc_mcu7t5v0__or3_4_0/A2 vdd vss
+ gf180mcu_fd_sc_mcu7t5v0__or3_4
Xgf180mcu_fd_sc_mcu7t5v0__inv_4_4 vss gf180mcu_fd_sc_mcu7t5v0__inv_4_4/ZN gf180mcu_fd_sc_mcu7t5v0__inv_4_4/I
+ vdd vdd vss gf180mcu_fd_sc_mcu7t5v0__inv_4
Xgf180mcu_fd_sc_mcu7t5v0__dffq_2_102 gf180mcu_fd_sc_mcu7t5v0__dffq_2_102/D vdd vss
+ gf180mcu_fd_sc_mcu7t5v0__dffq_4_1/CLK gf180mcu_fd_sc_mcu7t5v0__dffq_2_102/Q vdd
+ vss gf180mcu_fd_sc_mcu7t5v0__dffq_2
Xgf180mcu_fd_sc_mcu7t5v0__oai22_1_270 gf180mcu_fd_sc_mcu7t5v0__and2_2_9/Z gf180mcu_fd_sc_mcu7t5v0__and2_1_112/Z
+ gf180mcu_fd_sc_mcu7t5v0__oai32_1_8/A1 vdd vss gf180mcu_fd_sc_mcu7t5v0__oai221_1_11/C
+ gf180mcu_fd_sc_mcu7t5v0__inv_8_1/I vdd vss gf180mcu_fd_sc_mcu7t5v0__oai22_1
Xgf180mcu_fd_sc_mcu7t5v0__oai22_1_281 gf180mcu_fd_sc_mcu7t5v0__xnor3_1_45/A1 gf180mcu_fd_sc_mcu7t5v0__oai22_1_281/B1
+ gf180mcu_fd_sc_mcu7t5v0__xnor3_1_47/A2 vdd vss gf180mcu_fd_sc_mcu7t5v0__xor2_1_200/A1
+ gf180mcu_fd_sc_mcu7t5v0__xor3_1_147/A3 vdd vss gf180mcu_fd_sc_mcu7t5v0__oai22_1
Xgf180mcu_fd_sc_mcu7t5v0__clkinv_3_0 vdd gf180mcu_fd_sc_mcu7t5v0__nor3_4_2/A1 gf180mcu_fd_sc_mcu7t5v0__dffq_4_3/Q
+ vss vdd vss gf180mcu_fd_sc_mcu7t5v0__clkinv_3
Xgf180mcu_fd_sc_mcu7t5v0__dffq_1_190 vdd gf180mcu_fd_sc_mcu7t5v0__dffq_1_190/Q gf180mcu_fd_sc_mcu7t5v0__dffq_2_58/CLK
+ vss gf180mcu_fd_sc_mcu7t5v0__dffq_1_190/D vdd vss gf180mcu_fd_sc_mcu7t5v0__dffq_1
Xgf180mcu_fd_sc_mcu7t5v0__oai31_2_1 gf180mcu_fd_sc_mcu7t5v0__oai31_2_1/A2 gf180mcu_fd_sc_mcu7t5v0__inv_2_9/ZN
+ gf180mcu_fd_sc_mcu7t5v0__mux4_4_6/Z vdd vss gf180mcu_fd_sc_mcu7t5v0__oai31_2_1/ZN
+ gf180mcu_fd_sc_mcu7t5v0__dffq_2_98/Q vdd vss gf180mcu_fd_sc_mcu7t5v0__oai31_2
Xgf180mcu_fd_sc_mcu7t5v0__nand3_1_5 gf180mcu_fd_sc_mcu7t5v0__oai31_1_4/B vdd vss gf180mcu_fd_sc_mcu7t5v0__xor3_1_12/A3
+ gf180mcu_fd_sc_mcu7t5v0__and2_4_0/A1 gf180mcu_fd_sc_mcu7t5v0__and2_4_0/A2 vdd vss
+ gf180mcu_fd_sc_mcu7t5v0__nand3_1
Xgf180mcu_fd_sc_mcu7t5v0__nor2_1_390 vdd vss gf180mcu_fd_sc_mcu7t5v0__xor2_1_196/A1
+ gf180mcu_fd_sc_mcu7t5v0__nor2_1_391/ZN gf180mcu_fd_sc_mcu7t5v0__and2_1_142/Z vdd
+ vss gf180mcu_fd_sc_mcu7t5v0__nor2_1
Xgf180mcu_fd_sc_mcu7t5v0__oai22_2_1 gf180mcu_fd_sc_mcu7t5v0__oai22_2_1/B2 vdd vss
+ gf180mcu_fd_sc_mcu7t5v0__oai22_2_1/ZN gf180mcu_fd_sc_mcu7t5v0__oai22_2_1/A1 gf180mcu_fd_sc_mcu7t5v0__oai22_2_1/A2
+ gf180mcu_fd_sc_mcu7t5v0__oai22_2_1/B1 vdd vss gf180mcu_fd_sc_mcu7t5v0__oai22_2
Xgf180mcu_fd_sc_mcu7t5v0__clkinv_2_11 vdd vss gf180mcu_fd_sc_mcu7t5v0__dffq_4_32/Q
+ gf180mcu_fd_sc_mcu7t5v0__aoi22_2_8/A2 vdd vss gf180mcu_fd_sc_mcu7t5v0__clkinv_2
Xgf180mcu_fd_sc_mcu7t5v0__inv_2_1 vss gf180mcu_fd_sc_mcu7t5v0__inv_2_1/ZN gf180mcu_fd_sc_mcu7t5v0__inv_2_1/I
+ vdd vdd vss gf180mcu_fd_sc_mcu7t5v0__inv_2
Xgf180mcu_fd_sc_mcu7t5v0__aoi22_1_102 gf180mcu_fd_sc_mcu7t5v0__nor2_4_9/ZN gf180mcu_fd_sc_mcu7t5v0__dffq_1_154/Q
+ vdd vss gf180mcu_fd_sc_mcu7t5v0__nand2_1_245/A1 gf180mcu_fd_sc_mcu7t5v0__dffq_1_152/Q
+ gf180mcu_fd_sc_mcu7t5v0__nor2_4_8/ZN vdd vss gf180mcu_fd_sc_mcu7t5v0__aoi22_1
Xgf180mcu_fd_sc_mcu7t5v0__aoi22_1_113 gf180mcu_fd_sc_mcu7t5v0__nor2_4_11/ZN gf180mcu_fd_sc_mcu7t5v0__dffq_1_207/Q
+ vdd vss gf180mcu_fd_sc_mcu7t5v0__nand2_1_263/A2 gf180mcu_fd_sc_mcu7t5v0__dffq_1_206/Q
+ gf180mcu_fd_sc_mcu7t5v0__nor2_4_10/ZN vdd vss gf180mcu_fd_sc_mcu7t5v0__aoi22_1
Xgf180mcu_fd_sc_mcu7t5v0__aoi22_1_124 gf180mcu_fd_sc_mcu7t5v0__nor2_4_11/ZN gf180mcu_fd_sc_mcu7t5v0__dffq_1_225/Q
+ vdd vss gf180mcu_fd_sc_mcu7t5v0__nand2_1_273/A2 gf180mcu_fd_sc_mcu7t5v0__dffq_1_227/Q
+ gf180mcu_fd_sc_mcu7t5v0__nor2_4_10/ZN vdd vss gf180mcu_fd_sc_mcu7t5v0__aoi22_1
Xgf180mcu_fd_sc_mcu7t5v0__aoi22_1_135 gf180mcu_fd_sc_mcu7t5v0__nor2_4_9/ZN gf180mcu_fd_sc_mcu7t5v0__dffq_1_223/Q
+ vdd vss gf180mcu_fd_sc_mcu7t5v0__nand2_1_276/A1 gf180mcu_fd_sc_mcu7t5v0__dffq_1_252/Q
+ gf180mcu_fd_sc_mcu7t5v0__nor2_4_8/ZN vdd vss gf180mcu_fd_sc_mcu7t5v0__aoi22_1
Xgf180mcu_fd_sc_mcu7t5v0__aoi22_1_146 gf180mcu_fd_sc_mcu7t5v0__nor2_4_11/ZN gf180mcu_fd_sc_mcu7t5v0__dffq_1_30/Q
+ vdd vss gf180mcu_fd_sc_mcu7t5v0__nand2_1_298/A2 gf180mcu_fd_sc_mcu7t5v0__dffq_1_221/Q
+ gf180mcu_fd_sc_mcu7t5v0__nor2_4_10/ZN vdd vss gf180mcu_fd_sc_mcu7t5v0__aoi22_1
Xgf180mcu_fd_sc_mcu7t5v0__aoi22_1_157 gf180mcu_fd_sc_mcu7t5v0__and3_2_2/A2 gf180mcu_fd_sc_mcu7t5v0__dffq_1_322/Q
+ vdd vss gf180mcu_fd_sc_mcu7t5v0__clkinv_1_279/I gf180mcu_fd_sc_mcu7t5v0__dffq_1_411/Q
+ gf180mcu_fd_sc_mcu7t5v0__nor2_4_23/ZN vdd vss gf180mcu_fd_sc_mcu7t5v0__aoi22_1
Xgf180mcu_fd_sc_mcu7t5v0__or2_1_18 vdd vss gf180mcu_fd_sc_mcu7t5v0__or2_1_18/Z gf180mcu_fd_sc_mcu7t5v0__or2_1_18/A1
+ gf180mcu_fd_sc_mcu7t5v0__xor2_1_86/Z vdd vss gf180mcu_fd_sc_mcu7t5v0__or2_1
Xgf180mcu_fd_sc_mcu7t5v0__aoi22_1_168 gf180mcu_fd_sc_mcu7t5v0__or2_1_45/Z gf180mcu_fd_sc_mcu7t5v0__and2_1_127/Z
+ vdd vss gf180mcu_fd_sc_mcu7t5v0__xor3_1_121/A3 gf180mcu_fd_sc_mcu7t5v0__nor2_1_350/ZN
+ gf180mcu_fd_sc_mcu7t5v0__xor3_1_116/A1 vdd vss gf180mcu_fd_sc_mcu7t5v0__aoi22_1
Xgf180mcu_fd_sc_mcu7t5v0__or2_1_29 vdd vss gf180mcu_fd_sc_mcu7t5v0__or2_1_29/Z gf180mcu_fd_sc_mcu7t5v0__or2_1_29/A1
+ gf180mcu_fd_sc_mcu7t5v0__or2_1_29/A2 vdd vss gf180mcu_fd_sc_mcu7t5v0__or2_1
Xgf180mcu_fd_sc_mcu7t5v0__aoi22_1_179 gf180mcu_fd_sc_mcu7t5v0__nor2_4_44/ZN gf180mcu_fd_sc_mcu7t5v0__inv_12_1/I
+ vdd vss gf180mcu_fd_sc_mcu7t5v0__nand2_1_49/A1 gf180mcu_fd_sc_mcu7t5v0__nor2_2_3/ZN
+ gf180mcu_fd_sc_mcu7t5v0__nand2_1_259/ZN vdd vss gf180mcu_fd_sc_mcu7t5v0__aoi22_1
Xgf180mcu_fd_sc_mcu7t5v0__nor2_4_18 vdd vss gf180mcu_fd_sc_mcu7t5v0__nor2_4_18/ZN
+ gf180mcu_fd_sc_mcu7t5v0__nor2_4_28/A2 gf180mcu_fd_sc_mcu7t5v0__or2_4_1/Z vdd vss
+ gf180mcu_fd_sc_mcu7t5v0__nor2_4
Xgf180mcu_fd_sc_mcu7t5v0__nor2_4_29 vdd vss gf180mcu_fd_sc_mcu7t5v0__or2_1_34/A2 gf180mcu_fd_sc_mcu7t5v0__or3_4_0/A3
+ gf180mcu_fd_sc_mcu7t5v0__or2_4_4/A2 vdd vss gf180mcu_fd_sc_mcu7t5v0__nor2_4
Xgf180mcu_fd_sc_mcu7t5v0__oai21_1_280 vdd gf180mcu_fd_sc_mcu7t5v0__oai21_1_280/B gf180mcu_fd_sc_mcu7t5v0__mux4_4_12/Z
+ gf180mcu_fd_sc_mcu7t5v0__nand4_1_19/A4 gf180mcu_fd_sc_mcu7t5v0__dffq_4_37/Q vss
+ vdd vss gf180mcu_fd_sc_mcu7t5v0__oai21_1
Xgf180mcu_fd_sc_mcu7t5v0__oai21_1_291 vdd gf180mcu_fd_sc_mcu7t5v0__or4_1_3/A1 gf180mcu_fd_sc_mcu7t5v0__inv_3_4/ZN
+ gf180mcu_fd_sc_mcu7t5v0__nand3_1_86/A1 gf180mcu_fd_sc_mcu7t5v0__inv_12_1/I vss vdd
+ vss gf180mcu_fd_sc_mcu7t5v0__oai21_1
Xgf180mcu_fd_sc_mcu7t5v0__aoi21_1_304 gf180mcu_fd_sc_mcu7t5v0__aoi21_1_304/B vdd vss
+ gf180mcu_fd_sc_mcu7t5v0__dffq_2_74/D gf180mcu_fd_sc_mcu7t5v0__aoi21_1_304/A1 gf180mcu_fd_sc_mcu7t5v0__buf_20_0/Z
+ vdd vss gf180mcu_fd_sc_mcu7t5v0__aoi21_1
Xgf180mcu_fd_sc_mcu7t5v0__aoi21_1_315 gf180mcu_fd_sc_mcu7t5v0__or2_4_4/Z vdd vss gf180mcu_fd_sc_mcu7t5v0__aoi22_1_167/B2
+ gf180mcu_fd_sc_mcu7t5v0__nor2_1_345/ZN gf180mcu_fd_sc_mcu7t5v0__xor3_1_114/Z vdd
+ vss gf180mcu_fd_sc_mcu7t5v0__aoi21_1
Xgf180mcu_fd_sc_mcu7t5v0__aoi21_1_326 gf180mcu_fd_sc_mcu7t5v0__and2_1_126/Z vdd vss
+ gf180mcu_fd_sc_mcu7t5v0__or2_1_57/A1 gf180mcu_fd_sc_mcu7t5v0__xor2_1_227/A1 gf180mcu_fd_sc_mcu7t5v0__xor2_1_228/Z
+ vdd vss gf180mcu_fd_sc_mcu7t5v0__aoi21_1
Xgf180mcu_fd_sc_mcu7t5v0__aoi21_1_337 gf180mcu_fd_sc_mcu7t5v0__and2_1_135/Z vdd vss
+ gf180mcu_fd_sc_mcu7t5v0__xnor2_1_61/A1 gf180mcu_fd_sc_mcu7t5v0__xnor3_1_41/A2 gf180mcu_fd_sc_mcu7t5v0__or2_1_48/Z
+ vdd vss gf180mcu_fd_sc_mcu7t5v0__aoi21_1
Xgf180mcu_fd_sc_mcu7t5v0__aoi21_1_348 gf180mcu_fd_sc_mcu7t5v0__xor2_1_138/Z vdd vss
+ gf180mcu_fd_sc_mcu7t5v0__or3_1_18/A2 gf180mcu_fd_sc_mcu7t5v0__and3_1_15/A1 gf180mcu_fd_sc_mcu7t5v0__and3_1_15/A2
+ vdd vss gf180mcu_fd_sc_mcu7t5v0__aoi21_1
Xgf180mcu_fd_sc_mcu7t5v0__aoi21_1_359 gf180mcu_fd_sc_mcu7t5v0__aoi21_1_359/B vdd vss
+ gf180mcu_fd_sc_mcu7t5v0__xnor2_1_69/A1 gf180mcu_fd_sc_mcu7t5v0__aoi21_2_23/A1 gf180mcu_fd_sc_mcu7t5v0__and2_1_151/Z
+ vdd vss gf180mcu_fd_sc_mcu7t5v0__aoi21_1
Xgf180mcu_fd_sc_mcu7t5v0__xor3_1_14 gf180mcu_fd_sc_mcu7t5v0__xor3_1_61/Z vdd vss gf180mcu_fd_sc_mcu7t5v0__xor3_1_14/Z
+ gf180mcu_fd_sc_mcu7t5v0__dffq_2_8/Q gf180mcu_fd_sc_mcu7t5v0__xor3_1_14/A2 vdd vss
+ gf180mcu_fd_sc_mcu7t5v0__xor3_1
Xgf180mcu_fd_sc_mcu7t5v0__xor3_1_25 gf180mcu_fd_sc_mcu7t5v0__and2_1_6/A2 vdd vss gf180mcu_fd_sc_mcu7t5v0__xor3_1_25/Z
+ gf180mcu_fd_sc_mcu7t5v0__nor3_1_4/A1 gf180mcu_fd_sc_mcu7t5v0__and2_1_6/A1 vdd vss
+ gf180mcu_fd_sc_mcu7t5v0__xor3_1
Xgf180mcu_fd_sc_mcu7t5v0__aoi222_1_4 vss vdd gf180mcu_fd_sc_mcu7t5v0__nor2_4_12/ZN
+ gf180mcu_fd_sc_mcu7t5v0__aoi222_1_4/C1 gf180mcu_fd_sc_mcu7t5v0__nor2_4_4/ZN gf180mcu_fd_sc_mcu7t5v0__aoi222_1_4/B1
+ gf180mcu_fd_sc_mcu7t5v0__aoi222_1_4/A2 gf180mcu_fd_sc_mcu7t5v0__nor2_4_5/ZN gf180mcu_fd_sc_mcu7t5v0__nand3_1_46/A3
+ vdd vss gf180mcu_fd_sc_mcu7t5v0__aoi222_1
Xgf180mcu_fd_sc_mcu7t5v0__xor3_1_36 gf180mcu_fd_sc_mcu7t5v0__xor3_1_37/Z vdd vss gf180mcu_fd_sc_mcu7t5v0__xor3_1_36/Z
+ gf180mcu_fd_sc_mcu7t5v0__xor3_1_36/A1 gf180mcu_fd_sc_mcu7t5v0__xor3_1_36/A2 vdd
+ vss gf180mcu_fd_sc_mcu7t5v0__xor3_1
Xgf180mcu_fd_sc_mcu7t5v0__xor3_1_47 gf180mcu_fd_sc_mcu7t5v0__xor3_1_47/A3 vdd vss
+ gf180mcu_fd_sc_mcu7t5v0__xor3_1_47/Z gf180mcu_fd_sc_mcu7t5v0__xor3_1_47/A1 gf180mcu_fd_sc_mcu7t5v0__xor3_1_47/A2
+ vdd vss gf180mcu_fd_sc_mcu7t5v0__xor3_1
Xgf180mcu_fd_sc_mcu7t5v0__xor3_1_58 gf180mcu_fd_sc_mcu7t5v0__xor2_2_0/Z vdd vss gf180mcu_fd_sc_mcu7t5v0__xor3_1_58/Z
+ gf180mcu_fd_sc_mcu7t5v0__dffq_2_4/Q gf180mcu_fd_sc_mcu7t5v0__xor3_1_58/A2 vdd vss
+ gf180mcu_fd_sc_mcu7t5v0__xor3_1
Xgf180mcu_fd_sc_mcu7t5v0__xor3_1_69 gf180mcu_fd_sc_mcu7t5v0__xor3_1_69/A3 vdd vss
+ gf180mcu_fd_sc_mcu7t5v0__xor3_1_69/Z gf180mcu_fd_sc_mcu7t5v0__mux4_2_0/I0 gf180mcu_fd_sc_mcu7t5v0__xor3_1_69/A2
+ vdd vss gf180mcu_fd_sc_mcu7t5v0__xor3_1
Xgf180mcu_fd_sc_mcu7t5v0__nor3_1_6 gf180mcu_fd_sc_mcu7t5v0__nor3_1_6/A3 vdd vss gf180mcu_fd_sc_mcu7t5v0__nor3_1_6/ZN
+ gf180mcu_fd_sc_mcu7t5v0__nor3_1_6/A1 gf180mcu_fd_sc_mcu7t5v0__mux2_1_1/S vdd vss
+ gf180mcu_fd_sc_mcu7t5v0__nor3_1
Xgf180mcu_fd_sc_mcu7t5v0__nand2_1_604 vdd vss gf180mcu_fd_sc_mcu7t5v0__xor3_1_124/A3
+ gf180mcu_fd_sc_mcu7t5v0__inv_8_2/I gf180mcu_fd_sc_mcu7t5v0__mux4_4_13/Z vdd vss
+ gf180mcu_fd_sc_mcu7t5v0__nand2_1
Xgf180mcu_fd_sc_mcu7t5v0__nand2_1_615 vdd vss gf180mcu_fd_sc_mcu7t5v0__xor2_1_172/A2
+ gf180mcu_fd_sc_mcu7t5v0__inv_8_2/I gf180mcu_fd_sc_mcu7t5v0__xor2_1_192/A1 vdd vss
+ gf180mcu_fd_sc_mcu7t5v0__nand2_1
Xgf180mcu_fd_sc_mcu7t5v0__nand4_2_0 gf180mcu_fd_sc_mcu7t5v0__or4_1_1/A1 gf180mcu_fd_sc_mcu7t5v0__or4_1_1/A2
+ vdd vss gf180mcu_fd_sc_mcu7t5v0__xor3_1_57/A1 gf180mcu_fd_sc_mcu7t5v0__inv_8_1/I
+ gf180mcu_fd_sc_mcu7t5v0__inv_12_1/I vdd vss gf180mcu_fd_sc_mcu7t5v0__nand4_2
Xgf180mcu_fd_sc_mcu7t5v0__nand2_1_626 vdd vss gf180mcu_fd_sc_mcu7t5v0__xor3_1_137/A1
+ gf180mcu_fd_sc_mcu7t5v0__inv_4_6/I gf180mcu_fd_sc_mcu7t5v0__inv_1_23/I vdd vss gf180mcu_fd_sc_mcu7t5v0__nand2_1
Xgf180mcu_fd_sc_mcu7t5v0__nand2_1_637 vdd vss gf180mcu_fd_sc_mcu7t5v0__nand2_1_637/ZN
+ gf180mcu_fd_sc_mcu7t5v0__xor3_1_125/A2 gf180mcu_fd_sc_mcu7t5v0__xor3_1_118/Z vdd
+ vss gf180mcu_fd_sc_mcu7t5v0__nand2_1
Xgf180mcu_fd_sc_mcu7t5v0__nand2_1_648 vdd vss gf180mcu_fd_sc_mcu7t5v0__oai21_1_313/B
+ gf180mcu_fd_sc_mcu7t5v0__dffq_2_96/Q gf180mcu_fd_sc_mcu7t5v0__xor3_1_143/A3 vdd
+ vss gf180mcu_fd_sc_mcu7t5v0__nand2_1
Xgf180mcu_fd_sc_mcu7t5v0__nand2_1_659 vdd vss gf180mcu_fd_sc_mcu7t5v0__xnor2_1_67/A1
+ gf180mcu_fd_sc_mcu7t5v0__and2_1_144/Z gf180mcu_fd_sc_mcu7t5v0__and2_1_143/Z vdd
+ vss gf180mcu_fd_sc_mcu7t5v0__nand2_1
Xgf180mcu_fd_sc_mcu7t5v0__nand4_1_14 gf180mcu_fd_sc_mcu7t5v0__nand4_1_14/A3 gf180mcu_fd_sc_mcu7t5v0__oai32_1_7/ZN
+ vdd vss gf180mcu_fd_sc_mcu7t5v0__oai211_1_31/B gf180mcu_fd_sc_mcu7t5v0__nor3_1_33/A1
+ gf180mcu_fd_sc_mcu7t5v0__nand4_1_14/A2 vdd vss gf180mcu_fd_sc_mcu7t5v0__nand4_1
Xgf180mcu_fd_sc_mcu7t5v0__nand4_1_25 gf180mcu_fd_sc_mcu7t5v0__nand4_1_25/A3 gf180mcu_fd_sc_mcu7t5v0__oai21_1_25/ZN
+ vdd vss gf180mcu_fd_sc_mcu7t5v0__oai211_1_57/B gf180mcu_fd_sc_mcu7t5v0__nand4_1_1/A1
+ gf180mcu_fd_sc_mcu7t5v0__nand4_1_25/A2 vdd vss gf180mcu_fd_sc_mcu7t5v0__nand4_1
Xgf180mcu_fd_sc_mcu7t5v0__inv_1_15 vss gf180mcu_fd_sc_mcu7t5v0__inv_1_15/ZN gf180mcu_fd_sc_mcu7t5v0__inv_1_15/I
+ vdd vdd vss gf180mcu_fd_sc_mcu7t5v0__inv_1
Xgf180mcu_fd_sc_mcu7t5v0__xor2_1_80 vdd vss gf180mcu_fd_sc_mcu7t5v0__xor2_1_80/Z gf180mcu_fd_sc_mcu7t5v0__xor3_1_67/Z
+ gf180mcu_fd_sc_mcu7t5v0__xor2_1_79/Z vdd vss gf180mcu_fd_sc_mcu7t5v0__xor2_1
Xgf180mcu_fd_sc_mcu7t5v0__xor2_1_91 vdd vss gf180mcu_fd_sc_mcu7t5v0__xor2_1_91/Z gf180mcu_fd_sc_mcu7t5v0__nor4_4_3/A1
+ gf180mcu_fd_sc_mcu7t5v0__xor2_1_91/A2 vdd vss gf180mcu_fd_sc_mcu7t5v0__xor2_1
Xgf180mcu_fd_sc_mcu7t5v0__aoi21_1_101 gf180mcu_fd_sc_mcu7t5v0__nor2_1_124/ZN vdd vss
+ gf180mcu_fd_sc_mcu7t5v0__or3_1_9/A3 gf180mcu_fd_sc_mcu7t5v0__xnor3_1_18/A2 gf180mcu_fd_sc_mcu7t5v0__nand2_1_283/ZN
+ vdd vss gf180mcu_fd_sc_mcu7t5v0__aoi21_1
Xgf180mcu_fd_sc_mcu7t5v0__aoi21_1_112 gf180mcu_fd_sc_mcu7t5v0__oai21_1_98/ZN vdd vss
+ gf180mcu_fd_sc_mcu7t5v0__dffq_1_285/D gf180mcu_fd_sc_mcu7t5v0__nor3_4_14/ZN gf180mcu_fd_sc_mcu7t5v0__aoi22_4_4/ZN
+ vdd vss gf180mcu_fd_sc_mcu7t5v0__aoi21_1
Xgf180mcu_fd_sc_mcu7t5v0__aoi21_1_123 gf180mcu_fd_sc_mcu7t5v0__aoi21_1_123/B vdd vss
+ gf180mcu_fd_sc_mcu7t5v0__dffq_1_296/D gf180mcu_fd_sc_mcu7t5v0__nor3_4_14/ZN gf180mcu_fd_sc_mcu7t5v0__aoi22_4_6/ZN
+ vdd vss gf180mcu_fd_sc_mcu7t5v0__aoi21_1
Xgf180mcu_fd_sc_mcu7t5v0__aoi21_1_134 gf180mcu_fd_sc_mcu7t5v0__or2_1_23/A1 vdd vss
+ gf180mcu_fd_sc_mcu7t5v0__dffq_2_46/D gf180mcu_fd_sc_mcu7t5v0__nand2_1_323/ZN gf180mcu_fd_sc_mcu7t5v0__nand2_1_322/ZN
+ vdd vss gf180mcu_fd_sc_mcu7t5v0__aoi21_1
Xgf180mcu_fd_sc_mcu7t5v0__aoi21_1_145 gf180mcu_fd_sc_mcu7t5v0__aoi21_1_145/B vdd vss
+ gf180mcu_fd_sc_mcu7t5v0__dffq_1_321/D gf180mcu_fd_sc_mcu7t5v0__aoi21_1_145/A1 gf180mcu_fd_sc_mcu7t5v0__nand3_1_55/A2
+ vdd vss gf180mcu_fd_sc_mcu7t5v0__aoi21_1
Xgf180mcu_fd_sc_mcu7t5v0__and2_1_101 vdd vss gf180mcu_fd_sc_mcu7t5v0__and2_1_101/Z
+ gf180mcu_fd_sc_mcu7t5v0__xor2_1_207/A1 gf180mcu_fd_sc_mcu7t5v0__xor3_1_92/Z vdd
+ vss gf180mcu_fd_sc_mcu7t5v0__and2_1
Xgf180mcu_fd_sc_mcu7t5v0__and2_1_112 vdd vss gf180mcu_fd_sc_mcu7t5v0__and2_1_112/Z
+ gf180mcu_fd_sc_mcu7t5v0__nor2_1_271/ZN gf180mcu_fd_sc_mcu7t5v0__oai32_1_6/B1 vdd
+ vss gf180mcu_fd_sc_mcu7t5v0__and2_1
Xgf180mcu_fd_sc_mcu7t5v0__aoi21_1_156 gf180mcu_fd_sc_mcu7t5v0__aoi21_1_156/B vdd vss
+ gf180mcu_fd_sc_mcu7t5v0__dffq_1_333/D gf180mcu_fd_sc_mcu7t5v0__aoi21_1_156/A1 gf180mcu_fd_sc_mcu7t5v0__nand3_1_55/A2
+ vdd vss gf180mcu_fd_sc_mcu7t5v0__aoi21_1
Xgf180mcu_fd_sc_mcu7t5v0__and2_1_123 vdd vss gf180mcu_fd_sc_mcu7t5v0__and2_1_123/Z
+ gf180mcu_fd_sc_mcu7t5v0__nor3_4_21/ZN gf180mcu_fd_sc_mcu7t5v0__and2_1_123/A2 vdd
+ vss gf180mcu_fd_sc_mcu7t5v0__and2_1
Xgf180mcu_fd_sc_mcu7t5v0__aoi21_1_167 gf180mcu_fd_sc_mcu7t5v0__or2_1_23/A1 vdd vss
+ gf180mcu_fd_sc_mcu7t5v0__oai21_1_164/B gf180mcu_fd_sc_mcu7t5v0__aoi22_4_8/ZN gf180mcu_fd_sc_mcu7t5v0__nand2_1_356/ZN
+ vdd vss gf180mcu_fd_sc_mcu7t5v0__aoi21_1
Xgf180mcu_fd_sc_mcu7t5v0__and2_1_134 vdd vss gf180mcu_fd_sc_mcu7t5v0__oai32_1_9/A2
+ gf180mcu_fd_sc_mcu7t5v0__xor3_1_137/Z gf180mcu_fd_sc_mcu7t5v0__xor3_1_136/A3 vdd
+ vss gf180mcu_fd_sc_mcu7t5v0__and2_1
Xgf180mcu_fd_sc_mcu7t5v0__aoi21_1_178 gf180mcu_fd_sc_mcu7t5v0__aoi21_1_178/B vdd vss
+ gf180mcu_fd_sc_mcu7t5v0__dffq_1_390/D gf180mcu_fd_sc_mcu7t5v0__nor2_1_203/A1 gf180mcu_fd_sc_mcu7t5v0__nor3_4_15/ZN
+ vdd vss gf180mcu_fd_sc_mcu7t5v0__aoi21_1
Xgf180mcu_fd_sc_mcu7t5v0__aoi21_1_189 gf180mcu_fd_sc_mcu7t5v0__or2_4_4/Z vdd vss gf180mcu_fd_sc_mcu7t5v0__aoi22_1_159/B2
+ gf180mcu_fd_sc_mcu7t5v0__nor2_4_30/ZN gf180mcu_fd_sc_mcu7t5v0__xor2_1_98/Z vdd vss
+ gf180mcu_fd_sc_mcu7t5v0__aoi21_1
Xgf180mcu_fd_sc_mcu7t5v0__and2_1_145 vdd vss gf180mcu_fd_sc_mcu7t5v0__and2_1_145/Z
+ gf180mcu_fd_sc_mcu7t5v0__xor2_1_197/A1 gf180mcu_fd_sc_mcu7t5v0__xor2_1_197/A2 vdd
+ vss gf180mcu_fd_sc_mcu7t5v0__and2_1
Xgf180mcu_fd_sc_mcu7t5v0__and2_1_156 vdd vss gf180mcu_fd_sc_mcu7t5v0__dffq_2_25/D
+ gf180mcu_fd_sc_mcu7t5v0__buf_8_5/I gf180mcu_fd_sc_mcu7t5v0__nand3_1_43/ZN vdd vss
+ gf180mcu_fd_sc_mcu7t5v0__and2_1
Xgf180mcu_fd_sc_mcu7t5v0__nand3_1_80 gf180mcu_fd_sc_mcu7t5v0__and2_2_9/A2 vdd vss
+ gf180mcu_fd_sc_mcu7t5v0__or2_1_32/A2 gf180mcu_fd_sc_mcu7t5v0__inv_12_1/I gf180mcu_fd_sc_mcu7t5v0__and2_2_9/A1
+ vdd vss gf180mcu_fd_sc_mcu7t5v0__nand3_1
Xgf180mcu_fd_sc_mcu7t5v0__nand3_1_91 gf180mcu_fd_sc_mcu7t5v0__nand3_1_91/A3 vdd vss
+ gf180mcu_fd_sc_mcu7t5v0__nand3_1_91/ZN gf180mcu_fd_sc_mcu7t5v0__inv_8_1/I gf180mcu_fd_sc_mcu7t5v0__nor2_2_52/ZN
+ vdd vss gf180mcu_fd_sc_mcu7t5v0__nand3_1
Xgf180mcu_fd_sc_mcu7t5v0__nor4_4_4 gf180mcu_fd_sc_mcu7t5v0__nor4_4_4/A3 gf180mcu_fd_sc_mcu7t5v0__nor4_4_4/A4
+ vdd vss gf180mcu_fd_sc_mcu7t5v0__nor4_4_4/ZN gf180mcu_fd_sc_mcu7t5v0__nor4_4_4/A1
+ gf180mcu_fd_sc_mcu7t5v0__nor4_4_4/A2 vdd vss gf180mcu_fd_sc_mcu7t5v0__nor4_4
Xgf180mcu_fd_sc_mcu7t5v0__nor2_1_19 vdd vss gf180mcu_fd_sc_mcu7t5v0__mux2_1_0/S gf180mcu_fd_sc_mcu7t5v0__xnor2_1_8/A2
+ gf180mcu_fd_sc_mcu7t5v0__xor2_1_31/A1 vdd vss gf180mcu_fd_sc_mcu7t5v0__nor2_1
Xgf180mcu_fd_sc_mcu7t5v0__nor2_1_208 vdd vss gf180mcu_fd_sc_mcu7t5v0__dffq_1_409/D
+ gf180mcu_fd_sc_mcu7t5v0__oai21_1_99/ZN gf180mcu_fd_sc_mcu7t5v0__nor2_1_208/A2 vdd
+ vss gf180mcu_fd_sc_mcu7t5v0__nor2_1
Xgf180mcu_fd_sc_mcu7t5v0__nor2_1_219 vdd vss gf180mcu_fd_sc_mcu7t5v0__nor2_1_219/ZN
+ gf180mcu_fd_sc_mcu7t5v0__inv_12_1/I gf180mcu_fd_sc_mcu7t5v0__inv_1_13/I vdd vss
+ gf180mcu_fd_sc_mcu7t5v0__nor2_1
Xgf180mcu_fd_sc_mcu7t5v0__aoi21_1_4 gf180mcu_fd_sc_mcu7t5v0__aoi21_1_4/B vdd vss gf180mcu_fd_sc_mcu7t5v0__nor2_1_12/A2
+ gf180mcu_fd_sc_mcu7t5v0__inv_1_0/I gf180mcu_fd_sc_mcu7t5v0__or2_4_4/Z vdd vss gf180mcu_fd_sc_mcu7t5v0__aoi21_1
Xgf180mcu_fd_sc_mcu7t5v0__nand2_1_401 vdd vss gf180mcu_fd_sc_mcu7t5v0__nand3_1_64/A3
+ gf180mcu_fd_sc_mcu7t5v0__or2_1_27/A1 gf180mcu_fd_sc_mcu7t5v0__or2_1_27/A2 vdd vss
+ gf180mcu_fd_sc_mcu7t5v0__nand2_1
Xgf180mcu_fd_sc_mcu7t5v0__nand2_1_412 vdd vss gf180mcu_fd_sc_mcu7t5v0__xnor2_1_82/A1
+ gf180mcu_fd_sc_mcu7t5v0__inv_8_1/I gf180mcu_fd_sc_mcu7t5v0__mux4_4_9/Z vdd vss gf180mcu_fd_sc_mcu7t5v0__nand2_1
Xgf180mcu_fd_sc_mcu7t5v0__nand2_1_423 vdd vss gf180mcu_fd_sc_mcu7t5v0__xor2_1_219/A2
+ gf180mcu_fd_sc_mcu7t5v0__oai21_1_202/ZN gf180mcu_fd_sc_mcu7t5v0__or3_1_27/Z vdd
+ vss gf180mcu_fd_sc_mcu7t5v0__nand2_1
Xgf180mcu_fd_sc_mcu7t5v0__nand2_1_434 vdd vss gf180mcu_fd_sc_mcu7t5v0__nand2_1_434/ZN
+ gf180mcu_fd_sc_mcu7t5v0__xor3_1_78/A2 gf180mcu_fd_sc_mcu7t5v0__xor3_1_78/A3 vdd
+ vss gf180mcu_fd_sc_mcu7t5v0__nand2_1
Xgf180mcu_fd_sc_mcu7t5v0__nand2_1_445 vdd vss gf180mcu_fd_sc_mcu7t5v0__nand4_1_11/A1
+ gf180mcu_fd_sc_mcu7t5v0__and3_2_3/Z gf180mcu_fd_sc_mcu7t5v0__xor3_1_166/Z vdd vss
+ gf180mcu_fd_sc_mcu7t5v0__nand2_1
Xgf180mcu_fd_sc_mcu7t5v0__nand2_1_456 vdd vss gf180mcu_fd_sc_mcu7t5v0__nand2_1_458/A1
+ gf180mcu_fd_sc_mcu7t5v0__dffq_4_37/Q gf180mcu_fd_sc_mcu7t5v0__xor2_1_124/Z vdd vss
+ gf180mcu_fd_sc_mcu7t5v0__nand2_1
Xgf180mcu_fd_sc_mcu7t5v0__nand2_1_467 vdd vss gf180mcu_fd_sc_mcu7t5v0__oai21_1_219/A2
+ gf180mcu_fd_sc_mcu7t5v0__aoi21_2_9/A2 gf180mcu_fd_sc_mcu7t5v0__or3_1_17/Z vdd vss
+ gf180mcu_fd_sc_mcu7t5v0__nand2_1
Xgf180mcu_fd_sc_mcu7t5v0__nand2_1_478 vdd vss gf180mcu_fd_sc_mcu7t5v0__mux2_1_9/S
+ gf180mcu_fd_sc_mcu7t5v0__or2_1_7/A1 gf180mcu_fd_sc_mcu7t5v0__xor3_1_90/A2 vdd vss
+ gf180mcu_fd_sc_mcu7t5v0__nand2_1
Xgf180mcu_fd_sc_mcu7t5v0__nand2_1_489 vdd vss gf180mcu_fd_sc_mcu7t5v0__and2_1_98/A1
+ gf180mcu_fd_sc_mcu7t5v0__nor3_2_5/A1 gf180mcu_fd_sc_mcu7t5v0__nor4_2_5/A1 vdd vss
+ gf180mcu_fd_sc_mcu7t5v0__nand2_1
Xgf180mcu_fd_sc_mcu7t5v0__xor2_1_3 vdd vss gf180mcu_fd_sc_mcu7t5v0__xor2_1_3/Z gf180mcu_fd_sc_mcu7t5v0__xor3_2_0/A1
+ gf180mcu_fd_sc_mcu7t5v0__xor2_1_4/Z vdd vss gf180mcu_fd_sc_mcu7t5v0__xor2_1
Xgf180mcu_fd_sc_mcu7t5v0__oai211_1_4 gf180mcu_fd_sc_mcu7t5v0__oai22_1_1/ZN gf180mcu_fd_sc_mcu7t5v0__oai211_1_4/C
+ vdd vss gf180mcu_fd_sc_mcu7t5v0__aoi221_2_1/C gf180mcu_fd_sc_mcu7t5v0__oai32_1_3/B2
+ gf180mcu_fd_sc_mcu7t5v0__xnor3_1_8/A1 vdd vss gf180mcu_fd_sc_mcu7t5v0__oai211_1
Xgf180mcu_fd_sc_mcu7t5v0__mux2_1_4 gf180mcu_fd_sc_mcu7t5v0__mux2_1_4/S vdd vss gf180mcu_fd_sc_mcu7t5v0__mux2_1_4/Z
+ gf180mcu_fd_sc_mcu7t5v0__inv_8_0/I gf180mcu_fd_sc_mcu7t5v0__mux2_1_4/I1 vdd vss
+ gf180mcu_fd_sc_mcu7t5v0__mux2_1
Xgf180mcu_fd_sc_mcu7t5v0__xnor2_1_15 vdd vss gf180mcu_fd_sc_mcu7t5v0__xor3_1_56/A2
+ gf180mcu_fd_sc_mcu7t5v0__or2_1_13/A1 gf180mcu_fd_sc_mcu7t5v0__xor2_1_62/Z vdd vss
+ gf180mcu_fd_sc_mcu7t5v0__xnor2_1
Xgf180mcu_fd_sc_mcu7t5v0__xnor2_1_26 vdd vss gf180mcu_fd_sc_mcu7t5v0__xor2_2_1/A2
+ gf180mcu_fd_sc_mcu7t5v0__xnor2_1_26/A1 gf180mcu_fd_sc_mcu7t5v0__xor3_1_66/Z vdd
+ vss gf180mcu_fd_sc_mcu7t5v0__xnor2_1
Xgf180mcu_fd_sc_mcu7t5v0__xnor2_1_37 vdd vss gf180mcu_fd_sc_mcu7t5v0__xor2_1_108/A2
+ gf180mcu_fd_sc_mcu7t5v0__xnor2_1_37/A1 gf180mcu_fd_sc_mcu7t5v0__xor2_1_109/Z vdd
+ vss gf180mcu_fd_sc_mcu7t5v0__xnor2_1
Xgf180mcu_fd_sc_mcu7t5v0__xnor2_1_48 vdd vss gf180mcu_fd_sc_mcu7t5v0__xor3_1_156/A3
+ gf180mcu_fd_sc_mcu7t5v0__xnor3_1_33/ZN gf180mcu_fd_sc_mcu7t5v0__xnor2_1_48/A2 vdd
+ vss gf180mcu_fd_sc_mcu7t5v0__xnor2_1
Xgf180mcu_fd_sc_mcu7t5v0__xnor2_1_59 vdd vss gf180mcu_fd_sc_mcu7t5v0__xor3_1_139/A3
+ gf180mcu_fd_sc_mcu7t5v0__xnor2_1_59/A1 gf180mcu_fd_sc_mcu7t5v0__xnor2_1_59/A2 vdd
+ vss gf180mcu_fd_sc_mcu7t5v0__xnor2_1
Xgf180mcu_fd_sc_mcu7t5v0__dffq_2_20 gf180mcu_fd_sc_mcu7t5v0__dffq_2_20/D vdd vss gf180mcu_fd_sc_mcu7t5v0__dffq_4_6/CLK
+ gf180mcu_fd_sc_mcu7t5v0__inv_2_10/I vdd vss gf180mcu_fd_sc_mcu7t5v0__dffq_2
Xgf180mcu_fd_sc_mcu7t5v0__dffq_2_31 gf180mcu_fd_sc_mcu7t5v0__dffq_2_31/D vdd vss gf180mcu_fd_sc_mcu7t5v0__dffq_2_58/CLK
+ gf180mcu_fd_sc_mcu7t5v0__or2_4_2/A1 vdd vss gf180mcu_fd_sc_mcu7t5v0__dffq_2
Xgf180mcu_fd_sc_mcu7t5v0__dffq_2_42 gf180mcu_fd_sc_mcu7t5v0__dffq_2_42/D vdd vss gf180mcu_fd_sc_mcu7t5v0__dffq_4_21/CLK
+ gf180mcu_fd_sc_mcu7t5v0__dffq_2_42/Q vdd vss gf180mcu_fd_sc_mcu7t5v0__dffq_2
Xgf180mcu_fd_sc_mcu7t5v0__dffq_2_53 gf180mcu_fd_sc_mcu7t5v0__dffq_2_53/D vdd vss gf180mcu_fd_sc_mcu7t5v0__dffq_4_15/CLK
+ gf180mcu_fd_sc_mcu7t5v0__dffq_2_53/Q vdd vss gf180mcu_fd_sc_mcu7t5v0__dffq_2
Xgf180mcu_fd_sc_mcu7t5v0__and3_1_5 gf180mcu_fd_sc_mcu7t5v0__and3_1_5/A3 vdd vss gf180mcu_fd_sc_mcu7t5v0__and3_1_5/Z
+ gf180mcu_fd_sc_mcu7t5v0__and3_1_5/A1 gf180mcu_fd_sc_mcu7t5v0__and3_1_5/A2 vdd vss
+ gf180mcu_fd_sc_mcu7t5v0__and3_1
Xgf180mcu_fd_sc_mcu7t5v0__dffq_2_64 gf180mcu_fd_sc_mcu7t5v0__dffq_2_64/D vdd vss gf180mcu_fd_sc_mcu7t5v0__dffq_4_1/CLK
+ gf180mcu_fd_sc_mcu7t5v0__mux4_4_4/I1 vdd vss gf180mcu_fd_sc_mcu7t5v0__dffq_2
Xgf180mcu_fd_sc_mcu7t5v0__dffq_2_75 gf180mcu_fd_sc_mcu7t5v0__dffq_2_75/D vdd vss gf180mcu_fd_sc_mcu7t5v0__dffq_4_44/CLK
+ gf180mcu_fd_sc_mcu7t5v0__mux4_4_6/I0 vdd vss gf180mcu_fd_sc_mcu7t5v0__dffq_2
Xgf180mcu_fd_sc_mcu7t5v0__dffq_2_86 gf180mcu_fd_sc_mcu7t5v0__dffq_2_86/D vdd vss gf180mcu_fd_sc_mcu7t5v0__dffq_4_44/CLK
+ gf180mcu_fd_sc_mcu7t5v0__dffq_2_86/Q vdd vss gf180mcu_fd_sc_mcu7t5v0__dffq_2
Xgf180mcu_fd_sc_mcu7t5v0__dffq_2_97 gf180mcu_fd_sc_mcu7t5v0__dffq_2_97/D vdd vss gf180mcu_fd_sc_mcu7t5v0__dffq_4_1/CLK
+ gf180mcu_fd_sc_mcu7t5v0__dffq_2_97/Q vdd vss gf180mcu_fd_sc_mcu7t5v0__dffq_2
Xgf180mcu_fd_sc_mcu7t5v0__oai21_1_7 vdd gf180mcu_fd_sc_mcu7t5v0__or3_1_1/A3 gf180mcu_fd_sc_mcu7t5v0__or3_1_1/A2
+ gf180mcu_fd_sc_mcu7t5v0__and2_1_5/A2 gf180mcu_fd_sc_mcu7t5v0__or3_1_1/A1 vss vdd
+ vss gf180mcu_fd_sc_mcu7t5v0__oai21_1
Xgf180mcu_fd_sc_mcu7t5v0__or2_1_3 vdd vss gf180mcu_fd_sc_mcu7t5v0__or2_1_3/Z gf180mcu_fd_sc_mcu7t5v0__or2_1_3/A1
+ gf180mcu_fd_sc_mcu7t5v0__or2_1_3/A2 vdd vss gf180mcu_fd_sc_mcu7t5v0__or2_1
Xgf180mcu_fd_sc_mcu7t5v0__nor4_2_1 gf180mcu_fd_sc_mcu7t5v0__or4_1_0/A3 gf180mcu_fd_sc_mcu7t5v0__or4_1_0/A4
+ vdd vss gf180mcu_fd_sc_mcu7t5v0__nor4_2_1/ZN gf180mcu_fd_sc_mcu7t5v0__or4_1_0/A1
+ gf180mcu_fd_sc_mcu7t5v0__or4_1_0/A2 vdd vss gf180mcu_fd_sc_mcu7t5v0__nor4_2
Xgf180mcu_fd_sc_mcu7t5v0__aoi22_4_2 gf180mcu_fd_sc_mcu7t5v0__and2_2_7/Z gf180mcu_fd_sc_mcu7t5v0__nor2_2_4/ZN
+ gf180mcu_fd_sc_mcu7t5v0__inv_1_24/I vdd vss gf180mcu_fd_sc_mcu7t5v0__or4_1_0/A3
+ gf180mcu_fd_sc_mcu7t5v0__or3_2_2/A1 vdd vss gf180mcu_fd_sc_mcu7t5v0__aoi22_4
Xgf180mcu_fd_sc_mcu7t5v0__nand2_1_220 vdd vss gf180mcu_fd_sc_mcu7t5v0__aoi222_1_5/C1
+ gf180mcu_fd_sc_mcu7t5v0__aoi22_1_28/ZN gf180mcu_fd_sc_mcu7t5v0__aoi22_1_22/ZN vdd
+ vss gf180mcu_fd_sc_mcu7t5v0__nand2_1
Xgf180mcu_fd_sc_mcu7t5v0__nand2_1_231 vdd vss gf180mcu_fd_sc_mcu7t5v0__aoi222_2_5/B1
+ gf180mcu_fd_sc_mcu7t5v0__nand2_1_231/A1 gf180mcu_fd_sc_mcu7t5v0__aoi22_1_60/ZN vdd
+ vss gf180mcu_fd_sc_mcu7t5v0__nand2_1
Xgf180mcu_fd_sc_mcu7t5v0__nand2_1_242 vdd vss gf180mcu_fd_sc_mcu7t5v0__aoi222_1_1/B2
+ gf180mcu_fd_sc_mcu7t5v0__aoi22_1_80/ZN gf180mcu_fd_sc_mcu7t5v0__aoi22_1_78/ZN vdd
+ vss gf180mcu_fd_sc_mcu7t5v0__nand2_1
Xgf180mcu_fd_sc_mcu7t5v0__nand2_1_253 vdd vss gf180mcu_fd_sc_mcu7t5v0__aoi222_2_2/A2
+ gf180mcu_fd_sc_mcu7t5v0__aoi22_1_83/ZN gf180mcu_fd_sc_mcu7t5v0__aoi22_1_73/ZN vdd
+ vss gf180mcu_fd_sc_mcu7t5v0__nand2_1
Xgf180mcu_fd_sc_mcu7t5v0__nand2_1_264 vdd vss gf180mcu_fd_sc_mcu7t5v0__aoi222_2_4/A2
+ gf180mcu_fd_sc_mcu7t5v0__nand2_1_264/A1 gf180mcu_fd_sc_mcu7t5v0__aoi22_1_19/ZN vdd
+ vss gf180mcu_fd_sc_mcu7t5v0__nand2_1
Xgf180mcu_fd_sc_mcu7t5v0__nand2_1_275 vdd vss gf180mcu_fd_sc_mcu7t5v0__aoi222_2_6/A2
+ gf180mcu_fd_sc_mcu7t5v0__nand2_1_275/A1 gf180mcu_fd_sc_mcu7t5v0__nand2_1_275/A2
+ vdd vss gf180mcu_fd_sc_mcu7t5v0__nand2_1
Xgf180mcu_fd_sc_mcu7t5v0__nand2_1_286 vdd vss gf180mcu_fd_sc_mcu7t5v0__xnor3_1_18/A1
+ gf180mcu_fd_sc_mcu7t5v0__inv_8_1/I gf180mcu_fd_sc_mcu7t5v0__mux4_4_0/Z vdd vss gf180mcu_fd_sc_mcu7t5v0__nand2_1
Xgf180mcu_fd_sc_mcu7t5v0__nand2_1_297 vdd vss gf180mcu_fd_sc_mcu7t5v0__aoi222_2_8/B1
+ gf180mcu_fd_sc_mcu7t5v0__nand2_1_297/A1 gf180mcu_fd_sc_mcu7t5v0__aoi22_1_41/ZN vdd
+ vss gf180mcu_fd_sc_mcu7t5v0__nand2_1
Xgf180mcu_fd_sc_mcu7t5v0__aoi21_1_10 gf180mcu_fd_sc_mcu7t5v0__nor2_4_0/ZN vdd vss
+ gf180mcu_fd_sc_mcu7t5v0__aoi21_1_17/B gf180mcu_fd_sc_mcu7t5v0__nor2_2_2/ZN gf180mcu_fd_sc_mcu7t5v0__and2_1_3/A1
+ vdd vss gf180mcu_fd_sc_mcu7t5v0__aoi21_1
Xgf180mcu_fd_sc_mcu7t5v0__aoi21_1_21 gf180mcu_fd_sc_mcu7t5v0__xnor2_1_5/ZN vdd vss
+ gf180mcu_fd_sc_mcu7t5v0__oai211_1_3/A1 gf180mcu_fd_sc_mcu7t5v0__nand3_1_9/A1 gf180mcu_fd_sc_mcu7t5v0__nand3_1_9/A2
+ vdd vss gf180mcu_fd_sc_mcu7t5v0__aoi21_1
Xgf180mcu_fd_sc_mcu7t5v0__aoi21_1_32 gf180mcu_fd_sc_mcu7t5v0__aoi21_1_32/B vdd vss
+ gf180mcu_fd_sc_mcu7t5v0__dffq_4_4/D gf180mcu_fd_sc_mcu7t5v0__or3_2_2/A2 gf180mcu_fd_sc_mcu7t5v0__buf_20_0/Z
+ vdd vss gf180mcu_fd_sc_mcu7t5v0__aoi21_1
Xgf180mcu_fd_sc_mcu7t5v0__aoi21_1_43 gf180mcu_fd_sc_mcu7t5v0__aoi21_1_43/B vdd vss
+ gf180mcu_fd_sc_mcu7t5v0__dffq_4_2/D gf180mcu_fd_sc_mcu7t5v0__inv_3_0/ZN gf180mcu_fd_sc_mcu7t5v0__buf_20_0/Z
+ vdd vss gf180mcu_fd_sc_mcu7t5v0__aoi21_1
Xgf180mcu_fd_sc_mcu7t5v0__aoi21_1_54 gf180mcu_fd_sc_mcu7t5v0__and3_1_4/Z vdd vss gf180mcu_fd_sc_mcu7t5v0__xor3_1_50/A2
+ gf180mcu_fd_sc_mcu7t5v0__xor2_1_40/A1 gf180mcu_fd_sc_mcu7t5v0__xor3_1_43/Z vdd vss
+ gf180mcu_fd_sc_mcu7t5v0__aoi21_1
Xgf180mcu_fd_sc_mcu7t5v0__aoi21_1_65 gf180mcu_fd_sc_mcu7t5v0__or4_1_0/A2 vdd vss gf180mcu_fd_sc_mcu7t5v0__aoi21_1_77/B
+ gf180mcu_fd_sc_mcu7t5v0__nand3_1_28/ZN gf180mcu_fd_sc_mcu7t5v0__oai21_1_59/ZN vdd
+ vss gf180mcu_fd_sc_mcu7t5v0__aoi21_1
Xgf180mcu_fd_sc_mcu7t5v0__aoi21_1_76 gf180mcu_fd_sc_mcu7t5v0__aoi21_1_76/B vdd vss
+ gf180mcu_fd_sc_mcu7t5v0__dffq_2_19/D gf180mcu_fd_sc_mcu7t5v0__inv_4_0/ZN gf180mcu_fd_sc_mcu7t5v0__buf_20_0/Z
+ vdd vss gf180mcu_fd_sc_mcu7t5v0__aoi21_1
Xgf180mcu_fd_sc_mcu7t5v0__aoi21_1_87 gf180mcu_fd_sc_mcu7t5v0__aoi21_1_87/B vdd vss
+ gf180mcu_fd_sc_mcu7t5v0__nor2_1_83/A1 gf180mcu_fd_sc_mcu7t5v0__nor2_4_3/ZN gf180mcu_fd_sc_mcu7t5v0__xnor3_1_15/ZN
+ vdd vss gf180mcu_fd_sc_mcu7t5v0__aoi21_1
Xgf180mcu_fd_sc_mcu7t5v0__aoi21_1_98 gf180mcu_fd_sc_mcu7t5v0__aoi21_1_98/B vdd vss
+ gf180mcu_fd_sc_mcu7t5v0__dffq_4_8/D gf180mcu_fd_sc_mcu7t5v0__nor3_4_5/A1 gf180mcu_fd_sc_mcu7t5v0__buf_20_0/Z
+ vdd vss gf180mcu_fd_sc_mcu7t5v0__aoi21_1
Xgf180mcu_fd_sc_mcu7t5v0__oai21_1_109 vdd gf180mcu_fd_sc_mcu7t5v0__buf_8_6/Z gf180mcu_fd_sc_mcu7t5v0__dffq_1_300/Q
+ gf180mcu_fd_sc_mcu7t5v0__aoi21_1_129/B gf180mcu_fd_sc_mcu7t5v0__dffq_4_20/Q vss
+ vdd vss gf180mcu_fd_sc_mcu7t5v0__oai21_1
Xgf180mcu_fd_sc_mcu7t5v0__nor2_2_40 vdd vss gf180mcu_fd_sc_mcu7t5v0__nor2_2_40/ZN
+ gf180mcu_fd_sc_mcu7t5v0__dffq_4_28/Q gf180mcu_fd_sc_mcu7t5v0__nor2_4_38/A2 vdd vss
+ gf180mcu_fd_sc_mcu7t5v0__nor2_2
Xgf180mcu_fd_sc_mcu7t5v0__nor2_2_51 vdd vss gf180mcu_fd_sc_mcu7t5v0__xor3_2_2/A1 gf180mcu_fd_sc_mcu7t5v0__or2_1_43/Z
+ gf180mcu_fd_sc_mcu7t5v0__or3_1_24/A3 vdd vss gf180mcu_fd_sc_mcu7t5v0__nor2_2
Xgf180mcu_fd_sc_mcu7t5v0__dffq_1_350 vdd gf180mcu_fd_sc_mcu7t5v0__nor4_1_1/A1 gf180mcu_fd_sc_mcu7t5v0__dffq_4_15/CLK
+ vss gf180mcu_fd_sc_mcu7t5v0__dffq_1_350/D vdd vss gf180mcu_fd_sc_mcu7t5v0__dffq_1
Xgf180mcu_fd_sc_mcu7t5v0__dffq_1_361 vdd gf180mcu_fd_sc_mcu7t5v0__or4_1_2/A2 gf180mcu_fd_sc_mcu7t5v0__dffq_4_15/CLK
+ vss gf180mcu_fd_sc_mcu7t5v0__dffq_1_361/D vdd vss gf180mcu_fd_sc_mcu7t5v0__dffq_1
Xgf180mcu_fd_sc_mcu7t5v0__dffq_1_372 vdd gf180mcu_fd_sc_mcu7t5v0__nor4_4_2/A1 gf180mcu_fd_sc_mcu7t5v0__dffq_4_21/CLK
+ vss gf180mcu_fd_sc_mcu7t5v0__nand4_1_7/ZN vdd vss gf180mcu_fd_sc_mcu7t5v0__dffq_1
Xgf180mcu_fd_sc_mcu7t5v0__dffq_1_383 vdd gf180mcu_fd_sc_mcu7t5v0__dffq_1_383/Q gf180mcu_fd_sc_mcu7t5v0__dffq_4_15/CLK
+ vss gf180mcu_fd_sc_mcu7t5v0__dffq_1_383/D vdd vss gf180mcu_fd_sc_mcu7t5v0__dffq_1
Xgf180mcu_fd_sc_mcu7t5v0__dffq_1_394 vdd gf180mcu_fd_sc_mcu7t5v0__nor4_2_4/A3 gf180mcu_fd_sc_mcu7t5v0__dffq_4_21/CLK
+ vss gf180mcu_fd_sc_mcu7t5v0__dffq_1_394/D vdd vss gf180mcu_fd_sc_mcu7t5v0__dffq_1
Xgf180mcu_fd_sc_mcu7t5v0__oai22_1_40 gf180mcu_fd_sc_mcu7t5v0__oai22_1_48/A2 gf180mcu_fd_sc_mcu7t5v0__aoi21_4_5/ZN
+ gf180mcu_fd_sc_mcu7t5v0__nand2_4_5/ZN vdd vss gf180mcu_fd_sc_mcu7t5v0__dffq_1_54/D
+ gf180mcu_fd_sc_mcu7t5v0__oai22_1_40/A1 vdd vss gf180mcu_fd_sc_mcu7t5v0__oai22_1
Xgf180mcu_fd_sc_mcu7t5v0__oai31_4_5 gf180mcu_fd_sc_mcu7t5v0__inv_1_21/ZN gf180mcu_fd_sc_mcu7t5v0__oai31_4_5/B
+ vdd vss gf180mcu_fd_sc_mcu7t5v0__oai31_4_5/ZN gf180mcu_fd_sc_mcu7t5v0__inv_4_7/ZN
+ gf180mcu_fd_sc_mcu7t5v0__oai31_4_5/A2 vdd vss gf180mcu_fd_sc_mcu7t5v0__oai31_4
Xgf180mcu_fd_sc_mcu7t5v0__oai22_1_51 gf180mcu_fd_sc_mcu7t5v0__oai22_1_62/A2 gf180mcu_fd_sc_mcu7t5v0__oai22_1_62/B1
+ gf180mcu_fd_sc_mcu7t5v0__oai22_1_51/B2 vdd vss gf180mcu_fd_sc_mcu7t5v0__dffq_1_62/D
+ gf180mcu_fd_sc_mcu7t5v0__oai22_1_98/A1 vdd vss gf180mcu_fd_sc_mcu7t5v0__oai22_1
Xgf180mcu_fd_sc_mcu7t5v0__oai22_1_62 gf180mcu_fd_sc_mcu7t5v0__oai22_1_62/A2 gf180mcu_fd_sc_mcu7t5v0__oai22_1_62/B1
+ gf180mcu_fd_sc_mcu7t5v0__oai22_1_62/B2 vdd vss gf180mcu_fd_sc_mcu7t5v0__dffq_1_67/D
+ gf180mcu_fd_sc_mcu7t5v0__oai22_1_88/A1 vdd vss gf180mcu_fd_sc_mcu7t5v0__oai22_1
Xgf180mcu_fd_sc_mcu7t5v0__oai22_1_73 gf180mcu_fd_sc_mcu7t5v0__nand2_4_8/ZN gf180mcu_fd_sc_mcu7t5v0__oai22_1_89/B1
+ gf180mcu_fd_sc_mcu7t5v0__oai22_1_73/B2 vdd vss gf180mcu_fd_sc_mcu7t5v0__dffq_1_97/D
+ gf180mcu_fd_sc_mcu7t5v0__aoi21_4_1/ZN vdd vss gf180mcu_fd_sc_mcu7t5v0__oai22_1
Xgf180mcu_fd_sc_mcu7t5v0__oai22_1_84 gf180mcu_fd_sc_mcu7t5v0__oai22_1_90/A2 gf180mcu_fd_sc_mcu7t5v0__oai22_1_90/B1
+ gf180mcu_fd_sc_mcu7t5v0__oai22_1_84/B2 vdd vss gf180mcu_fd_sc_mcu7t5v0__dffq_1_81/D
+ gf180mcu_fd_sc_mcu7t5v0__oai22_1_98/A1 vdd vss gf180mcu_fd_sc_mcu7t5v0__oai22_1
Xgf180mcu_fd_sc_mcu7t5v0__oai22_1_95 gf180mcu_fd_sc_mcu7t5v0__nand2_4_9/ZN gf180mcu_fd_sc_mcu7t5v0__oai22_1_95/B1
+ gf180mcu_fd_sc_mcu7t5v0__oai22_1_95/B2 vdd vss gf180mcu_fd_sc_mcu7t5v0__dffq_1_55/D
+ gf180mcu_fd_sc_mcu7t5v0__aoi21_4_3/ZN vdd vss gf180mcu_fd_sc_mcu7t5v0__oai22_1
Xgf180mcu_fd_sc_mcu7t5v0__nand2_2_16 vdd vss gf180mcu_fd_sc_mcu7t5v0__oai22_1_62/B1
+ rst_n gf180mcu_fd_sc_mcu7t5v0__oai22_1_62/A2 vdd vss gf180mcu_fd_sc_mcu7t5v0__nand2_2
Xgf180mcu_fd_sc_mcu7t5v0__nand2_2_27 vdd vss gf180mcu_fd_sc_mcu7t5v0__nand2_2_27/ZN
+ gf180mcu_fd_sc_mcu7t5v0__buf_8_1/Z gf180mcu_fd_sc_mcu7t5v0__nand2_4_20/ZN vdd vss
+ gf180mcu_fd_sc_mcu7t5v0__nand2_2
Xgf180mcu_fd_sc_mcu7t5v0__nand2_2_38 vdd vss gf180mcu_fd_sc_mcu7t5v0__nand2_2_38/ZN
+ gf180mcu_fd_sc_mcu7t5v0__buf_8_2/Z gf180mcu_fd_sc_mcu7t5v0__nand2_4_26/ZN vdd vss
+ gf180mcu_fd_sc_mcu7t5v0__nand2_2
Xgf180mcu_fd_sc_mcu7t5v0__nand2_2_49 vdd vss gf180mcu_fd_sc_mcu7t5v0__oai32_1_5/A2
+ gf180mcu_fd_sc_mcu7t5v0__dffq_2_42/Q gf180mcu_fd_sc_mcu7t5v0__inv_1_7/ZN vdd vss
+ gf180mcu_fd_sc_mcu7t5v0__nand2_2
Xgf180mcu_fd_sc_mcu7t5v0__xor2_1_208 vdd vss gf180mcu_fd_sc_mcu7t5v0__xor2_1_208/Z
+ gf180mcu_fd_sc_mcu7t5v0__xor3_1_142/A2 gf180mcu_fd_sc_mcu7t5v0__xor3_1_156/Z vdd
+ vss gf180mcu_fd_sc_mcu7t5v0__xor2_1
Xgf180mcu_fd_sc_mcu7t5v0__xor2_1_219 vdd vss gf180mcu_fd_sc_mcu7t5v0__xor2_1_219/Z
+ gf180mcu_fd_sc_mcu7t5v0__xor2_1_219/A1 gf180mcu_fd_sc_mcu7t5v0__xor2_1_219/A2 vdd
+ vss gf180mcu_fd_sc_mcu7t5v0__xor2_1
Xgf180mcu_fd_sc_mcu7t5v0__clkinv_1_200 vdd vss gf180mcu_fd_sc_mcu7t5v0__dffq_1_169/Q
+ gf180mcu_fd_sc_mcu7t5v0__oai22_1_188/B2 vdd vss gf180mcu_fd_sc_mcu7t5v0__clkinv_1
Xgf180mcu_fd_sc_mcu7t5v0__clkinv_1_211 vdd vss gf180mcu_fd_sc_mcu7t5v0__dffq_1_200/Q
+ gf180mcu_fd_sc_mcu7t5v0__oai22_1_210/B2 vdd vss gf180mcu_fd_sc_mcu7t5v0__clkinv_1
Xgf180mcu_fd_sc_mcu7t5v0__clkinv_1_222 vdd vss gf180mcu_fd_sc_mcu7t5v0__dffq_1_205/Q
+ gf180mcu_fd_sc_mcu7t5v0__oai22_1_213/B2 vdd vss gf180mcu_fd_sc_mcu7t5v0__clkinv_1
Xgf180mcu_fd_sc_mcu7t5v0__clkinv_1_233 vdd vss gf180mcu_fd_sc_mcu7t5v0__mux2_2_0/Z
+ gf180mcu_fd_sc_mcu7t5v0__or2_2_0/A1 vdd vss gf180mcu_fd_sc_mcu7t5v0__clkinv_1
Xgf180mcu_fd_sc_mcu7t5v0__clkinv_1_244 vdd vss gf180mcu_fd_sc_mcu7t5v0__dffq_1_214/Q
+ gf180mcu_fd_sc_mcu7t5v0__oai22_1_220/B2 vdd vss gf180mcu_fd_sc_mcu7t5v0__clkinv_1
Xgf180mcu_fd_sc_mcu7t5v0__clkinv_1_255 vdd vss gf180mcu_fd_sc_mcu7t5v0__dffq_1_225/Q
+ gf180mcu_fd_sc_mcu7t5v0__oai22_1_236/B2 vdd vss gf180mcu_fd_sc_mcu7t5v0__clkinv_1
Xgf180mcu_fd_sc_mcu7t5v0__clkinv_1_266 vdd vss gf180mcu_fd_sc_mcu7t5v0__xor3_1_173/A1
+ gf180mcu_fd_sc_mcu7t5v0__aoi21_2_5/A1 vdd vss gf180mcu_fd_sc_mcu7t5v0__clkinv_1
Xgf180mcu_fd_sc_mcu7t5v0__clkinv_1_277 vdd vss gf180mcu_fd_sc_mcu7t5v0__dffq_1_313/Q
+ gf180mcu_fd_sc_mcu7t5v0__oai211_1_20/A1 vdd vss gf180mcu_fd_sc_mcu7t5v0__clkinv_1
Xgf180mcu_fd_sc_mcu7t5v0__clkinv_1_288 vdd vss gf180mcu_fd_sc_mcu7t5v0__dffq_1_312/Q
+ gf180mcu_fd_sc_mcu7t5v0__nor3_1_10/A1 vdd vss gf180mcu_fd_sc_mcu7t5v0__clkinv_1
Xgf180mcu_fd_sc_mcu7t5v0__clkinv_1_299 vdd vss gf180mcu_fd_sc_mcu7t5v0__dffq_1_326/Q
+ gf180mcu_fd_sc_mcu7t5v0__aoi21_1_150/A1 vdd vss gf180mcu_fd_sc_mcu7t5v0__clkinv_1
Xgf180mcu_fd_sc_mcu7t5v0__inv_4_5 vss gf180mcu_fd_sc_mcu7t5v0__inv_4_5/ZN gf180mcu_fd_sc_mcu7t5v0__inv_4_5/I
+ vdd vdd vss gf180mcu_fd_sc_mcu7t5v0__inv_4
Xgf180mcu_fd_sc_mcu7t5v0__dffq_2_103 gf180mcu_fd_sc_mcu7t5v0__dffq_2_103/D vdd vss
+ gf180mcu_fd_sc_mcu7t5v0__dffq_4_44/CLK gf180mcu_fd_sc_mcu7t5v0__mux4_4_8/I0 vdd
+ vss gf180mcu_fd_sc_mcu7t5v0__dffq_2
Xgf180mcu_fd_sc_mcu7t5v0__oai22_1_260 gf180mcu_fd_sc_mcu7t5v0__oai22_1_90/A2 gf180mcu_fd_sc_mcu7t5v0__oai22_1_90/B1
+ gf180mcu_fd_sc_mcu7t5v0__oai22_1_260/B2 vdd vss gf180mcu_fd_sc_mcu7t5v0__dffq_1_266/D
+ gf180mcu_fd_sc_mcu7t5v0__aoi21_4_4/ZN vdd vss gf180mcu_fd_sc_mcu7t5v0__oai22_1
Xgf180mcu_fd_sc_mcu7t5v0__oai22_1_271 gf180mcu_fd_sc_mcu7t5v0__nor4_2_5/A1 gf180mcu_fd_sc_mcu7t5v0__oai32_1_8/A1
+ gf180mcu_fd_sc_mcu7t5v0__oai22_1_271/B2 vdd vss gf180mcu_fd_sc_mcu7t5v0__oai22_1_271/ZN
+ gf180mcu_fd_sc_mcu7t5v0__inv_12_1/I vdd vss gf180mcu_fd_sc_mcu7t5v0__oai22_1
Xgf180mcu_fd_sc_mcu7t5v0__oai22_1_282 gf180mcu_fd_sc_mcu7t5v0__xor3_1_161/A1 gf180mcu_fd_sc_mcu7t5v0__and2_1_149/Z
+ gf180mcu_fd_sc_mcu7t5v0__xnor3_1_45/A2 vdd vss gf180mcu_fd_sc_mcu7t5v0__xor3_1_146/A3
+ gf180mcu_fd_sc_mcu7t5v0__xnor3_1_47/A3 vdd vss gf180mcu_fd_sc_mcu7t5v0__oai22_1
Xgf180mcu_fd_sc_mcu7t5v0__dffq_1_180 vdd gf180mcu_fd_sc_mcu7t5v0__dffq_1_180/Q gf180mcu_fd_sc_mcu7t5v0__dffq_1_96/CLK
+ vss gf180mcu_fd_sc_mcu7t5v0__dffq_1_180/D vdd vss gf180mcu_fd_sc_mcu7t5v0__dffq_1
Xgf180mcu_fd_sc_mcu7t5v0__clkinv_3_1 vdd gf180mcu_fd_sc_mcu7t5v0__xor3_1_159/A1 gf180mcu_fd_sc_mcu7t5v0__or2_1_7/A1
+ vss vdd vss gf180mcu_fd_sc_mcu7t5v0__clkinv_3
Xgf180mcu_fd_sc_mcu7t5v0__oai31_2_2 gf180mcu_fd_sc_mcu7t5v0__mux4_4_9/S0 gf180mcu_fd_sc_mcu7t5v0__inv_1_16/ZN
+ gf180mcu_fd_sc_mcu7t5v0__oai31_2_2/B vdd vss gf180mcu_fd_sc_mcu7t5v0__oai32_2_2/B1
+ gf180mcu_fd_sc_mcu7t5v0__xor3_1_43/A1 vdd vss gf180mcu_fd_sc_mcu7t5v0__oai31_2
Xgf180mcu_fd_sc_mcu7t5v0__dffq_1_191 vdd gf180mcu_fd_sc_mcu7t5v0__dffq_1_191/Q gf180mcu_fd_sc_mcu7t5v0__dffq_2_26/CLK
+ vss gf180mcu_fd_sc_mcu7t5v0__dffq_1_191/D vdd vss gf180mcu_fd_sc_mcu7t5v0__dffq_1
Xgf180mcu_fd_sc_mcu7t5v0__nor2_1_380 vdd vss gf180mcu_fd_sc_mcu7t5v0__xor3_1_137/A3
+ gf180mcu_fd_sc_mcu7t5v0__nor2_1_380/A1 gf180mcu_fd_sc_mcu7t5v0__nor2_1_381/ZN vdd
+ vss gf180mcu_fd_sc_mcu7t5v0__nor2_1
Xgf180mcu_fd_sc_mcu7t5v0__nand3_1_6 gf180mcu_fd_sc_mcu7t5v0__and3_1_1/A3 vdd vss gf180mcu_fd_sc_mcu7t5v0__xnor3_1_7/A2
+ gf180mcu_fd_sc_mcu7t5v0__or4_1_0/A1 gf180mcu_fd_sc_mcu7t5v0__or3_2_1/Z vdd vss gf180mcu_fd_sc_mcu7t5v0__nand3_1
Xgf180mcu_fd_sc_mcu7t5v0__nor2_1_391 vdd vss gf180mcu_fd_sc_mcu7t5v0__nor2_1_391/ZN
+ gf180mcu_fd_sc_mcu7t5v0__or4_1_0/A2 gf180mcu_fd_sc_mcu7t5v0__xor2_1_189/Z vdd vss
+ gf180mcu_fd_sc_mcu7t5v0__nor2_1
Xgf180mcu_fd_sc_mcu7t5v0__and4_2_0 gf180mcu_fd_sc_mcu7t5v0__nor4_1_2/ZN gf180mcu_fd_sc_mcu7t5v0__and4_2_0/A4
+ vdd vss gf180mcu_fd_sc_mcu7t5v0__and4_2_0/Z gf180mcu_fd_sc_mcu7t5v0__and4_2_0/A1
+ gf180mcu_fd_sc_mcu7t5v0__and4_2_0/A2 vdd vss gf180mcu_fd_sc_mcu7t5v0__and4_2
Xgf180mcu_fd_sc_mcu7t5v0__clkinv_2_12 vdd vss gf180mcu_fd_sc_mcu7t5v0__dffq_1_433/Q
+ gf180mcu_fd_sc_mcu7t5v0__xor3_1_91/A1 vdd vss gf180mcu_fd_sc_mcu7t5v0__clkinv_2
Xgf180mcu_fd_sc_mcu7t5v0__inv_2_2 vss gf180mcu_fd_sc_mcu7t5v0__inv_2_2/ZN gf180mcu_fd_sc_mcu7t5v0__inv_2_2/I
+ vdd vdd vss gf180mcu_fd_sc_mcu7t5v0__inv_2
Xgf180mcu_fd_sc_mcu7t5v0__aoi22_1_103 gf180mcu_fd_sc_mcu7t5v0__nor2_4_9/ZN gf180mcu_fd_sc_mcu7t5v0__dffq_1_139/Q
+ vdd vss gf180mcu_fd_sc_mcu7t5v0__nand2_1_240/A1 gf180mcu_fd_sc_mcu7t5v0__dffq_1_140/Q
+ gf180mcu_fd_sc_mcu7t5v0__nor2_4_8/ZN vdd vss gf180mcu_fd_sc_mcu7t5v0__aoi22_1
Xgf180mcu_fd_sc_mcu7t5v0__aoi22_1_114 gf180mcu_fd_sc_mcu7t5v0__nand2_1_214/ZN gf180mcu_fd_sc_mcu7t5v0__nor3_4_11/ZN
+ vdd vss gf180mcu_fd_sc_mcu7t5v0__nand3_1_46/A1 gf180mcu_fd_sc_mcu7t5v0__nor3_4_6/ZN
+ gf180mcu_fd_sc_mcu7t5v0__nand2_1_265/ZN vdd vss gf180mcu_fd_sc_mcu7t5v0__aoi22_1
Xgf180mcu_fd_sc_mcu7t5v0__aoi22_1_125 gf180mcu_fd_sc_mcu7t5v0__nor2_4_11/ZN gf180mcu_fd_sc_mcu7t5v0__dffq_1_231/Q
+ vdd vss gf180mcu_fd_sc_mcu7t5v0__nand2_1_293/A2 gf180mcu_fd_sc_mcu7t5v0__dffq_1_233/Q
+ gf180mcu_fd_sc_mcu7t5v0__nor2_4_10/ZN vdd vss gf180mcu_fd_sc_mcu7t5v0__aoi22_1
Xgf180mcu_fd_sc_mcu7t5v0__aoi22_1_136 gf180mcu_fd_sc_mcu7t5v0__nand2_1_246/ZN gf180mcu_fd_sc_mcu7t5v0__nor2_4_12/ZN
+ vdd vss gf180mcu_fd_sc_mcu7t5v0__nand3_1_38/A1 gf180mcu_fd_sc_mcu7t5v0__nor2_4_4/ZN
+ gf180mcu_fd_sc_mcu7t5v0__nand2_1_274/ZN vdd vss gf180mcu_fd_sc_mcu7t5v0__aoi22_1
Xgf180mcu_fd_sc_mcu7t5v0__aoi22_1_147 gf180mcu_fd_sc_mcu7t5v0__nor2_4_9/ZN gf180mcu_fd_sc_mcu7t5v0__dffq_1_204/Q
+ vdd vss gf180mcu_fd_sc_mcu7t5v0__nand2_1_298/A1 gf180mcu_fd_sc_mcu7t5v0__dffq_1_45/Q
+ gf180mcu_fd_sc_mcu7t5v0__nor2_4_8/ZN vdd vss gf180mcu_fd_sc_mcu7t5v0__aoi22_1
Xgf180mcu_fd_sc_mcu7t5v0__or2_1_19 vdd vss gf180mcu_fd_sc_mcu7t5v0__or2_1_19/Z gf180mcu_fd_sc_mcu7t5v0__or2_1_7/A1
+ gf180mcu_fd_sc_mcu7t5v0__mux4_2_1/Z vdd vss gf180mcu_fd_sc_mcu7t5v0__or2_1
Xgf180mcu_fd_sc_mcu7t5v0__aoi22_1_158 gf180mcu_fd_sc_mcu7t5v0__and3_2_2/A2 gf180mcu_fd_sc_mcu7t5v0__dffq_1_382/Q
+ vdd vss gf180mcu_fd_sc_mcu7t5v0__clkinv_1_313/I gf180mcu_fd_sc_mcu7t5v0__dffq_1_367/Q
+ gf180mcu_fd_sc_mcu7t5v0__nor2_4_23/ZN vdd vss gf180mcu_fd_sc_mcu7t5v0__aoi22_1
Xgf180mcu_fd_sc_mcu7t5v0__aoi22_1_169 gf180mcu_fd_sc_mcu7t5v0__oai32_2_1/ZN gf180mcu_fd_sc_mcu7t5v0__xor2_1_162/A2
+ vdd vss gf180mcu_fd_sc_mcu7t5v0__xor3_1_119/A3 gf180mcu_fd_sc_mcu7t5v0__dffq_2_87/Q
+ gf180mcu_fd_sc_mcu7t5v0__nor2_2_50/ZN vdd vss gf180mcu_fd_sc_mcu7t5v0__aoi22_1
Xgf180mcu_fd_sc_mcu7t5v0__nor2_4_19 vdd vss gf180mcu_fd_sc_mcu7t5v0__nor2_4_19/ZN
+ gf180mcu_fd_sc_mcu7t5v0__nor2_4_27/A2 gf180mcu_fd_sc_mcu7t5v0__or2_4_1/Z vdd vss
+ gf180mcu_fd_sc_mcu7t5v0__nor2_4
Xgf180mcu_fd_sc_mcu7t5v0__oai21_1_270 vdd gf180mcu_fd_sc_mcu7t5v0__buf_12_0/Z gf180mcu_fd_sc_mcu7t5v0__buf_20_0/Z
+ gf180mcu_fd_sc_mcu7t5v0__aoi21_1_303/B gf180mcu_fd_sc_mcu7t5v0__dffq_2_29/Q vss
+ vdd vss gf180mcu_fd_sc_mcu7t5v0__oai21_1
Xgf180mcu_fd_sc_mcu7t5v0__oai21_1_281 vdd gf180mcu_fd_sc_mcu7t5v0__oai21_1_281/B gf180mcu_fd_sc_mcu7t5v0__oai21_1_281/A2
+ gf180mcu_fd_sc_mcu7t5v0__oai21_1_280/B gf180mcu_fd_sc_mcu7t5v0__nand2_2_74/ZN vss
+ vdd vss gf180mcu_fd_sc_mcu7t5v0__oai21_1
Xgf180mcu_fd_sc_mcu7t5v0__oai21_1_292 vdd gf180mcu_fd_sc_mcu7t5v0__buf_8_4/Z gf180mcu_fd_sc_mcu7t5v0__buf_20_0/I
+ gf180mcu_fd_sc_mcu7t5v0__aoi21_1_325/B gf180mcu_fd_sc_mcu7t5v0__dffq_1_442/Q vss
+ vdd vss gf180mcu_fd_sc_mcu7t5v0__oai21_1
Xgf180mcu_fd_sc_mcu7t5v0__aoi21_1_305 gf180mcu_fd_sc_mcu7t5v0__aoi21_1_305/B vdd vss
+ gf180mcu_fd_sc_mcu7t5v0__dffq_4_34/D gf180mcu_fd_sc_mcu7t5v0__inv_4_7/ZN gf180mcu_fd_sc_mcu7t5v0__buf_20_0/I
+ vdd vss gf180mcu_fd_sc_mcu7t5v0__aoi21_1
Xgf180mcu_fd_sc_mcu7t5v0__aoi21_1_316 gf180mcu_fd_sc_mcu7t5v0__nor3_1_35/ZN vdd vss
+ gf180mcu_fd_sc_mcu7t5v0__xor3_1_114/A2 gf180mcu_fd_sc_mcu7t5v0__xor3_1_113/A2 gf180mcu_fd_sc_mcu7t5v0__oai21_1_283/ZN
+ vdd vss gf180mcu_fd_sc_mcu7t5v0__aoi21_1
Xgf180mcu_fd_sc_mcu7t5v0__aoi21_1_327 gf180mcu_fd_sc_mcu7t5v0__nor2_1_356/ZN vdd vss
+ gf180mcu_fd_sc_mcu7t5v0__xor3_1_117/A2 gf180mcu_fd_sc_mcu7t5v0__aoi21_1_327/A1 gf180mcu_fd_sc_mcu7t5v0__nand2_1_588/ZN
+ vdd vss gf180mcu_fd_sc_mcu7t5v0__aoi21_1
Xgf180mcu_fd_sc_mcu7t5v0__aoi21_1_338 gf180mcu_fd_sc_mcu7t5v0__nor2_2_46/A2 vdd vss
+ gf180mcu_fd_sc_mcu7t5v0__oai22_1_275/B2 gf180mcu_fd_sc_mcu7t5v0__xor3_1_159/A1 gf180mcu_fd_sc_mcu7t5v0__inv_3_4/I
+ vdd vss gf180mcu_fd_sc_mcu7t5v0__aoi21_1
Xgf180mcu_fd_sc_mcu7t5v0__aoi21_1_349 gf180mcu_fd_sc_mcu7t5v0__aoi21_1_7/B vdd vss
+ gf180mcu_fd_sc_mcu7t5v0__dffq_2_96/D gf180mcu_fd_sc_mcu7t5v0__nand2_1_645/ZN gf180mcu_fd_sc_mcu7t5v0__oai211_1_49/ZN
+ vdd vss gf180mcu_fd_sc_mcu7t5v0__aoi21_1
Xgf180mcu_fd_sc_mcu7t5v0__xor3_1_15 gf180mcu_fd_sc_mcu7t5v0__xor3_1_15/A3 vdd vss
+ gf180mcu_fd_sc_mcu7t5v0__xor3_1_15/Z gf180mcu_fd_sc_mcu7t5v0__xor3_1_15/A1 gf180mcu_fd_sc_mcu7t5v0__xor3_1_15/A2
+ vdd vss gf180mcu_fd_sc_mcu7t5v0__xor3_1
Xgf180mcu_fd_sc_mcu7t5v0__xor3_1_26 gf180mcu_fd_sc_mcu7t5v0__xor3_2_0/Z vdd vss gf180mcu_fd_sc_mcu7t5v0__xor3_1_26/Z
+ gf180mcu_fd_sc_mcu7t5v0__mux4_4_3/I2 gf180mcu_fd_sc_mcu7t5v0__xor3_1_26/A2 vdd vss
+ gf180mcu_fd_sc_mcu7t5v0__xor3_1
Xgf180mcu_fd_sc_mcu7t5v0__aoi222_1_5 vss vdd gf180mcu_fd_sc_mcu7t5v0__nor3_4_11/ZN
+ gf180mcu_fd_sc_mcu7t5v0__aoi222_1_5/C1 gf180mcu_fd_sc_mcu7t5v0__nor2_4_12/ZN gf180mcu_fd_sc_mcu7t5v0__aoi222_1_5/B1
+ gf180mcu_fd_sc_mcu7t5v0__aoi222_1_5/A2 gf180mcu_fd_sc_mcu7t5v0__nor2_4_13/ZN gf180mcu_fd_sc_mcu7t5v0__nand3_1_44/A3
+ vdd vss gf180mcu_fd_sc_mcu7t5v0__aoi222_1
Xgf180mcu_fd_sc_mcu7t5v0__xor3_1_37 gf180mcu_fd_sc_mcu7t5v0__xor3_1_55/Z vdd vss gf180mcu_fd_sc_mcu7t5v0__xor3_1_37/Z
+ gf180mcu_fd_sc_mcu7t5v0__xor3_1_37/A1 gf180mcu_fd_sc_mcu7t5v0__xor3_1_52/Z vdd vss
+ gf180mcu_fd_sc_mcu7t5v0__xor3_1
Xgf180mcu_fd_sc_mcu7t5v0__xor3_1_48 gf180mcu_fd_sc_mcu7t5v0__xor3_1_48/A3 vdd vss
+ gf180mcu_fd_sc_mcu7t5v0__xor3_1_48/Z gf180mcu_fd_sc_mcu7t5v0__or3_1_4/A1 gf180mcu_fd_sc_mcu7t5v0__xor3_1_48/A2
+ vdd vss gf180mcu_fd_sc_mcu7t5v0__xor3_1
Xgf180mcu_fd_sc_mcu7t5v0__xor3_1_59 gf180mcu_fd_sc_mcu7t5v0__xor3_1_1/Z vdd vss gf180mcu_fd_sc_mcu7t5v0__xor3_1_59/Z
+ gf180mcu_fd_sc_mcu7t5v0__nor2_1_1/A1 gf180mcu_fd_sc_mcu7t5v0__xor3_1_59/A2 vdd vss
+ gf180mcu_fd_sc_mcu7t5v0__xor3_1
Xgf180mcu_fd_sc_mcu7t5v0__nor3_1_7 gf180mcu_fd_sc_mcu7t5v0__xor2_1_72/Z vdd vss gf180mcu_fd_sc_mcu7t5v0__nor3_1_7/ZN
+ gf180mcu_fd_sc_mcu7t5v0__nor3_1_7/A1 gf180mcu_fd_sc_mcu7t5v0__nor3_1_7/A2 vdd vss
+ gf180mcu_fd_sc_mcu7t5v0__nor3_1
Xgf180mcu_fd_sc_mcu7t5v0__nand2_1_605 vdd vss gf180mcu_fd_sc_mcu7t5v0__xor2_1_170/A1
+ gf180mcu_fd_sc_mcu7t5v0__inv_8_2/I gf180mcu_fd_sc_mcu7t5v0__or3_1_12/A2 vdd vss
+ gf180mcu_fd_sc_mcu7t5v0__nand2_1
Xgf180mcu_fd_sc_mcu7t5v0__nand2_1_616 vdd vss gf180mcu_fd_sc_mcu7t5v0__nand2_1_691/A2
+ gf180mcu_fd_sc_mcu7t5v0__oai31_1_19/B gf180mcu_fd_sc_mcu7t5v0__and3_1_23/A2 vdd
+ vss gf180mcu_fd_sc_mcu7t5v0__nand2_1
Xgf180mcu_fd_sc_mcu7t5v0__nand4_2_1 gf180mcu_fd_sc_mcu7t5v0__inv_1_9/I gf180mcu_fd_sc_mcu7t5v0__and4_2_0/Z
+ vdd vss gf180mcu_fd_sc_mcu7t5v0__aoi21_2_6/B gf180mcu_fd_sc_mcu7t5v0__nand4_2_1/A1
+ gf180mcu_fd_sc_mcu7t5v0__nand4_2_1/A2 vdd vss gf180mcu_fd_sc_mcu7t5v0__nand4_2
Xgf180mcu_fd_sc_mcu7t5v0__nand2_1_627 vdd vss gf180mcu_fd_sc_mcu7t5v0__xor3_1_138/A3
+ gf180mcu_fd_sc_mcu7t5v0__inv_8_2/I gf180mcu_fd_sc_mcu7t5v0__inv_1_23/I vdd vss gf180mcu_fd_sc_mcu7t5v0__nand2_1
Xgf180mcu_fd_sc_mcu7t5v0__nand2_1_638 vdd vss gf180mcu_fd_sc_mcu7t5v0__nand2_1_638/ZN
+ gf180mcu_fd_sc_mcu7t5v0__or2_1_39/A1 gf180mcu_fd_sc_mcu7t5v0__or2_4_4/Z vdd vss
+ gf180mcu_fd_sc_mcu7t5v0__nand2_1
Xgf180mcu_fd_sc_mcu7t5v0__nand2_1_649 vdd vss gf180mcu_fd_sc_mcu7t5v0__nand2_1_649/ZN
+ gf180mcu_fd_sc_mcu7t5v0__inv_8_2/I gf180mcu_fd_sc_mcu7t5v0__xnor2_1_66/A1 vdd vss
+ gf180mcu_fd_sc_mcu7t5v0__nand2_1
Xgf180mcu_fd_sc_mcu7t5v0__nand4_1_15 gf180mcu_fd_sc_mcu7t5v0__nand4_1_15/A3 gf180mcu_fd_sc_mcu7t5v0__nand4_1_15/A4
+ vdd vss gf180mcu_fd_sc_mcu7t5v0__nand4_1_15/ZN gf180mcu_fd_sc_mcu7t5v0__nor3_1_33/A1
+ gf180mcu_fd_sc_mcu7t5v0__nand4_1_15/A2 vdd vss gf180mcu_fd_sc_mcu7t5v0__nand4_1
Xgf180mcu_fd_sc_mcu7t5v0__aoi21_4_10 gf180mcu_fd_sc_mcu7t5v0__inv_4_7/ZN gf180mcu_fd_sc_mcu7t5v0__dffq_4_35/Q
+ vdd vss gf180mcu_fd_sc_mcu7t5v0__nor4_4_4/A3 gf180mcu_fd_sc_mcu7t5v0__dffq_2_70/Q
+ vdd vss gf180mcu_fd_sc_mcu7t5v0__aoi21_4
Xgf180mcu_fd_sc_mcu7t5v0__inv_1_16 vss gf180mcu_fd_sc_mcu7t5v0__inv_1_16/ZN gf180mcu_fd_sc_mcu7t5v0__inv_1_16/I
+ vdd vdd vss gf180mcu_fd_sc_mcu7t5v0__inv_1
Xgf180mcu_fd_sc_mcu7t5v0__aoi222_1_10 vss vdd gf180mcu_fd_sc_mcu7t5v0__nor2_4_33/ZN
+ gf180mcu_fd_sc_mcu7t5v0__xor2_1_47/A2 gf180mcu_fd_sc_mcu7t5v0__mux2_1_8/I0 gf180mcu_fd_sc_mcu7t5v0__and2_1_91/Z
+ gf180mcu_fd_sc_mcu7t5v0__nor2_2_28/ZN gf180mcu_fd_sc_mcu7t5v0__inv_8_1/I gf180mcu_fd_sc_mcu7t5v0__oai211_1_56/B
+ vdd vss gf180mcu_fd_sc_mcu7t5v0__aoi222_1
Xgf180mcu_fd_sc_mcu7t5v0__xor2_1_70 vdd vss gf180mcu_fd_sc_mcu7t5v0__xor2_1_70/Z gf180mcu_fd_sc_mcu7t5v0__and2_2_2/Z
+ gf180mcu_fd_sc_mcu7t5v0__xor2_1_70/A2 vdd vss gf180mcu_fd_sc_mcu7t5v0__xor2_1
Xgf180mcu_fd_sc_mcu7t5v0__xor2_1_81 vdd vss gf180mcu_fd_sc_mcu7t5v0__xor2_1_81/Z gf180mcu_fd_sc_mcu7t5v0__xor3_1_67/A2
+ gf180mcu_fd_sc_mcu7t5v0__nor3_1_8/A3 vdd vss gf180mcu_fd_sc_mcu7t5v0__xor2_1
Xgf180mcu_fd_sc_mcu7t5v0__aoi21_1_102 gf180mcu_fd_sc_mcu7t5v0__or2_1_23/A1 vdd vss
+ gf180mcu_fd_sc_mcu7t5v0__dffq_2_28/D gf180mcu_fd_sc_mcu7t5v0__nor3_1_10/A3 gf180mcu_fd_sc_mcu7t5v0__clkinv_3_9/ZN
+ vdd vss gf180mcu_fd_sc_mcu7t5v0__aoi21_1
Xgf180mcu_fd_sc_mcu7t5v0__xor2_1_92 vdd vss gf180mcu_fd_sc_mcu7t5v0__xor2_1_92/Z gf180mcu_fd_sc_mcu7t5v0__xor2_1_92/A1
+ gf180mcu_fd_sc_mcu7t5v0__xor2_1_92/A2 vdd vss gf180mcu_fd_sc_mcu7t5v0__xor2_1
Xgf180mcu_fd_sc_mcu7t5v0__aoi21_1_113 gf180mcu_fd_sc_mcu7t5v0__aoi21_1_113/B vdd vss
+ gf180mcu_fd_sc_mcu7t5v0__dffq_1_286/D gf180mcu_fd_sc_mcu7t5v0__and3_1_13/A3 gf180mcu_fd_sc_mcu7t5v0__nor3_4_14/ZN
+ vdd vss gf180mcu_fd_sc_mcu7t5v0__aoi21_1
Xgf180mcu_fd_sc_mcu7t5v0__aoi21_1_124 gf180mcu_fd_sc_mcu7t5v0__aoi21_1_124/B vdd vss
+ gf180mcu_fd_sc_mcu7t5v0__dffq_1_297/D gf180mcu_fd_sc_mcu7t5v0__nor3_4_14/ZN gf180mcu_fd_sc_mcu7t5v0__aoi22_4_7/ZN
+ vdd vss gf180mcu_fd_sc_mcu7t5v0__aoi21_1
Xgf180mcu_fd_sc_mcu7t5v0__aoi21_1_135 gf180mcu_fd_sc_mcu7t5v0__aoi21_1_135/B vdd vss
+ gf180mcu_fd_sc_mcu7t5v0__dffq_4_43/D gf180mcu_fd_sc_mcu7t5v0__inv_8_0/ZN gf180mcu_fd_sc_mcu7t5v0__buf_20_0/I
+ vdd vss gf180mcu_fd_sc_mcu7t5v0__aoi21_1
Xgf180mcu_fd_sc_mcu7t5v0__and2_1_102 vdd vss gf180mcu_fd_sc_mcu7t5v0__nor3_1_42/A1
+ gf180mcu_fd_sc_mcu7t5v0__dffq_4_37/Q gf180mcu_fd_sc_mcu7t5v0__xor2_1_138/A2 vdd
+ vss gf180mcu_fd_sc_mcu7t5v0__and2_1
Xgf180mcu_fd_sc_mcu7t5v0__aoi21_1_146 gf180mcu_fd_sc_mcu7t5v0__aoi21_1_146/B vdd vss
+ gf180mcu_fd_sc_mcu7t5v0__dffq_1_325/D gf180mcu_fd_sc_mcu7t5v0__aoi21_1_146/A1 gf180mcu_fd_sc_mcu7t5v0__nand2_4_40/ZN
+ vdd vss gf180mcu_fd_sc_mcu7t5v0__aoi21_1
Xgf180mcu_fd_sc_mcu7t5v0__aoi21_1_157 gf180mcu_fd_sc_mcu7t5v0__aoi21_1_157/B vdd vss
+ gf180mcu_fd_sc_mcu7t5v0__dffq_1_411/D gf180mcu_fd_sc_mcu7t5v0__aoi22_4_8/ZN gf180mcu_fd_sc_mcu7t5v0__aoi21_1_157/A2
+ vdd vss gf180mcu_fd_sc_mcu7t5v0__aoi21_1
Xgf180mcu_fd_sc_mcu7t5v0__aoi21_1_168 gf180mcu_fd_sc_mcu7t5v0__aoi21_1_168/B vdd vss
+ gf180mcu_fd_sc_mcu7t5v0__dffq_1_401/D gf180mcu_fd_sc_mcu7t5v0__nor2_1_203/A1 gf180mcu_fd_sc_mcu7t5v0__nor3_4_14/ZN
+ vdd vss gf180mcu_fd_sc_mcu7t5v0__aoi21_1
Xgf180mcu_fd_sc_mcu7t5v0__and2_1_113 vdd vss gf180mcu_fd_sc_mcu7t5v0__and2_1_113/Z
+ gf180mcu_fd_sc_mcu7t5v0__or2_1_33/A1 gf180mcu_fd_sc_mcu7t5v0__xor3_1_82/Z vdd vss
+ gf180mcu_fd_sc_mcu7t5v0__and2_1
Xgf180mcu_fd_sc_mcu7t5v0__and2_1_124 vdd vss gf180mcu_fd_sc_mcu7t5v0__and2_1_124/Z
+ gf180mcu_fd_sc_mcu7t5v0__or2_1_42/A1 gf180mcu_fd_sc_mcu7t5v0__or2_1_42/A2 vdd vss
+ gf180mcu_fd_sc_mcu7t5v0__and2_1
Xgf180mcu_fd_sc_mcu7t5v0__and2_1_135 vdd vss gf180mcu_fd_sc_mcu7t5v0__and2_1_135/Z
+ gf180mcu_fd_sc_mcu7t5v0__or2_1_48/A1 gf180mcu_fd_sc_mcu7t5v0__or2_1_48/A2 vdd vss
+ gf180mcu_fd_sc_mcu7t5v0__and2_1
Xgf180mcu_fd_sc_mcu7t5v0__aoi21_1_179 gf180mcu_fd_sc_mcu7t5v0__aoi21_1_179/B vdd vss
+ gf180mcu_fd_sc_mcu7t5v0__dffq_1_406/D gf180mcu_fd_sc_mcu7t5v0__and3_1_13/A3 gf180mcu_fd_sc_mcu7t5v0__nor3_4_15/ZN
+ vdd vss gf180mcu_fd_sc_mcu7t5v0__aoi21_1
Xgf180mcu_fd_sc_mcu7t5v0__and2_1_146 vdd vss gf180mcu_fd_sc_mcu7t5v0__and2_1_146/Z
+ gf180mcu_fd_sc_mcu7t5v0__inv_8_0/I gf180mcu_fd_sc_mcu7t5v0__xor2_1_192/A1 vdd vss
+ gf180mcu_fd_sc_mcu7t5v0__and2_1
Xgf180mcu_fd_sc_mcu7t5v0__and2_1_157 vdd vss gf180mcu_fd_sc_mcu7t5v0__dffq_2_111/D
+ gf180mcu_fd_sc_mcu7t5v0__buf_8_5/I gf180mcu_fd_sc_mcu7t5v0__nand3_1_44/ZN vdd vss
+ gf180mcu_fd_sc_mcu7t5v0__and2_1
Xgf180mcu_fd_sc_mcu7t5v0__nand3_1_70 gf180mcu_fd_sc_mcu7t5v0__xor3_1_90/Z vdd vss
+ gf180mcu_fd_sc_mcu7t5v0__nand3_1_70/ZN gf180mcu_fd_sc_mcu7t5v0__nand3_1_70/A1 gf180mcu_fd_sc_mcu7t5v0__nand3_1_70/A2
+ vdd vss gf180mcu_fd_sc_mcu7t5v0__nand3_1
Xgf180mcu_fd_sc_mcu7t5v0__nand3_1_81 gf180mcu_fd_sc_mcu7t5v0__oai22_4_3/ZN vdd vss
+ gf180mcu_fd_sc_mcu7t5v0__or2_1_32/A1 gf180mcu_fd_sc_mcu7t5v0__inv_8_1/I gf180mcu_fd_sc_mcu7t5v0__and2_2_10/A1
+ vdd vss gf180mcu_fd_sc_mcu7t5v0__nand3_1
Xgf180mcu_fd_sc_mcu7t5v0__nand3_1_92 gf180mcu_fd_sc_mcu7t5v0__and3_1_21/A2 vdd vss
+ gf180mcu_fd_sc_mcu7t5v0__nand4_1_19/A3 gf180mcu_fd_sc_mcu7t5v0__nor3_4_20/ZN gf180mcu_fd_sc_mcu7t5v0__or3_1_22/Z
+ vdd vss gf180mcu_fd_sc_mcu7t5v0__nand3_1
Xgf180mcu_fd_sc_mcu7t5v0__nor2_1_209 vdd vss gf180mcu_fd_sc_mcu7t5v0__dffq_1_412/D
+ gf180mcu_fd_sc_mcu7t5v0__nand4_1_9/ZN gf180mcu_fd_sc_mcu7t5v0__nor3_1_24/A3 vdd
+ vss gf180mcu_fd_sc_mcu7t5v0__nor2_1
Xgf180mcu_fd_sc_mcu7t5v0__aoi21_1_5 gf180mcu_fd_sc_mcu7t5v0__aoi21_1_5/B vdd vss gf180mcu_fd_sc_mcu7t5v0__aoi21_1_4/B
+ gf180mcu_fd_sc_mcu7t5v0__nor3_4_2/ZN gf180mcu_fd_sc_mcu7t5v0__xor3_1_9/Z vdd vss
+ gf180mcu_fd_sc_mcu7t5v0__aoi21_1
Xgf180mcu_fd_sc_mcu7t5v0__nand2_1_402 vdd vss gf180mcu_fd_sc_mcu7t5v0__nor2_1_226/A2
+ gf180mcu_fd_sc_mcu7t5v0__dffq_1_399/Q gf180mcu_fd_sc_mcu7t5v0__nor4_4_2/A3 vdd vss
+ gf180mcu_fd_sc_mcu7t5v0__nand2_1
Xgf180mcu_fd_sc_mcu7t5v0__nand2_1_413 vdd vss gf180mcu_fd_sc_mcu7t5v0__xor3_1_86/A3
+ gf180mcu_fd_sc_mcu7t5v0__inv_8_2/I gf180mcu_fd_sc_mcu7t5v0__mux4_4_9/Z vdd vss gf180mcu_fd_sc_mcu7t5v0__nand2_1
Xgf180mcu_fd_sc_mcu7t5v0__nand2_1_424 vdd vss gf180mcu_fd_sc_mcu7t5v0__xnor3_1_26/A2
+ gf180mcu_fd_sc_mcu7t5v0__inv_8_1/I gf180mcu_fd_sc_mcu7t5v0__mux4_4_8/Z vdd vss gf180mcu_fd_sc_mcu7t5v0__nand2_1
Xgf180mcu_fd_sc_mcu7t5v0__nand2_1_435 vdd vss gf180mcu_fd_sc_mcu7t5v0__xor3_1_78/A2
+ gf180mcu_fd_sc_mcu7t5v0__dffq_4_37/Q gf180mcu_fd_sc_mcu7t5v0__mux4_4_19/Z vdd vss
+ gf180mcu_fd_sc_mcu7t5v0__nand2_1
Xgf180mcu_fd_sc_mcu7t5v0__nand2_1_446 vdd vss gf180mcu_fd_sc_mcu7t5v0__mux2_1_8/S
+ gf180mcu_fd_sc_mcu7t5v0__or2_1_7/A1 gf180mcu_fd_sc_mcu7t5v0__nor2_2_39/ZN vdd vss
+ gf180mcu_fd_sc_mcu7t5v0__nand2_1
Xgf180mcu_fd_sc_mcu7t5v0__nand2_1_457 vdd vss gf180mcu_fd_sc_mcu7t5v0__mux2_1_9/I1
+ gf180mcu_fd_sc_mcu7t5v0__nor2_2_33/A1 gf180mcu_fd_sc_mcu7t5v0__nor2_1_272/ZN vdd
+ vss gf180mcu_fd_sc_mcu7t5v0__nand2_1
Xgf180mcu_fd_sc_mcu7t5v0__nand2_1_468 vdd vss gf180mcu_fd_sc_mcu7t5v0__nand2_1_468/ZN
+ gf180mcu_fd_sc_mcu7t5v0__mux2_1_9/I0 gf180mcu_fd_sc_mcu7t5v0__oai221_1_11/B2 vdd
+ vss gf180mcu_fd_sc_mcu7t5v0__nand2_1
Xgf180mcu_fd_sc_mcu7t5v0__nand2_1_479 vdd vss gf180mcu_fd_sc_mcu7t5v0__nand4_1_13/A2
+ gf180mcu_fd_sc_mcu7t5v0__nor2_2_33/ZN gf180mcu_fd_sc_mcu7t5v0__xor2_2_4/Z vdd vss
+ gf180mcu_fd_sc_mcu7t5v0__nand2_1
Xgf180mcu_fd_sc_mcu7t5v0__xor2_1_4 vdd vss gf180mcu_fd_sc_mcu7t5v0__xor2_1_4/Z gf180mcu_fd_sc_mcu7t5v0__xor2_1_4/A1
+ gf180mcu_fd_sc_mcu7t5v0__xor2_1_4/A2 vdd vss gf180mcu_fd_sc_mcu7t5v0__xor2_1
Xgf180mcu_fd_sc_mcu7t5v0__oai211_1_5 gf180mcu_fd_sc_mcu7t5v0__oai211_1_5/B gf180mcu_fd_sc_mcu7t5v0__nor3_1_9/A1
+ vdd vss gf180mcu_fd_sc_mcu7t5v0__aoi21_1_23/B gf180mcu_fd_sc_mcu7t5v0__oai32_1_3/B2
+ gf180mcu_fd_sc_mcu7t5v0__xor3_1_62/A1 vdd vss gf180mcu_fd_sc_mcu7t5v0__oai211_1
Xgf180mcu_fd_sc_mcu7t5v0__mux2_1_5 gf180mcu_fd_sc_mcu7t5v0__mux2_1_5/S vdd vss gf180mcu_fd_sc_mcu7t5v0__mux2_1_5/Z
+ gf180mcu_fd_sc_mcu7t5v0__or2_1_7/A1 gf180mcu_fd_sc_mcu7t5v0__mux2_1_5/I1 vdd vss
+ gf180mcu_fd_sc_mcu7t5v0__mux2_1
Xgf180mcu_fd_sc_mcu7t5v0__xnor2_1_16 vdd vss gf180mcu_fd_sc_mcu7t5v0__or2_1_10/A2
+ gf180mcu_fd_sc_mcu7t5v0__or2_1_12/A1 gf180mcu_fd_sc_mcu7t5v0__xor3_1_28/Z vdd vss
+ gf180mcu_fd_sc_mcu7t5v0__xnor2_1
Xgf180mcu_fd_sc_mcu7t5v0__xnor2_1_27 vdd vss gf180mcu_fd_sc_mcu7t5v0__xor2_1_78/A2
+ gf180mcu_fd_sc_mcu7t5v0__xnor2_1_27/A1 gf180mcu_fd_sc_mcu7t5v0__xor2_1_220/Z vdd
+ vss gf180mcu_fd_sc_mcu7t5v0__xnor2_1
Xgf180mcu_fd_sc_mcu7t5v0__xnor2_1_38 vdd vss gf180mcu_fd_sc_mcu7t5v0__and2_1_87/A2
+ gf180mcu_fd_sc_mcu7t5v0__or2_1_28/A2 gf180mcu_fd_sc_mcu7t5v0__nand4_2_3/ZN vdd vss
+ gf180mcu_fd_sc_mcu7t5v0__xnor2_1
Xgf180mcu_fd_sc_mcu7t5v0__xnor2_1_49 vdd vss gf180mcu_fd_sc_mcu7t5v0__xnor2_1_49/ZN
+ gf180mcu_fd_sc_mcu7t5v0__xnor3_1_32/A1 gf180mcu_fd_sc_mcu7t5v0__xnor3_1_32/A2 vdd
+ vss gf180mcu_fd_sc_mcu7t5v0__xnor2_1
Xgf180mcu_fd_sc_mcu7t5v0__dffq_2_10 gf180mcu_fd_sc_mcu7t5v0__dffq_2_10/D vdd vss gf180mcu_fd_sc_mcu7t5v0__dffq_4_6/CLK
+ gf180mcu_fd_sc_mcu7t5v0__mux4_4_3/I2 vdd vss gf180mcu_fd_sc_mcu7t5v0__dffq_2
Xgf180mcu_fd_sc_mcu7t5v0__dffq_2_21 gf180mcu_fd_sc_mcu7t5v0__dffq_2_21/D vdd vss gf180mcu_fd_sc_mcu7t5v0__dffq_4_1/CLK
+ gf180mcu_fd_sc_mcu7t5v0__dffq_2_21/Q vdd vss gf180mcu_fd_sc_mcu7t5v0__dffq_2
Xgf180mcu_fd_sc_mcu7t5v0__dffq_2_32 gf180mcu_fd_sc_mcu7t5v0__dffq_2_32/D vdd vss gf180mcu_fd_sc_mcu7t5v0__dffq_2_58/CLK
+ gf180mcu_fd_sc_mcu7t5v0__or2_4_2/A2 vdd vss gf180mcu_fd_sc_mcu7t5v0__dffq_2
Xgf180mcu_fd_sc_mcu7t5v0__dffq_2_43 gf180mcu_fd_sc_mcu7t5v0__dffq_2_43/D vdd vss gf180mcu_fd_sc_mcu7t5v0__dffq_4_9/CLK
+ gf180mcu_fd_sc_mcu7t5v0__dffq_2_43/Q vdd vss gf180mcu_fd_sc_mcu7t5v0__dffq_2
Xgf180mcu_fd_sc_mcu7t5v0__dffq_2_54 gf180mcu_fd_sc_mcu7t5v0__dffq_2_54/D vdd vss gf180mcu_fd_sc_mcu7t5v0__dffq_4_21/CLK
+ gf180mcu_fd_sc_mcu7t5v0__inv_4_2/I vdd vss gf180mcu_fd_sc_mcu7t5v0__dffq_2
Xgf180mcu_fd_sc_mcu7t5v0__and3_1_6 gf180mcu_fd_sc_mcu7t5v0__xor2_1_61/Z vdd vss gf180mcu_fd_sc_mcu7t5v0__and3_1_6/Z
+ gf180mcu_fd_sc_mcu7t5v0__or2_1_17/Z gf180mcu_fd_sc_mcu7t5v0__and3_1_6/A2 vdd vss
+ gf180mcu_fd_sc_mcu7t5v0__and3_1
Xgf180mcu_fd_sc_mcu7t5v0__dffq_2_65 gf180mcu_fd_sc_mcu7t5v0__dffq_2_65/D vdd vss gf180mcu_fd_sc_mcu7t5v0__dffq_4_1/CLK
+ gf180mcu_fd_sc_mcu7t5v0__dffq_2_65/Q vdd vss gf180mcu_fd_sc_mcu7t5v0__dffq_2
Xgf180mcu_fd_sc_mcu7t5v0__dffq_2_76 gf180mcu_fd_sc_mcu7t5v0__dffq_2_76/D vdd vss gf180mcu_fd_sc_mcu7t5v0__dffq_4_9/CLK
+ gf180mcu_fd_sc_mcu7t5v0__mux4_4_1/I3 vdd vss gf180mcu_fd_sc_mcu7t5v0__dffq_2
Xgf180mcu_fd_sc_mcu7t5v0__dffq_2_87 gf180mcu_fd_sc_mcu7t5v0__dffq_2_87/D vdd vss gf180mcu_fd_sc_mcu7t5v0__dffq_4_44/CLK
+ gf180mcu_fd_sc_mcu7t5v0__dffq_2_87/Q vdd vss gf180mcu_fd_sc_mcu7t5v0__dffq_2
Xgf180mcu_fd_sc_mcu7t5v0__dffq_2_98 gf180mcu_fd_sc_mcu7t5v0__dffq_2_98/D vdd vss gf180mcu_fd_sc_mcu7t5v0__dffq_4_1/CLK
+ gf180mcu_fd_sc_mcu7t5v0__dffq_2_98/Q vdd vss gf180mcu_fd_sc_mcu7t5v0__dffq_2
Xgf180mcu_fd_sc_mcu7t5v0__oai21_1_8 vdd gf180mcu_fd_sc_mcu7t5v0__and3_2_0/Z gf180mcu_fd_sc_mcu7t5v0__xor3_1_12/Z
+ gf180mcu_fd_sc_mcu7t5v0__oai21_1_8/ZN gf180mcu_fd_sc_mcu7t5v0__oai21_1_8/A1 vss
+ vdd vss gf180mcu_fd_sc_mcu7t5v0__oai21_1
Xgf180mcu_fd_sc_mcu7t5v0__or2_1_4 vdd vss gf180mcu_fd_sc_mcu7t5v0__or2_1_4/Z gf180mcu_fd_sc_mcu7t5v0__or2_1_4/A1
+ gf180mcu_fd_sc_mcu7t5v0__or2_1_4/A2 vdd vss gf180mcu_fd_sc_mcu7t5v0__or2_1
Xgf180mcu_fd_sc_mcu7t5v0__nor4_2_2 gf180mcu_fd_sc_mcu7t5v0__and2_2_4/Z gf180mcu_fd_sc_mcu7t5v0__nor4_2_2/A4
+ vdd vss gf180mcu_fd_sc_mcu7t5v0__nor4_2_2/ZN gf180mcu_fd_sc_mcu7t5v0__and2_4_0/Z
+ gf180mcu_fd_sc_mcu7t5v0__and2_2_0/Z vdd vss gf180mcu_fd_sc_mcu7t5v0__nor4_2
Xgf180mcu_fd_sc_mcu7t5v0__aoi22_4_3 gf180mcu_fd_sc_mcu7t5v0__nor3_4_13/ZN gf180mcu_fd_sc_mcu7t5v0__aoi22_4_3/B1
+ gf180mcu_fd_sc_mcu7t5v0__nor4_4_1/ZN vdd vss gf180mcu_fd_sc_mcu7t5v0__aoi22_4_3/ZN
+ gf180mcu_fd_sc_mcu7t5v0__dffq_2_29/Q vdd vss gf180mcu_fd_sc_mcu7t5v0__aoi22_4
Xgf180mcu_fd_sc_mcu7t5v0__nand2_1_210 vdd vss gf180mcu_fd_sc_mcu7t5v0__xor3_1_4/A2
+ gf180mcu_fd_sc_mcu7t5v0__inv_8_2/I gf180mcu_fd_sc_mcu7t5v0__and2_4_1/Z vdd vss gf180mcu_fd_sc_mcu7t5v0__nand2_1
Xgf180mcu_fd_sc_mcu7t5v0__nand2_1_221 vdd vss gf180mcu_fd_sc_mcu7t5v0__nand2_1_221/ZN
+ gf180mcu_fd_sc_mcu7t5v0__aoi22_1_29/ZN gf180mcu_fd_sc_mcu7t5v0__aoi22_1_24/ZN vdd
+ vss gf180mcu_fd_sc_mcu7t5v0__nand2_1
Xgf180mcu_fd_sc_mcu7t5v0__nand2_1_232 vdd vss gf180mcu_fd_sc_mcu7t5v0__aoi222_2_1/C1
+ gf180mcu_fd_sc_mcu7t5v0__aoi22_1_57/ZN gf180mcu_fd_sc_mcu7t5v0__aoi22_1_63/ZN vdd
+ vss gf180mcu_fd_sc_mcu7t5v0__nand2_1
Xgf180mcu_fd_sc_mcu7t5v0__nand2_1_243 vdd vss gf180mcu_fd_sc_mcu7t5v0__aoi222_1_1/A2
+ gf180mcu_fd_sc_mcu7t5v0__aoi22_1_77/ZN gf180mcu_fd_sc_mcu7t5v0__aoi22_1_38/ZN vdd
+ vss gf180mcu_fd_sc_mcu7t5v0__nand2_1
Xgf180mcu_fd_sc_mcu7t5v0__nand2_1_254 vdd vss gf180mcu_fd_sc_mcu7t5v0__aoi21_1_93/A1
+ gf180mcu_fd_sc_mcu7t5v0__inv_8_2/I gf180mcu_fd_sc_mcu7t5v0__xor2_1_68/Z vdd vss
+ gf180mcu_fd_sc_mcu7t5v0__nand2_1
Xgf180mcu_fd_sc_mcu7t5v0__nand2_1_265 vdd vss gf180mcu_fd_sc_mcu7t5v0__nand2_1_265/ZN
+ gf180mcu_fd_sc_mcu7t5v0__nand2_1_265/A1 gf180mcu_fd_sc_mcu7t5v0__aoi22_1_62/ZN vdd
+ vss gf180mcu_fd_sc_mcu7t5v0__nand2_1
Xgf180mcu_fd_sc_mcu7t5v0__nand2_1_276 vdd vss gf180mcu_fd_sc_mcu7t5v0__aoi222_1_4/B1
+ gf180mcu_fd_sc_mcu7t5v0__nand2_1_276/A1 gf180mcu_fd_sc_mcu7t5v0__nand2_1_276/A2
+ vdd vss gf180mcu_fd_sc_mcu7t5v0__nand2_1
Xgf180mcu_fd_sc_mcu7t5v0__nand2_1_287 vdd vss gf180mcu_fd_sc_mcu7t5v0__aoi21_2_5/A2
+ gf180mcu_fd_sc_mcu7t5v0__or2_1_56/A2 gf180mcu_fd_sc_mcu7t5v0__xor3_1_173/A3 vdd
+ vss gf180mcu_fd_sc_mcu7t5v0__nand2_1
Xgf180mcu_fd_sc_mcu7t5v0__nand2_1_298 vdd vss gf180mcu_fd_sc_mcu7t5v0__aoi222_2_8/C1
+ gf180mcu_fd_sc_mcu7t5v0__nand2_1_298/A1 gf180mcu_fd_sc_mcu7t5v0__nand2_1_298/A2
+ vdd vss gf180mcu_fd_sc_mcu7t5v0__nand2_1
Xgf180mcu_fd_sc_mcu7t5v0__aoi21_1_11 gf180mcu_fd_sc_mcu7t5v0__oai21_1_8/ZN vdd vss
+ gf180mcu_fd_sc_mcu7t5v0__oai31_1_0/A1 gf180mcu_fd_sc_mcu7t5v0__oai21_1_8/A1 gf180mcu_fd_sc_mcu7t5v0__xor3_1_12/Z
+ vdd vss gf180mcu_fd_sc_mcu7t5v0__aoi21_1
Xgf180mcu_fd_sc_mcu7t5v0__aoi21_1_22 gf180mcu_fd_sc_mcu7t5v0__or2_1_4/A1 vdd vss gf180mcu_fd_sc_mcu7t5v0__oai211_1_4/C
+ gf180mcu_fd_sc_mcu7t5v0__or4_1_0/A1 gf180mcu_fd_sc_mcu7t5v0__nor2_4_44/ZN vdd vss
+ gf180mcu_fd_sc_mcu7t5v0__aoi21_1
Xgf180mcu_fd_sc_mcu7t5v0__aoi21_1_33 gf180mcu_fd_sc_mcu7t5v0__aoi21_1_33/B vdd vss
+ gf180mcu_fd_sc_mcu7t5v0__dffq_4_5/D gf180mcu_fd_sc_mcu7t5v0__inv_2_0/ZN gf180mcu_fd_sc_mcu7t5v0__buf_20_0/Z
+ vdd vss gf180mcu_fd_sc_mcu7t5v0__aoi21_1
Xgf180mcu_fd_sc_mcu7t5v0__aoi21_1_44 gf180mcu_fd_sc_mcu7t5v0__aoi21_1_44/B vdd vss
+ gf180mcu_fd_sc_mcu7t5v0__dffq_4_3/D gf180mcu_fd_sc_mcu7t5v0__nor3_4_2/A1 gf180mcu_fd_sc_mcu7t5v0__buf_20_0/Z
+ vdd vss gf180mcu_fd_sc_mcu7t5v0__aoi21_1
Xgf180mcu_fd_sc_mcu7t5v0__aoi21_1_55 gf180mcu_fd_sc_mcu7t5v0__nor2_4_0/ZN vdd vss
+ gf180mcu_fd_sc_mcu7t5v0__oai221_1_3/B1 gf180mcu_fd_sc_mcu7t5v0__nor2_2_2/ZN gf180mcu_fd_sc_mcu7t5v0__or3_1_4/A1
+ vdd vss gf180mcu_fd_sc_mcu7t5v0__aoi21_1
Xgf180mcu_fd_sc_mcu7t5v0__aoi21_1_66 gf180mcu_fd_sc_mcu7t5v0__aoi21_1_7/B vdd vss
+ gf180mcu_fd_sc_mcu7t5v0__dffq_1_13/D gf180mcu_fd_sc_mcu7t5v0__aoi21_1_66/A1 gf180mcu_fd_sc_mcu7t5v0__aoi21_1_66/A2
+ vdd vss gf180mcu_fd_sc_mcu7t5v0__aoi21_1
Xgf180mcu_fd_sc_mcu7t5v0__aoi21_1_77 gf180mcu_fd_sc_mcu7t5v0__aoi21_1_77/B vdd vss
+ gf180mcu_fd_sc_mcu7t5v0__xor3_1_51/A2 gf180mcu_fd_sc_mcu7t5v0__oai21_1_63/A1 gf180mcu_fd_sc_mcu7t5v0__xor3_1_53/Z
+ vdd vss gf180mcu_fd_sc_mcu7t5v0__aoi21_1
Xgf180mcu_fd_sc_mcu7t5v0__aoi21_1_88 gf180mcu_fd_sc_mcu7t5v0__xor3_1_41/A2 vdd vss
+ gf180mcu_fd_sc_mcu7t5v0__aoi21_1_88/ZN gf180mcu_fd_sc_mcu7t5v0__inv_12_1/I gf180mcu_fd_sc_mcu7t5v0__oai22_1_8/A2
+ vdd vss gf180mcu_fd_sc_mcu7t5v0__aoi21_1
Xgf180mcu_fd_sc_mcu7t5v0__aoi21_1_99 gf180mcu_fd_sc_mcu7t5v0__and3_1_2/A3 vdd vss
+ gf180mcu_fd_sc_mcu7t5v0__nor3_1_9/A2 gf180mcu_fd_sc_mcu7t5v0__mux4_4_2/I2 gf180mcu_fd_sc_mcu7t5v0__nor2_2_3/ZN
+ vdd vss gf180mcu_fd_sc_mcu7t5v0__aoi21_1
Xgf180mcu_fd_sc_mcu7t5v0__nor2_2_30 vdd vss gf180mcu_fd_sc_mcu7t5v0__nor2_2_30/ZN
+ gf180mcu_fd_sc_mcu7t5v0__nor2_2_30/A1 gf180mcu_fd_sc_mcu7t5v0__nor3_1_31/ZN vdd
+ vss gf180mcu_fd_sc_mcu7t5v0__nor2_2
Xgf180mcu_fd_sc_mcu7t5v0__nor2_2_41 vdd vss gf180mcu_fd_sc_mcu7t5v0__nor2_2_41/ZN
+ gf180mcu_fd_sc_mcu7t5v0__nor2_4_37/A1 gf180mcu_fd_sc_mcu7t5v0__inv_2_12/I vdd vss
+ gf180mcu_fd_sc_mcu7t5v0__nor2_2
Xgf180mcu_fd_sc_mcu7t5v0__nor2_2_52 vdd vss gf180mcu_fd_sc_mcu7t5v0__nor2_2_52/ZN
+ gf180mcu_fd_sc_mcu7t5v0__nor3_2_5/A1 gf180mcu_fd_sc_mcu7t5v0__inv_1_23/ZN vdd vss
+ gf180mcu_fd_sc_mcu7t5v0__nor2_2
Xgf180mcu_fd_sc_mcu7t5v0__dffq_1_340 vdd gf180mcu_fd_sc_mcu7t5v0__nand4_2_5/A3 gf180mcu_fd_sc_mcu7t5v0__dffq_4_15/CLK
+ vss gf180mcu_fd_sc_mcu7t5v0__nor3_1_12/ZN vdd vss gf180mcu_fd_sc_mcu7t5v0__dffq_1
Xgf180mcu_fd_sc_mcu7t5v0__dffq_1_351 vdd gf180mcu_fd_sc_mcu7t5v0__dffq_1_351/Q gf180mcu_fd_sc_mcu7t5v0__dffq_4_15/CLK
+ vss gf180mcu_fd_sc_mcu7t5v0__nor3_1_11/ZN vdd vss gf180mcu_fd_sc_mcu7t5v0__dffq_1
Xgf180mcu_fd_sc_mcu7t5v0__dffq_1_362 vdd gf180mcu_fd_sc_mcu7t5v0__nor4_1_2/A3 gf180mcu_fd_sc_mcu7t5v0__dffq_4_15/CLK
+ vss gf180mcu_fd_sc_mcu7t5v0__dffq_1_362/D vdd vss gf180mcu_fd_sc_mcu7t5v0__dffq_1
Xgf180mcu_fd_sc_mcu7t5v0__dffq_1_373 vdd gf180mcu_fd_sc_mcu7t5v0__nand4_2_1/A2 gf180mcu_fd_sc_mcu7t5v0__dffq_4_15/CLK
+ vss gf180mcu_fd_sc_mcu7t5v0__dffq_1_373/D vdd vss gf180mcu_fd_sc_mcu7t5v0__dffq_1
Xgf180mcu_fd_sc_mcu7t5v0__dffq_1_384 vdd gf180mcu_fd_sc_mcu7t5v0__and3_1_9/A1 gf180mcu_fd_sc_mcu7t5v0__dffq_2_58/CLK
+ vss gf180mcu_fd_sc_mcu7t5v0__dffq_1_384/D vdd vss gf180mcu_fd_sc_mcu7t5v0__dffq_1
Xgf180mcu_fd_sc_mcu7t5v0__oai22_1_30 gf180mcu_fd_sc_mcu7t5v0__nand2_4_4/ZN gf180mcu_fd_sc_mcu7t5v0__oai22_1_33/B1
+ gf180mcu_fd_sc_mcu7t5v0__oai22_1_30/B2 vdd vss gf180mcu_fd_sc_mcu7t5v0__dffq_1_31/D
+ gf180mcu_fd_sc_mcu7t5v0__aoi21_4_3/ZN vdd vss gf180mcu_fd_sc_mcu7t5v0__oai22_1
Xgf180mcu_fd_sc_mcu7t5v0__dffq_1_395 vdd gf180mcu_fd_sc_mcu7t5v0__dffq_1_395/Q gf180mcu_fd_sc_mcu7t5v0__dffq_4_21/CLK
+ vss gf180mcu_fd_sc_mcu7t5v0__dffq_1_395/D vdd vss gf180mcu_fd_sc_mcu7t5v0__dffq_1
Xgf180mcu_fd_sc_mcu7t5v0__oai22_1_41 gf180mcu_fd_sc_mcu7t5v0__oai22_1_48/A2 gf180mcu_fd_sc_mcu7t5v0__aoi21_4_4/ZN
+ gf180mcu_fd_sc_mcu7t5v0__nand2_4_5/ZN vdd vss gf180mcu_fd_sc_mcu7t5v0__dffq_1_42/D
+ gf180mcu_fd_sc_mcu7t5v0__oai22_1_41/A1 vdd vss gf180mcu_fd_sc_mcu7t5v0__oai22_1
Xgf180mcu_fd_sc_mcu7t5v0__oai22_1_52 gf180mcu_fd_sc_mcu7t5v0__oai22_1_62/A2 gf180mcu_fd_sc_mcu7t5v0__oai22_1_62/B1
+ gf180mcu_fd_sc_mcu7t5v0__oai22_1_52/B2 vdd vss gf180mcu_fd_sc_mcu7t5v0__dffq_1_59/D
+ gf180mcu_fd_sc_mcu7t5v0__aoi21_4_3/ZN vdd vss gf180mcu_fd_sc_mcu7t5v0__oai22_1
Xgf180mcu_fd_sc_mcu7t5v0__oai22_1_63 gf180mcu_fd_sc_mcu7t5v0__nand2_4_6/ZN gf180mcu_fd_sc_mcu7t5v0__oai22_1_96/B1
+ gf180mcu_fd_sc_mcu7t5v0__oai22_1_63/B2 vdd vss gf180mcu_fd_sc_mcu7t5v0__dffq_1_70/D
+ gf180mcu_fd_sc_mcu7t5v0__oai22_1_88/A1 vdd vss gf180mcu_fd_sc_mcu7t5v0__oai22_1
Xgf180mcu_fd_sc_mcu7t5v0__oai22_1_74 gf180mcu_fd_sc_mcu7t5v0__nand2_4_7/ZN gf180mcu_fd_sc_mcu7t5v0__oai22_1_94/B1
+ gf180mcu_fd_sc_mcu7t5v0__oai22_1_74/B2 vdd vss gf180mcu_fd_sc_mcu7t5v0__dffq_1_76/D
+ gf180mcu_fd_sc_mcu7t5v0__aoi21_4_5/ZN vdd vss gf180mcu_fd_sc_mcu7t5v0__oai22_1
Xgf180mcu_fd_sc_mcu7t5v0__oai22_1_85 gf180mcu_fd_sc_mcu7t5v0__oai22_1_97/A2 gf180mcu_fd_sc_mcu7t5v0__oai22_1_97/B1
+ gf180mcu_fd_sc_mcu7t5v0__oai22_1_85/B2 vdd vss gf180mcu_fd_sc_mcu7t5v0__dffq_1_83/D
+ gf180mcu_fd_sc_mcu7t5v0__aoi21_4_3/ZN vdd vss gf180mcu_fd_sc_mcu7t5v0__oai22_1
Xgf180mcu_fd_sc_mcu7t5v0__oai22_1_96 gf180mcu_fd_sc_mcu7t5v0__nand2_4_6/ZN gf180mcu_fd_sc_mcu7t5v0__oai22_1_96/B1
+ gf180mcu_fd_sc_mcu7t5v0__oai22_1_96/B2 vdd vss gf180mcu_fd_sc_mcu7t5v0__dffq_1_56/D
+ gf180mcu_fd_sc_mcu7t5v0__aoi21_4_5/ZN vdd vss gf180mcu_fd_sc_mcu7t5v0__oai22_1
Xgf180mcu_fd_sc_mcu7t5v0__nand2_2_17 vdd vss gf180mcu_fd_sc_mcu7t5v0__oai22_1_96/B1
+ rst_n gf180mcu_fd_sc_mcu7t5v0__nand2_4_6/ZN vdd vss gf180mcu_fd_sc_mcu7t5v0__nand2_2
Xgf180mcu_fd_sc_mcu7t5v0__nand2_2_28 vdd vss gf180mcu_fd_sc_mcu7t5v0__nand2_2_28/ZN
+ gf180mcu_fd_sc_mcu7t5v0__buf_8_1/Z gf180mcu_fd_sc_mcu7t5v0__nand2_4_21/ZN vdd vss
+ gf180mcu_fd_sc_mcu7t5v0__nand2_2
Xgf180mcu_fd_sc_mcu7t5v0__nand2_2_39 vdd vss gf180mcu_fd_sc_mcu7t5v0__nand2_2_39/ZN
+ gf180mcu_fd_sc_mcu7t5v0__buf_8_5/I gf180mcu_fd_sc_mcu7t5v0__nand2_4_29/ZN vdd vss
+ gf180mcu_fd_sc_mcu7t5v0__nand2_2
Xgf180mcu_fd_sc_mcu7t5v0__xor2_1_209 vdd vss gf180mcu_fd_sc_mcu7t5v0__xor2_1_209/Z
+ gf180mcu_fd_sc_mcu7t5v0__or2_1_7/A1 gf180mcu_fd_sc_mcu7t5v0__xor2_1_209/A2 vdd vss
+ gf180mcu_fd_sc_mcu7t5v0__xor2_1
Xgf180mcu_fd_sc_mcu7t5v0__clkinv_1_201 vdd vss gf180mcu_fd_sc_mcu7t5v0__dffq_1_175/Q
+ gf180mcu_fd_sc_mcu7t5v0__oai22_1_189/B2 vdd vss gf180mcu_fd_sc_mcu7t5v0__clkinv_1
Xgf180mcu_fd_sc_mcu7t5v0__clkinv_1_212 vdd vss gf180mcu_fd_sc_mcu7t5v0__dffq_1_202/Q
+ gf180mcu_fd_sc_mcu7t5v0__oai22_1_201/B2 vdd vss gf180mcu_fd_sc_mcu7t5v0__clkinv_1
Xgf180mcu_fd_sc_mcu7t5v0__clkinv_1_223 vdd vss gf180mcu_fd_sc_mcu7t5v0__dffq_1_217/Q
+ gf180mcu_fd_sc_mcu7t5v0__oai22_1_212/B2 vdd vss gf180mcu_fd_sc_mcu7t5v0__clkinv_1
Xgf180mcu_fd_sc_mcu7t5v0__clkinv_1_234 vdd vss gf180mcu_fd_sc_mcu7t5v0__dffq_1_218/Q
+ gf180mcu_fd_sc_mcu7t5v0__oai22_1_228/B2 vdd vss gf180mcu_fd_sc_mcu7t5v0__clkinv_1
Xgf180mcu_fd_sc_mcu7t5v0__clkinv_1_245 vdd vss gf180mcu_fd_sc_mcu7t5v0__dffq_1_249/Q
+ gf180mcu_fd_sc_mcu7t5v0__oai22_1_245/B2 vdd vss gf180mcu_fd_sc_mcu7t5v0__clkinv_1
Xgf180mcu_fd_sc_mcu7t5v0__clkinv_1_256 vdd vss gf180mcu_fd_sc_mcu7t5v0__dffq_1_264/Q
+ gf180mcu_fd_sc_mcu7t5v0__oai22_1_240/B2 vdd vss gf180mcu_fd_sc_mcu7t5v0__clkinv_1
Xgf180mcu_fd_sc_mcu7t5v0__clkinv_1_267 vdd vss gf180mcu_fd_sc_mcu7t5v0__dffq_1_237/Q
+ gf180mcu_fd_sc_mcu7t5v0__oai22_1_249/B2 vdd vss gf180mcu_fd_sc_mcu7t5v0__clkinv_1
Xgf180mcu_fd_sc_mcu7t5v0__clkinv_1_278 vdd vss gf180mcu_fd_sc_mcu7t5v0__clkinv_1_278/I
+ gf180mcu_fd_sc_mcu7t5v0__aoi22_4_5/B1 vdd vss gf180mcu_fd_sc_mcu7t5v0__clkinv_1
Xgf180mcu_fd_sc_mcu7t5v0__clkinv_1_289 vdd vss gf180mcu_fd_sc_mcu7t5v0__clkinv_1_289/I
+ gf180mcu_fd_sc_mcu7t5v0__aoi22_4_6/B1 vdd vss gf180mcu_fd_sc_mcu7t5v0__clkinv_1
Xgf180mcu_fd_sc_mcu7t5v0__aoi22_2_10 gf180mcu_fd_sc_mcu7t5v0__nor2_2_45/ZN gf180mcu_fd_sc_mcu7t5v0__inv_1_19/I
+ vdd vss gf180mcu_fd_sc_mcu7t5v0__oai31_4_5/B gf180mcu_fd_sc_mcu7t5v0__dffq_1_443/Q
+ gf180mcu_fd_sc_mcu7t5v0__nor2_4_40/ZN vdd vss gf180mcu_fd_sc_mcu7t5v0__aoi22_2
Xgf180mcu_fd_sc_mcu7t5v0__inv_4_6 vss gf180mcu_fd_sc_mcu7t5v0__inv_4_6/ZN gf180mcu_fd_sc_mcu7t5v0__inv_4_6/I
+ vdd vdd vss gf180mcu_fd_sc_mcu7t5v0__inv_4
Xgf180mcu_fd_sc_mcu7t5v0__dffq_2_104 gf180mcu_fd_sc_mcu7t5v0__dffq_2_104/D vdd vss
+ gf180mcu_fd_sc_mcu7t5v0__dffq_4_9/CLK gf180mcu_fd_sc_mcu7t5v0__mux4_4_5/I3 vdd vss
+ gf180mcu_fd_sc_mcu7t5v0__dffq_2
Xgf180mcu_fd_sc_mcu7t5v0__aoi22_2_0 gf180mcu_fd_sc_mcu7t5v0__nor2_2_5/ZN gf180mcu_fd_sc_mcu7t5v0__or2_1_55/A1
+ vdd vss gf180mcu_fd_sc_mcu7t5v0__nand2_4_1/A2 gf180mcu_fd_sc_mcu7t5v0__mux4_4_4/I3
+ gf180mcu_fd_sc_mcu7t5v0__and2_1_15/Z vdd vss gf180mcu_fd_sc_mcu7t5v0__aoi22_2
Xgf180mcu_fd_sc_mcu7t5v0__oai22_1_250 gf180mcu_fd_sc_mcu7t5v0__nand2_4_27/ZN gf180mcu_fd_sc_mcu7t5v0__nand2_2_43/ZN
+ gf180mcu_fd_sc_mcu7t5v0__oai22_1_250/B2 vdd vss gf180mcu_fd_sc_mcu7t5v0__dffq_1_238/D
+ gf180mcu_fd_sc_mcu7t5v0__oai22_1_88/A1 vdd vss gf180mcu_fd_sc_mcu7t5v0__oai22_1
Xgf180mcu_fd_sc_mcu7t5v0__oai22_1_261 gf180mcu_fd_sc_mcu7t5v0__oai22_1_90/A2 gf180mcu_fd_sc_mcu7t5v0__oai22_1_90/B1
+ gf180mcu_fd_sc_mcu7t5v0__oai22_1_261/B2 vdd vss gf180mcu_fd_sc_mcu7t5v0__dffq_1_267/D
+ gf180mcu_fd_sc_mcu7t5v0__aoi21_4_1/ZN vdd vss gf180mcu_fd_sc_mcu7t5v0__oai22_1
Xgf180mcu_fd_sc_mcu7t5v0__oai22_1_272 gf180mcu_fd_sc_mcu7t5v0__xor3_1_93/A1 gf180mcu_fd_sc_mcu7t5v0__oai22_1_272/B1
+ gf180mcu_fd_sc_mcu7t5v0__xor3_1_100/A3 vdd vss gf180mcu_fd_sc_mcu7t5v0__xnor3_1_29/A3
+ gf180mcu_fd_sc_mcu7t5v0__xnor3_1_33/A3 vdd vss gf180mcu_fd_sc_mcu7t5v0__oai22_1
Xgf180mcu_fd_sc_mcu7t5v0__oai221_2_0 gf180mcu_fd_sc_mcu7t5v0__and2_1_22/A1 gf180mcu_fd_sc_mcu7t5v0__mux2_1_2/I0
+ gf180mcu_fd_sc_mcu7t5v0__oai221_2_0/B1 gf180mcu_fd_sc_mcu7t5v0__oai221_2_0/C gf180mcu_fd_sc_mcu7t5v0__nor2_1_69/ZN
+ gf180mcu_fd_sc_mcu7t5v0__aoi211_1_0/B vss vdd vdd vss gf180mcu_fd_sc_mcu7t5v0__oai221_2
Xgf180mcu_fd_sc_mcu7t5v0__oai22_1_283 gf180mcu_fd_sc_mcu7t5v0__xnor3_1_44/A1 gf180mcu_fd_sc_mcu7t5v0__oai22_1_283/B1
+ gf180mcu_fd_sc_mcu7t5v0__xnor3_1_43/A2 vdd vss gf180mcu_fd_sc_mcu7t5v0__xor2_1_206/A1
+ gf180mcu_fd_sc_mcu7t5v0__oai22_1_283/A1 vdd vss gf180mcu_fd_sc_mcu7t5v0__oai22_1
Xgf180mcu_fd_sc_mcu7t5v0__dffq_1_170 vdd gf180mcu_fd_sc_mcu7t5v0__dffq_1_170/Q gf180mcu_fd_sc_mcu7t5v0__dffq_2_58/CLK
+ vss gf180mcu_fd_sc_mcu7t5v0__dffq_1_170/D vdd vss gf180mcu_fd_sc_mcu7t5v0__dffq_1
Xgf180mcu_fd_sc_mcu7t5v0__dffq_1_181 vdd gf180mcu_fd_sc_mcu7t5v0__dffq_1_181/Q gf180mcu_fd_sc_mcu7t5v0__dffq_1_96/CLK
+ vss gf180mcu_fd_sc_mcu7t5v0__dffq_1_181/D vdd vss gf180mcu_fd_sc_mcu7t5v0__dffq_1
Xgf180mcu_fd_sc_mcu7t5v0__clkinv_3_2 vdd gf180mcu_fd_sc_mcu7t5v0__nor2_2_6/A1 gf180mcu_fd_sc_mcu7t5v0__dffq_4_0/Q
+ vss vdd vss gf180mcu_fd_sc_mcu7t5v0__clkinv_3
Xgf180mcu_fd_sc_mcu7t5v0__nor2_1_370 vdd vss gf180mcu_fd_sc_mcu7t5v0__xor3_1_132/A2
+ gf180mcu_fd_sc_mcu7t5v0__inv_8_2/ZN gf180mcu_fd_sc_mcu7t5v0__or3_1_24/A2 vdd vss
+ gf180mcu_fd_sc_mcu7t5v0__nor2_1
Xgf180mcu_fd_sc_mcu7t5v0__dffq_1_192 vdd gf180mcu_fd_sc_mcu7t5v0__dffq_1_192/Q gf180mcu_fd_sc_mcu7t5v0__dffq_2_26/CLK
+ vss gf180mcu_fd_sc_mcu7t5v0__dffq_1_192/D vdd vss gf180mcu_fd_sc_mcu7t5v0__dffq_1
Xgf180mcu_fd_sc_mcu7t5v0__nand3_1_7 gf180mcu_fd_sc_mcu7t5v0__and3_1_0/A3 vdd vss gf180mcu_fd_sc_mcu7t5v0__nand4_1_0/A2
+ gf180mcu_fd_sc_mcu7t5v0__nor2_2_14/ZN gf180mcu_fd_sc_mcu7t5v0__or3_1_0/Z vdd vss
+ gf180mcu_fd_sc_mcu7t5v0__nand3_1
Xgf180mcu_fd_sc_mcu7t5v0__nor2_1_381 vdd vss gf180mcu_fd_sc_mcu7t5v0__nor2_1_381/ZN
+ gf180mcu_fd_sc_mcu7t5v0__xnor2_1_63/A1 gf180mcu_fd_sc_mcu7t5v0__xnor2_1_64/ZN vdd
+ vss gf180mcu_fd_sc_mcu7t5v0__nor2_1
Xgf180mcu_fd_sc_mcu7t5v0__nor2_1_392 vdd vss gf180mcu_fd_sc_mcu7t5v0__xnor2_1_77/A1
+ gf180mcu_fd_sc_mcu7t5v0__nor3_2_13/A1 gf180mcu_fd_sc_mcu7t5v0__xor2_1_195/Z vdd
+ vss gf180mcu_fd_sc_mcu7t5v0__nor2_1
Xgf180mcu_fd_sc_mcu7t5v0__clkinv_2_13 vdd vss gf180mcu_fd_sc_mcu7t5v0__dffq_2_86/Q
+ gf180mcu_fd_sc_mcu7t5v0__nor2_4_41/A1 vdd vss gf180mcu_fd_sc_mcu7t5v0__clkinv_2
Xgf180mcu_fd_sc_mcu7t5v0__inv_2_3 vss gf180mcu_fd_sc_mcu7t5v0__inv_2_3/ZN gf180mcu_fd_sc_mcu7t5v0__inv_2_3/I
+ vdd vdd vss gf180mcu_fd_sc_mcu7t5v0__inv_2
Xgf180mcu_fd_sc_mcu7t5v0__dffq_1_0 vdd gf180mcu_fd_sc_mcu7t5v0__dffq_1_0/Q gf180mcu_fd_sc_mcu7t5v0__dffq_4_6/CLK
+ vss gf180mcu_fd_sc_mcu7t5v0__dffq_1_0/D vdd vss gf180mcu_fd_sc_mcu7t5v0__dffq_1
Xgf180mcu_fd_sc_mcu7t5v0__aoi22_1_104 gf180mcu_fd_sc_mcu7t5v0__nor2_4_11/ZN gf180mcu_fd_sc_mcu7t5v0__dffq_1_178/Q
+ vdd vss gf180mcu_fd_sc_mcu7t5v0__nand2_1_233/A2 gf180mcu_fd_sc_mcu7t5v0__dffq_1_182/Q
+ gf180mcu_fd_sc_mcu7t5v0__nor2_4_10/ZN vdd vss gf180mcu_fd_sc_mcu7t5v0__aoi22_1
Xgf180mcu_fd_sc_mcu7t5v0__aoi22_1_115 gf180mcu_fd_sc_mcu7t5v0__nor2_4_11/ZN gf180mcu_fd_sc_mcu7t5v0__dffq_1_208/Q
+ vdd vss gf180mcu_fd_sc_mcu7t5v0__nand2_1_266/A2 gf180mcu_fd_sc_mcu7t5v0__dffq_1_222/Q
+ gf180mcu_fd_sc_mcu7t5v0__nor2_4_10/ZN vdd vss gf180mcu_fd_sc_mcu7t5v0__aoi22_1
Xgf180mcu_fd_sc_mcu7t5v0__aoi22_1_126 gf180mcu_fd_sc_mcu7t5v0__nor2_4_9/ZN gf180mcu_fd_sc_mcu7t5v0__dffq_1_211/Q
+ vdd vss gf180mcu_fd_sc_mcu7t5v0__nand2_1_293/A1 gf180mcu_fd_sc_mcu7t5v0__dffq_1_251/Q
+ gf180mcu_fd_sc_mcu7t5v0__nor2_4_8/ZN vdd vss gf180mcu_fd_sc_mcu7t5v0__aoi22_1
Xgf180mcu_fd_sc_mcu7t5v0__aoi22_1_137 gf180mcu_fd_sc_mcu7t5v0__nor2_4_9/ZN gf180mcu_fd_sc_mcu7t5v0__dffq_1_99/Q
+ vdd vss gf180mcu_fd_sc_mcu7t5v0__nand2_1_231/A1 gf180mcu_fd_sc_mcu7t5v0__dffq_1_257/Q
+ gf180mcu_fd_sc_mcu7t5v0__nor2_4_8/ZN vdd vss gf180mcu_fd_sc_mcu7t5v0__aoi22_1
Xgf180mcu_fd_sc_mcu7t5v0__aoi22_1_148 gf180mcu_fd_sc_mcu7t5v0__nor2_4_9/ZN gf180mcu_fd_sc_mcu7t5v0__dffq_1_168/Q
+ vdd vss gf180mcu_fd_sc_mcu7t5v0__nand2_1_299/A1 gf180mcu_fd_sc_mcu7t5v0__dffq_1_274/Q
+ gf180mcu_fd_sc_mcu7t5v0__nor2_4_8/ZN vdd vss gf180mcu_fd_sc_mcu7t5v0__aoi22_1
Xgf180mcu_fd_sc_mcu7t5v0__aoi22_1_159 gf180mcu_fd_sc_mcu7t5v0__nand2_1_392/ZN gf180mcu_fd_sc_mcu7t5v0__aoi22_1_159/B2
+ vdd vss gf180mcu_fd_sc_mcu7t5v0__nor2_1_216/A2 gf180mcu_fd_sc_mcu7t5v0__mux4_4_0/I0
+ gf180mcu_fd_sc_mcu7t5v0__or2_4_4/Z vdd vss gf180mcu_fd_sc_mcu7t5v0__aoi22_1
Xgf180mcu_fd_sc_mcu7t5v0__oai211_1_50 gf180mcu_fd_sc_mcu7t5v0__and2_4_3/Z gf180mcu_fd_sc_mcu7t5v0__oai211_1_50/C
+ vdd vss gf180mcu_fd_sc_mcu7t5v0__oai211_1_50/ZN gf180mcu_fd_sc_mcu7t5v0__dffq_2_94/Q
+ gf180mcu_fd_sc_mcu7t5v0__or2_1_34/A2 vdd vss gf180mcu_fd_sc_mcu7t5v0__oai211_1
Xgf180mcu_fd_sc_mcu7t5v0__oai21_1_260 vdd gf180mcu_fd_sc_mcu7t5v0__buf_8_4/Z gf180mcu_fd_sc_mcu7t5v0__buf_20_0/I
+ gf180mcu_fd_sc_mcu7t5v0__aoi21_1_296/B gf180mcu_fd_sc_mcu7t5v0__dffq_2_58/Q vss
+ vdd vss gf180mcu_fd_sc_mcu7t5v0__oai21_1
Xgf180mcu_fd_sc_mcu7t5v0__oai21_1_271 vdd gf180mcu_fd_sc_mcu7t5v0__buf_12_0/Z gf180mcu_fd_sc_mcu7t5v0__buf_20_0/Z
+ gf180mcu_fd_sc_mcu7t5v0__aoi21_1_310/B gf180mcu_fd_sc_mcu7t5v0__mux4_4_1/I3 vss
+ vdd vss gf180mcu_fd_sc_mcu7t5v0__oai21_1
Xgf180mcu_fd_sc_mcu7t5v0__oai21_1_282 vdd gf180mcu_fd_sc_mcu7t5v0__oai31_1_19/B gf180mcu_fd_sc_mcu7t5v0__and4_1_3/A4
+ gf180mcu_fd_sc_mcu7t5v0__xor3_1_162/A3 gf180mcu_fd_sc_mcu7t5v0__and4_1_3/A3 vss
+ vdd vss gf180mcu_fd_sc_mcu7t5v0__oai21_1
Xgf180mcu_fd_sc_mcu7t5v0__oai21_1_293 vdd gf180mcu_fd_sc_mcu7t5v0__oai31_1_21/B gf180mcu_fd_sc_mcu7t5v0__mux4_4_16/Z
+ gf180mcu_fd_sc_mcu7t5v0__xor2_1_224/A2 gf180mcu_fd_sc_mcu7t5v0__oai21_1_293/A1 vss
+ vdd vss gf180mcu_fd_sc_mcu7t5v0__oai21_1
Xgf180mcu_fd_sc_mcu7t5v0__aoi21_1_306 gf180mcu_fd_sc_mcu7t5v0__aoi21_1_7/B vdd vss
+ gf180mcu_fd_sc_mcu7t5v0__dffq_2_103/D gf180mcu_fd_sc_mcu7t5v0__nand2_1_558/ZN gf180mcu_fd_sc_mcu7t5v0__oai21_1_277/ZN
+ vdd vss gf180mcu_fd_sc_mcu7t5v0__aoi21_1
Xgf180mcu_fd_sc_mcu7t5v0__aoi21_1_317 gf180mcu_fd_sc_mcu7t5v0__and2_1_125/Z vdd vss
+ gf180mcu_fd_sc_mcu7t5v0__xor3_1_115/A2 gf180mcu_fd_sc_mcu7t5v0__xor3_1_112/A2 gf180mcu_fd_sc_mcu7t5v0__or2_1_44/Z
+ vdd vss gf180mcu_fd_sc_mcu7t5v0__aoi21_1
Xgf180mcu_fd_sc_mcu7t5v0__aoi21_1_328 gf180mcu_fd_sc_mcu7t5v0__xor2_1_161/Z vdd vss
+ gf180mcu_fd_sc_mcu7t5v0__nor2_1_357/A2 gf180mcu_fd_sc_mcu7t5v0__and3_1_21/A1 gf180mcu_fd_sc_mcu7t5v0__and3_1_21/A2
+ vdd vss gf180mcu_fd_sc_mcu7t5v0__aoi21_1
Xgf180mcu_fd_sc_mcu7t5v0__aoi21_1_339 gf180mcu_fd_sc_mcu7t5v0__xor2_1_180/Z vdd vss
+ gf180mcu_fd_sc_mcu7t5v0__or3_1_22/A2 gf180mcu_fd_sc_mcu7t5v0__nand2_1_633/A1 gf180mcu_fd_sc_mcu7t5v0__and3_1_20/A2
+ vdd vss gf180mcu_fd_sc_mcu7t5v0__aoi21_1
Xgf180mcu_fd_sc_mcu7t5v0__xor3_1_16 gf180mcu_fd_sc_mcu7t5v0__xor2_1_7/Z vdd vss gf180mcu_fd_sc_mcu7t5v0__xor3_1_16/Z
+ gf180mcu_fd_sc_mcu7t5v0__dffq_2_7/Q gf180mcu_fd_sc_mcu7t5v0__xor3_1_16/A2 vdd vss
+ gf180mcu_fd_sc_mcu7t5v0__xor3_1
Xgf180mcu_fd_sc_mcu7t5v0__xor3_1_27 gf180mcu_fd_sc_mcu7t5v0__or2_1_5/A2 vdd vss gf180mcu_fd_sc_mcu7t5v0__xor3_1_27/Z
+ gf180mcu_fd_sc_mcu7t5v0__or2_1_5/A1 gf180mcu_fd_sc_mcu7t5v0__or2_1_6/Z vdd vss gf180mcu_fd_sc_mcu7t5v0__xor3_1
Xgf180mcu_fd_sc_mcu7t5v0__xor3_1_38 gf180mcu_fd_sc_mcu7t5v0__xor3_1_38/A3 vdd vss
+ gf180mcu_fd_sc_mcu7t5v0__xor3_1_38/Z gf180mcu_fd_sc_mcu7t5v0__xor3_1_38/A1 gf180mcu_fd_sc_mcu7t5v0__xor3_1_38/A2
+ vdd vss gf180mcu_fd_sc_mcu7t5v0__xor3_1
Xgf180mcu_fd_sc_mcu7t5v0__aoi222_1_6 vss vdd gf180mcu_fd_sc_mcu7t5v0__aoi222_1_6/C2
+ gf180mcu_fd_sc_mcu7t5v0__nor2_4_7/ZN gf180mcu_fd_sc_mcu7t5v0__nor2_4_5/ZN gf180mcu_fd_sc_mcu7t5v0__aoi222_1_6/B1
+ gf180mcu_fd_sc_mcu7t5v0__aoi222_1_6/A2 gf180mcu_fd_sc_mcu7t5v0__nor2_4_6/ZN gf180mcu_fd_sc_mcu7t5v0__nand3_1_44/A2
+ vdd vss gf180mcu_fd_sc_mcu7t5v0__aoi222_1
Xgf180mcu_fd_sc_mcu7t5v0__xor3_1_49 gf180mcu_fd_sc_mcu7t5v0__xor3_1_46/Z vdd vss gf180mcu_fd_sc_mcu7t5v0__xor3_1_49/Z
+ gf180mcu_fd_sc_mcu7t5v0__xor2_1_42/Z gf180mcu_fd_sc_mcu7t5v0__mux2_1_4/Z vdd vss
+ gf180mcu_fd_sc_mcu7t5v0__xor3_1
Xgf180mcu_fd_sc_mcu7t5v0__nor3_1_8 gf180mcu_fd_sc_mcu7t5v0__nor3_1_8/A3 vdd vss gf180mcu_fd_sc_mcu7t5v0__nor3_1_8/ZN
+ gf180mcu_fd_sc_mcu7t5v0__inv_8_2/ZN gf180mcu_fd_sc_mcu7t5v0__or3_1_9/A2 vdd vss
+ gf180mcu_fd_sc_mcu7t5v0__nor3_1
Xgf180mcu_fd_sc_mcu7t5v0__nand2_1_606 vdd vss gf180mcu_fd_sc_mcu7t5v0__nand2_1_609/A2
+ gf180mcu_fd_sc_mcu7t5v0__xor2_1_168/A1 gf180mcu_fd_sc_mcu7t5v0__xor2_1_169/Z vdd
+ vss gf180mcu_fd_sc_mcu7t5v0__nand2_1
Xgf180mcu_fd_sc_mcu7t5v0__nand2_1_617 vdd vss gf180mcu_fd_sc_mcu7t5v0__xor3_1_161/A1
+ gf180mcu_fd_sc_mcu7t5v0__inv_4_6/I gf180mcu_fd_sc_mcu7t5v0__and4_1_3/A4 vdd vss
+ gf180mcu_fd_sc_mcu7t5v0__nand2_1
Xgf180mcu_fd_sc_mcu7t5v0__nand4_2_2 gf180mcu_fd_sc_mcu7t5v0__nand4_2_2/A3 gf180mcu_fd_sc_mcu7t5v0__inv_1_14/I
+ vdd vss gf180mcu_fd_sc_mcu7t5v0__nand4_2_2/ZN gf180mcu_fd_sc_mcu7t5v0__inv_12_1/I
+ gf180mcu_fd_sc_mcu7t5v0__or3_1_13/Z vdd vss gf180mcu_fd_sc_mcu7t5v0__nand4_2
Xgf180mcu_fd_sc_mcu7t5v0__nand2_1_628 vdd vss gf180mcu_fd_sc_mcu7t5v0__xor3_1_139/A2
+ gf180mcu_fd_sc_mcu7t5v0__or4_1_0/A1 gf180mcu_fd_sc_mcu7t5v0__inv_1_23/I vdd vss
+ gf180mcu_fd_sc_mcu7t5v0__nand2_1
Xgf180mcu_fd_sc_mcu7t5v0__nand2_1_639 vdd vss gf180mcu_fd_sc_mcu7t5v0__nand2_1_639/ZN
+ gf180mcu_fd_sc_mcu7t5v0__nor2_4_42/ZN gf180mcu_fd_sc_mcu7t5v0__xor3_1_154/Z vdd
+ vss gf180mcu_fd_sc_mcu7t5v0__nand2_1
Xgf180mcu_fd_sc_mcu7t5v0__nand4_1_16 gf180mcu_fd_sc_mcu7t5v0__or2_1_30/Z gf180mcu_fd_sc_mcu7t5v0__nand4_1_16/A4
+ vdd vss gf180mcu_fd_sc_mcu7t5v0__oai211_1_25/B gf180mcu_fd_sc_mcu7t5v0__oai31_1_14/B
+ gf180mcu_fd_sc_mcu7t5v0__nand4_1_16/A2 vdd vss gf180mcu_fd_sc_mcu7t5v0__nand4_1
Xgf180mcu_fd_sc_mcu7t5v0__aoi21_4_11 gf180mcu_fd_sc_mcu7t5v0__nor2_4_39/ZN gf180mcu_fd_sc_mcu7t5v0__nor3_2_9/ZN
+ vdd vss gf180mcu_fd_sc_mcu7t5v0__xor2_1_162/A1 gf180mcu_fd_sc_mcu7t5v0__inv_1_19/ZN
+ vdd vss gf180mcu_fd_sc_mcu7t5v0__aoi21_4
Xgf180mcu_fd_sc_mcu7t5v0__inv_1_17 vss gf180mcu_fd_sc_mcu7t5v0__inv_1_17/ZN gf180mcu_fd_sc_mcu7t5v0__inv_1_17/I
+ vdd vdd vss gf180mcu_fd_sc_mcu7t5v0__inv_1
Xgf180mcu_fd_sc_mcu7t5v0__aoi222_1_11 vss vdd gf180mcu_fd_sc_mcu7t5v0__nor2_2_56/ZN
+ gf180mcu_fd_sc_mcu7t5v0__xor3_1_144/Z gf180mcu_fd_sc_mcu7t5v0__nand3_1_89/ZN gf180mcu_fd_sc_mcu7t5v0__nor2_2_54/ZN
+ gf180mcu_fd_sc_mcu7t5v0__nor2_2_55/ZN gf180mcu_fd_sc_mcu7t5v0__or2_1_7/A1 gf180mcu_fd_sc_mcu7t5v0__oai211_1_51/C
+ vdd vss gf180mcu_fd_sc_mcu7t5v0__aoi222_1
Xgf180mcu_fd_sc_mcu7t5v0__xor2_1_60 vdd vss gf180mcu_fd_sc_mcu7t5v0__xor2_1_60/Z gf180mcu_fd_sc_mcu7t5v0__xor2_1_60/A1
+ gf180mcu_fd_sc_mcu7t5v0__xor2_1_56/Z vdd vss gf180mcu_fd_sc_mcu7t5v0__xor2_1
Xgf180mcu_fd_sc_mcu7t5v0__xor2_1_71 vdd vss gf180mcu_fd_sc_mcu7t5v0__xor2_1_71/Z gf180mcu_fd_sc_mcu7t5v0__inv_8_0/I
+ gf180mcu_fd_sc_mcu7t5v0__xor2_1_71/A2 vdd vss gf180mcu_fd_sc_mcu7t5v0__xor2_1
Xgf180mcu_fd_sc_mcu7t5v0__xor2_1_82 vdd vss gf180mcu_fd_sc_mcu7t5v0__xor2_1_82/Z gf180mcu_fd_sc_mcu7t5v0__xor2_1_82/A1
+ gf180mcu_fd_sc_mcu7t5v0__xor2_1_82/A2 vdd vss gf180mcu_fd_sc_mcu7t5v0__xor2_1
Xgf180mcu_fd_sc_mcu7t5v0__xor2_1_93 vdd vss gf180mcu_fd_sc_mcu7t5v0__xor2_1_93/Z gf180mcu_fd_sc_mcu7t5v0__nor4_1_1/A3
+ gf180mcu_fd_sc_mcu7t5v0__xor2_1_93/A2 vdd vss gf180mcu_fd_sc_mcu7t5v0__xor2_1
Xgf180mcu_fd_sc_mcu7t5v0__aoi21_1_103 gf180mcu_fd_sc_mcu7t5v0__oai21_1_91/ZN vdd vss
+ gf180mcu_fd_sc_mcu7t5v0__dffq_2_107/D gf180mcu_fd_sc_mcu7t5v0__inv_2_12/ZN gf180mcu_fd_sc_mcu7t5v0__buf_20_0/Z
+ vdd vss gf180mcu_fd_sc_mcu7t5v0__aoi21_1
Xgf180mcu_fd_sc_mcu7t5v0__aoi21_1_114 gf180mcu_fd_sc_mcu7t5v0__oai21_1_96/ZN vdd vss
+ gf180mcu_fd_sc_mcu7t5v0__dffq_1_410/D gf180mcu_fd_sc_mcu7t5v0__aoi22_4_8/ZN gf180mcu_fd_sc_mcu7t5v0__aoi21_1_114/A2
+ vdd vss gf180mcu_fd_sc_mcu7t5v0__aoi21_1
Xgf180mcu_fd_sc_mcu7t5v0__aoi21_1_125 gf180mcu_fd_sc_mcu7t5v0__aoi21_1_125/B vdd vss
+ gf180mcu_fd_sc_mcu7t5v0__dffq_1_305/D gf180mcu_fd_sc_mcu7t5v0__nor3_4_14/ZN gf180mcu_fd_sc_mcu7t5v0__aoi22_4_3/ZN
+ vdd vss gf180mcu_fd_sc_mcu7t5v0__aoi21_1
Xgf180mcu_fd_sc_mcu7t5v0__aoi21_1_136 gf180mcu_fd_sc_mcu7t5v0__aoi21_1_136/B vdd vss
+ gf180mcu_fd_sc_mcu7t5v0__dffq_4_12/D gf180mcu_fd_sc_mcu7t5v0__or3_1_24/A1 gf180mcu_fd_sc_mcu7t5v0__buf_20_0/I
+ vdd vss gf180mcu_fd_sc_mcu7t5v0__aoi21_1
Xgf180mcu_fd_sc_mcu7t5v0__and2_1_103 vdd vss gf180mcu_fd_sc_mcu7t5v0__and2_1_103/Z
+ gf180mcu_fd_sc_mcu7t5v0__xor2_1_145/A1 gf180mcu_fd_sc_mcu7t5v0__xor3_1_105/Z vdd
+ vss gf180mcu_fd_sc_mcu7t5v0__and2_1
Xgf180mcu_fd_sc_mcu7t5v0__aoi21_1_147 gf180mcu_fd_sc_mcu7t5v0__and3_1_9/A1 vdd vss
+ gf180mcu_fd_sc_mcu7t5v0__nor2_1_175/A2 gf180mcu_fd_sc_mcu7t5v0__and3_1_9/A2 gf180mcu_fd_sc_mcu7t5v0__aoi211_1_50/B
+ vdd vss gf180mcu_fd_sc_mcu7t5v0__aoi21_1
Xgf180mcu_fd_sc_mcu7t5v0__aoi21_1_158 gf180mcu_fd_sc_mcu7t5v0__aoi21_1_158/B vdd vss
+ gf180mcu_fd_sc_mcu7t5v0__dffq_1_322/D gf180mcu_fd_sc_mcu7t5v0__aoi21_1_158/A1 gf180mcu_fd_sc_mcu7t5v0__nand3_1_55/A2
+ vdd vss gf180mcu_fd_sc_mcu7t5v0__aoi21_1
Xgf180mcu_fd_sc_mcu7t5v0__and2_1_114 vdd vss gf180mcu_fd_sc_mcu7t5v0__and2_1_114/Z
+ gf180mcu_fd_sc_mcu7t5v0__and2_1_114/A1 gf180mcu_fd_sc_mcu7t5v0__nand3_1_83/ZN vdd
+ vss gf180mcu_fd_sc_mcu7t5v0__and2_1
Xgf180mcu_fd_sc_mcu7t5v0__and2_1_125 vdd vss gf180mcu_fd_sc_mcu7t5v0__and2_1_125/Z
+ gf180mcu_fd_sc_mcu7t5v0__inv_1_21/I gf180mcu_fd_sc_mcu7t5v0__or2_1_44/A2 vdd vss
+ gf180mcu_fd_sc_mcu7t5v0__and2_1
Xgf180mcu_fd_sc_mcu7t5v0__aoi21_1_169 gf180mcu_fd_sc_mcu7t5v0__aoi21_1_169/B vdd vss
+ gf180mcu_fd_sc_mcu7t5v0__nor2_1_234/A2 gf180mcu_fd_sc_mcu7t5v0__dffq_1_318/Q gf180mcu_fd_sc_mcu7t5v0__inv_2_8/ZN
+ vdd vss gf180mcu_fd_sc_mcu7t5v0__aoi21_1
Xgf180mcu_fd_sc_mcu7t5v0__and2_1_136 vdd vss gf180mcu_fd_sc_mcu7t5v0__and2_1_136/Z
+ gf180mcu_fd_sc_mcu7t5v0__or2_1_53/A1 gf180mcu_fd_sc_mcu7t5v0__or2_1_53/A2 vdd vss
+ gf180mcu_fd_sc_mcu7t5v0__and2_1
Xgf180mcu_fd_sc_mcu7t5v0__and2_1_147 vdd vss gf180mcu_fd_sc_mcu7t5v0__aoi21_2_23/B
+ gf180mcu_fd_sc_mcu7t5v0__xor2_1_206/A1 gf180mcu_fd_sc_mcu7t5v0__xor2_1_206/A2 vdd
+ vss gf180mcu_fd_sc_mcu7t5v0__and2_1
Xgf180mcu_fd_sc_mcu7t5v0__and2_1_158 vdd vss gf180mcu_fd_sc_mcu7t5v0__nor3_1_44/A1
+ gf180mcu_fd_sc_mcu7t5v0__nand4_2_5/A1 gf180mcu_fd_sc_mcu7t5v0__dffq_1_158/Q vdd
+ vss gf180mcu_fd_sc_mcu7t5v0__and2_1
Xgf180mcu_fd_sc_mcu7t5v0__oai32_1_10 gf180mcu_fd_sc_mcu7t5v0__and2_1_109/Z gf180mcu_fd_sc_mcu7t5v0__xnor3_1_31/ZN
+ gf180mcu_fd_sc_mcu7t5v0__xor3_1_142/A2 vdd vss gf180mcu_fd_sc_mcu7t5v0__xor2_2_3/A1
+ gf180mcu_fd_sc_mcu7t5v0__oai32_1_10/A1 gf180mcu_fd_sc_mcu7t5v0__oai32_1_10/A2 vdd
+ vss gf180mcu_fd_sc_mcu7t5v0__oai32_1
Xgf180mcu_fd_sc_mcu7t5v0__nand3_1_60 gf180mcu_fd_sc_mcu7t5v0__and3_2_2/A2 vdd vss
+ gf180mcu_fd_sc_mcu7t5v0__nand3_1_60/ZN gf180mcu_fd_sc_mcu7t5v0__dffq_1_407/Q gf180mcu_fd_sc_mcu7t5v0__nor4_4_1/ZN
+ vdd vss gf180mcu_fd_sc_mcu7t5v0__nand3_1
Xgf180mcu_fd_sc_mcu7t5v0__nand3_1_71 gf180mcu_fd_sc_mcu7t5v0__aoi21_2_9/B vdd vss
+ gf180mcu_fd_sc_mcu7t5v0__nand3_1_71/ZN gf180mcu_fd_sc_mcu7t5v0__aoi21_2_9/A1 gf180mcu_fd_sc_mcu7t5v0__aoi21_2_9/A2
+ vdd vss gf180mcu_fd_sc_mcu7t5v0__nand3_1
Xgf180mcu_fd_sc_mcu7t5v0__nand3_1_82 gf180mcu_fd_sc_mcu7t5v0__dffq_2_14/Q vdd vss
+ gf180mcu_fd_sc_mcu7t5v0__oai31_2_2/B gf180mcu_fd_sc_mcu7t5v0__mux4_4_9/S0 gf180mcu_fd_sc_mcu7t5v0__inv_1_16/I
+ vdd vss gf180mcu_fd_sc_mcu7t5v0__nand3_1
Xgf180mcu_fd_sc_mcu7t5v0__nand3_1_93 gf180mcu_fd_sc_mcu7t5v0__xor3_1_140/A2 vdd vss
+ gf180mcu_fd_sc_mcu7t5v0__nand3_1_93/ZN gf180mcu_fd_sc_mcu7t5v0__inv_1_23/ZN gf180mcu_fd_sc_mcu7t5v0__or3_1_24/A2
+ vdd vss gf180mcu_fd_sc_mcu7t5v0__nand3_1
Xgf180mcu_fd_sc_mcu7t5v0__aoi21_1_6 gf180mcu_fd_sc_mcu7t5v0__aoi21_1_6/B vdd vss gf180mcu_fd_sc_mcu7t5v0__nor2_1_16/A2
+ gf180mcu_fd_sc_mcu7t5v0__or3_2_1/A1 gf180mcu_fd_sc_mcu7t5v0__or2_4_4/Z vdd vss gf180mcu_fd_sc_mcu7t5v0__aoi21_1
Xgf180mcu_fd_sc_mcu7t5v0__nand2_1_403 vdd vss gf180mcu_fd_sc_mcu7t5v0__oai21_1_193/B
+ gf180mcu_fd_sc_mcu7t5v0__xor2_1_107/A1 gf180mcu_fd_sc_mcu7t5v0__xor2_1_107/A2 vdd
+ vss gf180mcu_fd_sc_mcu7t5v0__nand2_1
Xgf180mcu_fd_sc_mcu7t5v0__nand2_1_414 vdd vss gf180mcu_fd_sc_mcu7t5v0__xor3_1_86/A1
+ gf180mcu_fd_sc_mcu7t5v0__or4_1_0/A1 gf180mcu_fd_sc_mcu7t5v0__mux4_4_8/Z vdd vss
+ gf180mcu_fd_sc_mcu7t5v0__nand2_1
Xgf180mcu_fd_sc_mcu7t5v0__nand2_1_425 vdd vss gf180mcu_fd_sc_mcu7t5v0__xnor2_1_41/A2
+ gf180mcu_fd_sc_mcu7t5v0__inv_12_1/I gf180mcu_fd_sc_mcu7t5v0__mux4_4_7/Z vdd vss
+ gf180mcu_fd_sc_mcu7t5v0__nand2_1
Xgf180mcu_fd_sc_mcu7t5v0__nand2_1_436 vdd vss gf180mcu_fd_sc_mcu7t5v0__nand2_1_436/ZN
+ gf180mcu_fd_sc_mcu7t5v0__inv_4_6/I gf180mcu_fd_sc_mcu7t5v0__mux4_4_6/Z vdd vss gf180mcu_fd_sc_mcu7t5v0__nand2_1
Xgf180mcu_fd_sc_mcu7t5v0__nand2_1_447 vdd vss gf180mcu_fd_sc_mcu7t5v0__oai21_1_207/A2
+ gf180mcu_fd_sc_mcu7t5v0__inv_8_2/I gf180mcu_fd_sc_mcu7t5v0__mux4_4_18/Z vdd vss
+ gf180mcu_fd_sc_mcu7t5v0__nand2_1
Xgf180mcu_fd_sc_mcu7t5v0__nand2_1_458 vdd vss gf180mcu_fd_sc_mcu7t5v0__and2_1_95/A1
+ gf180mcu_fd_sc_mcu7t5v0__nand2_1_458/A1 gf180mcu_fd_sc_mcu7t5v0__nand3_1_68/A3 vdd
+ vss gf180mcu_fd_sc_mcu7t5v0__nand2_1
Xgf180mcu_fd_sc_mcu7t5v0__nand2_1_469 vdd vss gf180mcu_fd_sc_mcu7t5v0__nand2_1_469/ZN
+ gf180mcu_fd_sc_mcu7t5v0__nand2_1_475/ZN gf180mcu_fd_sc_mcu7t5v0__nand2_1_469/A2
+ vdd vss gf180mcu_fd_sc_mcu7t5v0__nand2_1
Xgf180mcu_fd_sc_mcu7t5v0__xor2_1_5 vdd vss gf180mcu_fd_sc_mcu7t5v0__xor2_1_5/Z gf180mcu_fd_sc_mcu7t5v0__xor2_1_5/A1
+ gf180mcu_fd_sc_mcu7t5v0__xor2_1_5/A2 vdd vss gf180mcu_fd_sc_mcu7t5v0__xor2_1
Xgf180mcu_fd_sc_mcu7t5v0__oai211_1_6 gf180mcu_fd_sc_mcu7t5v0__oai211_1_6/B gf180mcu_fd_sc_mcu7t5v0__or2_1_34/A2
+ vdd vss gf180mcu_fd_sc_mcu7t5v0__oai211_1_6/ZN gf180mcu_fd_sc_mcu7t5v0__or2_1_4/A1
+ gf180mcu_fd_sc_mcu7t5v0__oai211_1_6/A2 vdd vss gf180mcu_fd_sc_mcu7t5v0__oai211_1
Xgf180mcu_fd_sc_mcu7t5v0__mux2_1_6 gf180mcu_fd_sc_mcu7t5v0__mux2_1_6/S vdd vss gf180mcu_fd_sc_mcu7t5v0__mux2_1_6/Z
+ gf180mcu_fd_sc_mcu7t5v0__nor2_2_9/ZN gf180mcu_fd_sc_mcu7t5v0__mux2_1_6/I1 vdd vss
+ gf180mcu_fd_sc_mcu7t5v0__mux2_1
Xgf180mcu_fd_sc_mcu7t5v0__xnor2_1_17 vdd vss gf180mcu_fd_sc_mcu7t5v0__xnor2_1_17/ZN
+ gf180mcu_fd_sc_mcu7t5v0__xnor3_1_12/A1 gf180mcu_fd_sc_mcu7t5v0__xnor3_1_12/A2 vdd
+ vss gf180mcu_fd_sc_mcu7t5v0__xnor2_1
Xgf180mcu_fd_sc_mcu7t5v0__xnor2_1_28 vdd vss gf180mcu_fd_sc_mcu7t5v0__or3_1_29/A1
+ gf180mcu_fd_sc_mcu7t5v0__mux2_1_10/S gf180mcu_fd_sc_mcu7t5v0__oai31_1_8/A2 vdd vss
+ gf180mcu_fd_sc_mcu7t5v0__xnor2_1
Xgf180mcu_fd_sc_mcu7t5v0__xnor2_1_39 vdd vss gf180mcu_fd_sc_mcu7t5v0__xor2_1_109/A2
+ gf180mcu_fd_sc_mcu7t5v0__nor3_2_6/ZN gf180mcu_fd_sc_mcu7t5v0__aoi21_2_7/A2 vdd vss
+ gf180mcu_fd_sc_mcu7t5v0__xnor2_1
Xgf180mcu_fd_sc_mcu7t5v0__dffq_2_11 gf180mcu_fd_sc_mcu7t5v0__dffq_2_11/D vdd vss gf180mcu_fd_sc_mcu7t5v0__dffq_4_6/CLK
+ gf180mcu_fd_sc_mcu7t5v0__or2_1_5/A1 vdd vss gf180mcu_fd_sc_mcu7t5v0__dffq_2
Xgf180mcu_fd_sc_mcu7t5v0__dffq_2_22 gf180mcu_fd_sc_mcu7t5v0__dffq_2_22/D vdd vss gf180mcu_fd_sc_mcu7t5v0__dffq_4_6/CLK
+ gf180mcu_fd_sc_mcu7t5v0__mux4_4_5/I1 vdd vss gf180mcu_fd_sc_mcu7t5v0__dffq_2
Xgf180mcu_fd_sc_mcu7t5v0__dffq_2_33 gf180mcu_fd_sc_mcu7t5v0__dffq_2_33/D vdd vss gf180mcu_fd_sc_mcu7t5v0__dffq_4_9/CLK
+ gf180mcu_fd_sc_mcu7t5v0__dffq_2_33/Q vdd vss gf180mcu_fd_sc_mcu7t5v0__dffq_2
Xgf180mcu_fd_sc_mcu7t5v0__dffq_2_44 gf180mcu_fd_sc_mcu7t5v0__dffq_2_44/D vdd vss gf180mcu_fd_sc_mcu7t5v0__dffq_4_9/CLK
+ gf180mcu_fd_sc_mcu7t5v0__dffq_2_44/Q vdd vss gf180mcu_fd_sc_mcu7t5v0__dffq_2
Xgf180mcu_fd_sc_mcu7t5v0__and3_1_7 gf180mcu_fd_sc_mcu7t5v0__xor3_1_4/A3 vdd vss gf180mcu_fd_sc_mcu7t5v0__and3_1_7/Z
+ gf180mcu_fd_sc_mcu7t5v0__inv_8_2/I gf180mcu_fd_sc_mcu7t5v0__and2_4_1/Z vdd vss gf180mcu_fd_sc_mcu7t5v0__and3_1
Xgf180mcu_fd_sc_mcu7t5v0__dffq_2_55 gf180mcu_fd_sc_mcu7t5v0__dffq_2_55/D vdd vss gf180mcu_fd_sc_mcu7t5v0__dffq_4_21/CLK
+ gf180mcu_fd_sc_mcu7t5v0__dffq_2_55/Q vdd vss gf180mcu_fd_sc_mcu7t5v0__dffq_2
Xgf180mcu_fd_sc_mcu7t5v0__dffq_2_66 gf180mcu_fd_sc_mcu7t5v0__dffq_2_66/D vdd vss gf180mcu_fd_sc_mcu7t5v0__dffq_4_1/CLK
+ gf180mcu_fd_sc_mcu7t5v0__or2_1_41/A1 vdd vss gf180mcu_fd_sc_mcu7t5v0__dffq_2
Xgf180mcu_fd_sc_mcu7t5v0__dffq_2_77 gf180mcu_fd_sc_mcu7t5v0__dffq_2_77/D vdd vss gf180mcu_fd_sc_mcu7t5v0__dffq_4_9/CLK
+ gf180mcu_fd_sc_mcu7t5v0__mux4_4_0/I3 vdd vss gf180mcu_fd_sc_mcu7t5v0__dffq_2
Xgf180mcu_fd_sc_mcu7t5v0__dffq_2_88 gf180mcu_fd_sc_mcu7t5v0__dffq_2_88/D vdd vss gf180mcu_fd_sc_mcu7t5v0__dffq_4_1/CLK
+ gf180mcu_fd_sc_mcu7t5v0__dffq_2_88/Q vdd vss gf180mcu_fd_sc_mcu7t5v0__dffq_2
Xgf180mcu_fd_sc_mcu7t5v0__dffq_2_99 gf180mcu_fd_sc_mcu7t5v0__dffq_2_99/D vdd vss gf180mcu_fd_sc_mcu7t5v0__dffq_4_1/CLK
+ gf180mcu_fd_sc_mcu7t5v0__inv_2_9/I vdd vss gf180mcu_fd_sc_mcu7t5v0__dffq_2
Xgf180mcu_fd_sc_mcu7t5v0__oai21_1_9 vdd gf180mcu_fd_sc_mcu7t5v0__oai21_1_9/B gf180mcu_fd_sc_mcu7t5v0__xor3_1_20/A2
+ gf180mcu_fd_sc_mcu7t5v0__oai21_1_9/ZN gf180mcu_fd_sc_mcu7t5v0__or2_1_7/A1 vss vdd
+ vss gf180mcu_fd_sc_mcu7t5v0__oai21_1
Xgf180mcu_fd_sc_mcu7t5v0__and3_1_20 gf180mcu_fd_sc_mcu7t5v0__or3_1_23/Z vdd vss gf180mcu_fd_sc_mcu7t5v0__and3_1_20/Z
+ gf180mcu_fd_sc_mcu7t5v0__nor3_4_20/ZN gf180mcu_fd_sc_mcu7t5v0__and3_1_20/A2 vdd
+ vss gf180mcu_fd_sc_mcu7t5v0__and3_1
Xgf180mcu_fd_sc_mcu7t5v0__or2_1_5 vdd vss gf180mcu_fd_sc_mcu7t5v0__or2_1_5/Z gf180mcu_fd_sc_mcu7t5v0__or2_1_5/A1
+ gf180mcu_fd_sc_mcu7t5v0__or2_1_5/A2 vdd vss gf180mcu_fd_sc_mcu7t5v0__or2_1
Xgf180mcu_fd_sc_mcu7t5v0__nor4_2_3 gf180mcu_fd_sc_mcu7t5v0__and2_2_1/Z gf180mcu_fd_sc_mcu7t5v0__and2_2_2/Z
+ vdd vss gf180mcu_fd_sc_mcu7t5v0__nor4_2_3/ZN gf180mcu_fd_sc_mcu7t5v0__and2_4_2/Z
+ gf180mcu_fd_sc_mcu7t5v0__and2_4_1/Z vdd vss gf180mcu_fd_sc_mcu7t5v0__nor4_2
Xgf180mcu_fd_sc_mcu7t5v0__aoi22_4_4 gf180mcu_fd_sc_mcu7t5v0__nor3_4_13/ZN gf180mcu_fd_sc_mcu7t5v0__aoi22_4_4/B1
+ gf180mcu_fd_sc_mcu7t5v0__nor4_4_1/ZN vdd vss gf180mcu_fd_sc_mcu7t5v0__aoi22_4_4/ZN
+ gf180mcu_fd_sc_mcu7t5v0__dffq_2_26/Q vdd vss gf180mcu_fd_sc_mcu7t5v0__aoi22_4
Xgf180mcu_fd_sc_mcu7t5v0__nand2_1_200 vdd vss gf180mcu_fd_sc_mcu7t5v0__xnor2_1_24/A1
+ gf180mcu_fd_sc_mcu7t5v0__inv_2_3/I gf180mcu_fd_sc_mcu7t5v0__oai31_1_3/A1 vdd vss
+ gf180mcu_fd_sc_mcu7t5v0__nand2_1
Xgf180mcu_fd_sc_mcu7t5v0__nand2_1_211 vdd vss gf180mcu_fd_sc_mcu7t5v0__nand2_1_211/ZN
+ gf180mcu_fd_sc_mcu7t5v0__aoi22_1_27/ZN gf180mcu_fd_sc_mcu7t5v0__aoi22_1_16/ZN vdd
+ vss gf180mcu_fd_sc_mcu7t5v0__nand2_1
Xgf180mcu_fd_sc_mcu7t5v0__nand2_1_222 vdd vss gf180mcu_fd_sc_mcu7t5v0__xnor3_1_50/A1
+ gf180mcu_fd_sc_mcu7t5v0__inv_8_0/I gf180mcu_fd_sc_mcu7t5v0__and2_4_1/Z vdd vss gf180mcu_fd_sc_mcu7t5v0__nand2_1
Xgf180mcu_fd_sc_mcu7t5v0__nand2_1_233 vdd vss gf180mcu_fd_sc_mcu7t5v0__aoi222_2_3/C1
+ gf180mcu_fd_sc_mcu7t5v0__aoi22_1_68/ZN gf180mcu_fd_sc_mcu7t5v0__nand2_1_233/A2 vdd
+ vss gf180mcu_fd_sc_mcu7t5v0__nand2_1
Xgf180mcu_fd_sc_mcu7t5v0__nand2_1_244 vdd vss gf180mcu_fd_sc_mcu7t5v0__aoi222_2_3/B1
+ gf180mcu_fd_sc_mcu7t5v0__aoi22_1_87/ZN gf180mcu_fd_sc_mcu7t5v0__aoi22_1_88/ZN vdd
+ vss gf180mcu_fd_sc_mcu7t5v0__nand2_1
Xgf180mcu_fd_sc_mcu7t5v0__nand2_1_255 vdd vss gf180mcu_fd_sc_mcu7t5v0__nand3_1_40/A1
+ gf180mcu_fd_sc_mcu7t5v0__inv_8_0/I gf180mcu_fd_sc_mcu7t5v0__xor2_1_71/A2 vdd vss
+ gf180mcu_fd_sc_mcu7t5v0__nand2_1
Xgf180mcu_fd_sc_mcu7t5v0__nand2_1_266 vdd vss gf180mcu_fd_sc_mcu7t5v0__aoi222_1_7/C2
+ gf180mcu_fd_sc_mcu7t5v0__nand2_1_266/A1 gf180mcu_fd_sc_mcu7t5v0__nand2_1_266/A2
+ vdd vss gf180mcu_fd_sc_mcu7t5v0__nand2_1
Xgf180mcu_fd_sc_mcu7t5v0__nand2_1_277 vdd vss gf180mcu_fd_sc_mcu7t5v0__xor2_1_76/A1
+ gf180mcu_fd_sc_mcu7t5v0__inv_4_6/I gf180mcu_fd_sc_mcu7t5v0__mux4_4_2/Z vdd vss gf180mcu_fd_sc_mcu7t5v0__nand2_1
Xgf180mcu_fd_sc_mcu7t5v0__nand2_1_288 vdd vss gf180mcu_fd_sc_mcu7t5v0__xor3_1_173/A3
+ gf180mcu_fd_sc_mcu7t5v0__inv_12_1/I gf180mcu_fd_sc_mcu7t5v0__mux4_4_0/Z vdd vss
+ gf180mcu_fd_sc_mcu7t5v0__nand2_1
Xgf180mcu_fd_sc_mcu7t5v0__nand2_1_299 vdd vss gf180mcu_fd_sc_mcu7t5v0__aoi222_1_7/B1
+ gf180mcu_fd_sc_mcu7t5v0__nand2_1_299/A1 gf180mcu_fd_sc_mcu7t5v0__aoi22_1_90/ZN vdd
+ vss gf180mcu_fd_sc_mcu7t5v0__nand2_1
Xgf180mcu_fd_sc_mcu7t5v0__aoi21_1_12 gf180mcu_fd_sc_mcu7t5v0__and2_1_27/Z vdd vss
+ gf180mcu_fd_sc_mcu7t5v0__xor3_1_21/A2 gf180mcu_fd_sc_mcu7t5v0__xor2_1_30/A1 gf180mcu_fd_sc_mcu7t5v0__xor2_1_28/Z
+ vdd vss gf180mcu_fd_sc_mcu7t5v0__aoi21_1
Xgf180mcu_fd_sc_mcu7t5v0__aoi21_1_23 gf180mcu_fd_sc_mcu7t5v0__aoi21_1_23/B vdd vss
+ gf180mcu_fd_sc_mcu7t5v0__oai21_1_16/B gf180mcu_fd_sc_mcu7t5v0__nor2_2_14/ZN gf180mcu_fd_sc_mcu7t5v0__or2_1_5/A2
+ vdd vss gf180mcu_fd_sc_mcu7t5v0__aoi21_1
Xgf180mcu_fd_sc_mcu7t5v0__aoi21_1_34 gf180mcu_fd_sc_mcu7t5v0__and2_1_12/Z vdd vss
+ gf180mcu_fd_sc_mcu7t5v0__xor3_1_26/A2 gf180mcu_fd_sc_mcu7t5v0__or2_1_6/Z gf180mcu_fd_sc_mcu7t5v0__or2_1_5/Z
+ vdd vss gf180mcu_fd_sc_mcu7t5v0__aoi21_1
Xgf180mcu_fd_sc_mcu7t5v0__aoi21_1_45 gf180mcu_fd_sc_mcu7t5v0__or2_4_4/Z vdd vss gf180mcu_fd_sc_mcu7t5v0__aoi221_1_6/B2
+ gf180mcu_fd_sc_mcu7t5v0__nand4_1_1/A1 gf180mcu_fd_sc_mcu7t5v0__oai21_1_24/ZN vdd
+ vss gf180mcu_fd_sc_mcu7t5v0__aoi21_1
Xgf180mcu_fd_sc_mcu7t5v0__aoi21_1_56 gf180mcu_fd_sc_mcu7t5v0__nor2_4_0/ZN vdd vss
+ gf180mcu_fd_sc_mcu7t5v0__oai221_2_0/B1 gf180mcu_fd_sc_mcu7t5v0__nor2_2_2/ZN gf180mcu_fd_sc_mcu7t5v0__and2_1_22/A1
+ vdd vss gf180mcu_fd_sc_mcu7t5v0__aoi21_1
Xgf180mcu_fd_sc_mcu7t5v0__aoi21_1_67 gf180mcu_fd_sc_mcu7t5v0__nor3_2_5/A1 vdd vss
+ gf180mcu_fd_sc_mcu7t5v0__xor2_1_48/A2 gf180mcu_fd_sc_mcu7t5v0__nand2_2_9/A1 gf180mcu_fd_sc_mcu7t5v0__nand2_2_9/A2
+ vdd vss gf180mcu_fd_sc_mcu7t5v0__aoi21_1
Xgf180mcu_fd_sc_mcu7t5v0__aoi21_1_78 gf180mcu_fd_sc_mcu7t5v0__aoi21_1_78/B vdd vss
+ gf180mcu_fd_sc_mcu7t5v0__oai22_1_11/A1 gf180mcu_fd_sc_mcu7t5v0__oai21_1_63/A1 gf180mcu_fd_sc_mcu7t5v0__xor3_1_53/Z
+ vdd vss gf180mcu_fd_sc_mcu7t5v0__aoi21_1
Xgf180mcu_fd_sc_mcu7t5v0__aoi21_1_89 gf180mcu_fd_sc_mcu7t5v0__xor2_1_61/Z vdd vss
+ gf180mcu_fd_sc_mcu7t5v0__or3_1_8/A2 gf180mcu_fd_sc_mcu7t5v0__or2_1_17/Z gf180mcu_fd_sc_mcu7t5v0__and3_1_6/A2
+ vdd vss gf180mcu_fd_sc_mcu7t5v0__aoi21_1
Xgf180mcu_fd_sc_mcu7t5v0__nor2_2_20 vdd vss gf180mcu_fd_sc_mcu7t5v0__nor2_2_20/ZN
+ gf180mcu_fd_sc_mcu7t5v0__dffq_2_42/Q gf180mcu_fd_sc_mcu7t5v0__oai32_1_5/B1 vdd vss
+ gf180mcu_fd_sc_mcu7t5v0__nor2_2
Xgf180mcu_fd_sc_mcu7t5v0__nor2_2_31 vdd vss gf180mcu_fd_sc_mcu7t5v0__nor2_2_31/ZN
+ gf180mcu_fd_sc_mcu7t5v0__nor2_2_31/A1 gf180mcu_fd_sc_mcu7t5v0__nor2_2_31/A2 vdd
+ vss gf180mcu_fd_sc_mcu7t5v0__nor2_2
Xgf180mcu_fd_sc_mcu7t5v0__nor2_2_42 vdd vss gf180mcu_fd_sc_mcu7t5v0__nor2_2_42/ZN
+ gf180mcu_fd_sc_mcu7t5v0__nor3_4_18/A1 gf180mcu_fd_sc_mcu7t5v0__nor2_2_44/A2 vdd
+ vss gf180mcu_fd_sc_mcu7t5v0__nor2_2
Xgf180mcu_fd_sc_mcu7t5v0__nor2_2_53 vdd vss gf180mcu_fd_sc_mcu7t5v0__nor2_2_53/ZN
+ gf180mcu_fd_sc_mcu7t5v0__nor2_2_53/A1 gf180mcu_fd_sc_mcu7t5v0__nor3_1_41/A2 vdd
+ vss gf180mcu_fd_sc_mcu7t5v0__nor2_2
Xgf180mcu_fd_sc_mcu7t5v0__dffq_1_330 vdd gf180mcu_fd_sc_mcu7t5v0__dffq_1_330/Q gf180mcu_fd_sc_mcu7t5v0__dffq_2_58/CLK
+ vss gf180mcu_fd_sc_mcu7t5v0__dffq_1_330/D vdd vss gf180mcu_fd_sc_mcu7t5v0__dffq_1
Xgf180mcu_fd_sc_mcu7t5v0__dffq_1_341 vdd gf180mcu_fd_sc_mcu7t5v0__nor4_1_1/A2 gf180mcu_fd_sc_mcu7t5v0__dffq_4_15/CLK
+ vss gf180mcu_fd_sc_mcu7t5v0__dffq_1_341/D vdd vss gf180mcu_fd_sc_mcu7t5v0__dffq_1
Xgf180mcu_fd_sc_mcu7t5v0__dffq_1_352 vdd gf180mcu_fd_sc_mcu7t5v0__dffq_1_352/Q gf180mcu_fd_sc_mcu7t5v0__dffq_4_15/CLK
+ vss gf180mcu_fd_sc_mcu7t5v0__nor3_1_16/ZN vdd vss gf180mcu_fd_sc_mcu7t5v0__dffq_1
Xgf180mcu_fd_sc_mcu7t5v0__dffq_1_363 vdd gf180mcu_fd_sc_mcu7t5v0__nor4_1_2/A2 gf180mcu_fd_sc_mcu7t5v0__dffq_4_15/CLK
+ vss gf180mcu_fd_sc_mcu7t5v0__nor3_1_19/ZN vdd vss gf180mcu_fd_sc_mcu7t5v0__dffq_1
Xgf180mcu_fd_sc_mcu7t5v0__dffq_1_374 vdd gf180mcu_fd_sc_mcu7t5v0__dffq_1_374/Q gf180mcu_fd_sc_mcu7t5v0__dffq_4_21/CLK
+ vss gf180mcu_fd_sc_mcu7t5v0__and2_1_73/Z vdd vss gf180mcu_fd_sc_mcu7t5v0__dffq_1
Xgf180mcu_fd_sc_mcu7t5v0__oai22_1_20 gf180mcu_fd_sc_mcu7t5v0__nand2_4_4/ZN gf180mcu_fd_sc_mcu7t5v0__oai22_1_33/B1
+ gf180mcu_fd_sc_mcu7t5v0__oai22_1_20/B2 vdd vss gf180mcu_fd_sc_mcu7t5v0__dffq_1_26/D
+ gf180mcu_fd_sc_mcu7t5v0__oai22_1_98/A1 vdd vss gf180mcu_fd_sc_mcu7t5v0__oai22_1
Xgf180mcu_fd_sc_mcu7t5v0__dffq_1_385 vdd gf180mcu_fd_sc_mcu7t5v0__and3_1_9/A2 gf180mcu_fd_sc_mcu7t5v0__dffq_2_58/CLK
+ vss gf180mcu_fd_sc_mcu7t5v0__dffq_1_385/D vdd vss gf180mcu_fd_sc_mcu7t5v0__dffq_1
Xgf180mcu_fd_sc_mcu7t5v0__oai22_1_31 gf180mcu_fd_sc_mcu7t5v0__nand2_4_4/ZN gf180mcu_fd_sc_mcu7t5v0__oai22_1_33/B1
+ gf180mcu_fd_sc_mcu7t5v0__oai22_1_31/B2 vdd vss gf180mcu_fd_sc_mcu7t5v0__dffq_1_32/D
+ gf180mcu_fd_sc_mcu7t5v0__aoi21_4_4/ZN vdd vss gf180mcu_fd_sc_mcu7t5v0__oai22_1
Xgf180mcu_fd_sc_mcu7t5v0__dffq_1_396 vdd gf180mcu_fd_sc_mcu7t5v0__dffq_1_396/Q gf180mcu_fd_sc_mcu7t5v0__dffq_4_21/CLK
+ vss gf180mcu_fd_sc_mcu7t5v0__dffq_1_396/D vdd vss gf180mcu_fd_sc_mcu7t5v0__dffq_1
Xgf180mcu_fd_sc_mcu7t5v0__oai22_1_42 gf180mcu_fd_sc_mcu7t5v0__oai22_1_43/A2 gf180mcu_fd_sc_mcu7t5v0__oai22_1_43/B1
+ gf180mcu_fd_sc_mcu7t5v0__oai22_1_42/B2 vdd vss gf180mcu_fd_sc_mcu7t5v0__dffq_1_39/D
+ gf180mcu_fd_sc_mcu7t5v0__aoi21_4_1/ZN vdd vss gf180mcu_fd_sc_mcu7t5v0__oai22_1
Xgf180mcu_fd_sc_mcu7t5v0__oai22_1_53 gf180mcu_fd_sc_mcu7t5v0__oai22_1_62/A2 gf180mcu_fd_sc_mcu7t5v0__oai22_1_62/B1
+ gf180mcu_fd_sc_mcu7t5v0__oai22_1_53/B2 vdd vss gf180mcu_fd_sc_mcu7t5v0__dffq_1_68/D
+ gf180mcu_fd_sc_mcu7t5v0__aoi21_4_2/ZN vdd vss gf180mcu_fd_sc_mcu7t5v0__oai22_1
Xgf180mcu_fd_sc_mcu7t5v0__oai22_1_64 gf180mcu_fd_sc_mcu7t5v0__nand2_4_6/ZN gf180mcu_fd_sc_mcu7t5v0__oai22_1_96/B1
+ gf180mcu_fd_sc_mcu7t5v0__oai22_1_64/B2 vdd vss gf180mcu_fd_sc_mcu7t5v0__dffq_1_71/D
+ gf180mcu_fd_sc_mcu7t5v0__aoi21_4_2/ZN vdd vss gf180mcu_fd_sc_mcu7t5v0__oai22_1
Xgf180mcu_fd_sc_mcu7t5v0__oai22_1_75 gf180mcu_fd_sc_mcu7t5v0__nand2_4_7/ZN gf180mcu_fd_sc_mcu7t5v0__oai22_1_94/B1
+ gf180mcu_fd_sc_mcu7t5v0__oai22_1_75/B2 vdd vss gf180mcu_fd_sc_mcu7t5v0__dffq_1_77/D
+ gf180mcu_fd_sc_mcu7t5v0__aoi21_4_1/ZN vdd vss gf180mcu_fd_sc_mcu7t5v0__oai22_1
Xgf180mcu_fd_sc_mcu7t5v0__oai22_1_86 gf180mcu_fd_sc_mcu7t5v0__nand2_4_9/ZN gf180mcu_fd_sc_mcu7t5v0__oai22_1_95/B1
+ gf180mcu_fd_sc_mcu7t5v0__oai22_1_86/B2 vdd vss gf180mcu_fd_sc_mcu7t5v0__dffq_1_272/D
+ gf180mcu_fd_sc_mcu7t5v0__oai22_1_88/A1 vdd vss gf180mcu_fd_sc_mcu7t5v0__oai22_1
Xgf180mcu_fd_sc_mcu7t5v0__oai22_1_97 gf180mcu_fd_sc_mcu7t5v0__oai22_1_97/A2 gf180mcu_fd_sc_mcu7t5v0__oai22_1_97/B1
+ gf180mcu_fd_sc_mcu7t5v0__oai22_1_97/B2 vdd vss gf180mcu_fd_sc_mcu7t5v0__dffq_1_258/D
+ gf180mcu_fd_sc_mcu7t5v0__aoi21_4_5/ZN vdd vss gf180mcu_fd_sc_mcu7t5v0__oai22_1
Xgf180mcu_fd_sc_mcu7t5v0__nand2_2_18 vdd vss gf180mcu_fd_sc_mcu7t5v0__oai22_1_89/B1
+ rst_n gf180mcu_fd_sc_mcu7t5v0__nand2_4_8/ZN vdd vss gf180mcu_fd_sc_mcu7t5v0__nand2_2
Xgf180mcu_fd_sc_mcu7t5v0__nand2_2_29 vdd vss gf180mcu_fd_sc_mcu7t5v0__nand2_2_29/ZN
+ gf180mcu_fd_sc_mcu7t5v0__buf_8_5/I gf180mcu_fd_sc_mcu7t5v0__nand2_4_22/ZN vdd vss
+ gf180mcu_fd_sc_mcu7t5v0__nand2_2
Xgf180mcu_fd_sc_mcu7t5v0__clkinv_1_202 vdd vss gf180mcu_fd_sc_mcu7t5v0__dffq_1_131/Q
+ gf180mcu_fd_sc_mcu7t5v0__oai22_1_197/B2 vdd vss gf180mcu_fd_sc_mcu7t5v0__clkinv_1
Xgf180mcu_fd_sc_mcu7t5v0__clkinv_1_213 vdd vss gf180mcu_fd_sc_mcu7t5v0__dffq_1_194/Q
+ gf180mcu_fd_sc_mcu7t5v0__oai22_1_204/B2 vdd vss gf180mcu_fd_sc_mcu7t5v0__clkinv_1
Xgf180mcu_fd_sc_mcu7t5v0__clkinv_1_224 vdd vss gf180mcu_fd_sc_mcu7t5v0__dffq_1_220/Q
+ gf180mcu_fd_sc_mcu7t5v0__oai22_1_229/B2 vdd vss gf180mcu_fd_sc_mcu7t5v0__clkinv_1
Xgf180mcu_fd_sc_mcu7t5v0__clkinv_1_235 vdd vss gf180mcu_fd_sc_mcu7t5v0__dffq_1_210/Q
+ gf180mcu_fd_sc_mcu7t5v0__oai22_1_226/B2 vdd vss gf180mcu_fd_sc_mcu7t5v0__clkinv_1
Xgf180mcu_fd_sc_mcu7t5v0__clkinv_1_246 vdd vss gf180mcu_fd_sc_mcu7t5v0__dffq_1_219/Q
+ gf180mcu_fd_sc_mcu7t5v0__oai22_1_214/B2 vdd vss gf180mcu_fd_sc_mcu7t5v0__clkinv_1
Xgf180mcu_fd_sc_mcu7t5v0__clkinv_1_257 vdd vss gf180mcu_fd_sc_mcu7t5v0__dffq_1_235/Q
+ gf180mcu_fd_sc_mcu7t5v0__oai22_1_239/B2 vdd vss gf180mcu_fd_sc_mcu7t5v0__clkinv_1
Xgf180mcu_fd_sc_mcu7t5v0__clkinv_1_268 vdd vss gf180mcu_fd_sc_mcu7t5v0__dffq_1_250/Q
+ gf180mcu_fd_sc_mcu7t5v0__oai22_1_234/B2 vdd vss gf180mcu_fd_sc_mcu7t5v0__clkinv_1
Xgf180mcu_fd_sc_mcu7t5v0__clkinv_1_279 vdd vss gf180mcu_fd_sc_mcu7t5v0__clkinv_1_279/I
+ gf180mcu_fd_sc_mcu7t5v0__aoi22_4_4/B1 vdd vss gf180mcu_fd_sc_mcu7t5v0__clkinv_1
Xgf180mcu_fd_sc_mcu7t5v0__aoi22_2_11 gf180mcu_fd_sc_mcu7t5v0__nor2_2_45/ZN gf180mcu_fd_sc_mcu7t5v0__inv_1_22/I
+ vdd vss gf180mcu_fd_sc_mcu7t5v0__nand3_1_89/A3 gf180mcu_fd_sc_mcu7t5v0__dffq_1_433/Q
+ gf180mcu_fd_sc_mcu7t5v0__nor2_4_40/ZN vdd vss gf180mcu_fd_sc_mcu7t5v0__aoi22_2
Xgf180mcu_fd_sc_mcu7t5v0__inv_4_7 vss gf180mcu_fd_sc_mcu7t5v0__inv_4_7/ZN gf180mcu_fd_sc_mcu7t5v0__inv_4_7/I
+ vdd vdd vss gf180mcu_fd_sc_mcu7t5v0__inv_4
Xgf180mcu_fd_sc_mcu7t5v0__dffq_2_105 gf180mcu_fd_sc_mcu7t5v0__dffq_2_105/D vdd vss
+ gf180mcu_fd_sc_mcu7t5v0__dffq_2_58/CLK gf180mcu_fd_sc_mcu7t5v0__nand4_2_5/A2 vdd
+ vss gf180mcu_fd_sc_mcu7t5v0__dffq_2
Xgf180mcu_fd_sc_mcu7t5v0__aoi22_2_1 gf180mcu_fd_sc_mcu7t5v0__nor2_2_5/ZN gf180mcu_fd_sc_mcu7t5v0__mux4_2_1/I1
+ vdd vss gf180mcu_fd_sc_mcu7t5v0__aoi22_2_1/ZN gf180mcu_fd_sc_mcu7t5v0__mux4_2_1/I3
+ gf180mcu_fd_sc_mcu7t5v0__and2_1_15/Z vdd vss gf180mcu_fd_sc_mcu7t5v0__aoi22_2
Xgf180mcu_fd_sc_mcu7t5v0__oai22_1_240 gf180mcu_fd_sc_mcu7t5v0__nand2_4_31/ZN gf180mcu_fd_sc_mcu7t5v0__nand2_2_42/ZN
+ gf180mcu_fd_sc_mcu7t5v0__oai22_1_240/B2 vdd vss gf180mcu_fd_sc_mcu7t5v0__dffq_1_264/D
+ gf180mcu_fd_sc_mcu7t5v0__oai21_4_9/ZN vdd vss gf180mcu_fd_sc_mcu7t5v0__oai22_1
Xgf180mcu_fd_sc_mcu7t5v0__oai22_1_251 gf180mcu_fd_sc_mcu7t5v0__nand2_4_28/ZN gf180mcu_fd_sc_mcu7t5v0__nand2_2_44/ZN
+ gf180mcu_fd_sc_mcu7t5v0__oai22_1_251/B2 vdd vss gf180mcu_fd_sc_mcu7t5v0__dffq_1_252/D
+ gf180mcu_fd_sc_mcu7t5v0__aoi21_4_5/ZN vdd vss gf180mcu_fd_sc_mcu7t5v0__oai22_1
Xgf180mcu_fd_sc_mcu7t5v0__oai22_1_262 gf180mcu_fd_sc_mcu7t5v0__oai22_1_90/A2 gf180mcu_fd_sc_mcu7t5v0__oai22_1_90/B1
+ gf180mcu_fd_sc_mcu7t5v0__oai22_1_262/B2 vdd vss gf180mcu_fd_sc_mcu7t5v0__dffq_1_268/D
+ gf180mcu_fd_sc_mcu7t5v0__oai22_1_88/A1 vdd vss gf180mcu_fd_sc_mcu7t5v0__oai22_1
Xgf180mcu_fd_sc_mcu7t5v0__oai22_1_273 gf180mcu_fd_sc_mcu7t5v0__inv_1_5/I gf180mcu_fd_sc_mcu7t5v0__and2_1_115/Z
+ gf180mcu_fd_sc_mcu7t5v0__nor2_2_44/ZN vdd vss gf180mcu_fd_sc_mcu7t5v0__oai22_1_273/ZN
+ gf180mcu_fd_sc_mcu7t5v0__inv_8_0/I vdd vss gf180mcu_fd_sc_mcu7t5v0__oai22_1
Xgf180mcu_fd_sc_mcu7t5v0__oai22_1_284 gf180mcu_fd_sc_mcu7t5v0__and2_4_2/Z gf180mcu_fd_sc_mcu7t5v0__oai22_1_1/B2
+ gf180mcu_fd_sc_mcu7t5v0__aoi21_1_27/ZN vdd vss gf180mcu_fd_sc_mcu7t5v0__nand2_1_49/A2
+ gf180mcu_fd_sc_mcu7t5v0__inv_12_1/I vdd vss gf180mcu_fd_sc_mcu7t5v0__oai22_1
Xgf180mcu_fd_sc_mcu7t5v0__dffq_1_160 vdd gf180mcu_fd_sc_mcu7t5v0__dffq_1_160/Q gf180mcu_fd_sc_mcu7t5v0__dffq_2_26/CLK
+ vss gf180mcu_fd_sc_mcu7t5v0__dffq_1_160/D vdd vss gf180mcu_fd_sc_mcu7t5v0__dffq_1
Xgf180mcu_fd_sc_mcu7t5v0__dffq_1_171 vdd gf180mcu_fd_sc_mcu7t5v0__dffq_1_171/Q gf180mcu_fd_sc_mcu7t5v0__dffq_2_26/CLK
+ vss gf180mcu_fd_sc_mcu7t5v0__dffq_1_171/D vdd vss gf180mcu_fd_sc_mcu7t5v0__dffq_1
Xgf180mcu_fd_sc_mcu7t5v0__clkinv_3_3 vdd gf180mcu_fd_sc_mcu7t5v0__xor3_1_43/A1 gf180mcu_fd_sc_mcu7t5v0__dffq_1_16/Q
+ vss vdd vss gf180mcu_fd_sc_mcu7t5v0__clkinv_3
Xgf180mcu_fd_sc_mcu7t5v0__nor2_1_360 vdd vss gf180mcu_fd_sc_mcu7t5v0__or4_1_3/A3 gf180mcu_fd_sc_mcu7t5v0__inv_3_4/ZN
+ gf180mcu_fd_sc_mcu7t5v0__dffq_2_86/Q vdd vss gf180mcu_fd_sc_mcu7t5v0__nor2_1
Xgf180mcu_fd_sc_mcu7t5v0__dffq_1_182 vdd gf180mcu_fd_sc_mcu7t5v0__dffq_1_182/Q gf180mcu_fd_sc_mcu7t5v0__dffq_1_96/CLK
+ vss gf180mcu_fd_sc_mcu7t5v0__dffq_1_182/D vdd vss gf180mcu_fd_sc_mcu7t5v0__dffq_1
Xgf180mcu_fd_sc_mcu7t5v0__nor2_1_371 vdd vss gf180mcu_fd_sc_mcu7t5v0__aoi21_2_22/B
+ gf180mcu_fd_sc_mcu7t5v0__xnor2_1_59/A2 gf180mcu_fd_sc_mcu7t5v0__xnor2_1_64/A1 vdd
+ vss gf180mcu_fd_sc_mcu7t5v0__nor2_1
Xgf180mcu_fd_sc_mcu7t5v0__xor3_2_0 gf180mcu_fd_sc_mcu7t5v0__xor2_1_4/Z vdd vss gf180mcu_fd_sc_mcu7t5v0__xor3_2_0/Z
+ gf180mcu_fd_sc_mcu7t5v0__xor3_2_0/A1 gf180mcu_fd_sc_mcu7t5v0__xor3_2_0/A2 vdd vss
+ gf180mcu_fd_sc_mcu7t5v0__xor3_2
Xgf180mcu_fd_sc_mcu7t5v0__dffq_1_193 vdd gf180mcu_fd_sc_mcu7t5v0__dffq_1_193/Q gf180mcu_fd_sc_mcu7t5v0__dffq_4_8/CLK
+ vss gf180mcu_fd_sc_mcu7t5v0__dffq_1_193/D vdd vss gf180mcu_fd_sc_mcu7t5v0__dffq_1
Xgf180mcu_fd_sc_mcu7t5v0__nor2_1_382 vdd vss gf180mcu_fd_sc_mcu7t5v0__xor3_1_139/A1
+ gf180mcu_fd_sc_mcu7t5v0__inv_8_0/ZN gf180mcu_fd_sc_mcu7t5v0__or3_1_24/A2 vdd vss
+ gf180mcu_fd_sc_mcu7t5v0__nor2_1
Xgf180mcu_fd_sc_mcu7t5v0__nand3_1_8 gf180mcu_fd_sc_mcu7t5v0__and2_4_1/Z vdd vss gf180mcu_fd_sc_mcu7t5v0__xor2_1_21/A1
+ gf180mcu_fd_sc_mcu7t5v0__inv_8_1/I gf180mcu_fd_sc_mcu7t5v0__nor2_2_3/ZN vdd vss
+ gf180mcu_fd_sc_mcu7t5v0__nand3_1
Xgf180mcu_fd_sc_mcu7t5v0__nor2_1_393 vdd vss gf180mcu_fd_sc_mcu7t5v0__nor2_1_393/ZN
+ gf180mcu_fd_sc_mcu7t5v0__inv_8_1/I gf180mcu_fd_sc_mcu7t5v0__and4_1_3/A4 vdd vss
+ gf180mcu_fd_sc_mcu7t5v0__nor2_1
Xgf180mcu_fd_sc_mcu7t5v0__clkinv_2_14 vdd vss gf180mcu_fd_sc_mcu7t5v0__dffq_2_88/Q
+ gf180mcu_fd_sc_mcu7t5v0__aoi22_4_9/A1 vdd vss gf180mcu_fd_sc_mcu7t5v0__clkinv_2
Xgf180mcu_fd_sc_mcu7t5v0__or3_2_0 gf180mcu_fd_sc_mcu7t5v0__inv_2_0/I vdd vss gf180mcu_fd_sc_mcu7t5v0__or3_2_0/Z
+ gf180mcu_fd_sc_mcu7t5v0__or3_2_0/A1 gf180mcu_fd_sc_mcu7t5v0__or3_2_2/A2 vdd vss
+ gf180mcu_fd_sc_mcu7t5v0__or3_2
Xgf180mcu_fd_sc_mcu7t5v0__inv_2_4 vss gf180mcu_fd_sc_mcu7t5v0__inv_2_4/ZN gf180mcu_fd_sc_mcu7t5v0__inv_2_4/I
+ vdd vdd vss gf180mcu_fd_sc_mcu7t5v0__inv_2
Xgf180mcu_fd_sc_mcu7t5v0__dffq_1_1 vdd gf180mcu_fd_sc_mcu7t5v0__dffq_1_1/Q gf180mcu_fd_sc_mcu7t5v0__dffq_4_6/CLK
+ vss gf180mcu_fd_sc_mcu7t5v0__dffq_1_1/D vdd vss gf180mcu_fd_sc_mcu7t5v0__dffq_1
Xgf180mcu_fd_sc_mcu7t5v0__clkinv_1_0 vdd vss gf180mcu_fd_sc_mcu7t5v0__xor2_1_1/A1
+ gf180mcu_fd_sc_mcu7t5v0__aoi21_2_0/A1 vdd vss gf180mcu_fd_sc_mcu7t5v0__clkinv_1
Xgf180mcu_fd_sc_mcu7t5v0__nor2_1_190 vdd vss gf180mcu_fd_sc_mcu7t5v0__nor3_1_16/A2
+ gf180mcu_fd_sc_mcu7t5v0__dffq_1_352/Q gf180mcu_fd_sc_mcu7t5v0__and2_1_60/Z vdd vss
+ gf180mcu_fd_sc_mcu7t5v0__nor2_1
Xgf180mcu_fd_sc_mcu7t5v0__aoi22_1_105 gf180mcu_fd_sc_mcu7t5v0__nor2_4_9/ZN gf180mcu_fd_sc_mcu7t5v0__dffq_1_254/Q
+ vdd vss gf180mcu_fd_sc_mcu7t5v0__nand2_1_263/A1 gf180mcu_fd_sc_mcu7t5v0__dffq_1_193/Q
+ gf180mcu_fd_sc_mcu7t5v0__nor2_4_8/ZN vdd vss gf180mcu_fd_sc_mcu7t5v0__aoi22_1
Xgf180mcu_fd_sc_mcu7t5v0__aoi22_1_116 gf180mcu_fd_sc_mcu7t5v0__nand2_1_295/ZN gf180mcu_fd_sc_mcu7t5v0__nor3_4_6/ZN
+ vdd vss gf180mcu_fd_sc_mcu7t5v0__nand3_1_44/A1 gf180mcu_fd_sc_mcu7t5v0__nor2_4_4/ZN
+ gf180mcu_fd_sc_mcu7t5v0__nand2_1_267/ZN vdd vss gf180mcu_fd_sc_mcu7t5v0__aoi22_1
Xgf180mcu_fd_sc_mcu7t5v0__aoi22_1_127 gf180mcu_fd_sc_mcu7t5v0__nor2_4_11/ZN gf180mcu_fd_sc_mcu7t5v0__dffq_1_232/Q
+ vdd vss gf180mcu_fd_sc_mcu7t5v0__nand2_1_276/A2 gf180mcu_fd_sc_mcu7t5v0__dffq_1_234/Q
+ gf180mcu_fd_sc_mcu7t5v0__nor2_4_10/ZN vdd vss gf180mcu_fd_sc_mcu7t5v0__aoi22_1
Xgf180mcu_fd_sc_mcu7t5v0__aoi22_1_138 gf180mcu_fd_sc_mcu7t5v0__nor2_4_11/ZN gf180mcu_fd_sc_mcu7t5v0__dffq_1_271/Q
+ vdd vss gf180mcu_fd_sc_mcu7t5v0__nand2_1_215/A2 gf180mcu_fd_sc_mcu7t5v0__dffq_1_265/Q
+ gf180mcu_fd_sc_mcu7t5v0__nor2_4_10/ZN vdd vss gf180mcu_fd_sc_mcu7t5v0__aoi22_1
Xgf180mcu_fd_sc_mcu7t5v0__aoi22_1_149 gf180mcu_fd_sc_mcu7t5v0__and3_2_2/A2 gf180mcu_fd_sc_mcu7t5v0__dffq_1_321/Q
+ vdd vss gf180mcu_fd_sc_mcu7t5v0__clkinv_1_278/I gf180mcu_fd_sc_mcu7t5v0__dffq_1_293/Q
+ gf180mcu_fd_sc_mcu7t5v0__nor2_4_23/ZN vdd vss gf180mcu_fd_sc_mcu7t5v0__aoi22_1
Xgf180mcu_fd_sc_mcu7t5v0__oai211_1_40 gf180mcu_fd_sc_mcu7t5v0__oai211_1_40/B gf180mcu_fd_sc_mcu7t5v0__or2_1_34/A2
+ vdd vss gf180mcu_fd_sc_mcu7t5v0__oai211_1_40/ZN gf180mcu_fd_sc_mcu7t5v0__nand4_1_1/A1
+ gf180mcu_fd_sc_mcu7t5v0__xor3_1_111/Z vdd vss gf180mcu_fd_sc_mcu7t5v0__oai211_1
Xgf180mcu_fd_sc_mcu7t5v0__oai211_1_51 gf180mcu_fd_sc_mcu7t5v0__oai211_1_51/B gf180mcu_fd_sc_mcu7t5v0__oai211_1_51/C
+ vdd vss gf180mcu_fd_sc_mcu7t5v0__oai211_1_51/ZN gf180mcu_fd_sc_mcu7t5v0__nand3_1_96/A3
+ gf180mcu_fd_sc_mcu7t5v0__xor3_1_149/A3 vdd vss gf180mcu_fd_sc_mcu7t5v0__oai211_1
Xgf180mcu_fd_sc_mcu7t5v0__inv_12_0 vss gf180mcu_fd_sc_mcu7t5v0__or3_1_24/A1 gf180mcu_fd_sc_mcu7t5v0__or4_1_0/A1
+ vdd vdd vss gf180mcu_fd_sc_mcu7t5v0__inv_12
Xgf180mcu_fd_sc_mcu7t5v0__oai21_1_250 vdd gf180mcu_fd_sc_mcu7t5v0__buf_12_0/Z gf180mcu_fd_sc_mcu7t5v0__buf_20_0/Z
+ gf180mcu_fd_sc_mcu7t5v0__aoi21_1_277/B gf180mcu_fd_sc_mcu7t5v0__mux4_4_0/I3 vss
+ vdd vss gf180mcu_fd_sc_mcu7t5v0__oai21_1
Xgf180mcu_fd_sc_mcu7t5v0__oai21_1_261 vdd gf180mcu_fd_sc_mcu7t5v0__and2_4_3/Z gf180mcu_fd_sc_mcu7t5v0__or2_1_34/A2
+ gf180mcu_fd_sc_mcu7t5v0__aoi21_1_297/B gf180mcu_fd_sc_mcu7t5v0__dffq_2_80/Q vss
+ vdd vss gf180mcu_fd_sc_mcu7t5v0__oai21_1
Xgf180mcu_fd_sc_mcu7t5v0__oai21_1_272 vdd gf180mcu_fd_sc_mcu7t5v0__buf_12_0/Z gf180mcu_fd_sc_mcu7t5v0__buf_20_0/Z
+ gf180mcu_fd_sc_mcu7t5v0__aoi21_1_311/B gf180mcu_fd_sc_mcu7t5v0__mux4_4_4/I3 vss
+ vdd vss gf180mcu_fd_sc_mcu7t5v0__oai21_1
Xgf180mcu_fd_sc_mcu7t5v0__oai21_1_283 vdd gf180mcu_fd_sc_mcu7t5v0__nor3_1_35/A1 gf180mcu_fd_sc_mcu7t5v0__nor3_1_35/A3
+ gf180mcu_fd_sc_mcu7t5v0__oai21_1_283/ZN gf180mcu_fd_sc_mcu7t5v0__nor3_2_12/ZN vss
+ vdd vss gf180mcu_fd_sc_mcu7t5v0__oai21_1
Xgf180mcu_fd_sc_mcu7t5v0__oai21_1_294 vdd gf180mcu_fd_sc_mcu7t5v0__oai21_1_294/B gf180mcu_fd_sc_mcu7t5v0__oai21_1_294/A2
+ gf180mcu_fd_sc_mcu7t5v0__oai21_1_296/B gf180mcu_fd_sc_mcu7t5v0__nand2_2_74/ZN vss
+ vdd vss gf180mcu_fd_sc_mcu7t5v0__oai21_1
Xgf180mcu_fd_sc_mcu7t5v0__aoi21_1_307 gf180mcu_fd_sc_mcu7t5v0__and2_1_124/Z vdd vss
+ gf180mcu_fd_sc_mcu7t5v0__xor3_1_164/A2 gf180mcu_fd_sc_mcu7t5v0__xnor3_1_35/A2 gf180mcu_fd_sc_mcu7t5v0__or2_1_42/Z
+ vdd vss gf180mcu_fd_sc_mcu7t5v0__aoi21_1
Xgf180mcu_fd_sc_mcu7t5v0__aoi21_1_318 gf180mcu_fd_sc_mcu7t5v0__aoi21_1_7/B vdd vss
+ gf180mcu_fd_sc_mcu7t5v0__dffq_2_83/D gf180mcu_fd_sc_mcu7t5v0__nand2_1_573/ZN gf180mcu_fd_sc_mcu7t5v0__oai211_1_44/ZN
+ vdd vss gf180mcu_fd_sc_mcu7t5v0__aoi21_1
Xgf180mcu_fd_sc_mcu7t5v0__aoi21_1_329 gf180mcu_fd_sc_mcu7t5v0__xnor2_1_58/A2 vdd vss
+ gf180mcu_fd_sc_mcu7t5v0__xor2_1_162/A2 gf180mcu_fd_sc_mcu7t5v0__oai21_1_298/B gf180mcu_fd_sc_mcu7t5v0__mux4_4_12/Z
+ vdd vss gf180mcu_fd_sc_mcu7t5v0__aoi21_1
Xgf180mcu_fd_sc_mcu7t5v0__xor3_1_17 gf180mcu_fd_sc_mcu7t5v0__or2_1_3/Z vdd vss gf180mcu_fd_sc_mcu7t5v0__xor3_1_17/Z
+ gf180mcu_fd_sc_mcu7t5v0__dffq_2_9/Q gf180mcu_fd_sc_mcu7t5v0__xor3_1_17/A2 vdd vss
+ gf180mcu_fd_sc_mcu7t5v0__xor3_1
Xgf180mcu_fd_sc_mcu7t5v0__xor3_1_28 gf180mcu_fd_sc_mcu7t5v0__xor3_1_33/Z vdd vss gf180mcu_fd_sc_mcu7t5v0__xor3_1_28/Z
+ gf180mcu_fd_sc_mcu7t5v0__xor3_1_28/A1 gf180mcu_fd_sc_mcu7t5v0__mux2_1_3/Z vdd vss
+ gf180mcu_fd_sc_mcu7t5v0__xor3_1
Xgf180mcu_fd_sc_mcu7t5v0__aoi222_1_7 vss vdd gf180mcu_fd_sc_mcu7t5v0__aoi222_1_7/C2
+ gf180mcu_fd_sc_mcu7t5v0__nor2_4_6/ZN gf180mcu_fd_sc_mcu7t5v0__nor2_4_5/ZN gf180mcu_fd_sc_mcu7t5v0__aoi222_1_7/B1
+ gf180mcu_fd_sc_mcu7t5v0__aoi222_1_7/A2 gf180mcu_fd_sc_mcu7t5v0__nor2_4_4/ZN gf180mcu_fd_sc_mcu7t5v0__nand3_1_39/A2
+ vdd vss gf180mcu_fd_sc_mcu7t5v0__aoi222_1
Xgf180mcu_fd_sc_mcu7t5v0__xor3_1_39 gf180mcu_fd_sc_mcu7t5v0__xor3_1_31/Z vdd vss gf180mcu_fd_sc_mcu7t5v0__xor3_1_39/Z
+ gf180mcu_fd_sc_mcu7t5v0__or2_1_11/Z gf180mcu_fd_sc_mcu7t5v0__xor3_1_39/A2 vdd vss
+ gf180mcu_fd_sc_mcu7t5v0__xor3_1
Xgf180mcu_fd_sc_mcu7t5v0__nor3_1_9 gf180mcu_fd_sc_mcu7t5v0__or2_1_6/A2 vdd vss gf180mcu_fd_sc_mcu7t5v0__nor3_1_9/ZN
+ gf180mcu_fd_sc_mcu7t5v0__nor3_1_9/A1 gf180mcu_fd_sc_mcu7t5v0__nor3_1_9/A2 vdd vss
+ gf180mcu_fd_sc_mcu7t5v0__nor3_1
Xgf180mcu_fd_sc_mcu7t5v0__nand2_1_607 vdd vss gf180mcu_fd_sc_mcu7t5v0__nand2_1_609/A1
+ gf180mcu_fd_sc_mcu7t5v0__xor2_1_169/A1 gf180mcu_fd_sc_mcu7t5v0__xor3_1_125/Z vdd
+ vss gf180mcu_fd_sc_mcu7t5v0__nand2_1
Xgf180mcu_fd_sc_mcu7t5v0__nand4_2_3 gf180mcu_fd_sc_mcu7t5v0__mux4_4_9/Z gf180mcu_fd_sc_mcu7t5v0__mux4_4_8/Z
+ vdd vss gf180mcu_fd_sc_mcu7t5v0__nand4_2_3/ZN gf180mcu_fd_sc_mcu7t5v0__inv_8_1/I
+ gf180mcu_fd_sc_mcu7t5v0__inv_12_1/I vdd vss gf180mcu_fd_sc_mcu7t5v0__nand4_2
Xgf180mcu_fd_sc_mcu7t5v0__nand2_1_618 vdd vss gf180mcu_fd_sc_mcu7t5v0__xor2_1_172/A1
+ gf180mcu_fd_sc_mcu7t5v0__or4_1_0/A1 gf180mcu_fd_sc_mcu7t5v0__xnor2_1_66/A1 vdd vss
+ gf180mcu_fd_sc_mcu7t5v0__nand2_1
Xgf180mcu_fd_sc_mcu7t5v0__nand2_1_629 vdd vss gf180mcu_fd_sc_mcu7t5v0__or2_1_49/A1
+ gf180mcu_fd_sc_mcu7t5v0__inv_12_1/I gf180mcu_fd_sc_mcu7t5v0__mux4_4_13/Z vdd vss
+ gf180mcu_fd_sc_mcu7t5v0__nand2_1
Xgf180mcu_fd_sc_mcu7t5v0__nand4_1_17 gf180mcu_fd_sc_mcu7t5v0__nand4_1_17/A3 gf180mcu_fd_sc_mcu7t5v0__nand4_1_17/A4
+ vdd vss gf180mcu_fd_sc_mcu7t5v0__nand4_1_17/ZN gf180mcu_fd_sc_mcu7t5v0__nand4_1_1/A1
+ gf180mcu_fd_sc_mcu7t5v0__nand4_1_17/A2 vdd vss gf180mcu_fd_sc_mcu7t5v0__nand4_1
Xgf180mcu_fd_sc_mcu7t5v0__aoi21_4_12 gf180mcu_fd_sc_mcu7t5v0__or3_2_3/A2 gf180mcu_fd_sc_mcu7t5v0__inv_1_6/I
+ vdd vss gf180mcu_fd_sc_mcu7t5v0__oai21_4_8/A1 gf180mcu_fd_sc_mcu7t5v0__oai22_4_0/A2
+ vdd vss gf180mcu_fd_sc_mcu7t5v0__aoi21_4
Xgf180mcu_fd_sc_mcu7t5v0__inv_1_18 vss gf180mcu_fd_sc_mcu7t5v0__inv_1_18/ZN gf180mcu_fd_sc_mcu7t5v0__inv_1_18/I
+ vdd vdd vss gf180mcu_fd_sc_mcu7t5v0__inv_1
Xgf180mcu_fd_sc_mcu7t5v0__xor2_1_50 vdd vss gf180mcu_fd_sc_mcu7t5v0__xor2_1_50/Z gf180mcu_fd_sc_mcu7t5v0__xor2_1_50/A1
+ gf180mcu_fd_sc_mcu7t5v0__xor2_1_51/Z vdd vss gf180mcu_fd_sc_mcu7t5v0__xor2_1
Xgf180mcu_fd_sc_mcu7t5v0__xor2_1_61 vdd vss gf180mcu_fd_sc_mcu7t5v0__xor2_1_61/Z gf180mcu_fd_sc_mcu7t5v0__xor2_1_61/A1
+ gf180mcu_fd_sc_mcu7t5v0__xor2_1_61/A2 vdd vss gf180mcu_fd_sc_mcu7t5v0__xor2_1
Xgf180mcu_fd_sc_mcu7t5v0__xor2_1_72 vdd vss gf180mcu_fd_sc_mcu7t5v0__xor2_1_72/Z gf180mcu_fd_sc_mcu7t5v0__inv_8_2/I
+ gf180mcu_fd_sc_mcu7t5v0__xor2_1_68/Z vdd vss gf180mcu_fd_sc_mcu7t5v0__xor2_1
Xgf180mcu_fd_sc_mcu7t5v0__xor2_1_83 vdd vss gf180mcu_fd_sc_mcu7t5v0__xor2_1_83/Z gf180mcu_fd_sc_mcu7t5v0__xor2_1_83/A1
+ gf180mcu_fd_sc_mcu7t5v0__xor2_1_83/A2 vdd vss gf180mcu_fd_sc_mcu7t5v0__xor2_1
Xgf180mcu_fd_sc_mcu7t5v0__xor2_1_94 vdd vss gf180mcu_fd_sc_mcu7t5v0__xor2_1_94/Z gf180mcu_fd_sc_mcu7t5v0__xor2_1_94/A1
+ gf180mcu_fd_sc_mcu7t5v0__and4_2_0/A1 vdd vss gf180mcu_fd_sc_mcu7t5v0__xor2_1
Xgf180mcu_fd_sc_mcu7t5v0__aoi21_1_104 gf180mcu_fd_sc_mcu7t5v0__oai21_1_89/ZN vdd vss
+ gf180mcu_fd_sc_mcu7t5v0__dffq_4_9/D gf180mcu_fd_sc_mcu7t5v0__inv_1_6/ZN gf180mcu_fd_sc_mcu7t5v0__buf_20_0/Z
+ vdd vss gf180mcu_fd_sc_mcu7t5v0__aoi21_1
Xgf180mcu_fd_sc_mcu7t5v0__aoi21_1_115 gf180mcu_fd_sc_mcu7t5v0__nor2_1_149/ZN vdd vss
+ gf180mcu_fd_sc_mcu7t5v0__aoi21_1_115/ZN gf180mcu_fd_sc_mcu7t5v0__dffq_1_410/Q gf180mcu_fd_sc_mcu7t5v0__inv_2_8/I
+ vdd vss gf180mcu_fd_sc_mcu7t5v0__aoi21_1
Xgf180mcu_fd_sc_mcu7t5v0__aoi21_1_126 gf180mcu_fd_sc_mcu7t5v0__aoi21_1_126/B vdd vss
+ gf180mcu_fd_sc_mcu7t5v0__dffq_1_298/D gf180mcu_fd_sc_mcu7t5v0__dffq_4_20/Q gf180mcu_fd_sc_mcu7t5v0__aoi22_2_6/ZN
+ vdd vss gf180mcu_fd_sc_mcu7t5v0__aoi21_1
Xgf180mcu_fd_sc_mcu7t5v0__aoi21_1_137 gf180mcu_fd_sc_mcu7t5v0__or2_1_23/A1 vdd vss
+ gf180mcu_fd_sc_mcu7t5v0__dffq_2_41/D gf180mcu_fd_sc_mcu7t5v0__nand2_1_319/ZN gf180mcu_fd_sc_mcu7t5v0__nand2_1_325/ZN
+ vdd vss gf180mcu_fd_sc_mcu7t5v0__aoi21_1
Xgf180mcu_fd_sc_mcu7t5v0__xor2_1_190 vdd vss gf180mcu_fd_sc_mcu7t5v0__or3_1_25/A3
+ gf180mcu_fd_sc_mcu7t5v0__inv_8_2/I gf180mcu_fd_sc_mcu7t5v0__xor2_1_190/A2 vdd vss
+ gf180mcu_fd_sc_mcu7t5v0__xor2_1
Xgf180mcu_fd_sc_mcu7t5v0__aoi21_1_148 gf180mcu_fd_sc_mcu7t5v0__aoi21_1_148/B vdd vss
+ gf180mcu_fd_sc_mcu7t5v0__dffq_1_328/D gf180mcu_fd_sc_mcu7t5v0__aoi21_1_148/A1 gf180mcu_fd_sc_mcu7t5v0__nand3_1_55/A2
+ vdd vss gf180mcu_fd_sc_mcu7t5v0__aoi21_1
Xgf180mcu_fd_sc_mcu7t5v0__and2_1_104 vdd vss gf180mcu_fd_sc_mcu7t5v0__and2_1_104/Z
+ gf180mcu_fd_sc_mcu7t5v0__inv_4_4/I gf180mcu_fd_sc_mcu7t5v0__or2_1_36/A2 vdd vss
+ gf180mcu_fd_sc_mcu7t5v0__and2_1
Xgf180mcu_fd_sc_mcu7t5v0__aoi21_1_159 gf180mcu_fd_sc_mcu7t5v0__aoi21_1_159/B vdd vss
+ gf180mcu_fd_sc_mcu7t5v0__dffq_1_324/D gf180mcu_fd_sc_mcu7t5v0__aoi21_1_159/A1 gf180mcu_fd_sc_mcu7t5v0__nand2_4_40/ZN
+ vdd vss gf180mcu_fd_sc_mcu7t5v0__aoi21_1
Xgf180mcu_fd_sc_mcu7t5v0__and2_1_115 vdd vss gf180mcu_fd_sc_mcu7t5v0__and2_1_115/Z
+ gf180mcu_fd_sc_mcu7t5v0__nor3_4_17/ZN gf180mcu_fd_sc_mcu7t5v0__xor3_1_173/A1 vdd
+ vss gf180mcu_fd_sc_mcu7t5v0__and2_1
Xgf180mcu_fd_sc_mcu7t5v0__and2_1_126 vdd vss gf180mcu_fd_sc_mcu7t5v0__and2_1_126/Z
+ gf180mcu_fd_sc_mcu7t5v0__inv_8_2/I gf180mcu_fd_sc_mcu7t5v0__xor2_1_228/A2 vdd vss
+ gf180mcu_fd_sc_mcu7t5v0__and2_1
Xgf180mcu_fd_sc_mcu7t5v0__and2_1_137 vdd vss gf180mcu_fd_sc_mcu7t5v0__and2_1_137/Z
+ gf180mcu_fd_sc_mcu7t5v0__dffq_2_102/Q gf180mcu_fd_sc_mcu7t5v0__xor2_1_193/Z vdd
+ vss gf180mcu_fd_sc_mcu7t5v0__and2_1
Xgf180mcu_fd_sc_mcu7t5v0__and2_1_148 vdd vss gf180mcu_fd_sc_mcu7t5v0__nor3_1_41/A3
+ gf180mcu_fd_sc_mcu7t5v0__or4_1_0/A1 gf180mcu_fd_sc_mcu7t5v0__xor2_1_192/A1 vdd vss
+ gf180mcu_fd_sc_mcu7t5v0__and2_1
Xgf180mcu_fd_sc_mcu7t5v0__nand3_1_50 gf180mcu_fd_sc_mcu7t5v0__nor2_4_23/ZN vdd vss
+ gf180mcu_fd_sc_mcu7t5v0__or3_1_10/A1 gf180mcu_fd_sc_mcu7t5v0__dffq_2_44/Q gf180mcu_fd_sc_mcu7t5v0__and3_2_2/A1
+ vdd vss gf180mcu_fd_sc_mcu7t5v0__nand3_1
Xgf180mcu_fd_sc_mcu7t5v0__nand3_1_61 gf180mcu_fd_sc_mcu7t5v0__nand4_1_9/A4 vdd vss
+ gf180mcu_fd_sc_mcu7t5v0__nor3_1_24/A2 gf180mcu_fd_sc_mcu7t5v0__dffq_1_406/Q gf180mcu_fd_sc_mcu7t5v0__nor4_2_4/ZN
+ vdd vss gf180mcu_fd_sc_mcu7t5v0__nand3_1
Xgf180mcu_fd_sc_mcu7t5v0__nand3_1_72 gf180mcu_fd_sc_mcu7t5v0__xnor2_1_47/A1 vdd vss
+ gf180mcu_fd_sc_mcu7t5v0__xor2_1_142/A1 gf180mcu_fd_sc_mcu7t5v0__inv_12_1/I gf180mcu_fd_sc_mcu7t5v0__xnor3_1_33/ZN
+ vdd vss gf180mcu_fd_sc_mcu7t5v0__nand3_1
Xgf180mcu_fd_sc_mcu7t5v0__nand3_1_83 gf180mcu_fd_sc_mcu7t5v0__xor2_1_148/Z vdd vss
+ gf180mcu_fd_sc_mcu7t5v0__nand3_1_83/ZN gf180mcu_fd_sc_mcu7t5v0__mux4_4_6/I3 gf180mcu_fd_sc_mcu7t5v0__nor2_4_45/ZN
+ vdd vss gf180mcu_fd_sc_mcu7t5v0__nand3_1
Xgf180mcu_fd_sc_mcu7t5v0__nand3_1_94 gf180mcu_fd_sc_mcu7t5v0__nand3_1_97/A2 vdd vss
+ gf180mcu_fd_sc_mcu7t5v0__oai211_1_54/C gf180mcu_fd_sc_mcu7t5v0__nor2_2_56/ZN gf180mcu_fd_sc_mcu7t5v0__or3_1_25/Z
+ vdd vss gf180mcu_fd_sc_mcu7t5v0__nand3_1
Xgf180mcu_fd_sc_mcu7t5v0__aoi21_1_7 gf180mcu_fd_sc_mcu7t5v0__aoi21_1_7/B vdd vss gf180mcu_fd_sc_mcu7t5v0__dffq_2_5/D
+ gf180mcu_fd_sc_mcu7t5v0__aoi21_1_7/A1 gf180mcu_fd_sc_mcu7t5v0__nand3_1_0/ZN vdd
+ vss gf180mcu_fd_sc_mcu7t5v0__aoi21_1
Xgf180mcu_fd_sc_mcu7t5v0__nand2_1_404 vdd vss gf180mcu_fd_sc_mcu7t5v0__oai32_1_4/B1
+ gf180mcu_fd_sc_mcu7t5v0__or2_1_7/A1 gf180mcu_fd_sc_mcu7t5v0__mux4_2_1/Z vdd vss
+ gf180mcu_fd_sc_mcu7t5v0__nand2_1
Xgf180mcu_fd_sc_mcu7t5v0__nand2_1_415 vdd vss gf180mcu_fd_sc_mcu7t5v0__oai21_1_205/B
+ gf180mcu_fd_sc_mcu7t5v0__mux4_4_4/I1 gf180mcu_fd_sc_mcu7t5v0__xor2_1_108/Z vdd vss
+ gf180mcu_fd_sc_mcu7t5v0__nand2_1
Xgf180mcu_fd_sc_mcu7t5v0__nand2_1_426 vdd vss gf180mcu_fd_sc_mcu7t5v0__xor2_1_114/A1
+ gf180mcu_fd_sc_mcu7t5v0__or4_1_0/A1 gf180mcu_fd_sc_mcu7t5v0__mux4_4_18/Z vdd vss
+ gf180mcu_fd_sc_mcu7t5v0__nand2_1
Xgf180mcu_fd_sc_mcu7t5v0__nand2_1_437 vdd vss gf180mcu_fd_sc_mcu7t5v0__oai21_1_204/B
+ gf180mcu_fd_sc_mcu7t5v0__nor2_1_253/A1 gf180mcu_fd_sc_mcu7t5v0__xor3_1_79/A3 vdd
+ vss gf180mcu_fd_sc_mcu7t5v0__nand2_1
Xgf180mcu_fd_sc_mcu7t5v0__nand2_1_448 vdd vss gf180mcu_fd_sc_mcu7t5v0__oai221_1_9/C
+ gf180mcu_fd_sc_mcu7t5v0__or4_1_0/A1 gf180mcu_fd_sc_mcu7t5v0__nor2_2_28/ZN vdd vss
+ gf180mcu_fd_sc_mcu7t5v0__nand2_1
Xgf180mcu_fd_sc_mcu7t5v0__nand2_1_459 vdd vss gf180mcu_fd_sc_mcu7t5v0__oai211_1_27/C
+ gf180mcu_fd_sc_mcu7t5v0__nor2_4_33/ZN gf180mcu_fd_sc_mcu7t5v0__xor3_1_82/Z vdd vss
+ gf180mcu_fd_sc_mcu7t5v0__nand2_1
Xgf180mcu_fd_sc_mcu7t5v0__xor2_1_6 vdd vss gf180mcu_fd_sc_mcu7t5v0__xor2_1_6/Z gf180mcu_fd_sc_mcu7t5v0__xor3_1_3/A2
+ gf180mcu_fd_sc_mcu7t5v0__xor3_1_8/Z vdd vss gf180mcu_fd_sc_mcu7t5v0__xor2_1
Xgf180mcu_fd_sc_mcu7t5v0__oai211_1_7 gf180mcu_fd_sc_mcu7t5v0__oai211_1_7/B gf180mcu_fd_sc_mcu7t5v0__oai211_1_7/C
+ vdd vss gf180mcu_fd_sc_mcu7t5v0__aoi21_1_39/B gf180mcu_fd_sc_mcu7t5v0__oai21_1_28/A1
+ gf180mcu_fd_sc_mcu7t5v0__and2_1_13/A2 vdd vss gf180mcu_fd_sc_mcu7t5v0__oai211_1
Xgf180mcu_fd_sc_mcu7t5v0__mux2_1_7 gf180mcu_fd_sc_mcu7t5v0__mux2_1_7/S vdd vss gf180mcu_fd_sc_mcu7t5v0__mux2_1_7/Z
+ gf180mcu_fd_sc_mcu7t5v0__mux2_1_7/I0 gf180mcu_fd_sc_mcu7t5v0__inv_8_0/I vdd vss
+ gf180mcu_fd_sc_mcu7t5v0__mux2_1
Xgf180mcu_fd_sc_mcu7t5v0__xnor2_1_18 vdd vss gf180mcu_fd_sc_mcu7t5v0__xor3_1_1/A3
+ gf180mcu_fd_sc_mcu7t5v0__xnor3_1_14/ZN gf180mcu_fd_sc_mcu7t5v0__xnor2_1_18/A2 vdd
+ vss gf180mcu_fd_sc_mcu7t5v0__xnor2_1
Xgf180mcu_fd_sc_mcu7t5v0__xnor2_1_29 vdd vss gf180mcu_fd_sc_mcu7t5v0__xor3_1_107/A3
+ gf180mcu_fd_sc_mcu7t5v0__xnor2_1_29/A1 gf180mcu_fd_sc_mcu7t5v0__xor2_1_85/Z vdd
+ vss gf180mcu_fd_sc_mcu7t5v0__xnor2_1
Xgf180mcu_fd_sc_mcu7t5v0__dffq_2_12 gf180mcu_fd_sc_mcu7t5v0__dffq_2_12/D vdd vss gf180mcu_fd_sc_mcu7t5v0__dffq_4_6/CLK
+ gf180mcu_fd_sc_mcu7t5v0__inv_2_1/I vdd vss gf180mcu_fd_sc_mcu7t5v0__dffq_2
Xgf180mcu_fd_sc_mcu7t5v0__dffq_2_23 gf180mcu_fd_sc_mcu7t5v0__dffq_2_23/D vdd vss gf180mcu_fd_sc_mcu7t5v0__dffq_4_6/CLK
+ gf180mcu_fd_sc_mcu7t5v0__dffq_2_23/Q vdd vss gf180mcu_fd_sc_mcu7t5v0__dffq_2
Xgf180mcu_fd_sc_mcu7t5v0__dffq_2_34 gf180mcu_fd_sc_mcu7t5v0__dffq_2_34/D vdd vss gf180mcu_fd_sc_mcu7t5v0__dffq_4_9/CLK
+ gf180mcu_fd_sc_mcu7t5v0__dffq_2_34/Q vdd vss gf180mcu_fd_sc_mcu7t5v0__dffq_2
Xgf180mcu_fd_sc_mcu7t5v0__dffq_2_45 gf180mcu_fd_sc_mcu7t5v0__dffq_2_45/D vdd vss gf180mcu_fd_sc_mcu7t5v0__dffq_4_9/CLK
+ gf180mcu_fd_sc_mcu7t5v0__inv_2_7/I vdd vss gf180mcu_fd_sc_mcu7t5v0__dffq_2
Xgf180mcu_fd_sc_mcu7t5v0__dffq_2_56 gf180mcu_fd_sc_mcu7t5v0__dffq_2_56/D vdd vss gf180mcu_fd_sc_mcu7t5v0__dffq_4_21/CLK
+ gf180mcu_fd_sc_mcu7t5v0__dffq_2_56/Q vdd vss gf180mcu_fd_sc_mcu7t5v0__dffq_2
Xgf180mcu_fd_sc_mcu7t5v0__and3_1_8 gf180mcu_fd_sc_mcu7t5v0__xor3_1_65/Z vdd vss gf180mcu_fd_sc_mcu7t5v0__and3_1_8/Z
+ gf180mcu_fd_sc_mcu7t5v0__and3_1_8/A1 gf180mcu_fd_sc_mcu7t5v0__and3_1_8/A2 vdd vss
+ gf180mcu_fd_sc_mcu7t5v0__and3_1
Xgf180mcu_fd_sc_mcu7t5v0__dffq_2_67 gf180mcu_fd_sc_mcu7t5v0__dffq_2_67/D vdd vss gf180mcu_fd_sc_mcu7t5v0__dffq_4_44/CLK
+ gf180mcu_fd_sc_mcu7t5v0__mux4_4_4/I3 vdd vss gf180mcu_fd_sc_mcu7t5v0__dffq_2
Xgf180mcu_fd_sc_mcu7t5v0__dffq_2_78 gf180mcu_fd_sc_mcu7t5v0__dffq_2_78/D vdd vss gf180mcu_fd_sc_mcu7t5v0__dffq_4_1/CLK
+ gf180mcu_fd_sc_mcu7t5v0__mux4_4_9/I3 vdd vss gf180mcu_fd_sc_mcu7t5v0__dffq_2
Xgf180mcu_fd_sc_mcu7t5v0__dffq_2_89 gf180mcu_fd_sc_mcu7t5v0__dffq_2_89/D vdd vss gf180mcu_fd_sc_mcu7t5v0__dffq_4_1/CLK
+ gf180mcu_fd_sc_mcu7t5v0__or2_1_39/A1 vdd vss gf180mcu_fd_sc_mcu7t5v0__dffq_2
Xgf180mcu_fd_sc_mcu7t5v0__and3_1_10 gf180mcu_fd_sc_mcu7t5v0__xor2_1_91/A2 vdd vss
+ gf180mcu_fd_sc_mcu7t5v0__and3_1_10/Z gf180mcu_fd_sc_mcu7t5v0__nor4_4_3/A1 gf180mcu_fd_sc_mcu7t5v0__nand4_2_5/A3
+ vdd vss gf180mcu_fd_sc_mcu7t5v0__and3_1
Xgf180mcu_fd_sc_mcu7t5v0__and3_1_21 gf180mcu_fd_sc_mcu7t5v0__xor2_1_161/Z vdd vss
+ gf180mcu_fd_sc_mcu7t5v0__and3_1_21/Z gf180mcu_fd_sc_mcu7t5v0__and3_1_21/A1 gf180mcu_fd_sc_mcu7t5v0__and3_1_21/A2
+ vdd vss gf180mcu_fd_sc_mcu7t5v0__and3_1
Xgf180mcu_fd_sc_mcu7t5v0__or2_1_6 vdd vss gf180mcu_fd_sc_mcu7t5v0__or2_1_6/Z gf180mcu_fd_sc_mcu7t5v0__or2_1_6/A1
+ gf180mcu_fd_sc_mcu7t5v0__or2_1_6/A2 vdd vss gf180mcu_fd_sc_mcu7t5v0__or2_1
Xgf180mcu_fd_sc_mcu7t5v0__nor4_2_4 gf180mcu_fd_sc_mcu7t5v0__nor4_2_4/A3 gf180mcu_fd_sc_mcu7t5v0__nor4_2_4/A4
+ vdd vss gf180mcu_fd_sc_mcu7t5v0__nor4_2_4/ZN gf180mcu_fd_sc_mcu7t5v0__nor4_2_4/A1
+ gf180mcu_fd_sc_mcu7t5v0__nor4_2_4/A2 vdd vss gf180mcu_fd_sc_mcu7t5v0__nor4_2
Xgf180mcu_fd_sc_mcu7t5v0__aoi22_4_5 gf180mcu_fd_sc_mcu7t5v0__nor3_4_13/ZN gf180mcu_fd_sc_mcu7t5v0__aoi22_4_5/B1
+ gf180mcu_fd_sc_mcu7t5v0__nor4_4_1/ZN vdd vss gf180mcu_fd_sc_mcu7t5v0__aoi22_4_5/ZN
+ gf180mcu_fd_sc_mcu7t5v0__dffq_2_111/Q vdd vss gf180mcu_fd_sc_mcu7t5v0__aoi22_4
Xgf180mcu_fd_sc_mcu7t5v0__nand2_1_201 vdd vss gf180mcu_fd_sc_mcu7t5v0__oai21_1_72/A2
+ gf180mcu_fd_sc_mcu7t5v0__inv_4_6/I gf180mcu_fd_sc_mcu7t5v0__xor2_1_64/A1 vdd vss
+ gf180mcu_fd_sc_mcu7t5v0__nand2_1
Xgf180mcu_fd_sc_mcu7t5v0__nand2_1_212 vdd vss gf180mcu_fd_sc_mcu7t5v0__nand2_1_212/ZN
+ gf180mcu_fd_sc_mcu7t5v0__aoi22_1_26/ZN gf180mcu_fd_sc_mcu7t5v0__aoi22_1_15/ZN vdd
+ vss gf180mcu_fd_sc_mcu7t5v0__nand2_1
Xgf180mcu_fd_sc_mcu7t5v0__nand2_1_223 vdd vss gf180mcu_fd_sc_mcu7t5v0__xnor3_1_50/A2
+ gf180mcu_fd_sc_mcu7t5v0__or4_1_0/A1 gf180mcu_fd_sc_mcu7t5v0__and2_4_2/Z vdd vss
+ gf180mcu_fd_sc_mcu7t5v0__nand2_1
Xgf180mcu_fd_sc_mcu7t5v0__nand2_1_234 vdd vss gf180mcu_fd_sc_mcu7t5v0__aoi22_1_67/A2
+ gf180mcu_fd_sc_mcu7t5v0__aoi22_1_56/ZN gf180mcu_fd_sc_mcu7t5v0__aoi22_1_66/ZN vdd
+ vss gf180mcu_fd_sc_mcu7t5v0__nand2_1
Xgf180mcu_fd_sc_mcu7t5v0__nand2_1_245 vdd vss gf180mcu_fd_sc_mcu7t5v0__aoi222_1_4/C1
+ gf180mcu_fd_sc_mcu7t5v0__nand2_1_245/A1 gf180mcu_fd_sc_mcu7t5v0__aoi22_1_79/ZN vdd
+ vss gf180mcu_fd_sc_mcu7t5v0__nand2_1
Xgf180mcu_fd_sc_mcu7t5v0__nand2_1_256 vdd vss gf180mcu_fd_sc_mcu7t5v0__xor2_1_212/A1
+ gf180mcu_fd_sc_mcu7t5v0__aoi21_1_93/A1 gf180mcu_fd_sc_mcu7t5v0__oai21_1_75/ZN vdd
+ vss gf180mcu_fd_sc_mcu7t5v0__nand2_1
Xgf180mcu_fd_sc_mcu7t5v0__nand2_1_267 vdd vss gf180mcu_fd_sc_mcu7t5v0__nand2_1_267/ZN
+ gf180mcu_fd_sc_mcu7t5v0__nand2_1_267/A1 gf180mcu_fd_sc_mcu7t5v0__nand2_1_267/A2
+ vdd vss gf180mcu_fd_sc_mcu7t5v0__nand2_1
Xgf180mcu_fd_sc_mcu7t5v0__nand2_1_278 vdd vss gf180mcu_fd_sc_mcu7t5v0__xor3_1_67/A1
+ gf180mcu_fd_sc_mcu7t5v0__dffq_4_37/Q gf180mcu_fd_sc_mcu7t5v0__mux4_4_2/Z vdd vss
+ gf180mcu_fd_sc_mcu7t5v0__nand2_1
Xgf180mcu_fd_sc_mcu7t5v0__nand2_1_289 vdd vss gf180mcu_fd_sc_mcu7t5v0__and2_1_42/A1
+ gf180mcu_fd_sc_mcu7t5v0__or4_1_0/A1 gf180mcu_fd_sc_mcu7t5v0__mux4_4_3/Z vdd vss
+ gf180mcu_fd_sc_mcu7t5v0__nand2_1
Xgf180mcu_fd_sc_mcu7t5v0__aoi21_1_13 gf180mcu_fd_sc_mcu7t5v0__nor2_4_0/ZN vdd vss
+ gf180mcu_fd_sc_mcu7t5v0__aoi21_1_13/ZN gf180mcu_fd_sc_mcu7t5v0__or2_1_7/A1 gf180mcu_fd_sc_mcu7t5v0__nor2_4_1/ZN
+ vdd vss gf180mcu_fd_sc_mcu7t5v0__aoi21_1
Xgf180mcu_fd_sc_mcu7t5v0__aoi21_1_24 gf180mcu_fd_sc_mcu7t5v0__and2_1_38/Z vdd vss
+ gf180mcu_fd_sc_mcu7t5v0__xor2_1_214/A2 gf180mcu_fd_sc_mcu7t5v0__nor2_2_3/A2 gf180mcu_fd_sc_mcu7t5v0__nor3_4_1/A2
+ vdd vss gf180mcu_fd_sc_mcu7t5v0__aoi21_1
Xgf180mcu_fd_sc_mcu7t5v0__aoi21_1_35 gf180mcu_fd_sc_mcu7t5v0__aoi21_1_7/B vdd vss
+ gf180mcu_fd_sc_mcu7t5v0__dffq_2_11/D gf180mcu_fd_sc_mcu7t5v0__nand2_1_65/ZN gf180mcu_fd_sc_mcu7t5v0__oai221_1_2/ZN
+ vdd vss gf180mcu_fd_sc_mcu7t5v0__aoi21_1
Xgf180mcu_fd_sc_mcu7t5v0__aoi21_1_46 gf180mcu_fd_sc_mcu7t5v0__aoi21_1_7/B vdd vss
+ gf180mcu_fd_sc_mcu7t5v0__dffq_2_10/D gf180mcu_fd_sc_mcu7t5v0__nand2_1_68/ZN gf180mcu_fd_sc_mcu7t5v0__nand2_1_44/ZN
+ vdd vss gf180mcu_fd_sc_mcu7t5v0__aoi21_1
Xgf180mcu_fd_sc_mcu7t5v0__aoi21_1_57 gf180mcu_fd_sc_mcu7t5v0__nor2_1_71/ZN vdd vss
+ gf180mcu_fd_sc_mcu7t5v0__xor3_1_44/A1 gf180mcu_fd_sc_mcu7t5v0__xnor2_1_17/ZN gf180mcu_fd_sc_mcu7t5v0__xor2_1_44/Z
+ vdd vss gf180mcu_fd_sc_mcu7t5v0__aoi21_1
Xgf180mcu_fd_sc_mcu7t5v0__aoi21_1_68 gf180mcu_fd_sc_mcu7t5v0__and2_1_14/Z vdd vss
+ gf180mcu_fd_sc_mcu7t5v0__aoi21_1_69/B gf180mcu_fd_sc_mcu7t5v0__xor2_1_66/A1 gf180mcu_fd_sc_mcu7t5v0__nor4_2_2/ZN
+ vdd vss gf180mcu_fd_sc_mcu7t5v0__aoi21_1
Xgf180mcu_fd_sc_mcu7t5v0__aoi21_1_79 gf180mcu_fd_sc_mcu7t5v0__aoi21_1_79/B vdd vss
+ gf180mcu_fd_sc_mcu7t5v0__xor2_1_60/A1 gf180mcu_fd_sc_mcu7t5v0__xor2_1_50/A1 gf180mcu_fd_sc_mcu7t5v0__xor2_1_51/Z
+ vdd vss gf180mcu_fd_sc_mcu7t5v0__aoi21_1
Xgf180mcu_fd_sc_mcu7t5v0__nor2_2_10 vdd vss gf180mcu_fd_sc_mcu7t5v0__nor2_2_10/ZN
+ gf180mcu_fd_sc_mcu7t5v0__inv_4_0/ZN gf180mcu_fd_sc_mcu7t5v0__and2_2_8/A1 vdd vss
+ gf180mcu_fd_sc_mcu7t5v0__nor2_2
Xgf180mcu_fd_sc_mcu7t5v0__nor2_2_21 vdd vss gf180mcu_fd_sc_mcu7t5v0__oai31_1_9/A2
+ gf180mcu_fd_sc_mcu7t5v0__dffq_2_40/Q gf180mcu_fd_sc_mcu7t5v0__oai32_1_5/A2 vdd vss
+ gf180mcu_fd_sc_mcu7t5v0__nor2_2
Xgf180mcu_fd_sc_mcu7t5v0__nor2_2_32 vdd vss gf180mcu_fd_sc_mcu7t5v0__nor2_2_32/ZN
+ gf180mcu_fd_sc_mcu7t5v0__nor3_2_5/A1 gf180mcu_fd_sc_mcu7t5v0__nor2_2_32/A2 vdd vss
+ gf180mcu_fd_sc_mcu7t5v0__nor2_2
Xgf180mcu_fd_sc_mcu7t5v0__nor2_2_43 vdd vss gf180mcu_fd_sc_mcu7t5v0__nor2_2_43/ZN
+ gf180mcu_fd_sc_mcu7t5v0__dffq_4_28/Q gf180mcu_fd_sc_mcu7t5v0__nor3_4_18/A2 vdd vss
+ gf180mcu_fd_sc_mcu7t5v0__nor2_2
Xgf180mcu_fd_sc_mcu7t5v0__nor2_2_54 vdd vss gf180mcu_fd_sc_mcu7t5v0__nor2_2_54/ZN
+ gf180mcu_fd_sc_mcu7t5v0__nor2_2_54/A1 gf180mcu_fd_sc_mcu7t5v0__nor2_2_55/A2 vdd
+ vss gf180mcu_fd_sc_mcu7t5v0__nor2_2
Xgf180mcu_fd_sc_mcu7t5v0__dffq_1_320 vdd gf180mcu_fd_sc_mcu7t5v0__dffq_1_320/Q gf180mcu_fd_sc_mcu7t5v0__dffq_2_58/CLK
+ vss gf180mcu_fd_sc_mcu7t5v0__dffq_1_320/D vdd vss gf180mcu_fd_sc_mcu7t5v0__dffq_1
Xgf180mcu_fd_sc_mcu7t5v0__dffq_1_331 vdd gf180mcu_fd_sc_mcu7t5v0__dffq_1_331/Q gf180mcu_fd_sc_mcu7t5v0__dffq_2_58/CLK
+ vss gf180mcu_fd_sc_mcu7t5v0__dffq_1_331/D vdd vss gf180mcu_fd_sc_mcu7t5v0__dffq_1
Xgf180mcu_fd_sc_mcu7t5v0__dffq_1_342 vdd gf180mcu_fd_sc_mcu7t5v0__nor4_1_0/A3 gf180mcu_fd_sc_mcu7t5v0__dffq_4_15/CLK
+ vss gf180mcu_fd_sc_mcu7t5v0__dffq_1_342/D vdd vss gf180mcu_fd_sc_mcu7t5v0__dffq_1
Xgf180mcu_fd_sc_mcu7t5v0__dffq_1_353 vdd gf180mcu_fd_sc_mcu7t5v0__nor4_1_2/A1 gf180mcu_fd_sc_mcu7t5v0__dffq_4_15/CLK
+ vss gf180mcu_fd_sc_mcu7t5v0__nor3_1_14/ZN vdd vss gf180mcu_fd_sc_mcu7t5v0__dffq_1
Xgf180mcu_fd_sc_mcu7t5v0__dffq_1_364 vdd gf180mcu_fd_sc_mcu7t5v0__and4_2_0/A1 gf180mcu_fd_sc_mcu7t5v0__dffq_4_15/CLK
+ vss gf180mcu_fd_sc_mcu7t5v0__dffq_1_364/D vdd vss gf180mcu_fd_sc_mcu7t5v0__dffq_1
Xgf180mcu_fd_sc_mcu7t5v0__oai22_1_10 gf180mcu_fd_sc_mcu7t5v0__or4_1_1/A3 gf180mcu_fd_sc_mcu7t5v0__and2_1_18/Z
+ gf180mcu_fd_sc_mcu7t5v0__nor3_4_3/ZN vdd vss gf180mcu_fd_sc_mcu7t5v0__oai22_1_10/ZN
+ gf180mcu_fd_sc_mcu7t5v0__inv_8_0/I vdd vss gf180mcu_fd_sc_mcu7t5v0__oai22_1
Xgf180mcu_fd_sc_mcu7t5v0__dffq_1_375 vdd gf180mcu_fd_sc_mcu7t5v0__dffq_1_375/Q gf180mcu_fd_sc_mcu7t5v0__dffq_4_21/CLK
+ vss gf180mcu_fd_sc_mcu7t5v0__and2_1_70/Z vdd vss gf180mcu_fd_sc_mcu7t5v0__dffq_1
Xgf180mcu_fd_sc_mcu7t5v0__oai22_1_21 gf180mcu_fd_sc_mcu7t5v0__oai22_1_28/A2 gf180mcu_fd_sc_mcu7t5v0__oai22_1_28/B1
+ gf180mcu_fd_sc_mcu7t5v0__oai22_1_21/B2 vdd vss gf180mcu_fd_sc_mcu7t5v0__dffq_1_25/D
+ gf180mcu_fd_sc_mcu7t5v0__aoi21_4_5/ZN vdd vss gf180mcu_fd_sc_mcu7t5v0__oai22_1
Xgf180mcu_fd_sc_mcu7t5v0__dffq_1_386 vdd gf180mcu_fd_sc_mcu7t5v0__and3_1_9/A3 gf180mcu_fd_sc_mcu7t5v0__dffq_2_58/CLK
+ vss gf180mcu_fd_sc_mcu7t5v0__dffq_1_386/D vdd vss gf180mcu_fd_sc_mcu7t5v0__dffq_1
Xgf180mcu_fd_sc_mcu7t5v0__oai22_1_32 gf180mcu_fd_sc_mcu7t5v0__nand2_4_4/ZN gf180mcu_fd_sc_mcu7t5v0__oai22_1_33/B1
+ gf180mcu_fd_sc_mcu7t5v0__oai22_1_32/B2 vdd vss gf180mcu_fd_sc_mcu7t5v0__dffq_1_48/D
+ gf180mcu_fd_sc_mcu7t5v0__aoi21_4_1/ZN vdd vss gf180mcu_fd_sc_mcu7t5v0__oai22_1
Xgf180mcu_fd_sc_mcu7t5v0__dffq_1_397 vdd gf180mcu_fd_sc_mcu7t5v0__dffq_1_397/Q gf180mcu_fd_sc_mcu7t5v0__dffq_4_21/CLK
+ vss gf180mcu_fd_sc_mcu7t5v0__dffq_1_397/D vdd vss gf180mcu_fd_sc_mcu7t5v0__dffq_1
Xgf180mcu_fd_sc_mcu7t5v0__oai22_1_43 gf180mcu_fd_sc_mcu7t5v0__oai22_1_43/A2 gf180mcu_fd_sc_mcu7t5v0__oai22_1_43/B1
+ gf180mcu_fd_sc_mcu7t5v0__oai22_1_43/B2 vdd vss gf180mcu_fd_sc_mcu7t5v0__dffq_1_45/D
+ gf180mcu_fd_sc_mcu7t5v0__oai22_1_88/A1 vdd vss gf180mcu_fd_sc_mcu7t5v0__oai22_1
Xgf180mcu_fd_sc_mcu7t5v0__oai22_1_54 gf180mcu_fd_sc_mcu7t5v0__nand2_4_6/ZN gf180mcu_fd_sc_mcu7t5v0__oai22_1_96/B1
+ gf180mcu_fd_sc_mcu7t5v0__oai22_1_54/B2 vdd vss gf180mcu_fd_sc_mcu7t5v0__dffq_1_60/D
+ gf180mcu_fd_sc_mcu7t5v0__oai22_1_98/A1 vdd vss gf180mcu_fd_sc_mcu7t5v0__oai22_1
Xgf180mcu_fd_sc_mcu7t5v0__oai22_1_65 gf180mcu_fd_sc_mcu7t5v0__nand2_4_9/ZN gf180mcu_fd_sc_mcu7t5v0__oai22_1_95/B1
+ gf180mcu_fd_sc_mcu7t5v0__oai22_1_65/B2 vdd vss gf180mcu_fd_sc_mcu7t5v0__dffq_1_98/D
+ gf180mcu_fd_sc_mcu7t5v0__aoi21_4_1/ZN vdd vss gf180mcu_fd_sc_mcu7t5v0__oai22_1
Xgf180mcu_fd_sc_mcu7t5v0__oai22_1_76 gf180mcu_fd_sc_mcu7t5v0__nand2_4_7/ZN gf180mcu_fd_sc_mcu7t5v0__oai22_1_94/B1
+ gf180mcu_fd_sc_mcu7t5v0__oai22_1_76/B2 vdd vss gf180mcu_fd_sc_mcu7t5v0__dffq_1_78/D
+ gf180mcu_fd_sc_mcu7t5v0__oai22_1_88/A1 vdd vss gf180mcu_fd_sc_mcu7t5v0__oai22_1
Xgf180mcu_fd_sc_mcu7t5v0__oai22_1_87 gf180mcu_fd_sc_mcu7t5v0__oai22_1_97/A2 gf180mcu_fd_sc_mcu7t5v0__oai22_1_97/B1
+ gf180mcu_fd_sc_mcu7t5v0__oai22_1_87/B2 vdd vss gf180mcu_fd_sc_mcu7t5v0__dffq_1_260/D
+ gf180mcu_fd_sc_mcu7t5v0__aoi21_4_2/ZN vdd vss gf180mcu_fd_sc_mcu7t5v0__oai22_1
Xgf180mcu_fd_sc_mcu7t5v0__oai22_1_98 gf180mcu_fd_sc_mcu7t5v0__oai22_1_99/A2 gf180mcu_fd_sc_mcu7t5v0__oai22_1_99/B1
+ gf180mcu_fd_sc_mcu7t5v0__oai22_1_98/B2 vdd vss gf180mcu_fd_sc_mcu7t5v0__dffq_1_111/D
+ gf180mcu_fd_sc_mcu7t5v0__oai22_1_98/A1 vdd vss gf180mcu_fd_sc_mcu7t5v0__oai22_1
Xgf180mcu_fd_sc_mcu7t5v0__nand2_2_19 vdd vss gf180mcu_fd_sc_mcu7t5v0__oai22_1_94/B1
+ rst_n gf180mcu_fd_sc_mcu7t5v0__nand2_4_7/ZN vdd vss gf180mcu_fd_sc_mcu7t5v0__nand2_2
Xgf180mcu_fd_sc_mcu7t5v0__clkinv_1_203 vdd vss gf180mcu_fd_sc_mcu7t5v0__dffq_1_141/Q
+ gf180mcu_fd_sc_mcu7t5v0__oai22_1_143/B2 vdd vss gf180mcu_fd_sc_mcu7t5v0__clkinv_1
Xgf180mcu_fd_sc_mcu7t5v0__clkinv_1_214 vdd vss gf180mcu_fd_sc_mcu7t5v0__dffq_1_196/Q
+ gf180mcu_fd_sc_mcu7t5v0__oai22_1_205/B2 vdd vss gf180mcu_fd_sc_mcu7t5v0__clkinv_1
Xgf180mcu_fd_sc_mcu7t5v0__clkinv_1_225 vdd vss gf180mcu_fd_sc_mcu7t5v0__dffq_1_221/Q
+ gf180mcu_fd_sc_mcu7t5v0__oai22_1_227/B2 vdd vss gf180mcu_fd_sc_mcu7t5v0__clkinv_1
Xgf180mcu_fd_sc_mcu7t5v0__clkinv_1_236 vdd vss gf180mcu_fd_sc_mcu7t5v0__dffq_1_209/Q
+ gf180mcu_fd_sc_mcu7t5v0__oai22_1_219/B2 vdd vss gf180mcu_fd_sc_mcu7t5v0__clkinv_1
Xgf180mcu_fd_sc_mcu7t5v0__clkinv_1_247 vdd vss gf180mcu_fd_sc_mcu7t5v0__dffq_1_215/Q
+ gf180mcu_fd_sc_mcu7t5v0__oai22_1_243/B2 vdd vss gf180mcu_fd_sc_mcu7t5v0__clkinv_1
Xgf180mcu_fd_sc_mcu7t5v0__clkinv_1_258 vdd vss gf180mcu_fd_sc_mcu7t5v0__dffq_1_228/Q
+ gf180mcu_fd_sc_mcu7t5v0__oai22_1_238/B2 vdd vss gf180mcu_fd_sc_mcu7t5v0__clkinv_1
Xgf180mcu_fd_sc_mcu7t5v0__clkinv_1_269 vdd vss gf180mcu_fd_sc_mcu7t5v0__dffq_1_252/Q
+ gf180mcu_fd_sc_mcu7t5v0__oai22_1_251/B2 vdd vss gf180mcu_fd_sc_mcu7t5v0__clkinv_1
Xgf180mcu_fd_sc_mcu7t5v0__aoi22_2_12 gf180mcu_fd_sc_mcu7t5v0__or3_1_24/A2 gf180mcu_fd_sc_mcu7t5v0__inv_1_23/ZN
+ vdd vss gf180mcu_fd_sc_mcu7t5v0__xor3_1_140/A3 gf180mcu_fd_sc_mcu7t5v0__dffq_2_87/Q
+ gf180mcu_fd_sc_mcu7t5v0__nor2_2_50/ZN vdd vss gf180mcu_fd_sc_mcu7t5v0__aoi22_2
Xgf180mcu_fd_sc_mcu7t5v0__dffq_2_106 gf180mcu_fd_sc_mcu7t5v0__dffq_2_106/D vdd vss
+ gf180mcu_fd_sc_mcu7t5v0__dffq_4_9/CLK gf180mcu_fd_sc_mcu7t5v0__nor3_4_18/A2 vdd
+ vss gf180mcu_fd_sc_mcu7t5v0__dffq_2
Xgf180mcu_fd_sc_mcu7t5v0__aoi22_2_2 gf180mcu_fd_sc_mcu7t5v0__nor2_2_5/ZN gf180mcu_fd_sc_mcu7t5v0__dffq_2_14/Q
+ vdd vss gf180mcu_fd_sc_mcu7t5v0__oai31_4_0/B gf180mcu_fd_sc_mcu7t5v0__mux4_4_1/I3
+ gf180mcu_fd_sc_mcu7t5v0__and2_1_15/Z vdd vss gf180mcu_fd_sc_mcu7t5v0__aoi22_2
Xgf180mcu_fd_sc_mcu7t5v0__oai22_1_230 gf180mcu_fd_sc_mcu7t5v0__nand2_4_29/ZN gf180mcu_fd_sc_mcu7t5v0__nand2_2_39/ZN
+ gf180mcu_fd_sc_mcu7t5v0__oai22_1_230/B2 vdd vss gf180mcu_fd_sc_mcu7t5v0__dffq_1_233/D
+ gf180mcu_fd_sc_mcu7t5v0__oai22_1_98/A1 vdd vss gf180mcu_fd_sc_mcu7t5v0__oai22_1
Xgf180mcu_fd_sc_mcu7t5v0__oai22_1_241 gf180mcu_fd_sc_mcu7t5v0__nand2_4_27/ZN gf180mcu_fd_sc_mcu7t5v0__nand2_2_43/ZN
+ gf180mcu_fd_sc_mcu7t5v0__oai22_1_241/B2 vdd vss gf180mcu_fd_sc_mcu7t5v0__dffq_1_223/D
+ gf180mcu_fd_sc_mcu7t5v0__aoi21_4_5/ZN vdd vss gf180mcu_fd_sc_mcu7t5v0__oai22_1
Xgf180mcu_fd_sc_mcu7t5v0__oai22_1_252 gf180mcu_fd_sc_mcu7t5v0__nand2_4_28/ZN gf180mcu_fd_sc_mcu7t5v0__nand2_2_44/ZN
+ gf180mcu_fd_sc_mcu7t5v0__oai22_1_252/B2 vdd vss gf180mcu_fd_sc_mcu7t5v0__dffq_1_253/D
+ gf180mcu_fd_sc_mcu7t5v0__aoi21_4_1/ZN vdd vss gf180mcu_fd_sc_mcu7t5v0__oai22_1
Xgf180mcu_fd_sc_mcu7t5v0__oai22_1_263 gf180mcu_fd_sc_mcu7t5v0__nand2_4_17/ZN gf180mcu_fd_sc_mcu7t5v0__nand2_2_23/ZN
+ gf180mcu_fd_sc_mcu7t5v0__oai22_1_263/B2 vdd vss gf180mcu_fd_sc_mcu7t5v0__dffq_1_136/D
+ gf180mcu_fd_sc_mcu7t5v0__oai22_1_88/A1 vdd vss gf180mcu_fd_sc_mcu7t5v0__oai22_1
Xgf180mcu_fd_sc_mcu7t5v0__oai22_1_274 gf180mcu_fd_sc_mcu7t5v0__mux4_4_13/Z gf180mcu_fd_sc_mcu7t5v0__and2_1_123/Z
+ gf180mcu_fd_sc_mcu7t5v0__nor2_2_46/ZN vdd vss gf180mcu_fd_sc_mcu7t5v0__oai22_1_274/ZN
+ gf180mcu_fd_sc_mcu7t5v0__inv_8_0/I vdd vss gf180mcu_fd_sc_mcu7t5v0__oai22_1
Xgf180mcu_fd_sc_mcu7t5v0__oai22_1_285 gf180mcu_fd_sc_mcu7t5v0__xor3_1_170/A1 gf180mcu_fd_sc_mcu7t5v0__and2_1_42/Z
+ gf180mcu_fd_sc_mcu7t5v0__xor3_1_171/A3 vdd vss gf180mcu_fd_sc_mcu7t5v0__xor3_1_168/A1
+ gf180mcu_fd_sc_mcu7t5v0__xnor3_1_18/A3 vdd vss gf180mcu_fd_sc_mcu7t5v0__oai22_1
Xgf180mcu_fd_sc_mcu7t5v0__dffq_1_150 vdd gf180mcu_fd_sc_mcu7t5v0__dffq_1_150/Q gf180mcu_fd_sc_mcu7t5v0__dffq_2_26/CLK
+ vss gf180mcu_fd_sc_mcu7t5v0__dffq_1_150/D vdd vss gf180mcu_fd_sc_mcu7t5v0__dffq_1
Xgf180mcu_fd_sc_mcu7t5v0__dffq_1_161 vdd gf180mcu_fd_sc_mcu7t5v0__dffq_1_161/Q gf180mcu_fd_sc_mcu7t5v0__dffq_2_26/CLK
+ vss gf180mcu_fd_sc_mcu7t5v0__dffq_1_161/D vdd vss gf180mcu_fd_sc_mcu7t5v0__dffq_1
Xgf180mcu_fd_sc_mcu7t5v0__nor2_1_350 vdd vss gf180mcu_fd_sc_mcu7t5v0__nor2_1_350/ZN
+ gf180mcu_fd_sc_mcu7t5v0__inv_8_0/ZN gf180mcu_fd_sc_mcu7t5v0__nor2_2_49/A2 vdd vss
+ gf180mcu_fd_sc_mcu7t5v0__nor2_1
Xgf180mcu_fd_sc_mcu7t5v0__dffq_1_172 vdd gf180mcu_fd_sc_mcu7t5v0__dffq_1_172/Q gf180mcu_fd_sc_mcu7t5v0__dffq_2_26/CLK
+ vss gf180mcu_fd_sc_mcu7t5v0__dffq_1_172/D vdd vss gf180mcu_fd_sc_mcu7t5v0__dffq_1
Xgf180mcu_fd_sc_mcu7t5v0__nor2_1_361 vdd vss gf180mcu_fd_sc_mcu7t5v0__xor3_1_123/A2
+ gf180mcu_fd_sc_mcu7t5v0__inv_4_6/ZN gf180mcu_fd_sc_mcu7t5v0__or3_1_24/A2 vdd vss
+ gf180mcu_fd_sc_mcu7t5v0__nor2_1
Xgf180mcu_fd_sc_mcu7t5v0__clkinv_3_4 vdd gf180mcu_fd_sc_mcu7t5v0__nor3_4_4/A1 gf180mcu_fd_sc_mcu7t5v0__nor3_4_3/A1
+ vss vdd vss gf180mcu_fd_sc_mcu7t5v0__clkinv_3
Xgf180mcu_fd_sc_mcu7t5v0__dffq_1_183 vdd gf180mcu_fd_sc_mcu7t5v0__dffq_1_183/Q gf180mcu_fd_sc_mcu7t5v0__dffq_1_96/CLK
+ vss gf180mcu_fd_sc_mcu7t5v0__dffq_1_183/D vdd vss gf180mcu_fd_sc_mcu7t5v0__dffq_1
Xgf180mcu_fd_sc_mcu7t5v0__xor3_2_1 gf180mcu_fd_sc_mcu7t5v0__xor3_2_1/A3 vdd vss gf180mcu_fd_sc_mcu7t5v0__xor3_2_1/Z
+ gf180mcu_fd_sc_mcu7t5v0__xor3_2_1/A1 gf180mcu_fd_sc_mcu7t5v0__xor3_2_1/A2 vdd vss
+ gf180mcu_fd_sc_mcu7t5v0__xor3_2
Xgf180mcu_fd_sc_mcu7t5v0__dffq_1_194 vdd gf180mcu_fd_sc_mcu7t5v0__dffq_1_194/Q gf180mcu_fd_sc_mcu7t5v0__dffq_4_8/CLK
+ vss gf180mcu_fd_sc_mcu7t5v0__dffq_1_194/D vdd vss gf180mcu_fd_sc_mcu7t5v0__dffq_1
Xgf180mcu_fd_sc_mcu7t5v0__nor2_1_372 vdd vss gf180mcu_fd_sc_mcu7t5v0__or3_1_23/A1
+ gf180mcu_fd_sc_mcu7t5v0__inv_8_0/ZN gf180mcu_fd_sc_mcu7t5v0__xor2_1_182/Z vdd vss
+ gf180mcu_fd_sc_mcu7t5v0__nor2_1
Xgf180mcu_fd_sc_mcu7t5v0__nor2_1_383 vdd vss gf180mcu_fd_sc_mcu7t5v0__nor2_1_383/ZN
+ gf180mcu_fd_sc_mcu7t5v0__xor3_1_142/A1 gf180mcu_fd_sc_mcu7t5v0__xor2_1_208/Z vdd
+ vss gf180mcu_fd_sc_mcu7t5v0__nor2_1
Xgf180mcu_fd_sc_mcu7t5v0__nand3_1_9 gf180mcu_fd_sc_mcu7t5v0__xnor2_1_5/ZN vdd vss
+ gf180mcu_fd_sc_mcu7t5v0__nand3_1_9/ZN gf180mcu_fd_sc_mcu7t5v0__nand3_1_9/A1 gf180mcu_fd_sc_mcu7t5v0__nand3_1_9/A2
+ vdd vss gf180mcu_fd_sc_mcu7t5v0__nand3_1
Xgf180mcu_fd_sc_mcu7t5v0__nor2_1_394 vdd vss gf180mcu_fd_sc_mcu7t5v0__nor2_1_394/ZN
+ gf180mcu_fd_sc_mcu7t5v0__inv_8_2/I gf180mcu_fd_sc_mcu7t5v0__xnor2_1_66/A1 vdd vss
+ gf180mcu_fd_sc_mcu7t5v0__nor2_1
Xgf180mcu_fd_sc_mcu7t5v0__clkbuf_16_0 vdd vss gf180mcu_fd_sc_mcu7t5v0__dffq_4_6/CLK
+ gf180mcu_fd_sc_mcu7t5v0__clkbuf_16_8/I vdd vss gf180mcu_fd_sc_mcu7t5v0__clkbuf_16
Xgf180mcu_fd_sc_mcu7t5v0__clkinv_2_15 vdd vss gf180mcu_fd_sc_mcu7t5v0__dffq_2_91/Q
+ gf180mcu_fd_sc_mcu7t5v0__xor3_1_151/A1 vdd vss gf180mcu_fd_sc_mcu7t5v0__clkinv_2
Xgf180mcu_fd_sc_mcu7t5v0__or3_2_1 gf180mcu_fd_sc_mcu7t5v0__inv_2_0/I vdd vss gf180mcu_fd_sc_mcu7t5v0__or3_2_1/Z
+ gf180mcu_fd_sc_mcu7t5v0__or3_2_1/A1 gf180mcu_fd_sc_mcu7t5v0__or3_2_2/A2 vdd vss
+ gf180mcu_fd_sc_mcu7t5v0__or3_2
Xgf180mcu_fd_sc_mcu7t5v0__inv_2_5 vss gf180mcu_fd_sc_mcu7t5v0__inv_2_5/ZN gf180mcu_fd_sc_mcu7t5v0__inv_2_5/I
+ vdd vdd vss gf180mcu_fd_sc_mcu7t5v0__inv_2
Xgf180mcu_fd_sc_mcu7t5v0__dffq_1_2 vdd gf180mcu_fd_sc_mcu7t5v0__dffq_1_2/Q gf180mcu_fd_sc_mcu7t5v0__dffq_4_6/CLK
+ vss gf180mcu_fd_sc_mcu7t5v0__dffq_1_2/D vdd vss gf180mcu_fd_sc_mcu7t5v0__dffq_1
Xgf180mcu_fd_sc_mcu7t5v0__clkinv_1_1 vdd vss gf180mcu_fd_sc_mcu7t5v0__xor3_2_0/A2
+ gf180mcu_fd_sc_mcu7t5v0__nor3_2_0/A1 vdd vss gf180mcu_fd_sc_mcu7t5v0__clkinv_1
Xgf180mcu_fd_sc_mcu7t5v0__nor2_1_180 vdd vss gf180mcu_fd_sc_mcu7t5v0__xor2_1_91/A2
+ gf180mcu_fd_sc_mcu7t5v0__nand4_1_6/A2 gf180mcu_fd_sc_mcu7t5v0__xor2_1_92/A2 vdd
+ vss gf180mcu_fd_sc_mcu7t5v0__nor2_1
Xgf180mcu_fd_sc_mcu7t5v0__aoi22_1_106 gf180mcu_fd_sc_mcu7t5v0__nor2_4_9/ZN gf180mcu_fd_sc_mcu7t5v0__dffq_1_196/Q
+ vdd vss gf180mcu_fd_sc_mcu7t5v0__nand2_1_266/A1 gf180mcu_fd_sc_mcu7t5v0__dffq_1_195/Q
+ gf180mcu_fd_sc_mcu7t5v0__nor2_4_8/ZN vdd vss gf180mcu_fd_sc_mcu7t5v0__aoi22_1
Xgf180mcu_fd_sc_mcu7t5v0__nor2_1_191 vdd vss gf180mcu_fd_sc_mcu7t5v0__nor3_1_14/A2
+ gf180mcu_fd_sc_mcu7t5v0__nor4_1_2/A1 gf180mcu_fd_sc_mcu7t5v0__and2_1_61/Z vdd vss
+ gf180mcu_fd_sc_mcu7t5v0__nor2_1
Xgf180mcu_fd_sc_mcu7t5v0__xor3_1_170 gf180mcu_fd_sc_mcu7t5v0__xor2_1_27/Z vdd vss
+ gf180mcu_fd_sc_mcu7t5v0__xor3_1_170/Z gf180mcu_fd_sc_mcu7t5v0__xor3_1_170/A1 gf180mcu_fd_sc_mcu7t5v0__xor3_1_170/A2
+ vdd vss gf180mcu_fd_sc_mcu7t5v0__xor3_1
Xgf180mcu_fd_sc_mcu7t5v0__aoi22_1_117 gf180mcu_fd_sc_mcu7t5v0__nor2_4_11/ZN gf180mcu_fd_sc_mcu7t5v0__dffq_1_209/Q
+ vdd vss gf180mcu_fd_sc_mcu7t5v0__nand2_1_267/A2 gf180mcu_fd_sc_mcu7t5v0__dffq_1_210/Q
+ gf180mcu_fd_sc_mcu7t5v0__nor2_4_10/ZN vdd vss gf180mcu_fd_sc_mcu7t5v0__aoi22_1
Xgf180mcu_fd_sc_mcu7t5v0__aoi22_1_128 gf180mcu_fd_sc_mcu7t5v0__nor2_4_9/ZN gf180mcu_fd_sc_mcu7t5v0__dffq_1_224/Q
+ vdd vss gf180mcu_fd_sc_mcu7t5v0__nand2_1_274/A1 gf180mcu_fd_sc_mcu7t5v0__dffq_1_250/Q
+ gf180mcu_fd_sc_mcu7t5v0__nor2_4_8/ZN vdd vss gf180mcu_fd_sc_mcu7t5v0__aoi22_1
Xgf180mcu_fd_sc_mcu7t5v0__aoi22_1_139 gf180mcu_fd_sc_mcu7t5v0__nor2_4_9/ZN gf180mcu_fd_sc_mcu7t5v0__dffq_1_256/Q
+ vdd vss gf180mcu_fd_sc_mcu7t5v0__nand2_1_264/A1 gf180mcu_fd_sc_mcu7t5v0__dffq_1_49/Q
+ gf180mcu_fd_sc_mcu7t5v0__nor2_4_8/ZN vdd vss gf180mcu_fd_sc_mcu7t5v0__aoi22_1
Xgf180mcu_fd_sc_mcu7t5v0__oai211_1_30 gf180mcu_fd_sc_mcu7t5v0__oai211_1_30/B gf180mcu_fd_sc_mcu7t5v0__oai211_1_30/C
+ vdd vss gf180mcu_fd_sc_mcu7t5v0__oai211_1_29/B gf180mcu_fd_sc_mcu7t5v0__and2_2_12/Z
+ gf180mcu_fd_sc_mcu7t5v0__nor2_1_265/ZN vdd vss gf180mcu_fd_sc_mcu7t5v0__oai211_1
Xgf180mcu_fd_sc_mcu7t5v0__oai211_1_41 gf180mcu_fd_sc_mcu7t5v0__oai211_1_41/B gf180mcu_fd_sc_mcu7t5v0__or2_1_34/A2
+ vdd vss gf180mcu_fd_sc_mcu7t5v0__oai211_1_41/ZN gf180mcu_fd_sc_mcu7t5v0__oai211_1_43/C
+ gf180mcu_fd_sc_mcu7t5v0__xor3_1_113/Z vdd vss gf180mcu_fd_sc_mcu7t5v0__oai211_1
Xgf180mcu_fd_sc_mcu7t5v0__oai211_1_52 gf180mcu_fd_sc_mcu7t5v0__or2_1_34/A2 gf180mcu_fd_sc_mcu7t5v0__oai211_1_52/C
+ vdd vss gf180mcu_fd_sc_mcu7t5v0__oai211_1_50/C gf180mcu_fd_sc_mcu7t5v0__and2_1_140/Z
+ gf180mcu_fd_sc_mcu7t5v0__oai21_1_323/ZN vdd vss gf180mcu_fd_sc_mcu7t5v0__oai211_1
Xgf180mcu_fd_sc_mcu7t5v0__inv_12_1 vss gf180mcu_fd_sc_mcu7t5v0__nor3_2_5/A1 gf180mcu_fd_sc_mcu7t5v0__inv_12_1/I
+ vdd vdd vss gf180mcu_fd_sc_mcu7t5v0__inv_12
Xgf180mcu_fd_sc_mcu7t5v0__oai21_1_240 vdd gf180mcu_fd_sc_mcu7t5v0__buf_12_0/Z gf180mcu_fd_sc_mcu7t5v0__buf_20_0/Z
+ gf180mcu_fd_sc_mcu7t5v0__aoi21_1_232/B gf180mcu_fd_sc_mcu7t5v0__dffq_1_419/Q vss
+ vdd vss gf180mcu_fd_sc_mcu7t5v0__oai21_1
Xgf180mcu_fd_sc_mcu7t5v0__oai21_1_251 vdd gf180mcu_fd_sc_mcu7t5v0__buf_12_0/Z gf180mcu_fd_sc_mcu7t5v0__buf_20_0/Z
+ gf180mcu_fd_sc_mcu7t5v0__aoi21_1_279/B gf180mcu_fd_sc_mcu7t5v0__dffq_2_41/Q vss
+ vdd vss gf180mcu_fd_sc_mcu7t5v0__oai21_1
Xgf180mcu_fd_sc_mcu7t5v0__oai21_1_262 vdd gf180mcu_fd_sc_mcu7t5v0__buf_8_4/Z gf180mcu_fd_sc_mcu7t5v0__buf_20_0/I
+ gf180mcu_fd_sc_mcu7t5v0__aoi21_1_294/B gf180mcu_fd_sc_mcu7t5v0__dffq_1_427/Q vss
+ vdd vss gf180mcu_fd_sc_mcu7t5v0__oai21_1
Xgf180mcu_fd_sc_mcu7t5v0__oai21_1_273 vdd gf180mcu_fd_sc_mcu7t5v0__buf_12_0/Z gf180mcu_fd_sc_mcu7t5v0__buf_20_0/Z
+ gf180mcu_fd_sc_mcu7t5v0__aoi21_1_256/B gf180mcu_fd_sc_mcu7t5v0__dffq_1_436/Q vss
+ vdd vss gf180mcu_fd_sc_mcu7t5v0__oai21_1
Xgf180mcu_fd_sc_mcu7t5v0__oai21_1_284 vdd gf180mcu_fd_sc_mcu7t5v0__oai21_1_284/B gf180mcu_fd_sc_mcu7t5v0__mux4_4_14/Z
+ gf180mcu_fd_sc_mcu7t5v0__nand4_1_20/A4 gf180mcu_fd_sc_mcu7t5v0__inv_8_2/I vss vdd
+ vss gf180mcu_fd_sc_mcu7t5v0__oai21_1
Xgf180mcu_fd_sc_mcu7t5v0__oai21_1_295 vdd gf180mcu_fd_sc_mcu7t5v0__or3_1_22/A3 gf180mcu_fd_sc_mcu7t5v0__or3_1_22/A2
+ gf180mcu_fd_sc_mcu7t5v0__and3_1_21/A2 gf180mcu_fd_sc_mcu7t5v0__or3_1_22/A1 vss vdd
+ vss gf180mcu_fd_sc_mcu7t5v0__oai21_1
Xgf180mcu_fd_sc_mcu7t5v0__aoi21_1_308 gf180mcu_fd_sc_mcu7t5v0__aoi21_1_308/B vdd vss
+ gf180mcu_fd_sc_mcu7t5v0__dffq_4_35/D gf180mcu_fd_sc_mcu7t5v0__oai31_4_5/A2 gf180mcu_fd_sc_mcu7t5v0__buf_20_0/I
+ vdd vss gf180mcu_fd_sc_mcu7t5v0__aoi21_1
Xgf180mcu_fd_sc_mcu7t5v0__aoi21_1_319 gf180mcu_fd_sc_mcu7t5v0__xor3_1_131/Z vdd vss
+ gf180mcu_fd_sc_mcu7t5v0__nor3_1_35/A3 gf180mcu_fd_sc_mcu7t5v0__aoi21_1_319/A1 gf180mcu_fd_sc_mcu7t5v0__xor2_1_159/Z
+ vdd vss gf180mcu_fd_sc_mcu7t5v0__aoi21_1
Xgf180mcu_fd_sc_mcu7t5v0__xor3_1_18 gf180mcu_fd_sc_mcu7t5v0__xor3_1_18/A3 vdd vss
+ gf180mcu_fd_sc_mcu7t5v0__xor3_1_18/Z gf180mcu_fd_sc_mcu7t5v0__nor3_1_6/ZN gf180mcu_fd_sc_mcu7t5v0__xor3_1_18/A2
+ vdd vss gf180mcu_fd_sc_mcu7t5v0__xor3_1
Xgf180mcu_fd_sc_mcu7t5v0__xor3_1_29 gf180mcu_fd_sc_mcu7t5v0__xor3_1_36/Z vdd vss gf180mcu_fd_sc_mcu7t5v0__xor3_1_29/Z
+ gf180mcu_fd_sc_mcu7t5v0__xor3_1_29/A1 gf180mcu_fd_sc_mcu7t5v0__xor3_1_29/A2 vdd
+ vss gf180mcu_fd_sc_mcu7t5v0__xor3_1
Xgf180mcu_fd_sc_mcu7t5v0__aoi222_1_8 vss vdd gf180mcu_fd_sc_mcu7t5v0__dffq_1_366/Q
+ gf180mcu_fd_sc_mcu7t5v0__and2_1_47/Z gf180mcu_fd_sc_mcu7t5v0__dffq_1_333/Q gf180mcu_fd_sc_mcu7t5v0__and3_2_2/A2
+ gf180mcu_fd_sc_mcu7t5v0__nor2_4_23/ZN gf180mcu_fd_sc_mcu7t5v0__dffq_1_381/Q gf180mcu_fd_sc_mcu7t5v0__inv_1_10/I
+ vdd vss gf180mcu_fd_sc_mcu7t5v0__aoi222_1
Xgf180mcu_fd_sc_mcu7t5v0__nand2_1_608 vdd vss gf180mcu_fd_sc_mcu7t5v0__oai21_1_299/B
+ gf180mcu_fd_sc_mcu7t5v0__and4_1_2/Z gf180mcu_fd_sc_mcu7t5v0__xor3_1_178/Z vdd vss
+ gf180mcu_fd_sc_mcu7t5v0__nand2_1
Xgf180mcu_fd_sc_mcu7t5v0__nand2_1_619 vdd vss gf180mcu_fd_sc_mcu7t5v0__xor3_1_132/A1
+ gf180mcu_fd_sc_mcu7t5v0__dffq_4_37/Q gf180mcu_fd_sc_mcu7t5v0__inv_1_23/I vdd vss
+ gf180mcu_fd_sc_mcu7t5v0__nand2_1
Xgf180mcu_fd_sc_mcu7t5v0__nand4_2_4 gf180mcu_fd_sc_mcu7t5v0__inv_1_5/ZN gf180mcu_fd_sc_mcu7t5v0__nand4_2_4/A4
+ vdd vss gf180mcu_fd_sc_mcu7t5v0__oai31_1_1/A2 gf180mcu_fd_sc_mcu7t5v0__nor2_4_45/A2
+ gf180mcu_fd_sc_mcu7t5v0__or3_1_9/A2 vdd vss gf180mcu_fd_sc_mcu7t5v0__nand4_2
Xgf180mcu_fd_sc_mcu7t5v0__nand4_1_18 gf180mcu_fd_sc_mcu7t5v0__nand4_1_18/A3 gf180mcu_fd_sc_mcu7t5v0__nand4_1_18/A4
+ vdd vss gf180mcu_fd_sc_mcu7t5v0__oai211_1_44/B gf180mcu_fd_sc_mcu7t5v0__oai211_1_43/C
+ gf180mcu_fd_sc_mcu7t5v0__nand4_1_18/A2 vdd vss gf180mcu_fd_sc_mcu7t5v0__nand4_1
Xgf180mcu_fd_sc_mcu7t5v0__aoi21_4_13 gf180mcu_fd_sc_mcu7t5v0__or3_4_0/Z gf180mcu_fd_sc_mcu7t5v0__aoi21_4_13/B
+ vdd vss gf180mcu_fd_sc_mcu7t5v0__oai22_1_88/A1 gf180mcu_fd_sc_mcu7t5v0__or3_2_3/A3
+ vdd vss gf180mcu_fd_sc_mcu7t5v0__aoi21_4
Xgf180mcu_fd_sc_mcu7t5v0__inv_1_19 vss gf180mcu_fd_sc_mcu7t5v0__inv_1_19/ZN gf180mcu_fd_sc_mcu7t5v0__inv_1_19/I
+ vdd vdd vss gf180mcu_fd_sc_mcu7t5v0__inv_1
Xgf180mcu_fd_sc_mcu7t5v0__xor2_1_40 vdd vss gf180mcu_fd_sc_mcu7t5v0__xor2_1_40/Z gf180mcu_fd_sc_mcu7t5v0__xor2_1_40/A1
+ gf180mcu_fd_sc_mcu7t5v0__xor3_1_43/Z vdd vss gf180mcu_fd_sc_mcu7t5v0__xor2_1
Xgf180mcu_fd_sc_mcu7t5v0__xor2_1_51 vdd vss gf180mcu_fd_sc_mcu7t5v0__xor2_1_51/Z gf180mcu_fd_sc_mcu7t5v0__or4_1_0/A1
+ gf180mcu_fd_sc_mcu7t5v0__xor2_1_52/Z vdd vss gf180mcu_fd_sc_mcu7t5v0__xor2_1
Xgf180mcu_fd_sc_mcu7t5v0__xor2_1_62 vdd vss gf180mcu_fd_sc_mcu7t5v0__xor2_1_62/Z gf180mcu_fd_sc_mcu7t5v0__xor2_1_63/Z
+ gf180mcu_fd_sc_mcu7t5v0__xor2_1_62/A2 vdd vss gf180mcu_fd_sc_mcu7t5v0__xor2_1
Xgf180mcu_fd_sc_mcu7t5v0__xor2_1_73 vdd vss gf180mcu_fd_sc_mcu7t5v0__xor2_1_73/Z gf180mcu_fd_sc_mcu7t5v0__inv_8_1/I
+ gf180mcu_fd_sc_mcu7t5v0__xor2_1_74/Z vdd vss gf180mcu_fd_sc_mcu7t5v0__xor2_1
Xgf180mcu_fd_sc_mcu7t5v0__xor2_1_84 vdd vss gf180mcu_fd_sc_mcu7t5v0__xor2_1_84/Z gf180mcu_fd_sc_mcu7t5v0__or2_1_18/A1
+ gf180mcu_fd_sc_mcu7t5v0__xor2_1_86/Z vdd vss gf180mcu_fd_sc_mcu7t5v0__xor2_1
Xgf180mcu_fd_sc_mcu7t5v0__xor2_1_95 vdd vss gf180mcu_fd_sc_mcu7t5v0__xor2_1_95/Z gf180mcu_fd_sc_mcu7t5v0__or4_1_2/A3
+ gf180mcu_fd_sc_mcu7t5v0__xor2_1_95/A2 vdd vss gf180mcu_fd_sc_mcu7t5v0__xor2_1
Xgf180mcu_fd_sc_mcu7t5v0__aoi21_1_105 gf180mcu_fd_sc_mcu7t5v0__oai21_1_92/ZN vdd vss
+ gf180mcu_fd_sc_mcu7t5v0__dffq_4_10/D gf180mcu_fd_sc_mcu7t5v0__aoi21_1_105/A1 gf180mcu_fd_sc_mcu7t5v0__buf_20_0/Z
+ vdd vss gf180mcu_fd_sc_mcu7t5v0__aoi21_1
Xgf180mcu_fd_sc_mcu7t5v0__aoi21_1_116 gf180mcu_fd_sc_mcu7t5v0__oai21_1_97/ZN vdd vss
+ gf180mcu_fd_sc_mcu7t5v0__dffq_1_289/D gf180mcu_fd_sc_mcu7t5v0__nor3_4_14/ZN gf180mcu_fd_sc_mcu7t5v0__aoi22_4_5/ZN
+ vdd vss gf180mcu_fd_sc_mcu7t5v0__aoi21_1
Xgf180mcu_fd_sc_mcu7t5v0__aoi21_1_127 gf180mcu_fd_sc_mcu7t5v0__aoi21_1_127/B vdd vss
+ gf180mcu_fd_sc_mcu7t5v0__dffq_1_299/D gf180mcu_fd_sc_mcu7t5v0__aoi22_2_6/ZN gf180mcu_fd_sc_mcu7t5v0__nor2_4_31/ZN
+ vdd vss gf180mcu_fd_sc_mcu7t5v0__aoi21_1
Xgf180mcu_fd_sc_mcu7t5v0__xor2_1_180 vdd vss gf180mcu_fd_sc_mcu7t5v0__xor2_1_180/Z
+ gf180mcu_fd_sc_mcu7t5v0__inv_8_2/ZN gf180mcu_fd_sc_mcu7t5v0__xor2_1_181/Z vdd vss
+ gf180mcu_fd_sc_mcu7t5v0__xor2_1
Xgf180mcu_fd_sc_mcu7t5v0__aoi21_1_138 gf180mcu_fd_sc_mcu7t5v0__or2_1_23/A1 vdd vss
+ gf180mcu_fd_sc_mcu7t5v0__dffq_4_13/D gf180mcu_fd_sc_mcu7t5v0__or2_4_4/A2 gf180mcu_fd_sc_mcu7t5v0__buf_20_0/I
+ vdd vss gf180mcu_fd_sc_mcu7t5v0__aoi21_1
Xgf180mcu_fd_sc_mcu7t5v0__xor2_1_191 vdd vss gf180mcu_fd_sc_mcu7t5v0__xor2_1_191/Z
+ gf180mcu_fd_sc_mcu7t5v0__or3_1_24/A1 gf180mcu_fd_sc_mcu7t5v0__xor2_1_192/Z vdd vss
+ gf180mcu_fd_sc_mcu7t5v0__xor2_1
Xgf180mcu_fd_sc_mcu7t5v0__and2_1_105 vdd vss gf180mcu_fd_sc_mcu7t5v0__and2_1_105/Z
+ gf180mcu_fd_sc_mcu7t5v0__inv_1_3/I gf180mcu_fd_sc_mcu7t5v0__and2_1_104/Z vdd vss
+ gf180mcu_fd_sc_mcu7t5v0__and2_1
Xgf180mcu_fd_sc_mcu7t5v0__aoi21_1_149 gf180mcu_fd_sc_mcu7t5v0__aoi21_1_149/B vdd vss
+ gf180mcu_fd_sc_mcu7t5v0__dffq_1_332/D gf180mcu_fd_sc_mcu7t5v0__aoi21_1_149/A1 gf180mcu_fd_sc_mcu7t5v0__nand3_1_55/A2
+ vdd vss gf180mcu_fd_sc_mcu7t5v0__aoi21_1
Xgf180mcu_fd_sc_mcu7t5v0__and2_1_116 vdd vss gf180mcu_fd_sc_mcu7t5v0__and2_1_116/Z
+ gf180mcu_fd_sc_mcu7t5v0__or2_1_41/A1 gf180mcu_fd_sc_mcu7t5v0__xor2_1_84/Z vdd vss
+ gf180mcu_fd_sc_mcu7t5v0__and2_1
Xgf180mcu_fd_sc_mcu7t5v0__and2_1_127 vdd vss gf180mcu_fd_sc_mcu7t5v0__and2_1_127/Z
+ gf180mcu_fd_sc_mcu7t5v0__inv_8_1/I gf180mcu_fd_sc_mcu7t5v0__mux4_4_16/Z vdd vss
+ gf180mcu_fd_sc_mcu7t5v0__and2_1
Xgf180mcu_fd_sc_mcu7t5v0__and2_1_138 vdd vss gf180mcu_fd_sc_mcu7t5v0__and2_1_138/Z
+ gf180mcu_fd_sc_mcu7t5v0__or2_1_39/A1 gf180mcu_fd_sc_mcu7t5v0__xor2_1_194/Z vdd vss
+ gf180mcu_fd_sc_mcu7t5v0__and2_1
Xgf180mcu_fd_sc_mcu7t5v0__and2_1_149 vdd vss gf180mcu_fd_sc_mcu7t5v0__and2_1_149/Z
+ gf180mcu_fd_sc_mcu7t5v0__xnor3_1_45/A1 gf180mcu_fd_sc_mcu7t5v0__xnor3_1_45/A3 vdd
+ vss gf180mcu_fd_sc_mcu7t5v0__and2_1
Xgf180mcu_fd_sc_mcu7t5v0__nand3_1_40 gf180mcu_fd_sc_mcu7t5v0__xor2_1_69/Z vdd vss
+ gf180mcu_fd_sc_mcu7t5v0__nand3_1_40/ZN gf180mcu_fd_sc_mcu7t5v0__nand3_1_40/A1 gf180mcu_fd_sc_mcu7t5v0__oai21_1_80/ZN
+ vdd vss gf180mcu_fd_sc_mcu7t5v0__nand3_1
Xgf180mcu_fd_sc_mcu7t5v0__nand3_1_51 gf180mcu_fd_sc_mcu7t5v0__dffq_2_40/Q vdd vss
+ gf180mcu_fd_sc_mcu7t5v0__oai221_1_7/A1 gf180mcu_fd_sc_mcu7t5v0__dffq_2_42/Q gf180mcu_fd_sc_mcu7t5v0__inv_1_7/ZN
+ vdd vss gf180mcu_fd_sc_mcu7t5v0__nand3_1
Xgf180mcu_fd_sc_mcu7t5v0__nand3_1_62 gf180mcu_fd_sc_mcu7t5v0__nand3_1_62/A3 vdd vss
+ gf180mcu_fd_sc_mcu7t5v0__oai21_1_177/B gf180mcu_fd_sc_mcu7t5v0__inv_8_1/I gf180mcu_fd_sc_mcu7t5v0__or3_1_12/Z
+ vdd vss gf180mcu_fd_sc_mcu7t5v0__nand3_1
Xgf180mcu_fd_sc_mcu7t5v0__nand3_1_73 gf180mcu_fd_sc_mcu7t5v0__or2_1_36/A2 vdd vss
+ gf180mcu_fd_sc_mcu7t5v0__nand3_1_73/ZN gf180mcu_fd_sc_mcu7t5v0__dffq_2_21/Q gf180mcu_fd_sc_mcu7t5v0__inv_4_4/ZN
+ vdd vss gf180mcu_fd_sc_mcu7t5v0__nand3_1
Xgf180mcu_fd_sc_mcu7t5v0__nand3_1_84 gf180mcu_fd_sc_mcu7t5v0__inv_4_5/I vdd vss gf180mcu_fd_sc_mcu7t5v0__nand3_1_84/ZN
+ gf180mcu_fd_sc_mcu7t5v0__mux4_4_2/I3 gf180mcu_fd_sc_mcu7t5v0__or2_2_1/A1 vdd vss
+ gf180mcu_fd_sc_mcu7t5v0__nand3_1
Xgf180mcu_fd_sc_mcu7t5v0__nand3_1_95 gf180mcu_fd_sc_mcu7t5v0__xor2_1_191/Z vdd vss
+ gf180mcu_fd_sc_mcu7t5v0__nand3_1_95/ZN gf180mcu_fd_sc_mcu7t5v0__nand3_1_95/A1 gf180mcu_fd_sc_mcu7t5v0__nand3_1_95/A2
+ vdd vss gf180mcu_fd_sc_mcu7t5v0__nand3_1
Xgf180mcu_fd_sc_mcu7t5v0__aoi21_1_8 gf180mcu_fd_sc_mcu7t5v0__aoi21_1_8/B vdd vss gf180mcu_fd_sc_mcu7t5v0__xor3_1_10/A2
+ gf180mcu_fd_sc_mcu7t5v0__xnor2_1_7/ZN gf180mcu_fd_sc_mcu7t5v0__xor2_1_32/Z vdd vss
+ gf180mcu_fd_sc_mcu7t5v0__aoi21_1
Xgf180mcu_fd_sc_mcu7t5v0__nand2_1_405 vdd vss gf180mcu_fd_sc_mcu7t5v0__nor2_4_30/A2
+ gf180mcu_fd_sc_mcu7t5v0__inv_1_7/I gf180mcu_fd_sc_mcu7t5v0__nor2_2_22/A1 vdd vss
+ gf180mcu_fd_sc_mcu7t5v0__nand2_1
Xgf180mcu_fd_sc_mcu7t5v0__nand2_1_416 vdd vss gf180mcu_fd_sc_mcu7t5v0__xnor2_1_43/A1
+ gf180mcu_fd_sc_mcu7t5v0__inv_8_1/I gf180mcu_fd_sc_mcu7t5v0__mux4_4_18/Z vdd vss
+ gf180mcu_fd_sc_mcu7t5v0__nand2_1
Xgf180mcu_fd_sc_mcu7t5v0__nand2_1_427 vdd vss gf180mcu_fd_sc_mcu7t5v0__nand2_1_427/ZN
+ gf180mcu_fd_sc_mcu7t5v0__or2_1_33/A1 gf180mcu_fd_sc_mcu7t5v0__or2_4_4/Z vdd vss
+ gf180mcu_fd_sc_mcu7t5v0__nand2_1
Xgf180mcu_fd_sc_mcu7t5v0__nand2_1_438 vdd vss gf180mcu_fd_sc_mcu7t5v0__xor3_1_79/A1
+ gf180mcu_fd_sc_mcu7t5v0__xor3_1_83/Z gf180mcu_fd_sc_mcu7t5v0__nand2_1_438/A2 vdd
+ vss gf180mcu_fd_sc_mcu7t5v0__nand2_1
Xgf180mcu_fd_sc_mcu7t5v0__nand2_1_449 vdd vss gf180mcu_fd_sc_mcu7t5v0__oai31_1_15/B
+ gf180mcu_fd_sc_mcu7t5v0__inv_2_9/I gf180mcu_fd_sc_mcu7t5v0__and2_1_94/A2 vdd vss
+ gf180mcu_fd_sc_mcu7t5v0__nand2_1
Xgf180mcu_fd_sc_mcu7t5v0__xor2_1_7 vdd vss gf180mcu_fd_sc_mcu7t5v0__xor2_1_7/Z gf180mcu_fd_sc_mcu7t5v0__xor2_1_7/A1
+ gf180mcu_fd_sc_mcu7t5v0__xor3_1_3/Z vdd vss gf180mcu_fd_sc_mcu7t5v0__xor2_1
Xgf180mcu_fd_sc_mcu7t5v0__oai211_1_8 gf180mcu_fd_sc_mcu7t5v0__oai21_1_9/ZN gf180mcu_fd_sc_mcu7t5v0__oai211_1_8/C
+ vdd vss gf180mcu_fd_sc_mcu7t5v0__oai211_1_8/ZN gf180mcu_fd_sc_mcu7t5v0__nor2_1_22/A1
+ gf180mcu_fd_sc_mcu7t5v0__xor2_1_29/Z vdd vss gf180mcu_fd_sc_mcu7t5v0__oai211_1
Xgf180mcu_fd_sc_mcu7t5v0__mux2_1_8 gf180mcu_fd_sc_mcu7t5v0__mux2_1_8/S vdd vss gf180mcu_fd_sc_mcu7t5v0__mux2_1_8/Z
+ gf180mcu_fd_sc_mcu7t5v0__mux2_1_8/I0 gf180mcu_fd_sc_mcu7t5v0__mux2_1_8/I1 vdd vss
+ gf180mcu_fd_sc_mcu7t5v0__mux2_1
Xgf180mcu_fd_sc_mcu7t5v0__xnor2_1_19 vdd vss gf180mcu_fd_sc_mcu7t5v0__xor2_1_44/A2
+ gf180mcu_fd_sc_mcu7t5v0__xnor3_1_13/ZN gf180mcu_fd_sc_mcu7t5v0__xor2_1_48/Z vdd
+ vss gf180mcu_fd_sc_mcu7t5v0__xnor2_1
Xgf180mcu_fd_sc_mcu7t5v0__dffq_2_13 gf180mcu_fd_sc_mcu7t5v0__dffq_2_13/D vdd vss gf180mcu_fd_sc_mcu7t5v0__dffq_4_6/CLK
+ gf180mcu_fd_sc_mcu7t5v0__mux4_2_1/I1 vdd vss gf180mcu_fd_sc_mcu7t5v0__dffq_2
Xgf180mcu_fd_sc_mcu7t5v0__dffq_2_24 gf180mcu_fd_sc_mcu7t5v0__dffq_2_24/D vdd vss gf180mcu_fd_sc_mcu7t5v0__dffq_4_8/CLK
+ gf180mcu_fd_sc_mcu7t5v0__inv_2_6/I vdd vss gf180mcu_fd_sc_mcu7t5v0__dffq_2
Xgf180mcu_fd_sc_mcu7t5v0__dffq_2_35 gf180mcu_fd_sc_mcu7t5v0__dffq_2_35/D vdd vss gf180mcu_fd_sc_mcu7t5v0__dffq_4_9/CLK
+ gf180mcu_fd_sc_mcu7t5v0__nor4_4_1/A1 vdd vss gf180mcu_fd_sc_mcu7t5v0__dffq_2
Xgf180mcu_fd_sc_mcu7t5v0__dffq_2_46 gf180mcu_fd_sc_mcu7t5v0__dffq_2_46/D vdd vss gf180mcu_fd_sc_mcu7t5v0__dffq_4_9/CLK
+ gf180mcu_fd_sc_mcu7t5v0__mux4_4_3/I3 vdd vss gf180mcu_fd_sc_mcu7t5v0__dffq_2
Xgf180mcu_fd_sc_mcu7t5v0__dffq_2_57 gf180mcu_fd_sc_mcu7t5v0__dffq_2_57/D vdd vss gf180mcu_fd_sc_mcu7t5v0__dffq_2_58/CLK
+ gf180mcu_fd_sc_mcu7t5v0__dffq_2_57/Q vdd vss gf180mcu_fd_sc_mcu7t5v0__dffq_2
Xgf180mcu_fd_sc_mcu7t5v0__and3_1_9 gf180mcu_fd_sc_mcu7t5v0__and3_1_9/A3 vdd vss gf180mcu_fd_sc_mcu7t5v0__and3_1_9/Z
+ gf180mcu_fd_sc_mcu7t5v0__and3_1_9/A1 gf180mcu_fd_sc_mcu7t5v0__and3_1_9/A2 vdd vss
+ gf180mcu_fd_sc_mcu7t5v0__and3_1
Xgf180mcu_fd_sc_mcu7t5v0__dffq_2_68 gf180mcu_fd_sc_mcu7t5v0__dffq_2_68/D vdd vss gf180mcu_fd_sc_mcu7t5v0__dffq_4_44/CLK
+ gf180mcu_fd_sc_mcu7t5v0__mux4_4_6/I3 vdd vss gf180mcu_fd_sc_mcu7t5v0__dffq_2
Xgf180mcu_fd_sc_mcu7t5v0__dffq_2_79 gf180mcu_fd_sc_mcu7t5v0__dffq_2_79/D vdd vss gf180mcu_fd_sc_mcu7t5v0__dffq_4_1/CLK
+ gf180mcu_fd_sc_mcu7t5v0__dffq_2_79/Q vdd vss gf180mcu_fd_sc_mcu7t5v0__dffq_2
Xgf180mcu_fd_sc_mcu7t5v0__and3_1_11 gf180mcu_fd_sc_mcu7t5v0__xor2_1_91/Z vdd vss gf180mcu_fd_sc_mcu7t5v0__dffq_2_48/D
+ rst_n gf180mcu_fd_sc_mcu7t5v0__and3_1_11/A2 vdd vss gf180mcu_fd_sc_mcu7t5v0__and3_1
Xgf180mcu_fd_sc_mcu7t5v0__and3_1_22 gf180mcu_fd_sc_mcu7t5v0__and3_1_22/A3 vdd vss
+ gf180mcu_fd_sc_mcu7t5v0__and3_1_22/Z gf180mcu_fd_sc_mcu7t5v0__or3_1_24/Z gf180mcu_fd_sc_mcu7t5v0__and3_1_22/A2
+ vdd vss gf180mcu_fd_sc_mcu7t5v0__and3_1
Xgf180mcu_fd_sc_mcu7t5v0__or2_1_7 vdd vss gf180mcu_fd_sc_mcu7t5v0__or2_1_7/Z gf180mcu_fd_sc_mcu7t5v0__or2_1_7/A1
+ gf180mcu_fd_sc_mcu7t5v0__or2_1_7/A2 vdd vss gf180mcu_fd_sc_mcu7t5v0__or2_1
Xgf180mcu_fd_sc_mcu7t5v0__nor4_2_5 gf180mcu_fd_sc_mcu7t5v0__nor4_2_5/A3 gf180mcu_fd_sc_mcu7t5v0__nor4_2_5/A4
+ vdd vss gf180mcu_fd_sc_mcu7t5v0__nor4_2_5/ZN gf180mcu_fd_sc_mcu7t5v0__nor4_2_5/A1
+ gf180mcu_fd_sc_mcu7t5v0__and2_2_9/Z vdd vss gf180mcu_fd_sc_mcu7t5v0__nor4_2
Xgf180mcu_fd_sc_mcu7t5v0__aoi22_4_6 gf180mcu_fd_sc_mcu7t5v0__nor3_4_13/ZN gf180mcu_fd_sc_mcu7t5v0__aoi22_4_6/B1
+ gf180mcu_fd_sc_mcu7t5v0__nor4_4_1/ZN vdd vss gf180mcu_fd_sc_mcu7t5v0__aoi22_4_6/ZN
+ gf180mcu_fd_sc_mcu7t5v0__dffq_2_58/Q vdd vss gf180mcu_fd_sc_mcu7t5v0__aoi22_4
Xgf180mcu_fd_sc_mcu7t5v0__nand2_1_202 vdd vss gf180mcu_fd_sc_mcu7t5v0__xor2_1_42/A1
+ gf180mcu_fd_sc_mcu7t5v0__inv_8_1/I gf180mcu_fd_sc_mcu7t5v0__xor2_1_64/A1 vdd vss
+ gf180mcu_fd_sc_mcu7t5v0__nand2_1
Xgf180mcu_fd_sc_mcu7t5v0__nand2_1_213 vdd vss gf180mcu_fd_sc_mcu7t5v0__aoi222_2_8/A2
+ gf180mcu_fd_sc_mcu7t5v0__aoi22_1_52/ZN gf180mcu_fd_sc_mcu7t5v0__aoi22_1_20/ZN vdd
+ vss gf180mcu_fd_sc_mcu7t5v0__nand2_1
Xgf180mcu_fd_sc_mcu7t5v0__nand2_1_224 vdd vss gf180mcu_fd_sc_mcu7t5v0__aoi222_2_4/B1
+ gf180mcu_fd_sc_mcu7t5v0__aoi22_1_53/ZN gf180mcu_fd_sc_mcu7t5v0__aoi22_1_34/ZN vdd
+ vss gf180mcu_fd_sc_mcu7t5v0__nand2_1
Xgf180mcu_fd_sc_mcu7t5v0__nand2_1_235 vdd vss gf180mcu_fd_sc_mcu7t5v0__aoi222_2_2/B1
+ gf180mcu_fd_sc_mcu7t5v0__aoi22_1_69/ZN gf180mcu_fd_sc_mcu7t5v0__aoi22_1_65/ZN vdd
+ vss gf180mcu_fd_sc_mcu7t5v0__nand2_1
Xgf180mcu_fd_sc_mcu7t5v0__nand2_1_246 vdd vss gf180mcu_fd_sc_mcu7t5v0__nand2_1_246/ZN
+ gf180mcu_fd_sc_mcu7t5v0__aoi22_1_86/ZN gf180mcu_fd_sc_mcu7t5v0__aoi22_1_81/ZN vdd
+ vss gf180mcu_fd_sc_mcu7t5v0__nand2_1
Xgf180mcu_fd_sc_mcu7t5v0__nand2_1_257 vdd vss gf180mcu_fd_sc_mcu7t5v0__oai221_1_15/B2
+ gf180mcu_fd_sc_mcu7t5v0__and3_1_24/Z gf180mcu_fd_sc_mcu7t5v0__oai21_1_75/ZN vdd
+ vss gf180mcu_fd_sc_mcu7t5v0__nand2_1
Xgf180mcu_fd_sc_mcu7t5v0__nand2_1_268 vdd vss gf180mcu_fd_sc_mcu7t5v0__aoi222_1_3/C2
+ gf180mcu_fd_sc_mcu7t5v0__nand2_1_268/A1 gf180mcu_fd_sc_mcu7t5v0__nand2_1_268/A2
+ vdd vss gf180mcu_fd_sc_mcu7t5v0__nand2_1
Xgf180mcu_fd_sc_mcu7t5v0__nand2_1_279 vdd vss gf180mcu_fd_sc_mcu7t5v0__oai21_1_83/B
+ gf180mcu_fd_sc_mcu7t5v0__xor3_1_65/A1 gf180mcu_fd_sc_mcu7t5v0__xor2_1_80/Z vdd vss
+ gf180mcu_fd_sc_mcu7t5v0__nand2_1
Xgf180mcu_fd_sc_mcu7t5v0__aoi21_1_14 gf180mcu_fd_sc_mcu7t5v0__and2_1_8/Z vdd vss gf180mcu_fd_sc_mcu7t5v0__oai22_1_0/B2
+ gf180mcu_fd_sc_mcu7t5v0__mux2_1_2/I1 gf180mcu_fd_sc_mcu7t5v0__nor2_1_22/A1 vdd vss
+ gf180mcu_fd_sc_mcu7t5v0__aoi21_1
Xgf180mcu_fd_sc_mcu7t5v0__aoi21_1_25 gf180mcu_fd_sc_mcu7t5v0__aoi21_1_25/B vdd vss
+ gf180mcu_fd_sc_mcu7t5v0__oai221_1_2/B1 gf180mcu_fd_sc_mcu7t5v0__inv_8_0/ZN gf180mcu_fd_sc_mcu7t5v0__nor2_1_24/A2
+ vdd vss gf180mcu_fd_sc_mcu7t5v0__aoi21_1
Xgf180mcu_fd_sc_mcu7t5v0__aoi21_1_36 gf180mcu_fd_sc_mcu7t5v0__xor2_1_24/Z vdd vss
+ gf180mcu_fd_sc_mcu7t5v0__nor2_1_36/A2 gf180mcu_fd_sc_mcu7t5v0__or2_1_8/Z gf180mcu_fd_sc_mcu7t5v0__and3_1_3/A2
+ vdd vss gf180mcu_fd_sc_mcu7t5v0__aoi21_1
Xgf180mcu_fd_sc_mcu7t5v0__aoi21_1_47 gf180mcu_fd_sc_mcu7t5v0__aoi21_1_47/B vdd vss
+ gf180mcu_fd_sc_mcu7t5v0__xor3_1_29/A1 gf180mcu_fd_sc_mcu7t5v0__xor2_1_37/A1 gf180mcu_fd_sc_mcu7t5v0__xor2_1_37/A2
+ vdd vss gf180mcu_fd_sc_mcu7t5v0__aoi21_1
Xgf180mcu_fd_sc_mcu7t5v0__aoi21_1_58 gf180mcu_fd_sc_mcu7t5v0__aoi21_1_7/B vdd vss
+ gf180mcu_fd_sc_mcu7t5v0__dffq_1_16/D gf180mcu_fd_sc_mcu7t5v0__aoi21_1_58/A1 gf180mcu_fd_sc_mcu7t5v0__oai211_1_9/ZN
+ vdd vss gf180mcu_fd_sc_mcu7t5v0__aoi21_1
Xgf180mcu_fd_sc_mcu7t5v0__aoi21_1_69 gf180mcu_fd_sc_mcu7t5v0__aoi21_1_69/B vdd vss
+ gf180mcu_fd_sc_mcu7t5v0__xor2_1_64/A2 gf180mcu_fd_sc_mcu7t5v0__oai31_1_4/B gf180mcu_fd_sc_mcu7t5v0__xnor2_1_25/A1
+ vdd vss gf180mcu_fd_sc_mcu7t5v0__aoi21_1
Xgf180mcu_fd_sc_mcu7t5v0__nor2_2_11 vdd vss gf180mcu_fd_sc_mcu7t5v0__oai31_1_3/A1
+ gf180mcu_fd_sc_mcu7t5v0__nor3_2_5/A1 gf180mcu_fd_sc_mcu7t5v0__or4_1_0/A3 vdd vss
+ gf180mcu_fd_sc_mcu7t5v0__nor2_2
Xgf180mcu_fd_sc_mcu7t5v0__nor2_2_22 vdd vss gf180mcu_fd_sc_mcu7t5v0__nor2_2_22/ZN
+ gf180mcu_fd_sc_mcu7t5v0__nor2_2_22/A1 gf180mcu_fd_sc_mcu7t5v0__oai32_1_5/A2 vdd
+ vss gf180mcu_fd_sc_mcu7t5v0__nor2_2
Xgf180mcu_fd_sc_mcu7t5v0__nor2_2_33 vdd vss gf180mcu_fd_sc_mcu7t5v0__nor2_2_33/ZN
+ gf180mcu_fd_sc_mcu7t5v0__nor2_2_33/A1 gf180mcu_fd_sc_mcu7t5v0__nor2_2_33/A2 vdd
+ vss gf180mcu_fd_sc_mcu7t5v0__nor2_2
Xgf180mcu_fd_sc_mcu7t5v0__nor2_2_44 vdd vss gf180mcu_fd_sc_mcu7t5v0__nor2_2_44/ZN
+ gf180mcu_fd_sc_mcu7t5v0__dffq_4_28/Q gf180mcu_fd_sc_mcu7t5v0__nor2_2_44/A2 vdd vss
+ gf180mcu_fd_sc_mcu7t5v0__nor2_2
Xgf180mcu_fd_sc_mcu7t5v0__nor2_2_55 vdd vss gf180mcu_fd_sc_mcu7t5v0__nor2_2_55/ZN
+ gf180mcu_fd_sc_mcu7t5v0__nor2_4_42/A1 gf180mcu_fd_sc_mcu7t5v0__nor2_2_55/A2 vdd
+ vss gf180mcu_fd_sc_mcu7t5v0__nor2_2
Xgf180mcu_fd_sc_mcu7t5v0__dffq_1_310 vdd gf180mcu_fd_sc_mcu7t5v0__dffq_1_310/Q gf180mcu_fd_sc_mcu7t5v0__dffq_4_9/CLK
+ vss gf180mcu_fd_sc_mcu7t5v0__dffq_1_310/D vdd vss gf180mcu_fd_sc_mcu7t5v0__dffq_1
Xgf180mcu_fd_sc_mcu7t5v0__dffq_1_321 vdd gf180mcu_fd_sc_mcu7t5v0__dffq_1_321/Q gf180mcu_fd_sc_mcu7t5v0__dffq_2_58/CLK
+ vss gf180mcu_fd_sc_mcu7t5v0__dffq_1_321/D vdd vss gf180mcu_fd_sc_mcu7t5v0__dffq_1
Xgf180mcu_fd_sc_mcu7t5v0__dffq_1_332 vdd gf180mcu_fd_sc_mcu7t5v0__dffq_1_332/Q gf180mcu_fd_sc_mcu7t5v0__dffq_2_58/CLK
+ vss gf180mcu_fd_sc_mcu7t5v0__dffq_1_332/D vdd vss gf180mcu_fd_sc_mcu7t5v0__dffq_1
Xgf180mcu_fd_sc_mcu7t5v0__dffq_1_343 vdd gf180mcu_fd_sc_mcu7t5v0__nor4_1_0/A4 gf180mcu_fd_sc_mcu7t5v0__dffq_4_15/CLK
+ vss gf180mcu_fd_sc_mcu7t5v0__dffq_1_343/D vdd vss gf180mcu_fd_sc_mcu7t5v0__dffq_1
Xgf180mcu_fd_sc_mcu7t5v0__dffq_1_354 vdd gf180mcu_fd_sc_mcu7t5v0__dffq_1_354/Q gf180mcu_fd_sc_mcu7t5v0__dffq_4_15/CLK
+ vss gf180mcu_fd_sc_mcu7t5v0__nor3_1_15/ZN vdd vss gf180mcu_fd_sc_mcu7t5v0__dffq_1
Xgf180mcu_fd_sc_mcu7t5v0__dffq_1_365 vdd gf180mcu_fd_sc_mcu7t5v0__nor4_1_3/A1 gf180mcu_fd_sc_mcu7t5v0__dffq_4_21/CLK
+ vss gf180mcu_fd_sc_mcu7t5v0__dffq_1_365/D vdd vss gf180mcu_fd_sc_mcu7t5v0__dffq_1
Xgf180mcu_fd_sc_mcu7t5v0__oai22_1_11 gf180mcu_fd_sc_mcu7t5v0__oai22_1_11/A2 gf180mcu_fd_sc_mcu7t5v0__xnor2_1_24/ZN
+ gf180mcu_fd_sc_mcu7t5v0__nand3_4_7/ZN vdd vss gf180mcu_fd_sc_mcu7t5v0__oai22_1_11/ZN
+ gf180mcu_fd_sc_mcu7t5v0__oai22_1_11/A1 vdd vss gf180mcu_fd_sc_mcu7t5v0__oai22_1
Xgf180mcu_fd_sc_mcu7t5v0__dffq_1_376 vdd gf180mcu_fd_sc_mcu7t5v0__nor4_1_4/A3 gf180mcu_fd_sc_mcu7t5v0__dffq_4_21/CLK
+ vss gf180mcu_fd_sc_mcu7t5v0__and2_1_75/Z vdd vss gf180mcu_fd_sc_mcu7t5v0__dffq_1
Xgf180mcu_fd_sc_mcu7t5v0__oai22_1_22 gf180mcu_fd_sc_mcu7t5v0__nand2_4_4/ZN gf180mcu_fd_sc_mcu7t5v0__oai22_1_33/B1
+ gf180mcu_fd_sc_mcu7t5v0__oai22_1_22/B2 vdd vss gf180mcu_fd_sc_mcu7t5v0__dffq_1_34/D
+ gf180mcu_fd_sc_mcu7t5v0__aoi21_4_2/ZN vdd vss gf180mcu_fd_sc_mcu7t5v0__oai22_1
Xgf180mcu_fd_sc_mcu7t5v0__dffq_1_387 vdd gf180mcu_fd_sc_mcu7t5v0__dffq_1_387/Q gf180mcu_fd_sc_mcu7t5v0__dffq_4_15/CLK
+ vss gf180mcu_fd_sc_mcu7t5v0__dffq_1_387/D vdd vss gf180mcu_fd_sc_mcu7t5v0__dffq_1
Xgf180mcu_fd_sc_mcu7t5v0__oai22_1_33 gf180mcu_fd_sc_mcu7t5v0__nand2_4_4/ZN gf180mcu_fd_sc_mcu7t5v0__oai22_1_33/B1
+ gf180mcu_fd_sc_mcu7t5v0__oai22_1_33/B2 vdd vss gf180mcu_fd_sc_mcu7t5v0__dffq_1_33/D
+ gf180mcu_fd_sc_mcu7t5v0__oai22_1_88/A1 vdd vss gf180mcu_fd_sc_mcu7t5v0__oai22_1
Xgf180mcu_fd_sc_mcu7t5v0__dffq_1_398 vdd gf180mcu_fd_sc_mcu7t5v0__dffq_1_398/Q gf180mcu_fd_sc_mcu7t5v0__dffq_4_21/CLK
+ vss gf180mcu_fd_sc_mcu7t5v0__dffq_1_398/D vdd vss gf180mcu_fd_sc_mcu7t5v0__dffq_1
Xgf180mcu_fd_sc_mcu7t5v0__oai22_1_44 gf180mcu_fd_sc_mcu7t5v0__nand2_4_3/ZN gf180mcu_fd_sc_mcu7t5v0__oai22_1_45/B1
+ gf180mcu_fd_sc_mcu7t5v0__oai22_1_44/B2 vdd vss gf180mcu_fd_sc_mcu7t5v0__dffq_1_46/D
+ gf180mcu_fd_sc_mcu7t5v0__aoi21_4_4/ZN vdd vss gf180mcu_fd_sc_mcu7t5v0__oai22_1
Xgf180mcu_fd_sc_mcu7t5v0__oai22_1_55 gf180mcu_fd_sc_mcu7t5v0__oai22_1_55/A2 gf180mcu_fd_sc_mcu7t5v0__oai22_1_55/B1
+ gf180mcu_fd_sc_mcu7t5v0__oai22_1_55/B2 vdd vss gf180mcu_fd_sc_mcu7t5v0__dffq_1_269/D
+ gf180mcu_fd_sc_mcu7t5v0__aoi21_4_1/ZN vdd vss gf180mcu_fd_sc_mcu7t5v0__oai22_1
Xgf180mcu_fd_sc_mcu7t5v0__oai22_1_66 gf180mcu_fd_sc_mcu7t5v0__nand2_4_9/ZN gf180mcu_fd_sc_mcu7t5v0__oai22_1_95/B1
+ gf180mcu_fd_sc_mcu7t5v0__oai22_1_66/B2 vdd vss gf180mcu_fd_sc_mcu7t5v0__dffq_1_75/D
+ gf180mcu_fd_sc_mcu7t5v0__oai21_4_9/ZN vdd vss gf180mcu_fd_sc_mcu7t5v0__oai22_1
Xgf180mcu_fd_sc_mcu7t5v0__oai22_1_77 gf180mcu_fd_sc_mcu7t5v0__nand2_4_8/ZN gf180mcu_fd_sc_mcu7t5v0__oai22_1_89/B1
+ gf180mcu_fd_sc_mcu7t5v0__oai22_1_77/B2 vdd vss gf180mcu_fd_sc_mcu7t5v0__dffq_1_84/D
+ gf180mcu_fd_sc_mcu7t5v0__oai22_1_98/A1 vdd vss gf180mcu_fd_sc_mcu7t5v0__oai22_1
Xgf180mcu_fd_sc_mcu7t5v0__oai22_1_88 gf180mcu_fd_sc_mcu7t5v0__nand2_4_8/ZN gf180mcu_fd_sc_mcu7t5v0__oai22_1_89/B1
+ gf180mcu_fd_sc_mcu7t5v0__oai22_1_88/B2 vdd vss gf180mcu_fd_sc_mcu7t5v0__dffq_1_86/D
+ gf180mcu_fd_sc_mcu7t5v0__oai22_1_88/A1 vdd vss gf180mcu_fd_sc_mcu7t5v0__oai22_1
Xgf180mcu_fd_sc_mcu7t5v0__oai22_1_99 gf180mcu_fd_sc_mcu7t5v0__oai22_1_99/A2 gf180mcu_fd_sc_mcu7t5v0__oai22_1_99/B1
+ gf180mcu_fd_sc_mcu7t5v0__oai22_1_99/B2 vdd vss gf180mcu_fd_sc_mcu7t5v0__dffq_1_263/D
+ gf180mcu_fd_sc_mcu7t5v0__aoi21_4_5/ZN vdd vss gf180mcu_fd_sc_mcu7t5v0__oai22_1
Xgf180mcu_fd_sc_mcu7t5v0__clkinv_1_204 vdd vss gf180mcu_fd_sc_mcu7t5v0__dffq_1_192/Q
+ gf180mcu_fd_sc_mcu7t5v0__oai22_1_175/B2 vdd vss gf180mcu_fd_sc_mcu7t5v0__clkinv_1
Xgf180mcu_fd_sc_mcu7t5v0__clkinv_1_215 vdd vss gf180mcu_fd_sc_mcu7t5v0__dffq_1_199/Q
+ gf180mcu_fd_sc_mcu7t5v0__oai22_1_253/B2 vdd vss gf180mcu_fd_sc_mcu7t5v0__clkinv_1
Xgf180mcu_fd_sc_mcu7t5v0__clkinv_1_226 vdd vss gf180mcu_fd_sc_mcu7t5v0__dffq_1_254/Q
+ gf180mcu_fd_sc_mcu7t5v0__oai22_1_254/B2 vdd vss gf180mcu_fd_sc_mcu7t5v0__clkinv_1
Xgf180mcu_fd_sc_mcu7t5v0__clkinv_1_237 vdd vss gf180mcu_fd_sc_mcu7t5v0__dffq_1_255/Q
+ gf180mcu_fd_sc_mcu7t5v0__oai22_1_255/B2 vdd vss gf180mcu_fd_sc_mcu7t5v0__clkinv_1
Xgf180mcu_fd_sc_mcu7t5v0__clkinv_1_248 vdd vss gf180mcu_fd_sc_mcu7t5v0__dffq_1_222/Q
+ gf180mcu_fd_sc_mcu7t5v0__oai22_1_218/B2 vdd vss gf180mcu_fd_sc_mcu7t5v0__clkinv_1
Xgf180mcu_fd_sc_mcu7t5v0__clkinv_1_259 vdd vss gf180mcu_fd_sc_mcu7t5v0__dffq_1_274/Q
+ gf180mcu_fd_sc_mcu7t5v0__oai22_1_187/B2 vdd vss gf180mcu_fd_sc_mcu7t5v0__clkinv_1
Xgf180mcu_fd_sc_mcu7t5v0__oai221_1_10 gf180mcu_fd_sc_mcu7t5v0__xor2_1_131/Z gf180mcu_fd_sc_mcu7t5v0__oai32_1_8/ZN
+ vdd vss gf180mcu_fd_sc_mcu7t5v0__oai221_1_10/ZN gf180mcu_fd_sc_mcu7t5v0__oai221_1_11/B2
+ gf180mcu_fd_sc_mcu7t5v0__or2_1_37/Z gf180mcu_fd_sc_mcu7t5v0__or3_1_18/A1 vdd vss
+ gf180mcu_fd_sc_mcu7t5v0__oai221_1
Xgf180mcu_fd_sc_mcu7t5v0__dffq_2_107 gf180mcu_fd_sc_mcu7t5v0__dffq_2_107/D vdd vss
+ gf180mcu_fd_sc_mcu7t5v0__dffq_4_9/CLK gf180mcu_fd_sc_mcu7t5v0__inv_2_12/I vdd vss
+ gf180mcu_fd_sc_mcu7t5v0__dffq_2
Xgf180mcu_fd_sc_mcu7t5v0__aoi22_2_3 gf180mcu_fd_sc_mcu7t5v0__nor2_4_2/ZN gf180mcu_fd_sc_mcu7t5v0__or2_1_33/A1
+ vdd vss gf180mcu_fd_sc_mcu7t5v0__nand2_2_9/A2 gf180mcu_fd_sc_mcu7t5v0__dffq_2_6/Q
+ gf180mcu_fd_sc_mcu7t5v0__and2_2_6/Z vdd vss gf180mcu_fd_sc_mcu7t5v0__aoi22_2
Xgf180mcu_fd_sc_mcu7t5v0__oai22_1_220 gf180mcu_fd_sc_mcu7t5v0__nand2_4_31/ZN gf180mcu_fd_sc_mcu7t5v0__nand2_2_42/ZN
+ gf180mcu_fd_sc_mcu7t5v0__oai22_1_220/B2 vdd vss gf180mcu_fd_sc_mcu7t5v0__dffq_1_214/D
+ gf180mcu_fd_sc_mcu7t5v0__aoi21_4_1/ZN vdd vss gf180mcu_fd_sc_mcu7t5v0__oai22_1
Xgf180mcu_fd_sc_mcu7t5v0__oai22_1_231 gf180mcu_fd_sc_mcu7t5v0__nand2_4_28/ZN gf180mcu_fd_sc_mcu7t5v0__nand2_2_44/ZN
+ gf180mcu_fd_sc_mcu7t5v0__oai22_1_231/B2 vdd vss gf180mcu_fd_sc_mcu7t5v0__dffq_1_251/D
+ gf180mcu_fd_sc_mcu7t5v0__oai22_1_98/A1 vdd vss gf180mcu_fd_sc_mcu7t5v0__oai22_1
Xgf180mcu_fd_sc_mcu7t5v0__oai22_1_242 gf180mcu_fd_sc_mcu7t5v0__nand2_4_31/ZN gf180mcu_fd_sc_mcu7t5v0__nand2_2_42/ZN
+ gf180mcu_fd_sc_mcu7t5v0__oai22_1_242/B2 vdd vss gf180mcu_fd_sc_mcu7t5v0__dffq_1_232/D
+ gf180mcu_fd_sc_mcu7t5v0__aoi21_4_5/ZN vdd vss gf180mcu_fd_sc_mcu7t5v0__oai22_1
Xgf180mcu_fd_sc_mcu7t5v0__oai22_1_253 gf180mcu_fd_sc_mcu7t5v0__nand2_4_28/ZN gf180mcu_fd_sc_mcu7t5v0__nand2_2_44/ZN
+ gf180mcu_fd_sc_mcu7t5v0__oai22_1_253/B2 vdd vss gf180mcu_fd_sc_mcu7t5v0__dffq_1_199/D
+ gf180mcu_fd_sc_mcu7t5v0__oai22_1_88/A1 vdd vss gf180mcu_fd_sc_mcu7t5v0__oai22_1
Xgf180mcu_fd_sc_mcu7t5v0__oai22_1_264 gf180mcu_fd_sc_mcu7t5v0__nand2_4_24/ZN gf180mcu_fd_sc_mcu7t5v0__nand2_2_52/ZN
+ gf180mcu_fd_sc_mcu7t5v0__oai22_1_264/B2 vdd vss gf180mcu_fd_sc_mcu7t5v0__dffq_1_458/D
+ gf180mcu_fd_sc_mcu7t5v0__oai21_4_9/ZN vdd vss gf180mcu_fd_sc_mcu7t5v0__oai22_1
Xgf180mcu_fd_sc_mcu7t5v0__oai22_1_275 gf180mcu_fd_sc_mcu7t5v0__xor3_1_119/A2 gf180mcu_fd_sc_mcu7t5v0__mux2_1_13/Z
+ gf180mcu_fd_sc_mcu7t5v0__oai22_1_275/B2 vdd vss gf180mcu_fd_sc_mcu7t5v0__nand3_1_85/A3
+ gf180mcu_fd_sc_mcu7t5v0__or2_1_7/A1 vdd vss gf180mcu_fd_sc_mcu7t5v0__oai22_1
Xgf180mcu_fd_sc_mcu7t5v0__oai22_1_286 gf180mcu_fd_sc_mcu7t5v0__nand2_4_36/ZN gf180mcu_fd_sc_mcu7t5v0__nand2_2_31/ZN
+ gf180mcu_fd_sc_mcu7t5v0__oai22_1_286/B2 vdd vss gf180mcu_fd_sc_mcu7t5v0__dffq_1_170/D
+ gf180mcu_fd_sc_mcu7t5v0__oai21_4_9/ZN vdd vss gf180mcu_fd_sc_mcu7t5v0__oai22_1
Xgf180mcu_fd_sc_mcu7t5v0__dffq_1_140 vdd gf180mcu_fd_sc_mcu7t5v0__dffq_1_140/Q gf180mcu_fd_sc_mcu7t5v0__dffq_2_26/CLK
+ vss gf180mcu_fd_sc_mcu7t5v0__dffq_1_140/D vdd vss gf180mcu_fd_sc_mcu7t5v0__dffq_1
Xgf180mcu_fd_sc_mcu7t5v0__dffq_1_151 vdd gf180mcu_fd_sc_mcu7t5v0__dffq_1_151/Q gf180mcu_fd_sc_mcu7t5v0__dffq_2_26/CLK
+ vss gf180mcu_fd_sc_mcu7t5v0__dffq_1_151/D vdd vss gf180mcu_fd_sc_mcu7t5v0__dffq_1
Xgf180mcu_fd_sc_mcu7t5v0__dffq_1_162 vdd gf180mcu_fd_sc_mcu7t5v0__dffq_1_162/Q gf180mcu_fd_sc_mcu7t5v0__dffq_2_26/CLK
+ vss gf180mcu_fd_sc_mcu7t5v0__dffq_1_162/D vdd vss gf180mcu_fd_sc_mcu7t5v0__dffq_1
Xgf180mcu_fd_sc_mcu7t5v0__nor2_1_340 vdd vss gf180mcu_fd_sc_mcu7t5v0__dffq_2_85/D
+ gf180mcu_fd_sc_mcu7t5v0__aoi21_1_7/B gf180mcu_fd_sc_mcu7t5v0__nor2_1_340/A2 vdd
+ vss gf180mcu_fd_sc_mcu7t5v0__nor2_1
Xgf180mcu_fd_sc_mcu7t5v0__nor2_1_351 vdd vss gf180mcu_fd_sc_mcu7t5v0__aoi21_2_20/B
+ gf180mcu_fd_sc_mcu7t5v0__or2_1_46/Z gf180mcu_fd_sc_mcu7t5v0__xor3_1_178/A3 vdd vss
+ gf180mcu_fd_sc_mcu7t5v0__nor2_1
Xgf180mcu_fd_sc_mcu7t5v0__clkinv_3_5 vdd gf180mcu_fd_sc_mcu7t5v0__nor2_2_14/A1 gf180mcu_fd_sc_mcu7t5v0__dffq_4_7/Q
+ vss vdd vss gf180mcu_fd_sc_mcu7t5v0__clkinv_3
Xgf180mcu_fd_sc_mcu7t5v0__dffq_1_173 vdd gf180mcu_fd_sc_mcu7t5v0__dffq_1_173/Q gf180mcu_fd_sc_mcu7t5v0__dffq_2_26/CLK
+ vss gf180mcu_fd_sc_mcu7t5v0__dffq_1_173/D vdd vss gf180mcu_fd_sc_mcu7t5v0__dffq_1
Xgf180mcu_fd_sc_mcu7t5v0__nor2_1_362 vdd vss gf180mcu_fd_sc_mcu7t5v0__xor3_1_141/A1
+ gf180mcu_fd_sc_mcu7t5v0__or2_1_47/Z gf180mcu_fd_sc_mcu7t5v0__xnor3_1_39/A1 vdd vss
+ gf180mcu_fd_sc_mcu7t5v0__nor2_1
Xgf180mcu_fd_sc_mcu7t5v0__dffq_1_184 vdd gf180mcu_fd_sc_mcu7t5v0__dffq_1_184/Q gf180mcu_fd_sc_mcu7t5v0__dffq_2_26/CLK
+ vss gf180mcu_fd_sc_mcu7t5v0__dffq_1_184/D vdd vss gf180mcu_fd_sc_mcu7t5v0__dffq_1
Xgf180mcu_fd_sc_mcu7t5v0__nor2_1_373 vdd vss gf180mcu_fd_sc_mcu7t5v0__xor3_1_138/A1
+ gf180mcu_fd_sc_mcu7t5v0__or3_1_24/A1 gf180mcu_fd_sc_mcu7t5v0__or3_1_24/A2 vdd vss
+ gf180mcu_fd_sc_mcu7t5v0__nor2_1
Xgf180mcu_fd_sc_mcu7t5v0__xor3_2_2 gf180mcu_fd_sc_mcu7t5v0__xor3_2_2/A3 vdd vss gf180mcu_fd_sc_mcu7t5v0__xor3_2_2/Z
+ gf180mcu_fd_sc_mcu7t5v0__xor3_2_2/A1 gf180mcu_fd_sc_mcu7t5v0__xor3_2_2/A2 vdd vss
+ gf180mcu_fd_sc_mcu7t5v0__xor3_2
Xgf180mcu_fd_sc_mcu7t5v0__dffq_1_195 vdd gf180mcu_fd_sc_mcu7t5v0__dffq_1_195/Q gf180mcu_fd_sc_mcu7t5v0__dffq_4_8/CLK
+ vss gf180mcu_fd_sc_mcu7t5v0__dffq_1_195/D vdd vss gf180mcu_fd_sc_mcu7t5v0__dffq_1
Xgf180mcu_fd_sc_mcu7t5v0__nor2_1_384 vdd vss gf180mcu_fd_sc_mcu7t5v0__nor2_1_384/ZN
+ gf180mcu_fd_sc_mcu7t5v0__dffq_2_96/Q gf180mcu_fd_sc_mcu7t5v0__xor3_1_143/A3 vdd
+ vss gf180mcu_fd_sc_mcu7t5v0__nor2_1
Xgf180mcu_fd_sc_mcu7t5v0__nor2_1_395 vdd vss gf180mcu_fd_sc_mcu7t5v0__nor2_1_395/ZN
+ gf180mcu_fd_sc_mcu7t5v0__inv_8_0/I gf180mcu_fd_sc_mcu7t5v0__xor3_1_162/A2 vdd vss
+ gf180mcu_fd_sc_mcu7t5v0__nor2_1
Xgf180mcu_fd_sc_mcu7t5v0__clkbuf_16_1 vdd vss gf180mcu_fd_sc_mcu7t5v0__dffq_1_99/CLK
+ gf180mcu_fd_sc_mcu7t5v0__clkbuf_16_9/I vdd vss gf180mcu_fd_sc_mcu7t5v0__clkbuf_16
Xgf180mcu_fd_sc_mcu7t5v0__clkinv_2_16 vdd vss gf180mcu_fd_sc_mcu7t5v0__oai31_2_1/A2
+ gf180mcu_fd_sc_mcu7t5v0__nor2_2_29/A1 vdd vss gf180mcu_fd_sc_mcu7t5v0__clkinv_2
Xgf180mcu_fd_sc_mcu7t5v0__or3_2_2 gf180mcu_fd_sc_mcu7t5v0__inv_2_0/I vdd vss gf180mcu_fd_sc_mcu7t5v0__or3_2_2/Z
+ gf180mcu_fd_sc_mcu7t5v0__or3_2_2/A1 gf180mcu_fd_sc_mcu7t5v0__or3_2_2/A2 vdd vss
+ gf180mcu_fd_sc_mcu7t5v0__or3_2
Xgf180mcu_fd_sc_mcu7t5v0__inv_2_6 vss gf180mcu_fd_sc_mcu7t5v0__inv_2_6/ZN gf180mcu_fd_sc_mcu7t5v0__inv_2_6/I
+ vdd vdd vss gf180mcu_fd_sc_mcu7t5v0__inv_2
Xgf180mcu_fd_sc_mcu7t5v0__dffq_1_3 vdd gf180mcu_fd_sc_mcu7t5v0__dffq_1_3/Q gf180mcu_fd_sc_mcu7t5v0__dffq_4_6/CLK
+ vss gf180mcu_fd_sc_mcu7t5v0__dffq_1_3/D vdd vss gf180mcu_fd_sc_mcu7t5v0__dffq_1
Xgf180mcu_fd_sc_mcu7t5v0__clkinv_1_2 vdd vss gf180mcu_fd_sc_mcu7t5v0__xor2_1_5/A1
+ gf180mcu_fd_sc_mcu7t5v0__aoi21_2_1/A1 vdd vss gf180mcu_fd_sc_mcu7t5v0__clkinv_1
Xgf180mcu_fd_sc_mcu7t5v0__nor2_1_170 vdd vss gf180mcu_fd_sc_mcu7t5v0__nor2_1_170/ZN
+ gf180mcu_fd_sc_mcu7t5v0__dffq_1_307/Q gf180mcu_fd_sc_mcu7t5v0__nor2_4_28/ZN vdd
+ vss gf180mcu_fd_sc_mcu7t5v0__nor2_1
Xgf180mcu_fd_sc_mcu7t5v0__nor2_1_181 vdd vss gf180mcu_fd_sc_mcu7t5v0__dffq_1_339/D
+ gf180mcu_fd_sc_mcu7t5v0__and2_1_52/Z gf180mcu_fd_sc_mcu7t5v0__nor2_1_181/A2 vdd
+ vss gf180mcu_fd_sc_mcu7t5v0__nor2_1
Xgf180mcu_fd_sc_mcu7t5v0__nor2_1_192 vdd vss gf180mcu_fd_sc_mcu7t5v0__nor3_1_15/A2
+ gf180mcu_fd_sc_mcu7t5v0__dffq_1_354/Q gf180mcu_fd_sc_mcu7t5v0__and2_1_77/Z vdd vss
+ gf180mcu_fd_sc_mcu7t5v0__nor2_1
Xgf180mcu_fd_sc_mcu7t5v0__aoi22_1_107 gf180mcu_fd_sc_mcu7t5v0__nor2_4_9/ZN gf180mcu_fd_sc_mcu7t5v0__dffq_1_202/Q
+ vdd vss gf180mcu_fd_sc_mcu7t5v0__nand2_1_261/A1 gf180mcu_fd_sc_mcu7t5v0__dffq_1_200/Q
+ gf180mcu_fd_sc_mcu7t5v0__nor2_4_8/ZN vdd vss gf180mcu_fd_sc_mcu7t5v0__aoi22_1
Xgf180mcu_fd_sc_mcu7t5v0__xor3_1_160 gf180mcu_fd_sc_mcu7t5v0__xor3_1_160/A3 vdd vss
+ gf180mcu_fd_sc_mcu7t5v0__xor3_1_160/Z gf180mcu_fd_sc_mcu7t5v0__xor3_1_160/A1 gf180mcu_fd_sc_mcu7t5v0__xor3_1_160/A2
+ vdd vss gf180mcu_fd_sc_mcu7t5v0__xor3_1
Xgf180mcu_fd_sc_mcu7t5v0__aoi22_1_118 gf180mcu_fd_sc_mcu7t5v0__nor2_4_11/ZN gf180mcu_fd_sc_mcu7t5v0__dffq_1_213/Q
+ vdd vss gf180mcu_fd_sc_mcu7t5v0__nand2_1_268/A2 gf180mcu_fd_sc_mcu7t5v0__dffq_1_219/Q
+ gf180mcu_fd_sc_mcu7t5v0__nor2_4_10/ZN vdd vss gf180mcu_fd_sc_mcu7t5v0__aoi22_1
Xgf180mcu_fd_sc_mcu7t5v0__xor3_1_171 gf180mcu_fd_sc_mcu7t5v0__xor3_1_171/A3 vdd vss
+ gf180mcu_fd_sc_mcu7t5v0__nor3_1_6/A1 gf180mcu_fd_sc_mcu7t5v0__and2_1_42/A1 gf180mcu_fd_sc_mcu7t5v0__and2_1_42/A2
+ vdd vss gf180mcu_fd_sc_mcu7t5v0__xor3_1
Xgf180mcu_fd_sc_mcu7t5v0__aoi22_1_129 gf180mcu_fd_sc_mcu7t5v0__nor2_4_11/ZN gf180mcu_fd_sc_mcu7t5v0__dffq_1_215/Q
+ vdd vss gf180mcu_fd_sc_mcu7t5v0__nand2_1_270/A2 gf180mcu_fd_sc_mcu7t5v0__dffq_1_249/Q
+ gf180mcu_fd_sc_mcu7t5v0__nor2_4_10/ZN vdd vss gf180mcu_fd_sc_mcu7t5v0__aoi22_1
Xgf180mcu_fd_sc_mcu7t5v0__oai211_1_20 gf180mcu_fd_sc_mcu7t5v0__oai211_1_20/B gf180mcu_fd_sc_mcu7t5v0__buf_8_5/I
+ vdd vss gf180mcu_fd_sc_mcu7t5v0__dffq_1_313/D gf180mcu_fd_sc_mcu7t5v0__oai211_1_20/A1
+ gf180mcu_fd_sc_mcu7t5v0__nor2_4_21/ZN vdd vss gf180mcu_fd_sc_mcu7t5v0__oai211_1
Xgf180mcu_fd_sc_mcu7t5v0__oai211_1_31 gf180mcu_fd_sc_mcu7t5v0__oai211_1_31/B gf180mcu_fd_sc_mcu7t5v0__or2_1_34/A2
+ vdd vss gf180mcu_fd_sc_mcu7t5v0__oai211_1_31/ZN gf180mcu_fd_sc_mcu7t5v0__nor3_1_33/A1
+ gf180mcu_fd_sc_mcu7t5v0__xor2_1_207/Z vdd vss gf180mcu_fd_sc_mcu7t5v0__oai211_1
Xgf180mcu_fd_sc_mcu7t5v0__oai211_1_42 gf180mcu_fd_sc_mcu7t5v0__oai211_1_42/B gf180mcu_fd_sc_mcu7t5v0__oai211_1_43/C
+ vdd vss gf180mcu_fd_sc_mcu7t5v0__aoi221_1_54/C gf180mcu_fd_sc_mcu7t5v0__nand2_2_74/ZN
+ gf180mcu_fd_sc_mcu7t5v0__and2_1_123/A2 vdd vss gf180mcu_fd_sc_mcu7t5v0__oai211_1
Xgf180mcu_fd_sc_mcu7t5v0__oai211_1_53 gf180mcu_fd_sc_mcu7t5v0__oai211_1_53/B gf180mcu_fd_sc_mcu7t5v0__oai211_1_53/C
+ vdd vss gf180mcu_fd_sc_mcu7t5v0__oai211_1_52/C gf180mcu_fd_sc_mcu7t5v0__inv_12_1/I
+ gf180mcu_fd_sc_mcu7t5v0__and4_1_3/A3 vdd vss gf180mcu_fd_sc_mcu7t5v0__oai211_1
Xgf180mcu_fd_sc_mcu7t5v0__oai21_1_230 vdd gf180mcu_fd_sc_mcu7t5v0__or2_1_38/Z gf180mcu_fd_sc_mcu7t5v0__or3_1_19/A2
+ gf180mcu_fd_sc_mcu7t5v0__xor3_1_99/A3 gf180mcu_fd_sc_mcu7t5v0__or3_1_19/A1 vss vdd
+ vss gf180mcu_fd_sc_mcu7t5v0__oai21_1
Xgf180mcu_fd_sc_mcu7t5v0__oai21_1_241 vdd gf180mcu_fd_sc_mcu7t5v0__buf_12_0/Z gf180mcu_fd_sc_mcu7t5v0__buf_20_0/Z
+ gf180mcu_fd_sc_mcu7t5v0__aoi21_1_264/B gf180mcu_fd_sc_mcu7t5v0__dffq_1_418/Q vss
+ vdd vss gf180mcu_fd_sc_mcu7t5v0__oai21_1
Xgf180mcu_fd_sc_mcu7t5v0__oai21_1_252 vdd gf180mcu_fd_sc_mcu7t5v0__nor2_4_37/ZN gf180mcu_fd_sc_mcu7t5v0__nor3_4_18/A1
+ gf180mcu_fd_sc_mcu7t5v0__oai211_1_35/C gf180mcu_fd_sc_mcu7t5v0__inv_12_1/I vss vdd
+ vss gf180mcu_fd_sc_mcu7t5v0__oai21_1
Xgf180mcu_fd_sc_mcu7t5v0__oai21_1_263 vdd gf180mcu_fd_sc_mcu7t5v0__buf_8_4/Z gf180mcu_fd_sc_mcu7t5v0__buf_20_0/I
+ gf180mcu_fd_sc_mcu7t5v0__aoi21_1_295/B gf180mcu_fd_sc_mcu7t5v0__dffq_1_426/Q vss
+ vdd vss gf180mcu_fd_sc_mcu7t5v0__oai21_1
Xgf180mcu_fd_sc_mcu7t5v0__oai21_1_274 vdd gf180mcu_fd_sc_mcu7t5v0__buf_12_0/Z gf180mcu_fd_sc_mcu7t5v0__buf_20_0/I
+ gf180mcu_fd_sc_mcu7t5v0__aoi21_1_313/B gf180mcu_fd_sc_mcu7t5v0__dffq_1_440/Q vss
+ vdd vss gf180mcu_fd_sc_mcu7t5v0__oai21_1
Xgf180mcu_fd_sc_mcu7t5v0__oai21_1_285 vdd gf180mcu_fd_sc_mcu7t5v0__oai21_1_285/B gf180mcu_fd_sc_mcu7t5v0__oai21_1_285/A2
+ gf180mcu_fd_sc_mcu7t5v0__oai21_1_284/B gf180mcu_fd_sc_mcu7t5v0__nand2_2_74/ZN vss
+ vdd vss gf180mcu_fd_sc_mcu7t5v0__oai21_1
Xgf180mcu_fd_sc_mcu7t5v0__oai21_1_296 vdd gf180mcu_fd_sc_mcu7t5v0__oai21_1_296/B gf180mcu_fd_sc_mcu7t5v0__xor2_1_162/A1
+ gf180mcu_fd_sc_mcu7t5v0__nand4_1_18/A4 gf180mcu_fd_sc_mcu7t5v0__inv_4_6/I vss vdd
+ vss gf180mcu_fd_sc_mcu7t5v0__oai21_1
Xgf180mcu_fd_sc_mcu7t5v0__aoi21_1_309 gf180mcu_fd_sc_mcu7t5v0__or2_1_23/A1 vdd vss
+ gf180mcu_fd_sc_mcu7t5v0__dffq_2_71/D gf180mcu_fd_sc_mcu7t5v0__nand2_1_548/ZN gf180mcu_fd_sc_mcu7t5v0__nand2_1_547/ZN
+ vdd vss gf180mcu_fd_sc_mcu7t5v0__aoi21_1
Xgf180mcu_fd_sc_mcu7t5v0__xor3_1_19 gf180mcu_fd_sc_mcu7t5v0__xor3_1_19/A3 vdd vss
+ gf180mcu_fd_sc_mcu7t5v0__xor3_1_19/Z gf180mcu_fd_sc_mcu7t5v0__xor3_1_19/A1 gf180mcu_fd_sc_mcu7t5v0__and2_1_13/Z
+ vdd vss gf180mcu_fd_sc_mcu7t5v0__xor3_1
Xgf180mcu_fd_sc_mcu7t5v0__aoi222_1_9 vss vdd gf180mcu_fd_sc_mcu7t5v0__nor2_1_213/ZN
+ gf180mcu_fd_sc_mcu7t5v0__or2_1_45/A1 gf180mcu_fd_sc_mcu7t5v0__oai32_1_5/ZN gf180mcu_fd_sc_mcu7t5v0__aoi222_1_9/B1
+ gf180mcu_fd_sc_mcu7t5v0__nor2_2_23/ZN gf180mcu_fd_sc_mcu7t5v0__or4_1_0/A1 gf180mcu_fd_sc_mcu7t5v0__aoi222_1_9/ZN
+ vdd vss gf180mcu_fd_sc_mcu7t5v0__aoi222_1
Xgf180mcu_fd_sc_mcu7t5v0__nand2_1_609 vdd vss gf180mcu_fd_sc_mcu7t5v0__xnor3_1_51/A2
+ gf180mcu_fd_sc_mcu7t5v0__nand2_1_609/A1 gf180mcu_fd_sc_mcu7t5v0__nand2_1_609/A2
+ vdd vss gf180mcu_fd_sc_mcu7t5v0__nand2_1
Xgf180mcu_fd_sc_mcu7t5v0__nand4_2_5 gf180mcu_fd_sc_mcu7t5v0__nand4_2_5/A3 gf180mcu_fd_sc_mcu7t5v0__nand4_2_5/A4
+ vdd vss gf180mcu_fd_sc_mcu7t5v0__nor4_4_3/A3 gf180mcu_fd_sc_mcu7t5v0__nand4_2_5/A1
+ gf180mcu_fd_sc_mcu7t5v0__nand4_2_5/A2 vdd vss gf180mcu_fd_sc_mcu7t5v0__nand4_2
Xgf180mcu_fd_sc_mcu7t5v0__nand4_1_19 gf180mcu_fd_sc_mcu7t5v0__nand4_1_19/A3 gf180mcu_fd_sc_mcu7t5v0__nand4_1_19/A4
+ vdd vss gf180mcu_fd_sc_mcu7t5v0__nand4_1_19/ZN gf180mcu_fd_sc_mcu7t5v0__oai211_1_43/C
+ gf180mcu_fd_sc_mcu7t5v0__nand4_1_19/A2 vdd vss gf180mcu_fd_sc_mcu7t5v0__nand4_1
Xgf180mcu_fd_sc_mcu7t5v0__nor2_1_0 vdd vss gf180mcu_fd_sc_mcu7t5v0__nor2_1_0/ZN gf180mcu_fd_sc_mcu7t5v0__xor3_1_6/A1
+ gf180mcu_fd_sc_mcu7t5v0__xor3_1_0/Z vdd vss gf180mcu_fd_sc_mcu7t5v0__nor2_1
Xgf180mcu_fd_sc_mcu7t5v0__aoi21_4_14 gf180mcu_fd_sc_mcu7t5v0__or3_4_0/Z gf180mcu_fd_sc_mcu7t5v0__aoi21_4_14/B
+ vdd vss gf180mcu_fd_sc_mcu7t5v0__nor2_4_7/A1 gf180mcu_fd_sc_mcu7t5v0__mux2_4_3/I1
+ vdd vss gf180mcu_fd_sc_mcu7t5v0__aoi21_4
Xgf180mcu_fd_sc_mcu7t5v0__xor2_1_30 vdd vss gf180mcu_fd_sc_mcu7t5v0__xor2_1_30/Z gf180mcu_fd_sc_mcu7t5v0__xor2_1_30/A1
+ gf180mcu_fd_sc_mcu7t5v0__xor2_1_28/Z vdd vss gf180mcu_fd_sc_mcu7t5v0__xor2_1
Xgf180mcu_fd_sc_mcu7t5v0__xor2_1_41 vdd vss gf180mcu_fd_sc_mcu7t5v0__xor2_1_41/Z gf180mcu_fd_sc_mcu7t5v0__nor4_2_2/A4
+ gf180mcu_fd_sc_mcu7t5v0__xor2_1_41/A2 vdd vss gf180mcu_fd_sc_mcu7t5v0__xor2_1
Xgf180mcu_fd_sc_mcu7t5v0__xor2_1_52 vdd vss gf180mcu_fd_sc_mcu7t5v0__xor2_1_52/Z gf180mcu_fd_sc_mcu7t5v0__or4_1_1/A4
+ gf180mcu_fd_sc_mcu7t5v0__xor2_1_52/A2 vdd vss gf180mcu_fd_sc_mcu7t5v0__xor2_1
Xgf180mcu_fd_sc_mcu7t5v0__xor2_1_63 vdd vss gf180mcu_fd_sc_mcu7t5v0__xor2_1_63/Z gf180mcu_fd_sc_mcu7t5v0__xor2_1_63/A1
+ gf180mcu_fd_sc_mcu7t5v0__xor2_1_63/A2 vdd vss gf180mcu_fd_sc_mcu7t5v0__xor2_1
Xgf180mcu_fd_sc_mcu7t5v0__xor2_1_74 vdd vss gf180mcu_fd_sc_mcu7t5v0__xor2_1_74/Z gf180mcu_fd_sc_mcu7t5v0__and2_4_1/Z
+ gf180mcu_fd_sc_mcu7t5v0__xor2_1_74/A2 vdd vss gf180mcu_fd_sc_mcu7t5v0__xor2_1
Xgf180mcu_fd_sc_mcu7t5v0__xor2_1_85 vdd vss gf180mcu_fd_sc_mcu7t5v0__xor2_1_85/Z gf180mcu_fd_sc_mcu7t5v0__or3_1_29/A1
+ gf180mcu_fd_sc_mcu7t5v0__or3_1_29/A2 vdd vss gf180mcu_fd_sc_mcu7t5v0__xor2_1
Xgf180mcu_fd_sc_mcu7t5v0__xor2_1_96 vdd vss gf180mcu_fd_sc_mcu7t5v0__xor2_1_96/Z gf180mcu_fd_sc_mcu7t5v0__xor2_1_96/A1
+ gf180mcu_fd_sc_mcu7t5v0__xor2_1_97/Z vdd vss gf180mcu_fd_sc_mcu7t5v0__xor2_1
Xgf180mcu_fd_sc_mcu7t5v0__aoi21_1_106 gf180mcu_fd_sc_mcu7t5v0__xor3_1_65/Z vdd vss
+ gf180mcu_fd_sc_mcu7t5v0__nor2_1_409/A1 gf180mcu_fd_sc_mcu7t5v0__and3_1_8/A1 gf180mcu_fd_sc_mcu7t5v0__and3_1_8/A2
+ vdd vss gf180mcu_fd_sc_mcu7t5v0__aoi21_1
Xgf180mcu_fd_sc_mcu7t5v0__aoi21_1_117 gf180mcu_fd_sc_mcu7t5v0__oai21_1_94/ZN vdd vss
+ gf180mcu_fd_sc_mcu7t5v0__dffq_1_292/D gf180mcu_fd_sc_mcu7t5v0__oai21_1_94/A2 gf180mcu_fd_sc_mcu7t5v0__aoi221_2_5/ZN
+ vdd vss gf180mcu_fd_sc_mcu7t5v0__aoi21_1
Xgf180mcu_fd_sc_mcu7t5v0__xor2_1_170 vdd vss gf180mcu_fd_sc_mcu7t5v0__xor2_1_170/Z
+ gf180mcu_fd_sc_mcu7t5v0__xor2_1_170/A1 gf180mcu_fd_sc_mcu7t5v0__or2_1_47/Z vdd vss
+ gf180mcu_fd_sc_mcu7t5v0__xor2_1
Xgf180mcu_fd_sc_mcu7t5v0__aoi21_1_128 gf180mcu_fd_sc_mcu7t5v0__aoi21_1_128/B vdd vss
+ gf180mcu_fd_sc_mcu7t5v0__dffq_1_301/D gf180mcu_fd_sc_mcu7t5v0__aoi22_4_5/ZN gf180mcu_fd_sc_mcu7t5v0__nor2_4_31/ZN
+ vdd vss gf180mcu_fd_sc_mcu7t5v0__aoi21_1
Xgf180mcu_fd_sc_mcu7t5v0__xor2_1_181 vdd vss gf180mcu_fd_sc_mcu7t5v0__xor2_1_181/Z
+ gf180mcu_fd_sc_mcu7t5v0__mux4_4_14/Z gf180mcu_fd_sc_mcu7t5v0__xor2_1_181/A2 vdd
+ vss gf180mcu_fd_sc_mcu7t5v0__xor2_1
Xgf180mcu_fd_sc_mcu7t5v0__aoi21_1_139 gf180mcu_fd_sc_mcu7t5v0__aoi21_1_139/B vdd vss
+ gf180mcu_fd_sc_mcu7t5v0__dffq_2_42/D gf180mcu_fd_sc_mcu7t5v0__nor2_4_30/A1 gf180mcu_fd_sc_mcu7t5v0__buf_20_0/I
+ vdd vss gf180mcu_fd_sc_mcu7t5v0__aoi21_1
Xgf180mcu_fd_sc_mcu7t5v0__xor2_1_192 vdd vss gf180mcu_fd_sc_mcu7t5v0__xor2_1_192/Z
+ gf180mcu_fd_sc_mcu7t5v0__xor2_1_192/A1 gf180mcu_fd_sc_mcu7t5v0__xor2_1_192/A2 vdd
+ vss gf180mcu_fd_sc_mcu7t5v0__xor2_1
Xgf180mcu_fd_sc_mcu7t5v0__and2_1_106 vdd vss gf180mcu_fd_sc_mcu7t5v0__oai33_2_3/A3
+ gf180mcu_fd_sc_mcu7t5v0__nor3_4_16/ZN gf180mcu_fd_sc_mcu7t5v0__xor2_1_143/Z vdd
+ vss gf180mcu_fd_sc_mcu7t5v0__and2_1
Xgf180mcu_fd_sc_mcu7t5v0__and2_1_117 vdd vss gf180mcu_fd_sc_mcu7t5v0__and2_1_117/Z
+ gf180mcu_fd_sc_mcu7t5v0__mux4_4_2/Z gf180mcu_fd_sc_mcu7t5v0__oai31_1_1/B vdd vss
+ gf180mcu_fd_sc_mcu7t5v0__and2_1
Xgf180mcu_fd_sc_mcu7t5v0__and2_1_128 vdd vss gf180mcu_fd_sc_mcu7t5v0__and2_1_128/Z
+ gf180mcu_fd_sc_mcu7t5v0__inv_12_1/I gf180mcu_fd_sc_mcu7t5v0__mux4_4_16/Z vdd vss
+ gf180mcu_fd_sc_mcu7t5v0__and2_1
Xgf180mcu_fd_sc_mcu7t5v0__and2_1_139 vdd vss gf180mcu_fd_sc_mcu7t5v0__nor4_4_4/A4
+ gf180mcu_fd_sc_mcu7t5v0__nor3_1_41/A1 gf180mcu_fd_sc_mcu7t5v0__nor2_1_386/ZN vdd
+ vss gf180mcu_fd_sc_mcu7t5v0__and2_1
Xgf180mcu_fd_sc_mcu7t5v0__nand3_1_30 gf180mcu_fd_sc_mcu7t5v0__xor2_1_47/Z vdd vss
+ gf180mcu_fd_sc_mcu7t5v0__and3_1_5/A2 gf180mcu_fd_sc_mcu7t5v0__inv_1_15/I gf180mcu_fd_sc_mcu7t5v0__and2_2_12/Z
+ vdd vss gf180mcu_fd_sc_mcu7t5v0__nand3_1
Xgf180mcu_fd_sc_mcu7t5v0__nand3_1_41 gf180mcu_fd_sc_mcu7t5v0__and2_4_1/A2 vdd vss
+ gf180mcu_fd_sc_mcu7t5v0__xnor2_1_80/A2 gf180mcu_fd_sc_mcu7t5v0__inv_12_1/I gf180mcu_fd_sc_mcu7t5v0__and2_4_1/A1
+ vdd vss gf180mcu_fd_sc_mcu7t5v0__nand3_1
Xgf180mcu_fd_sc_mcu7t5v0__nand3_1_52 gf180mcu_fd_sc_mcu7t5v0__oai221_1_7/A1 vdd vss
+ gf180mcu_fd_sc_mcu7t5v0__oai31_1_9/B gf180mcu_fd_sc_mcu7t5v0__xor2_1_89/A2 gf180mcu_fd_sc_mcu7t5v0__oai32_1_4/B2
+ vdd vss gf180mcu_fd_sc_mcu7t5v0__nand3_1
Xgf180mcu_fd_sc_mcu7t5v0__nand3_1_63 gf180mcu_fd_sc_mcu7t5v0__xor3_1_75/A3 vdd vss
+ gf180mcu_fd_sc_mcu7t5v0__xnor3_1_23/A1 gf180mcu_fd_sc_mcu7t5v0__or3_1_14/Z gf180mcu_fd_sc_mcu7t5v0__nand3_1_63/A2
+ vdd vss gf180mcu_fd_sc_mcu7t5v0__nand3_1
Xgf180mcu_fd_sc_mcu7t5v0__nand3_1_74 gf180mcu_fd_sc_mcu7t5v0__and2_2_11/A2 vdd vss
+ gf180mcu_fd_sc_mcu7t5v0__xnor2_1_50/A1 gf180mcu_fd_sc_mcu7t5v0__inv_8_1/I gf180mcu_fd_sc_mcu7t5v0__and2_2_11/A1
+ vdd vss gf180mcu_fd_sc_mcu7t5v0__nand3_1
Xgf180mcu_fd_sc_mcu7t5v0__nand3_1_85 gf180mcu_fd_sc_mcu7t5v0__nand3_1_85/A3 vdd vss
+ gf180mcu_fd_sc_mcu7t5v0__nand3_1_85/ZN gf180mcu_fd_sc_mcu7t5v0__nand3_1_85/A1 gf180mcu_fd_sc_mcu7t5v0__nand3_1_85/A2
+ vdd vss gf180mcu_fd_sc_mcu7t5v0__nand3_1
Xgf180mcu_fd_sc_mcu7t5v0__nand3_1_96 gf180mcu_fd_sc_mcu7t5v0__nand3_1_96/A3 vdd vss
+ gf180mcu_fd_sc_mcu7t5v0__oai31_1_20/B gf180mcu_fd_sc_mcu7t5v0__and2_1_141/Z gf180mcu_fd_sc_mcu7t5v0__nor2_1_389/A1
+ vdd vss gf180mcu_fd_sc_mcu7t5v0__nand3_1
Xgf180mcu_fd_sc_mcu7t5v0__aoi21_1_9 gf180mcu_fd_sc_mcu7t5v0__or2_4_4/Z vdd vss gf180mcu_fd_sc_mcu7t5v0__aoi21_1_9/ZN
+ gf180mcu_fd_sc_mcu7t5v0__aoi21_1_9/A1 gf180mcu_fd_sc_mcu7t5v0__nor2_1_18/ZN vdd
+ vss gf180mcu_fd_sc_mcu7t5v0__aoi21_1
Xgf180mcu_fd_sc_mcu7t5v0__nand2_1_406 vdd vss gf180mcu_fd_sc_mcu7t5v0__nor3_1_22/A3
+ gf180mcu_fd_sc_mcu7t5v0__dffq_1_375/Q gf180mcu_fd_sc_mcu7t5v0__buf_8_8/Z vdd vss
+ gf180mcu_fd_sc_mcu7t5v0__nand2_1
Xgf180mcu_fd_sc_mcu7t5v0__nand2_1_417 vdd vss gf180mcu_fd_sc_mcu7t5v0__xnor3_1_26/A3
+ gf180mcu_fd_sc_mcu7t5v0__inv_12_1/I gf180mcu_fd_sc_mcu7t5v0__mux4_4_18/Z vdd vss
+ gf180mcu_fd_sc_mcu7t5v0__nand2_1
Xgf180mcu_fd_sc_mcu7t5v0__nand2_1_428 vdd vss gf180mcu_fd_sc_mcu7t5v0__xnor2_1_43/A2
+ gf180mcu_fd_sc_mcu7t5v0__inv_8_0/I gf180mcu_fd_sc_mcu7t5v0__mux4_4_8/Z vdd vss gf180mcu_fd_sc_mcu7t5v0__nand2_1
Xgf180mcu_fd_sc_mcu7t5v0__nand2_1_439 vdd vss gf180mcu_fd_sc_mcu7t5v0__xor3_1_83/A2
+ gf180mcu_fd_sc_mcu7t5v0__inv_8_2/I gf180mcu_fd_sc_mcu7t5v0__mux4_4_19/Z vdd vss
+ gf180mcu_fd_sc_mcu7t5v0__nand2_1
Xgf180mcu_fd_sc_mcu7t5v0__xor2_1_8 vdd vss gf180mcu_fd_sc_mcu7t5v0__xor2_1_8/Z gf180mcu_fd_sc_mcu7t5v0__xor2_1_8/A1
+ gf180mcu_fd_sc_mcu7t5v0__xor2_1_8/A2 vdd vss gf180mcu_fd_sc_mcu7t5v0__xor2_1
Xgf180mcu_fd_sc_mcu7t5v0__oai211_1_9 gf180mcu_fd_sc_mcu7t5v0__oai211_1_9/B gf180mcu_fd_sc_mcu7t5v0__or2_1_34/A2
+ vdd vss gf180mcu_fd_sc_mcu7t5v0__oai211_1_9/ZN gf180mcu_fd_sc_mcu7t5v0__oai31_1_0/B
+ gf180mcu_fd_sc_mcu7t5v0__xor2_1_40/Z vdd vss gf180mcu_fd_sc_mcu7t5v0__oai211_1
Xgf180mcu_fd_sc_mcu7t5v0__mux2_1_9 gf180mcu_fd_sc_mcu7t5v0__mux2_1_9/S vdd vss gf180mcu_fd_sc_mcu7t5v0__mux2_1_9/Z
+ gf180mcu_fd_sc_mcu7t5v0__mux2_1_9/I0 gf180mcu_fd_sc_mcu7t5v0__mux2_1_9/I1 vdd vss
+ gf180mcu_fd_sc_mcu7t5v0__mux2_1
Xgf180mcu_fd_sc_mcu7t5v0__dffq_2_14 gf180mcu_fd_sc_mcu7t5v0__dffq_2_14/D vdd vss gf180mcu_fd_sc_mcu7t5v0__dffq_4_6/CLK
+ gf180mcu_fd_sc_mcu7t5v0__dffq_2_14/Q vdd vss gf180mcu_fd_sc_mcu7t5v0__dffq_2
Xgf180mcu_fd_sc_mcu7t5v0__dffq_2_25 gf180mcu_fd_sc_mcu7t5v0__dffq_2_25/D vdd vss gf180mcu_fd_sc_mcu7t5v0__dffq_2_58/CLK
+ gf180mcu_fd_sc_mcu7t5v0__dffq_2_25/Q vdd vss gf180mcu_fd_sc_mcu7t5v0__dffq_2
Xgf180mcu_fd_sc_mcu7t5v0__dffq_2_36 gf180mcu_fd_sc_mcu7t5v0__dffq_2_36/D vdd vss gf180mcu_fd_sc_mcu7t5v0__dffq_4_9/CLK
+ gf180mcu_fd_sc_mcu7t5v0__nor4_4_1/A2 vdd vss gf180mcu_fd_sc_mcu7t5v0__dffq_2
Xgf180mcu_fd_sc_mcu7t5v0__dffq_2_47 gf180mcu_fd_sc_mcu7t5v0__dffq_2_47/D vdd vss gf180mcu_fd_sc_mcu7t5v0__dffq_4_15/CLK
+ gf180mcu_fd_sc_mcu7t5v0__or2_1_20/A1 vdd vss gf180mcu_fd_sc_mcu7t5v0__dffq_2
Xgf180mcu_fd_sc_mcu7t5v0__dffq_2_58 gf180mcu_fd_sc_mcu7t5v0__dffq_2_58/D vdd vss gf180mcu_fd_sc_mcu7t5v0__dffq_2_58/CLK
+ gf180mcu_fd_sc_mcu7t5v0__dffq_2_58/Q vdd vss gf180mcu_fd_sc_mcu7t5v0__dffq_2
Xgf180mcu_fd_sc_mcu7t5v0__dffq_2_69 gf180mcu_fd_sc_mcu7t5v0__dffq_2_69/D vdd vss gf180mcu_fd_sc_mcu7t5v0__dffq_4_44/CLK
+ gf180mcu_fd_sc_mcu7t5v0__mux4_2_1/I3 vdd vss gf180mcu_fd_sc_mcu7t5v0__dffq_2
Xgf180mcu_fd_sc_mcu7t5v0__and3_1_12 gf180mcu_fd_sc_mcu7t5v0__dffq_1_380/Q vdd vss
+ gf180mcu_fd_sc_mcu7t5v0__and3_1_12/Z gf180mcu_fd_sc_mcu7t5v0__dffq_1_358/Q gf180mcu_fd_sc_mcu7t5v0__and4_2_0/A1
+ vdd vss gf180mcu_fd_sc_mcu7t5v0__and3_1
Xgf180mcu_fd_sc_mcu7t5v0__and3_1_23 gf180mcu_fd_sc_mcu7t5v0__xor2_1_198/Z vdd vss
+ gf180mcu_fd_sc_mcu7t5v0__and3_1_23/Z gf180mcu_fd_sc_mcu7t5v0__inv_12_1/I gf180mcu_fd_sc_mcu7t5v0__and3_1_23/A2
+ vdd vss gf180mcu_fd_sc_mcu7t5v0__and3_1
Xgf180mcu_fd_sc_mcu7t5v0__or2_1_8 vdd vss gf180mcu_fd_sc_mcu7t5v0__or2_1_8/Z gf180mcu_fd_sc_mcu7t5v0__or3_1_9/A1
+ gf180mcu_fd_sc_mcu7t5v0__or2_1_8/A2 vdd vss gf180mcu_fd_sc_mcu7t5v0__or2_1
Xgf180mcu_fd_sc_mcu7t5v0__aoi22_4_7 gf180mcu_fd_sc_mcu7t5v0__nor3_4_13/ZN gf180mcu_fd_sc_mcu7t5v0__aoi22_4_7/B1
+ gf180mcu_fd_sc_mcu7t5v0__nor4_4_1/ZN vdd vss gf180mcu_fd_sc_mcu7t5v0__aoi22_4_7/ZN
+ gf180mcu_fd_sc_mcu7t5v0__dffq_2_25/Q vdd vss gf180mcu_fd_sc_mcu7t5v0__aoi22_4
Xgf180mcu_fd_sc_mcu7t5v0__nand2_1_203 vdd vss gf180mcu_fd_sc_mcu7t5v0__oai21_1_53/A2
+ gf180mcu_fd_sc_mcu7t5v0__dffq_4_37/Q gf180mcu_fd_sc_mcu7t5v0__xnor2_1_25/A1 vdd
+ vss gf180mcu_fd_sc_mcu7t5v0__nand2_1
Xgf180mcu_fd_sc_mcu7t5v0__nand2_1_214 vdd vss gf180mcu_fd_sc_mcu7t5v0__nand2_1_214/ZN
+ gf180mcu_fd_sc_mcu7t5v0__aoi22_1_32/ZN gf180mcu_fd_sc_mcu7t5v0__aoi22_1_18/ZN vdd
+ vss gf180mcu_fd_sc_mcu7t5v0__nand2_1
Xgf180mcu_fd_sc_mcu7t5v0__nand2_1_225 vdd vss gf180mcu_fd_sc_mcu7t5v0__aoi222_2_7/B1
+ gf180mcu_fd_sc_mcu7t5v0__aoi22_1_51/ZN gf180mcu_fd_sc_mcu7t5v0__nand2_1_225/A2 vdd
+ vss gf180mcu_fd_sc_mcu7t5v0__nand2_1
Xgf180mcu_fd_sc_mcu7t5v0__nand2_1_236 vdd vss gf180mcu_fd_sc_mcu7t5v0__aoi222_2_5/C1
+ gf180mcu_fd_sc_mcu7t5v0__aoi22_1_70/ZN gf180mcu_fd_sc_mcu7t5v0__aoi22_1_39/ZN vdd
+ vss gf180mcu_fd_sc_mcu7t5v0__nand2_1
Xgf180mcu_fd_sc_mcu7t5v0__nand2_1_247 vdd vss gf180mcu_fd_sc_mcu7t5v0__aoi222_2_6/B1
+ gf180mcu_fd_sc_mcu7t5v0__aoi22_1_85/ZN gf180mcu_fd_sc_mcu7t5v0__aoi22_1_82/ZN vdd
+ vss gf180mcu_fd_sc_mcu7t5v0__nand2_1
Xgf180mcu_fd_sc_mcu7t5v0__nand2_1_258 vdd vss gf180mcu_fd_sc_mcu7t5v0__and2_1_36/A1
+ gf180mcu_fd_sc_mcu7t5v0__nor3_2_5/A1 gf180mcu_fd_sc_mcu7t5v0__and2_4_2/Z vdd vss
+ gf180mcu_fd_sc_mcu7t5v0__nand2_1
Xgf180mcu_fd_sc_mcu7t5v0__nand2_1_269 vdd vss gf180mcu_fd_sc_mcu7t5v0__nand2_1_269/ZN
+ gf180mcu_fd_sc_mcu7t5v0__nand2_1_269/A1 gf180mcu_fd_sc_mcu7t5v0__nand2_1_269/A2
+ vdd vss gf180mcu_fd_sc_mcu7t5v0__nand2_1
Xgf180mcu_fd_sc_mcu7t5v0__aoi21_1_15 gf180mcu_fd_sc_mcu7t5v0__oai31_1_0/B vdd vss
+ gf180mcu_fd_sc_mcu7t5v0__aoi211_1_1/B gf180mcu_fd_sc_mcu7t5v0__or3_1_1/Z gf180mcu_fd_sc_mcu7t5v0__and2_1_5/A2
+ vdd vss gf180mcu_fd_sc_mcu7t5v0__aoi21_1
Xgf180mcu_fd_sc_mcu7t5v0__aoi21_1_26 gf180mcu_fd_sc_mcu7t5v0__oai22_1_1/B2 vdd vss
+ gf180mcu_fd_sc_mcu7t5v0__aoi21_1_25/B gf180mcu_fd_sc_mcu7t5v0__nor2_2_15/ZN gf180mcu_fd_sc_mcu7t5v0__xor3_1_62/A1
+ vdd vss gf180mcu_fd_sc_mcu7t5v0__aoi21_1
Xgf180mcu_fd_sc_mcu7t5v0__aoi21_1_37 gf180mcu_fd_sc_mcu7t5v0__nor2_1_36/A2 vdd vss
+ gf180mcu_fd_sc_mcu7t5v0__xor3_1_19/A1 gf180mcu_fd_sc_mcu7t5v0__inv_4_6/I gf180mcu_fd_sc_mcu7t5v0__xor2_1_25/Z
+ vdd vss gf180mcu_fd_sc_mcu7t5v0__aoi21_1
Xgf180mcu_fd_sc_mcu7t5v0__aoi21_1_48 gf180mcu_fd_sc_mcu7t5v0__xor2_1_33/Z vdd vss
+ gf180mcu_fd_sc_mcu7t5v0__aoi21_1_47/B gf180mcu_fd_sc_mcu7t5v0__or2_1_12/Z gf180mcu_fd_sc_mcu7t5v0__or2_1_10/Z
+ vdd vss gf180mcu_fd_sc_mcu7t5v0__aoi21_1
Xgf180mcu_fd_sc_mcu7t5v0__aoi21_1_59 gf180mcu_fd_sc_mcu7t5v0__aoi21_1_59/B vdd vss
+ gf180mcu_fd_sc_mcu7t5v0__xnor3_1_11/A2 gf180mcu_fd_sc_mcu7t5v0__aoi21_1_59/A1 gf180mcu_fd_sc_mcu7t5v0__nand3_1_18/ZN
+ vdd vss gf180mcu_fd_sc_mcu7t5v0__aoi21_1
Xgf180mcu_fd_sc_mcu7t5v0__nor2_2_12 vdd vss gf180mcu_fd_sc_mcu7t5v0__xor3_1_7/A1 gf180mcu_fd_sc_mcu7t5v0__and2_1_3/A1
+ gf180mcu_fd_sc_mcu7t5v0__nor3_4_0/A3 vdd vss gf180mcu_fd_sc_mcu7t5v0__nor2_2
Xgf180mcu_fd_sc_mcu7t5v0__nor2_2_23 vdd vss gf180mcu_fd_sc_mcu7t5v0__nor2_2_23/ZN
+ gf180mcu_fd_sc_mcu7t5v0__nor2_4_30/A1 gf180mcu_fd_sc_mcu7t5v0__oai32_1_5/B1 vdd
+ vss gf180mcu_fd_sc_mcu7t5v0__nor2_2
Xgf180mcu_fd_sc_mcu7t5v0__nor2_2_34 vdd vss gf180mcu_fd_sc_mcu7t5v0__xor3_2_1/A2 gf180mcu_fd_sc_mcu7t5v0__or2_1_32/Z
+ gf180mcu_fd_sc_mcu7t5v0__xor3_1_103/Z vdd vss gf180mcu_fd_sc_mcu7t5v0__nor2_2
Xgf180mcu_fd_sc_mcu7t5v0__nor2_2_45 vdd vss gf180mcu_fd_sc_mcu7t5v0__nor2_2_45/ZN
+ gf180mcu_fd_sc_mcu7t5v0__inv_4_7/I gf180mcu_fd_sc_mcu7t5v0__dffq_4_35/Q vdd vss
+ gf180mcu_fd_sc_mcu7t5v0__nor2_2
Xgf180mcu_fd_sc_mcu7t5v0__nor2_2_56 vdd vss gf180mcu_fd_sc_mcu7t5v0__nor2_2_56/ZN
+ gf180mcu_fd_sc_mcu7t5v0__nor2_2_56/A1 gf180mcu_fd_sc_mcu7t5v0__nor2_2_56/A2 vdd
+ vss gf180mcu_fd_sc_mcu7t5v0__nor2_2
Xgf180mcu_fd_sc_mcu7t5v0__dffq_1_300 vdd gf180mcu_fd_sc_mcu7t5v0__dffq_1_300/Q gf180mcu_fd_sc_mcu7t5v0__dffq_4_9/CLK
+ vss gf180mcu_fd_sc_mcu7t5v0__dffq_1_300/D vdd vss gf180mcu_fd_sc_mcu7t5v0__dffq_1
Xgf180mcu_fd_sc_mcu7t5v0__dffq_1_311 vdd gf180mcu_fd_sc_mcu7t5v0__dffq_1_311/Q gf180mcu_fd_sc_mcu7t5v0__dffq_4_9/CLK
+ vss gf180mcu_fd_sc_mcu7t5v0__dffq_1_311/D vdd vss gf180mcu_fd_sc_mcu7t5v0__dffq_1
Xgf180mcu_fd_sc_mcu7t5v0__dffq_1_322 vdd gf180mcu_fd_sc_mcu7t5v0__dffq_1_322/Q gf180mcu_fd_sc_mcu7t5v0__dffq_2_58/CLK
+ vss gf180mcu_fd_sc_mcu7t5v0__dffq_1_322/D vdd vss gf180mcu_fd_sc_mcu7t5v0__dffq_1
Xgf180mcu_fd_sc_mcu7t5v0__dffq_1_333 vdd gf180mcu_fd_sc_mcu7t5v0__dffq_1_333/Q gf180mcu_fd_sc_mcu7t5v0__dffq_2_58/CLK
+ vss gf180mcu_fd_sc_mcu7t5v0__dffq_1_333/D vdd vss gf180mcu_fd_sc_mcu7t5v0__dffq_1
Xgf180mcu_fd_sc_mcu7t5v0__dffq_1_344 vdd gf180mcu_fd_sc_mcu7t5v0__dffq_1_344/Q gf180mcu_fd_sc_mcu7t5v0__dffq_4_15/CLK
+ vss gf180mcu_fd_sc_mcu7t5v0__or2_1_23/Z vdd vss gf180mcu_fd_sc_mcu7t5v0__dffq_1
Xgf180mcu_fd_sc_mcu7t5v0__dffq_1_355 vdd gf180mcu_fd_sc_mcu7t5v0__nor3_1_17/A1 gf180mcu_fd_sc_mcu7t5v0__dffq_4_15/CLK
+ vss gf180mcu_fd_sc_mcu7t5v0__dffq_1_355/D vdd vss gf180mcu_fd_sc_mcu7t5v0__dffq_1
Xgf180mcu_fd_sc_mcu7t5v0__dffq_1_366 vdd gf180mcu_fd_sc_mcu7t5v0__dffq_1_366/Q gf180mcu_fd_sc_mcu7t5v0__dffq_4_15/CLK
+ vss gf180mcu_fd_sc_mcu7t5v0__dffq_1_366/D vdd vss gf180mcu_fd_sc_mcu7t5v0__dffq_1
Xgf180mcu_fd_sc_mcu7t5v0__oai22_1_12 gf180mcu_fd_sc_mcu7t5v0__nand2_4_3/ZN gf180mcu_fd_sc_mcu7t5v0__oai22_1_45/B1
+ gf180mcu_fd_sc_mcu7t5v0__oai22_1_12/B2 vdd vss gf180mcu_fd_sc_mcu7t5v0__dffq_1_52/D
+ gf180mcu_fd_sc_mcu7t5v0__aoi21_4_5/ZN vdd vss gf180mcu_fd_sc_mcu7t5v0__oai22_1
Xgf180mcu_fd_sc_mcu7t5v0__dffq_1_377 vdd gf180mcu_fd_sc_mcu7t5v0__dffq_1_377/Q gf180mcu_fd_sc_mcu7t5v0__dffq_4_15/CLK
+ vss gf180mcu_fd_sc_mcu7t5v0__and2_1_72/Z vdd vss gf180mcu_fd_sc_mcu7t5v0__dffq_1
Xgf180mcu_fd_sc_mcu7t5v0__oai22_1_23 gf180mcu_fd_sc_mcu7t5v0__nand2_4_2/ZN gf180mcu_fd_sc_mcu7t5v0__oai22_1_29/B1
+ gf180mcu_fd_sc_mcu7t5v0__oai22_1_23/B2 vdd vss gf180mcu_fd_sc_mcu7t5v0__dffq_1_24/D
+ gf180mcu_fd_sc_mcu7t5v0__oai22_1_98/A1 vdd vss gf180mcu_fd_sc_mcu7t5v0__oai22_1
Xgf180mcu_fd_sc_mcu7t5v0__dffq_1_388 vdd gf180mcu_fd_sc_mcu7t5v0__oai31_4_2/A3 gf180mcu_fd_sc_mcu7t5v0__dffq_4_15/CLK
+ vss gf180mcu_fd_sc_mcu7t5v0__dffq_1_388/D vdd vss gf180mcu_fd_sc_mcu7t5v0__dffq_1
Xgf180mcu_fd_sc_mcu7t5v0__oai22_1_34 gf180mcu_fd_sc_mcu7t5v0__nand2_4_3/ZN gf180mcu_fd_sc_mcu7t5v0__oai22_1_45/B1
+ gf180mcu_fd_sc_mcu7t5v0__oai22_1_34/B2 vdd vss gf180mcu_fd_sc_mcu7t5v0__dffq_1_29/D
+ gf180mcu_fd_sc_mcu7t5v0__aoi21_4_2/ZN vdd vss gf180mcu_fd_sc_mcu7t5v0__oai22_1
Xgf180mcu_fd_sc_mcu7t5v0__dffq_1_399 vdd gf180mcu_fd_sc_mcu7t5v0__dffq_1_399/Q gf180mcu_fd_sc_mcu7t5v0__dffq_4_21/CLK
+ vss gf180mcu_fd_sc_mcu7t5v0__dffq_1_399/D vdd vss gf180mcu_fd_sc_mcu7t5v0__dffq_1
Xgf180mcu_fd_sc_mcu7t5v0__oai22_1_45 gf180mcu_fd_sc_mcu7t5v0__nand2_4_3/ZN gf180mcu_fd_sc_mcu7t5v0__oai22_1_45/B1
+ gf180mcu_fd_sc_mcu7t5v0__oai22_1_45/B2 vdd vss gf180mcu_fd_sc_mcu7t5v0__dffq_1_47/D
+ gf180mcu_fd_sc_mcu7t5v0__oai22_1_88/A1 vdd vss gf180mcu_fd_sc_mcu7t5v0__oai22_1
Xgf180mcu_fd_sc_mcu7t5v0__oai22_1_56 gf180mcu_fd_sc_mcu7t5v0__nand2_4_6/ZN gf180mcu_fd_sc_mcu7t5v0__oai22_1_96/B1
+ gf180mcu_fd_sc_mcu7t5v0__oai22_1_56/B2 vdd vss gf180mcu_fd_sc_mcu7t5v0__dffq_1_61/D
+ gf180mcu_fd_sc_mcu7t5v0__aoi21_4_3/ZN vdd vss gf180mcu_fd_sc_mcu7t5v0__oai22_1
Xgf180mcu_fd_sc_mcu7t5v0__oai22_1_67 gf180mcu_fd_sc_mcu7t5v0__nand2_4_9/ZN gf180mcu_fd_sc_mcu7t5v0__oai22_1_95/B1
+ gf180mcu_fd_sc_mcu7t5v0__oai22_1_67/B2 vdd vss gf180mcu_fd_sc_mcu7t5v0__dffq_1_271/D
+ gf180mcu_fd_sc_mcu7t5v0__aoi21_4_5/ZN vdd vss gf180mcu_fd_sc_mcu7t5v0__oai22_1
Xgf180mcu_fd_sc_mcu7t5v0__oai22_1_78 gf180mcu_fd_sc_mcu7t5v0__nand2_4_8/ZN gf180mcu_fd_sc_mcu7t5v0__oai22_1_89/B1
+ gf180mcu_fd_sc_mcu7t5v0__oai22_1_78/B2 vdd vss gf180mcu_fd_sc_mcu7t5v0__dffq_1_96/D
+ gf180mcu_fd_sc_mcu7t5v0__aoi21_4_4/ZN vdd vss gf180mcu_fd_sc_mcu7t5v0__oai22_1
Xgf180mcu_fd_sc_mcu7t5v0__oai22_1_89 gf180mcu_fd_sc_mcu7t5v0__nand2_4_8/ZN gf180mcu_fd_sc_mcu7t5v0__oai22_1_89/B1
+ gf180mcu_fd_sc_mcu7t5v0__oai22_1_89/B2 vdd vss gf180mcu_fd_sc_mcu7t5v0__dffq_1_87/D
+ gf180mcu_fd_sc_mcu7t5v0__aoi21_4_2/ZN vdd vss gf180mcu_fd_sc_mcu7t5v0__oai22_1
Xgf180mcu_fd_sc_mcu7t5v0__clkinv_1_205 vdd vss gf180mcu_fd_sc_mcu7t5v0__dffq_1_182/Q
+ gf180mcu_fd_sc_mcu7t5v0__oai22_1_110/B2 vdd vss gf180mcu_fd_sc_mcu7t5v0__clkinv_1
Xgf180mcu_fd_sc_mcu7t5v0__clkinv_1_216 vdd vss gf180mcu_fd_sc_mcu7t5v0__dffq_1_238/Q
+ gf180mcu_fd_sc_mcu7t5v0__oai22_1_250/B2 vdd vss gf180mcu_fd_sc_mcu7t5v0__clkinv_1
Xgf180mcu_fd_sc_mcu7t5v0__clkinv_1_227 vdd vss gf180mcu_fd_sc_mcu7t5v0__dffq_1_277/Q
+ gf180mcu_fd_sc_mcu7t5v0__oai22_1_211/B2 vdd vss gf180mcu_fd_sc_mcu7t5v0__clkinv_1
Xgf180mcu_fd_sc_mcu7t5v0__clkinv_1_238 vdd vss gf180mcu_fd_sc_mcu7t5v0__dffq_1_213/Q
+ gf180mcu_fd_sc_mcu7t5v0__oai22_1_225/B2 vdd vss gf180mcu_fd_sc_mcu7t5v0__clkinv_1
Xgf180mcu_fd_sc_mcu7t5v0__clkinv_1_249 vdd vss gf180mcu_fd_sc_mcu7t5v0__dffq_1_224/Q
+ gf180mcu_fd_sc_mcu7t5v0__oai22_1_233/B2 vdd vss gf180mcu_fd_sc_mcu7t5v0__clkinv_1
Xgf180mcu_fd_sc_mcu7t5v0__oai221_1_11 gf180mcu_fd_sc_mcu7t5v0__xor2_1_157/A2 gf180mcu_fd_sc_mcu7t5v0__oai221_1_11/C
+ vdd vss gf180mcu_fd_sc_mcu7t5v0__oai221_1_11/ZN gf180mcu_fd_sc_mcu7t5v0__or3_1_17/A2
+ gf180mcu_fd_sc_mcu7t5v0__or2_1_35/Z gf180mcu_fd_sc_mcu7t5v0__oai221_1_11/B2 vdd
+ vss gf180mcu_fd_sc_mcu7t5v0__oai221_1
Xgf180mcu_fd_sc_mcu7t5v0__dffq_2_108 gf180mcu_fd_sc_mcu7t5v0__dffq_2_108/D vdd vss
+ gf180mcu_fd_sc_mcu7t5v0__dffq_4_1/CLK gf180mcu_fd_sc_mcu7t5v0__or2_1_55/A1 vdd vss
+ gf180mcu_fd_sc_mcu7t5v0__dffq_2
Xgf180mcu_fd_sc_mcu7t5v0__aoi22_2_4 gf180mcu_fd_sc_mcu7t5v0__nor2_4_2/ZN gf180mcu_fd_sc_mcu7t5v0__mux4_4_4/I1
+ vdd vss gf180mcu_fd_sc_mcu7t5v0__aoi22_2_4/ZN gf180mcu_fd_sc_mcu7t5v0__dffq_2_7/Q
+ gf180mcu_fd_sc_mcu7t5v0__and2_2_6/Z vdd vss gf180mcu_fd_sc_mcu7t5v0__aoi22_2
Xgf180mcu_fd_sc_mcu7t5v0__oai22_1_210 gf180mcu_fd_sc_mcu7t5v0__oai22_1_43/A2 gf180mcu_fd_sc_mcu7t5v0__oai22_1_43/B1
+ gf180mcu_fd_sc_mcu7t5v0__oai22_1_210/B2 vdd vss gf180mcu_fd_sc_mcu7t5v0__dffq_1_200/D
+ gf180mcu_fd_sc_mcu7t5v0__aoi21_4_3/ZN vdd vss gf180mcu_fd_sc_mcu7t5v0__oai22_1
Xgf180mcu_fd_sc_mcu7t5v0__oai22_1_221 gf180mcu_fd_sc_mcu7t5v0__oai22_1_28/A2 gf180mcu_fd_sc_mcu7t5v0__oai22_1_28/B1
+ gf180mcu_fd_sc_mcu7t5v0__oai22_1_221/B2 vdd vss gf180mcu_fd_sc_mcu7t5v0__dffq_1_208/D
+ gf180mcu_fd_sc_mcu7t5v0__aoi21_4_2/ZN vdd vss gf180mcu_fd_sc_mcu7t5v0__oai22_1
Xgf180mcu_fd_sc_mcu7t5v0__oai22_1_232 gf180mcu_fd_sc_mcu7t5v0__nand2_4_31/ZN gf180mcu_fd_sc_mcu7t5v0__nand2_2_42/ZN
+ gf180mcu_fd_sc_mcu7t5v0__oai22_1_232/B2 vdd vss gf180mcu_fd_sc_mcu7t5v0__dffq_1_231/D
+ gf180mcu_fd_sc_mcu7t5v0__oai22_1_98/A1 vdd vss gf180mcu_fd_sc_mcu7t5v0__oai22_1
Xgf180mcu_fd_sc_mcu7t5v0__oai22_1_243 gf180mcu_fd_sc_mcu7t5v0__nand2_4_31/ZN gf180mcu_fd_sc_mcu7t5v0__nand2_2_42/ZN
+ gf180mcu_fd_sc_mcu7t5v0__oai22_1_243/B2 vdd vss gf180mcu_fd_sc_mcu7t5v0__dffq_1_215/D
+ gf180mcu_fd_sc_mcu7t5v0__oai22_1_88/A1 vdd vss gf180mcu_fd_sc_mcu7t5v0__oai22_1
Xgf180mcu_fd_sc_mcu7t5v0__oai22_1_254 gf180mcu_fd_sc_mcu7t5v0__nand2_4_32/ZN gf180mcu_fd_sc_mcu7t5v0__nand2_2_33/ZN
+ gf180mcu_fd_sc_mcu7t5v0__oai22_1_254/B2 vdd vss gf180mcu_fd_sc_mcu7t5v0__dffq_1_254/D
+ gf180mcu_fd_sc_mcu7t5v0__oai21_4_9/ZN vdd vss gf180mcu_fd_sc_mcu7t5v0__oai22_1
Xgf180mcu_fd_sc_mcu7t5v0__oai22_1_265 gf180mcu_fd_sc_mcu7t5v0__oai22_1_265/A2 gf180mcu_fd_sc_mcu7t5v0__oai22_1_265/B1
+ gf180mcu_fd_sc_mcu7t5v0__or2_1_21/A1 vdd vss gf180mcu_fd_sc_mcu7t5v0__dffq_2_53/D
+ gf180mcu_fd_sc_mcu7t5v0__nand3_1_54/A3 vdd vss gf180mcu_fd_sc_mcu7t5v0__oai22_1
Xgf180mcu_fd_sc_mcu7t5v0__oai22_1_276 gf180mcu_fd_sc_mcu7t5v0__xor2_1_166/A1 gf180mcu_fd_sc_mcu7t5v0__and2_1_131/Z
+ gf180mcu_fd_sc_mcu7t5v0__xor3_1_124/A3 vdd vss gf180mcu_fd_sc_mcu7t5v0__xor3_1_123/A3
+ gf180mcu_fd_sc_mcu7t5v0__xnor2_1_64/A2 vdd vss gf180mcu_fd_sc_mcu7t5v0__oai22_1
Xgf180mcu_fd_sc_mcu7t5v0__oai22_1_287 gf180mcu_fd_sc_mcu7t5v0__nand2_4_24/ZN gf180mcu_fd_sc_mcu7t5v0__nand2_2_52/ZN
+ gf180mcu_fd_sc_mcu7t5v0__oai22_1_287/B2 vdd vss gf180mcu_fd_sc_mcu7t5v0__dffq_1_320/D
+ gf180mcu_fd_sc_mcu7t5v0__oai22_1_98/A1 vdd vss gf180mcu_fd_sc_mcu7t5v0__oai22_1
Xgf180mcu_fd_sc_mcu7t5v0__dffq_1_130 vdd gf180mcu_fd_sc_mcu7t5v0__dffq_1_130/Q gf180mcu_fd_sc_mcu7t5v0__dffq_1_96/CLK
+ vss gf180mcu_fd_sc_mcu7t5v0__dffq_1_130/D vdd vss gf180mcu_fd_sc_mcu7t5v0__dffq_1
Xgf180mcu_fd_sc_mcu7t5v0__dffq_1_141 vdd gf180mcu_fd_sc_mcu7t5v0__dffq_1_141/Q gf180mcu_fd_sc_mcu7t5v0__dffq_1_96/CLK
+ vss gf180mcu_fd_sc_mcu7t5v0__dffq_1_141/D vdd vss gf180mcu_fd_sc_mcu7t5v0__dffq_1
Xgf180mcu_fd_sc_mcu7t5v0__nor2_1_330 vdd vss gf180mcu_fd_sc_mcu7t5v0__dffq_1_435/D
+ gf180mcu_fd_sc_mcu7t5v0__aoi21_1_7/B gf180mcu_fd_sc_mcu7t5v0__nor2_1_330/A2 vdd
+ vss gf180mcu_fd_sc_mcu7t5v0__nor2_1
Xgf180mcu_fd_sc_mcu7t5v0__dffq_1_152 vdd gf180mcu_fd_sc_mcu7t5v0__dffq_1_152/Q gf180mcu_fd_sc_mcu7t5v0__dffq_2_26/CLK
+ vss gf180mcu_fd_sc_mcu7t5v0__dffq_1_152/D vdd vss gf180mcu_fd_sc_mcu7t5v0__dffq_1
Xgf180mcu_fd_sc_mcu7t5v0__nor2_1_341 vdd vss gf180mcu_fd_sc_mcu7t5v0__xor3_1_113/A3
+ gf180mcu_fd_sc_mcu7t5v0__nor3_2_12/ZN gf180mcu_fd_sc_mcu7t5v0__nor3_1_35/A3 vdd
+ vss gf180mcu_fd_sc_mcu7t5v0__nor2_1
Xgf180mcu_fd_sc_mcu7t5v0__dffq_1_163 vdd gf180mcu_fd_sc_mcu7t5v0__dffq_1_163/Q gf180mcu_fd_sc_mcu7t5v0__dffq_2_26/CLK
+ vss gf180mcu_fd_sc_mcu7t5v0__dffq_1_163/D vdd vss gf180mcu_fd_sc_mcu7t5v0__dffq_1
Xgf180mcu_fd_sc_mcu7t5v0__nor2_1_352 vdd vss gf180mcu_fd_sc_mcu7t5v0__aoi21_2_21/B
+ gf180mcu_fd_sc_mcu7t5v0__or2_1_46/A2 gf180mcu_fd_sc_mcu7t5v0__xnor3_1_38/A3 vdd
+ vss gf180mcu_fd_sc_mcu7t5v0__nor2_1
Xgf180mcu_fd_sc_mcu7t5v0__dffq_1_174 vdd gf180mcu_fd_sc_mcu7t5v0__dffq_1_174/Q gf180mcu_fd_sc_mcu7t5v0__dffq_2_26/CLK
+ vss gf180mcu_fd_sc_mcu7t5v0__dffq_1_174/D vdd vss gf180mcu_fd_sc_mcu7t5v0__dffq_1
Xgf180mcu_fd_sc_mcu7t5v0__dffq_1_185 vdd gf180mcu_fd_sc_mcu7t5v0__dffq_1_185/Q gf180mcu_fd_sc_mcu7t5v0__dffq_2_58/CLK
+ vss gf180mcu_fd_sc_mcu7t5v0__dffq_1_185/D vdd vss gf180mcu_fd_sc_mcu7t5v0__dffq_1
Xgf180mcu_fd_sc_mcu7t5v0__clkinv_3_6 vdd gf180mcu_fd_sc_mcu7t5v0__nor3_4_5/A1 gf180mcu_fd_sc_mcu7t5v0__dffq_4_8/Q
+ vss vdd vss gf180mcu_fd_sc_mcu7t5v0__clkinv_3
Xgf180mcu_fd_sc_mcu7t5v0__nor2_1_363 vdd vss gf180mcu_fd_sc_mcu7t5v0__nor2_1_363/ZN
+ gf180mcu_fd_sc_mcu7t5v0__and4_1_2/Z gf180mcu_fd_sc_mcu7t5v0__xor3_1_178/Z vdd vss
+ gf180mcu_fd_sc_mcu7t5v0__nor2_1
Xgf180mcu_fd_sc_mcu7t5v0__nor2_1_374 vdd vss gf180mcu_fd_sc_mcu7t5v0__xor3_1_137/A2
+ gf180mcu_fd_sc_mcu7t5v0__or3_1_9/A1 gf180mcu_fd_sc_mcu7t5v0__or3_1_24/A2 vdd vss
+ gf180mcu_fd_sc_mcu7t5v0__nor2_1
Xgf180mcu_fd_sc_mcu7t5v0__dffq_1_196 vdd gf180mcu_fd_sc_mcu7t5v0__dffq_1_196/Q gf180mcu_fd_sc_mcu7t5v0__dffq_4_8/CLK
+ vss gf180mcu_fd_sc_mcu7t5v0__dffq_1_196/D vdd vss gf180mcu_fd_sc_mcu7t5v0__dffq_1
Xgf180mcu_fd_sc_mcu7t5v0__nor2_1_385 vdd vss gf180mcu_fd_sc_mcu7t5v0__nor2_1_385/ZN
+ gf180mcu_fd_sc_mcu7t5v0__dffq_2_88/Q gf180mcu_fd_sc_mcu7t5v0__xor3_1_154/A3 vdd
+ vss gf180mcu_fd_sc_mcu7t5v0__nor2_1
Xgf180mcu_fd_sc_mcu7t5v0__nor2_1_396 vdd vss gf180mcu_fd_sc_mcu7t5v0__nor2_1_396/ZN
+ gf180mcu_fd_sc_mcu7t5v0__inv_4_6/I gf180mcu_fd_sc_mcu7t5v0__xor3_1_150/A3 vdd vss
+ gf180mcu_fd_sc_mcu7t5v0__nor2_1
Xgf180mcu_fd_sc_mcu7t5v0__clkbuf_16_2 vdd vss gf180mcu_fd_sc_mcu7t5v0__dffq_1_95/CLK
+ gf180mcu_fd_sc_mcu7t5v0__clkbuf_16_9/I vdd vss gf180mcu_fd_sc_mcu7t5v0__clkbuf_16
Xgf180mcu_fd_sc_mcu7t5v0__nand2_1_0 vdd vss gf180mcu_fd_sc_mcu7t5v0__xor2_1_1/A1 gf180mcu_fd_sc_mcu7t5v0__or4_1_0/A1
+ gf180mcu_fd_sc_mcu7t5v0__and2_2_0/Z vdd vss gf180mcu_fd_sc_mcu7t5v0__nand2_1
Xgf180mcu_fd_sc_mcu7t5v0__or3_2_3 gf180mcu_fd_sc_mcu7t5v0__or3_2_3/A3 vdd vss gf180mcu_fd_sc_mcu7t5v0__or3_2_3/Z
+ gf180mcu_fd_sc_mcu7t5v0__inv_1_6/I gf180mcu_fd_sc_mcu7t5v0__or3_2_3/A2 vdd vss gf180mcu_fd_sc_mcu7t5v0__or3_2
Xgf180mcu_fd_sc_mcu7t5v0__inv_2_7 vss gf180mcu_fd_sc_mcu7t5v0__inv_2_7/ZN gf180mcu_fd_sc_mcu7t5v0__inv_2_7/I
+ vdd vdd vss gf180mcu_fd_sc_mcu7t5v0__inv_2
Xgf180mcu_fd_sc_mcu7t5v0__dffq_1_4 vdd gf180mcu_fd_sc_mcu7t5v0__dffq_1_4/Q gf180mcu_fd_sc_mcu7t5v0__dffq_4_6/CLK
+ vss gf180mcu_fd_sc_mcu7t5v0__dffq_1_4/D vdd vss gf180mcu_fd_sc_mcu7t5v0__dffq_1
Xgf180mcu_fd_sc_mcu7t5v0__nor2_1_160 vdd vss gf180mcu_fd_sc_mcu7t5v0__dffq_2_35/D
+ gf180mcu_fd_sc_mcu7t5v0__or2_1_23/A1 gf180mcu_fd_sc_mcu7t5v0__nor2_1_160/A2 vdd
+ vss gf180mcu_fd_sc_mcu7t5v0__nor2_1
Xgf180mcu_fd_sc_mcu7t5v0__clkinv_1_3 vdd vss gf180mcu_fd_sc_mcu7t5v0__xor3_1_7/A2
+ gf180mcu_fd_sc_mcu7t5v0__nor3_2_2/A1 vdd vss gf180mcu_fd_sc_mcu7t5v0__clkinv_1
Xgf180mcu_fd_sc_mcu7t5v0__nor2_1_171 vdd vss gf180mcu_fd_sc_mcu7t5v0__nor2_1_171/ZN
+ gf180mcu_fd_sc_mcu7t5v0__dffq_1_309/Q gf180mcu_fd_sc_mcu7t5v0__nor2_4_28/ZN vdd
+ vss gf180mcu_fd_sc_mcu7t5v0__nor2_1
Xgf180mcu_fd_sc_mcu7t5v0__xor3_1_150 gf180mcu_fd_sc_mcu7t5v0__xor3_1_150/A3 vdd vss
+ gf180mcu_fd_sc_mcu7t5v0__xor3_1_150/Z gf180mcu_fd_sc_mcu7t5v0__inv_4_6/ZN gf180mcu_fd_sc_mcu7t5v0__xor3_1_150/A2
+ vdd vss gf180mcu_fd_sc_mcu7t5v0__xor3_1
Xgf180mcu_fd_sc_mcu7t5v0__nor2_1_182 vdd vss gf180mcu_fd_sc_mcu7t5v0__nand4_2_5/A4
+ gf180mcu_fd_sc_mcu7t5v0__dffq_1_158/Q gf180mcu_fd_sc_mcu7t5v0__dffq_1_337/Q vdd
+ vss gf180mcu_fd_sc_mcu7t5v0__nor2_1
Xgf180mcu_fd_sc_mcu7t5v0__xor3_1_161 gf180mcu_fd_sc_mcu7t5v0__xor3_1_161/A3 vdd vss
+ gf180mcu_fd_sc_mcu7t5v0__xor3_1_161/Z gf180mcu_fd_sc_mcu7t5v0__xor3_1_161/A1 gf180mcu_fd_sc_mcu7t5v0__xor2_1_172/Z
+ vdd vss gf180mcu_fd_sc_mcu7t5v0__xor3_1
Xgf180mcu_fd_sc_mcu7t5v0__nor2_1_193 vdd vss gf180mcu_fd_sc_mcu7t5v0__dffq_1_364/D
+ gf180mcu_fd_sc_mcu7t5v0__oai31_4_2/ZN gf180mcu_fd_sc_mcu7t5v0__xor2_1_94/Z vdd vss
+ gf180mcu_fd_sc_mcu7t5v0__nor2_1
Xgf180mcu_fd_sc_mcu7t5v0__aoi22_1_108 gf180mcu_fd_sc_mcu7t5v0__nor2_4_9/ZN gf180mcu_fd_sc_mcu7t5v0__dffq_1_197/Q
+ vdd vss gf180mcu_fd_sc_mcu7t5v0__nand2_1_267/A1 gf180mcu_fd_sc_mcu7t5v0__dffq_1_198/Q
+ gf180mcu_fd_sc_mcu7t5v0__nor2_4_8/ZN vdd vss gf180mcu_fd_sc_mcu7t5v0__aoi22_1
Xgf180mcu_fd_sc_mcu7t5v0__aoi22_1_119 gf180mcu_fd_sc_mcu7t5v0__nand2_1_269/ZN gf180mcu_fd_sc_mcu7t5v0__nor2_4_4/ZN
+ vdd vss gf180mcu_fd_sc_mcu7t5v0__nand3_1_36/A1 gf180mcu_fd_sc_mcu7t5v0__nor3_4_11/ZN
+ gf180mcu_fd_sc_mcu7t5v0__nand2_1_211/ZN vdd vss gf180mcu_fd_sc_mcu7t5v0__aoi22_1
Xgf180mcu_fd_sc_mcu7t5v0__oai211_1_10 gf180mcu_fd_sc_mcu7t5v0__and2_4_3/Z gf180mcu_fd_sc_mcu7t5v0__oai211_1_10/C
+ vdd vss gf180mcu_fd_sc_mcu7t5v0__clkinv_1_13/I gf180mcu_fd_sc_mcu7t5v0__inv_2_3/I
+ gf180mcu_fd_sc_mcu7t5v0__or2_1_34/A2 vdd vss gf180mcu_fd_sc_mcu7t5v0__oai211_1
Xgf180mcu_fd_sc_mcu7t5v0__xor3_1_172 gf180mcu_fd_sc_mcu7t5v0__xor2_1_82/Z vdd vss
+ gf180mcu_fd_sc_mcu7t5v0__xor3_1_172/Z gf180mcu_fd_sc_mcu7t5v0__or2_1_55/A1 gf180mcu_fd_sc_mcu7t5v0__xor3_1_172/A2
+ vdd vss gf180mcu_fd_sc_mcu7t5v0__xor3_1
Xgf180mcu_fd_sc_mcu7t5v0__oai211_1_21 gf180mcu_fd_sc_mcu7t5v0__oai211_1_21/B gf180mcu_fd_sc_mcu7t5v0__buf_8_8/Z
+ vdd vss gf180mcu_fd_sc_mcu7t5v0__aoi21_1_173/B gf180mcu_fd_sc_mcu7t5v0__dffq_1_366/Q
+ gf180mcu_fd_sc_mcu7t5v0__nor2_1_205/ZN vdd vss gf180mcu_fd_sc_mcu7t5v0__oai211_1
Xgf180mcu_fd_sc_mcu7t5v0__oai211_1_32 gf180mcu_fd_sc_mcu7t5v0__xnor2_1_47/A1 gf180mcu_fd_sc_mcu7t5v0__inv_8_0/I
+ vdd vss gf180mcu_fd_sc_mcu7t5v0__oai31_1_17/B gf180mcu_fd_sc_mcu7t5v0__nor3_2_5/A1
+ gf180mcu_fd_sc_mcu7t5v0__xor2_1_139/A1 vdd vss gf180mcu_fd_sc_mcu7t5v0__oai211_1
Xgf180mcu_fd_sc_mcu7t5v0__oai211_1_43 gf180mcu_fd_sc_mcu7t5v0__oai211_1_43/B gf180mcu_fd_sc_mcu7t5v0__oai211_1_43/C
+ vdd vss gf180mcu_fd_sc_mcu7t5v0__oai211_1_39/B gf180mcu_fd_sc_mcu7t5v0__inv_12_1/I
+ gf180mcu_fd_sc_mcu7t5v0__inv_1_23/I vdd vss gf180mcu_fd_sc_mcu7t5v0__oai211_1
Xgf180mcu_fd_sc_mcu7t5v0__oai211_1_54 gf180mcu_fd_sc_mcu7t5v0__oai211_1_54/B gf180mcu_fd_sc_mcu7t5v0__oai211_1_54/C
+ vdd vss gf180mcu_fd_sc_mcu7t5v0__oai211_1_54/ZN gf180mcu_fd_sc_mcu7t5v0__nor2_1_394/ZN
+ gf180mcu_fd_sc_mcu7t5v0__oai211_1_54/A2 vdd vss gf180mcu_fd_sc_mcu7t5v0__oai211_1
Xgf180mcu_fd_sc_mcu7t5v0__oai21_1_220 vdd gf180mcu_fd_sc_mcu7t5v0__or2_1_34/A2 gf180mcu_fd_sc_mcu7t5v0__oai221_1_10/ZN
+ gf180mcu_fd_sc_mcu7t5v0__aoi21_1_366/B gf180mcu_fd_sc_mcu7t5v0__nor2_4_34/ZN vss
+ vdd vss gf180mcu_fd_sc_mcu7t5v0__oai21_1
Xgf180mcu_fd_sc_mcu7t5v0__oai21_1_231 vdd gf180mcu_fd_sc_mcu7t5v0__xor2_2_3/Z gf180mcu_fd_sc_mcu7t5v0__and2_1_110/Z
+ gf180mcu_fd_sc_mcu7t5v0__oai21_1_231/ZN gf180mcu_fd_sc_mcu7t5v0__nor2_1_383/ZN vss
+ vdd vss gf180mcu_fd_sc_mcu7t5v0__oai21_1
Xgf180mcu_fd_sc_mcu7t5v0__oai21_1_242 vdd gf180mcu_fd_sc_mcu7t5v0__oai21_1_242/B gf180mcu_fd_sc_mcu7t5v0__oai21_1_242/A2
+ gf180mcu_fd_sc_mcu7t5v0__oai21_1_254/B gf180mcu_fd_sc_mcu7t5v0__oai21_1_28/A1 vss
+ vdd vss gf180mcu_fd_sc_mcu7t5v0__oai21_1
Xgf180mcu_fd_sc_mcu7t5v0__oai21_1_253 vdd gf180mcu_fd_sc_mcu7t5v0__and2_4_3/Z gf180mcu_fd_sc_mcu7t5v0__or2_1_34/A2
+ gf180mcu_fd_sc_mcu7t5v0__nor2_1_316/A2 gf180mcu_fd_sc_mcu7t5v0__dffq_2_79/Q vss
+ vdd vss gf180mcu_fd_sc_mcu7t5v0__oai21_1
Xgf180mcu_fd_sc_mcu7t5v0__oai21_1_264 vdd gf180mcu_fd_sc_mcu7t5v0__or3_1_20/A3 gf180mcu_fd_sc_mcu7t5v0__or3_1_20/A2
+ gf180mcu_fd_sc_mcu7t5v0__and2_1_122/A2 gf180mcu_fd_sc_mcu7t5v0__or3_1_20/A1 vss
+ vdd vss gf180mcu_fd_sc_mcu7t5v0__oai21_1
Xgf180mcu_fd_sc_mcu7t5v0__oai21_1_275 vdd gf180mcu_fd_sc_mcu7t5v0__buf_12_0/Z gf180mcu_fd_sc_mcu7t5v0__buf_20_0/I
+ gf180mcu_fd_sc_mcu7t5v0__aoi21_1_368/B gf180mcu_fd_sc_mcu7t5v0__dffq_1_439/Q vss
+ vdd vss gf180mcu_fd_sc_mcu7t5v0__oai21_1
Xgf180mcu_fd_sc_mcu7t5v0__oai21_1_286 vdd gf180mcu_fd_sc_mcu7t5v0__oai21_1_286/B gf180mcu_fd_sc_mcu7t5v0__nor2_1_342/ZN
+ gf180mcu_fd_sc_mcu7t5v0__xor3_1_112/A2 gf180mcu_fd_sc_mcu7t5v0__xor3_1_114/A2 vss
+ vdd vss gf180mcu_fd_sc_mcu7t5v0__oai21_1
Xgf180mcu_fd_sc_mcu7t5v0__oai21_1_297 vdd gf180mcu_fd_sc_mcu7t5v0__buf_8_4/Z gf180mcu_fd_sc_mcu7t5v0__buf_20_0/I
+ gf180mcu_fd_sc_mcu7t5v0__aoi21_1_324/B gf180mcu_fd_sc_mcu7t5v0__dffq_1_441/Q vss
+ vdd vss gf180mcu_fd_sc_mcu7t5v0__oai21_1
Xgf180mcu_fd_sc_mcu7t5v0__nor2_1_1 vdd vss gf180mcu_fd_sc_mcu7t5v0__or3_1_5/A1 gf180mcu_fd_sc_mcu7t5v0__nor2_1_1/A1
+ gf180mcu_fd_sc_mcu7t5v0__xor2_1_65/Z vdd vss gf180mcu_fd_sc_mcu7t5v0__nor2_1
Xgf180mcu_fd_sc_mcu7t5v0__xor2_1_20 vdd vss gf180mcu_fd_sc_mcu7t5v0__xor2_1_20/Z gf180mcu_fd_sc_mcu7t5v0__xor2_1_20/A1
+ gf180mcu_fd_sc_mcu7t5v0__xor2_1_20/A2 vdd vss gf180mcu_fd_sc_mcu7t5v0__xor2_1
Xgf180mcu_fd_sc_mcu7t5v0__xor2_1_31 vdd vss gf180mcu_fd_sc_mcu7t5v0__xor2_1_31/Z gf180mcu_fd_sc_mcu7t5v0__xor2_1_31/A1
+ gf180mcu_fd_sc_mcu7t5v0__xor2_1_31/A2 vdd vss gf180mcu_fd_sc_mcu7t5v0__xor2_1
Xgf180mcu_fd_sc_mcu7t5v0__xor2_1_42 vdd vss gf180mcu_fd_sc_mcu7t5v0__xor2_1_42/Z gf180mcu_fd_sc_mcu7t5v0__xor2_1_42/A1
+ gf180mcu_fd_sc_mcu7t5v0__xor2_1_42/A2 vdd vss gf180mcu_fd_sc_mcu7t5v0__xor2_1
Xgf180mcu_fd_sc_mcu7t5v0__xor2_1_53 vdd vss gf180mcu_fd_sc_mcu7t5v0__or3_1_6/A3 gf180mcu_fd_sc_mcu7t5v0__or2_1_17/A1
+ gf180mcu_fd_sc_mcu7t5v0__or2_1_17/A2 vdd vss gf180mcu_fd_sc_mcu7t5v0__xor2_1
Xgf180mcu_fd_sc_mcu7t5v0__xor2_1_64 vdd vss gf180mcu_fd_sc_mcu7t5v0__xor2_1_64/Z gf180mcu_fd_sc_mcu7t5v0__xor2_1_64/A1
+ gf180mcu_fd_sc_mcu7t5v0__xor2_1_64/A2 vdd vss gf180mcu_fd_sc_mcu7t5v0__xor2_1
Xgf180mcu_fd_sc_mcu7t5v0__xor2_1_75 vdd vss gf180mcu_fd_sc_mcu7t5v0__xor2_1_75/Z gf180mcu_fd_sc_mcu7t5v0__xor2_1_75/A1
+ gf180mcu_fd_sc_mcu7t5v0__xor2_1_71/Z vdd vss gf180mcu_fd_sc_mcu7t5v0__xor2_1
Xgf180mcu_fd_sc_mcu7t5v0__xor2_1_86 vdd vss gf180mcu_fd_sc_mcu7t5v0__xor2_1_86/Z gf180mcu_fd_sc_mcu7t5v0__xor2_1_86/A1
+ gf180mcu_fd_sc_mcu7t5v0__xor2_1_86/A2 vdd vss gf180mcu_fd_sc_mcu7t5v0__xor2_1
Xgf180mcu_fd_sc_mcu7t5v0__xor2_1_97 vdd vss gf180mcu_fd_sc_mcu7t5v0__xor2_1_97/Z gf180mcu_fd_sc_mcu7t5v0__mux4_4_5/I0
+ gf180mcu_fd_sc_mcu7t5v0__xor2_1_97/A2 vdd vss gf180mcu_fd_sc_mcu7t5v0__xor2_1
Xgf180mcu_fd_sc_mcu7t5v0__aoi21_1_107 gf180mcu_fd_sc_mcu7t5v0__oai21_1_93/ZN vdd vss
+ gf180mcu_fd_sc_mcu7t5v0__dffq_1_291/D gf180mcu_fd_sc_mcu7t5v0__oai21_1_94/A2 gf180mcu_fd_sc_mcu7t5v0__aoi221_2_4/ZN
+ vdd vss gf180mcu_fd_sc_mcu7t5v0__aoi21_1
Xgf180mcu_fd_sc_mcu7t5v0__xor2_1_160 vdd vss gf180mcu_fd_sc_mcu7t5v0__xor2_1_160/Z
+ gf180mcu_fd_sc_mcu7t5v0__nor3_1_36/A2 gf180mcu_fd_sc_mcu7t5v0__xor2_1_160/A2 vdd
+ vss gf180mcu_fd_sc_mcu7t5v0__xor2_1
Xgf180mcu_fd_sc_mcu7t5v0__aoi21_1_118 gf180mcu_fd_sc_mcu7t5v0__or2_1_23/A1 vdd vss
+ gf180mcu_fd_sc_mcu7t5v0__dffq_1_287/D gf180mcu_fd_sc_mcu7t5v0__nand3_1_49/ZN gf180mcu_fd_sc_mcu7t5v0__nand2_1_309/ZN
+ vdd vss gf180mcu_fd_sc_mcu7t5v0__aoi21_1
Xgf180mcu_fd_sc_mcu7t5v0__xor2_1_171 vdd vss gf180mcu_fd_sc_mcu7t5v0__xor2_1_171/Z
+ gf180mcu_fd_sc_mcu7t5v0__xor3_2_2/A1 gf180mcu_fd_sc_mcu7t5v0__xor3_2_2/A3 vdd vss
+ gf180mcu_fd_sc_mcu7t5v0__xor2_1
Xgf180mcu_fd_sc_mcu7t5v0__aoi21_1_129 gf180mcu_fd_sc_mcu7t5v0__aoi21_1_129/B vdd vss
+ gf180mcu_fd_sc_mcu7t5v0__dffq_1_300/D gf180mcu_fd_sc_mcu7t5v0__dffq_4_20/Q gf180mcu_fd_sc_mcu7t5v0__aoi22_4_6/ZN
+ vdd vss gf180mcu_fd_sc_mcu7t5v0__aoi21_1
Xgf180mcu_fd_sc_mcu7t5v0__xor2_1_182 vdd vss gf180mcu_fd_sc_mcu7t5v0__xor2_1_182/Z
+ gf180mcu_fd_sc_mcu7t5v0__mux4_4_13/Z gf180mcu_fd_sc_mcu7t5v0__xor3_1_140/A3 vdd
+ vss gf180mcu_fd_sc_mcu7t5v0__xor2_1
Xgf180mcu_fd_sc_mcu7t5v0__xor2_1_193 vdd vss gf180mcu_fd_sc_mcu7t5v0__xor2_1_193/Z
+ gf180mcu_fd_sc_mcu7t5v0__and2_1_144/Z gf180mcu_fd_sc_mcu7t5v0__and2_1_143/Z vdd
+ vss gf180mcu_fd_sc_mcu7t5v0__xor2_1
Xgf180mcu_fd_sc_mcu7t5v0__and2_1_107 vdd vss gf180mcu_fd_sc_mcu7t5v0__nor3_2_7/A2
+ gf180mcu_fd_sc_mcu7t5v0__oai32_1_6/B1 gf180mcu_fd_sc_mcu7t5v0__nor3_4_16/A3 vdd
+ vss gf180mcu_fd_sc_mcu7t5v0__and2_1
Xgf180mcu_fd_sc_mcu7t5v0__and2_1_118 vdd vss gf180mcu_fd_sc_mcu7t5v0__aoi22_2_8/B2
+ gf180mcu_fd_sc_mcu7t5v0__dffq_4_32/Q gf180mcu_fd_sc_mcu7t5v0__inv_1_20/I vdd vss
+ gf180mcu_fd_sc_mcu7t5v0__and2_1
Xgf180mcu_fd_sc_mcu7t5v0__and2_1_129 vdd vss gf180mcu_fd_sc_mcu7t5v0__and2_1_129/Z
+ gf180mcu_fd_sc_mcu7t5v0__inv_1_23/I gf180mcu_fd_sc_mcu7t5v0__oai21_1_298/B vdd vss
+ gf180mcu_fd_sc_mcu7t5v0__and2_1
Xgf180mcu_fd_sc_mcu7t5v0__nand3_1_20 gf180mcu_fd_sc_mcu7t5v0__oai22_1_6/ZN vdd vss
+ gf180mcu_fd_sc_mcu7t5v0__nand3_1_20/ZN gf180mcu_fd_sc_mcu7t5v0__dffq_4_37/Q gf180mcu_fd_sc_mcu7t5v0__and2_2_0/Z
+ vdd vss gf180mcu_fd_sc_mcu7t5v0__nand3_1
Xgf180mcu_fd_sc_mcu7t5v0__nand3_1_31 gf180mcu_fd_sc_mcu7t5v0__inv_4_1/ZN vdd vss gf180mcu_fd_sc_mcu7t5v0__nand2_2_9/A1
+ gf180mcu_fd_sc_mcu7t5v0__dffq_2_21/Q gf180mcu_fd_sc_mcu7t5v0__inv_3_0/I vdd vss
+ gf180mcu_fd_sc_mcu7t5v0__nand3_1
Xgf180mcu_fd_sc_mcu7t5v0__nand3_1_42 gf180mcu_fd_sc_mcu7t5v0__nor2_2_14/A1 vdd vss
+ gf180mcu_fd_sc_mcu7t5v0__oai22_1_2/B2 gf180mcu_fd_sc_mcu7t5v0__dffq_4_8/Q gf180mcu_fd_sc_mcu7t5v0__inv_2_6/ZN
+ vdd vss gf180mcu_fd_sc_mcu7t5v0__nand3_1
Xgf180mcu_fd_sc_mcu7t5v0__nand3_1_53 gf180mcu_fd_sc_mcu7t5v0__nor3_4_13/ZN vdd vss
+ gf180mcu_fd_sc_mcu7t5v0__nand3_1_53/ZN gf180mcu_fd_sc_mcu7t5v0__dffq_2_44/Q gf180mcu_fd_sc_mcu7t5v0__nor3_2_3/ZN
+ vdd vss gf180mcu_fd_sc_mcu7t5v0__nand3_1
Xgf180mcu_fd_sc_mcu7t5v0__nand3_1_64 gf180mcu_fd_sc_mcu7t5v0__nand3_1_64/A3 vdd vss
+ gf180mcu_fd_sc_mcu7t5v0__nand3_1_64/ZN gf180mcu_fd_sc_mcu7t5v0__xor3_1_76/A2 gf180mcu_fd_sc_mcu7t5v0__or2_1_27/Z
+ vdd vss gf180mcu_fd_sc_mcu7t5v0__nand3_1
Xgf180mcu_fd_sc_mcu7t5v0__nand3_1_75 gf180mcu_fd_sc_mcu7t5v0__and2_2_11/A2 vdd vss
+ gf180mcu_fd_sc_mcu7t5v0__oai22_2_1/B2 gf180mcu_fd_sc_mcu7t5v0__or4_1_0/A1 gf180mcu_fd_sc_mcu7t5v0__and2_2_11/A1
+ vdd vss gf180mcu_fd_sc_mcu7t5v0__nand3_1
Xgf180mcu_fd_sc_mcu7t5v0__nand3_1_86 gf180mcu_fd_sc_mcu7t5v0__nand3_1_86/A3 vdd vss
+ gf180mcu_fd_sc_mcu7t5v0__oai211_1_43/B gf180mcu_fd_sc_mcu7t5v0__nand3_1_86/A1 gf180mcu_fd_sc_mcu7t5v0__nand3_1_86/A2
+ vdd vss gf180mcu_fd_sc_mcu7t5v0__nand3_1
Xgf180mcu_fd_sc_mcu7t5v0__nand3_1_97 gf180mcu_fd_sc_mcu7t5v0__xor2_1_188/Z vdd vss
+ gf180mcu_fd_sc_mcu7t5v0__nand3_1_97/ZN gf180mcu_fd_sc_mcu7t5v0__nand3_1_97/A1 gf180mcu_fd_sc_mcu7t5v0__nand3_1_97/A2
+ vdd vss gf180mcu_fd_sc_mcu7t5v0__nand3_1
Xgf180mcu_fd_sc_mcu7t5v0__nand2_1_407 vdd vss gf180mcu_fd_sc_mcu7t5v0__aoi21_2_8/A2
+ gf180mcu_fd_sc_mcu7t5v0__xnor3_1_26/A2 gf180mcu_fd_sc_mcu7t5v0__xnor3_1_26/A3 vdd
+ vss gf180mcu_fd_sc_mcu7t5v0__nand2_1
Xgf180mcu_fd_sc_mcu7t5v0__nand2_1_418 vdd vss gf180mcu_fd_sc_mcu7t5v0__nand2_1_418/ZN
+ gf180mcu_fd_sc_mcu7t5v0__inv_1_3/I gf180mcu_fd_sc_mcu7t5v0__or2_4_4/Z vdd vss gf180mcu_fd_sc_mcu7t5v0__nand2_1
Xgf180mcu_fd_sc_mcu7t5v0__nand2_1_429 vdd vss gf180mcu_fd_sc_mcu7t5v0__xor3_1_85/A2
+ gf180mcu_fd_sc_mcu7t5v0__or2_1_7/A1 gf180mcu_fd_sc_mcu7t5v0__mux4_4_6/Z vdd vss
+ gf180mcu_fd_sc_mcu7t5v0__nand2_1
Xgf180mcu_fd_sc_mcu7t5v0__xor2_1_9 vdd vss gf180mcu_fd_sc_mcu7t5v0__xor2_1_9/Z gf180mcu_fd_sc_mcu7t5v0__xor3_1_7/A1
+ gf180mcu_fd_sc_mcu7t5v0__xor3_1_7/A3 vdd vss gf180mcu_fd_sc_mcu7t5v0__xor2_1
Xgf180mcu_fd_sc_mcu7t5v0__dffq_2_15 gf180mcu_fd_sc_mcu7t5v0__dffq_2_15/D vdd vss gf180mcu_fd_sc_mcu7t5v0__dffq_4_6/CLK
+ gf180mcu_fd_sc_mcu7t5v0__inv_3_3/I vdd vss gf180mcu_fd_sc_mcu7t5v0__dffq_2
Xgf180mcu_fd_sc_mcu7t5v0__dffq_2_26 gf180mcu_fd_sc_mcu7t5v0__dffq_2_26/D vdd vss gf180mcu_fd_sc_mcu7t5v0__dffq_2_26/CLK
+ gf180mcu_fd_sc_mcu7t5v0__dffq_2_26/Q vdd vss gf180mcu_fd_sc_mcu7t5v0__dffq_2
Xgf180mcu_fd_sc_mcu7t5v0__dffq_2_37 gf180mcu_fd_sc_mcu7t5v0__dffq_2_37/D vdd vss gf180mcu_fd_sc_mcu7t5v0__dffq_4_9/CLK
+ gf180mcu_fd_sc_mcu7t5v0__mux4_2_0/I0 vdd vss gf180mcu_fd_sc_mcu7t5v0__dffq_2
Xgf180mcu_fd_sc_mcu7t5v0__dffq_2_48 gf180mcu_fd_sc_mcu7t5v0__dffq_2_48/D vdd vss gf180mcu_fd_sc_mcu7t5v0__dffq_4_15/CLK
+ gf180mcu_fd_sc_mcu7t5v0__nor4_4_3/A1 vdd vss gf180mcu_fd_sc_mcu7t5v0__dffq_2
Xgf180mcu_fd_sc_mcu7t5v0__dffq_2_59 gf180mcu_fd_sc_mcu7t5v0__dffq_2_59/D vdd vss gf180mcu_fd_sc_mcu7t5v0__dffq_4_21/CLK
+ gf180mcu_fd_sc_mcu7t5v0__or2_4_3/A1 vdd vss gf180mcu_fd_sc_mcu7t5v0__dffq_2
Xgf180mcu_fd_sc_mcu7t5v0__and3_1_13 gf180mcu_fd_sc_mcu7t5v0__and3_1_13/A3 vdd vss
+ gf180mcu_fd_sc_mcu7t5v0__dffq_4_21/D gf180mcu_fd_sc_mcu7t5v0__buf_8_7/Z gf180mcu_fd_sc_mcu7t5v0__dffq_1_374/Q
+ vdd vss gf180mcu_fd_sc_mcu7t5v0__and3_1
Xgf180mcu_fd_sc_mcu7t5v0__and3_1_24 gf180mcu_fd_sc_mcu7t5v0__oai32_1_3/A3 vdd vss
+ gf180mcu_fd_sc_mcu7t5v0__and3_1_24/Z gf180mcu_fd_sc_mcu7t5v0__nor2_2_15/A2 gf180mcu_fd_sc_mcu7t5v0__oai32_1_3/B2
+ vdd vss gf180mcu_fd_sc_mcu7t5v0__and3_1
Xgf180mcu_fd_sc_mcu7t5v0__or2_1_9 vdd vss gf180mcu_fd_sc_mcu7t5v0__or2_1_9/Z gf180mcu_fd_sc_mcu7t5v0__or2_1_9/A1
+ gf180mcu_fd_sc_mcu7t5v0__or2_1_9/A2 vdd vss gf180mcu_fd_sc_mcu7t5v0__or2_1
Xgf180mcu_fd_sc_mcu7t5v0__and2_1_0 vdd vss gf180mcu_fd_sc_mcu7t5v0__and2_1_0/Z gf180mcu_fd_sc_mcu7t5v0__xor3_1_6/A1
+ gf180mcu_fd_sc_mcu7t5v0__xor2_1_0/Z vdd vss gf180mcu_fd_sc_mcu7t5v0__and2_1
Xgf180mcu_fd_sc_mcu7t5v0__aoi22_4_8 gf180mcu_fd_sc_mcu7t5v0__nand4_4_2/ZN gf180mcu_fd_sc_mcu7t5v0__aoi22_4_8/B1
+ gf180mcu_fd_sc_mcu7t5v0__aoi22_4_8/B2 vdd vss gf180mcu_fd_sc_mcu7t5v0__aoi22_4_8/ZN
+ gf180mcu_fd_sc_mcu7t5v0__dffq_2_52/Q vdd vss gf180mcu_fd_sc_mcu7t5v0__aoi22_4
Xgf180mcu_fd_sc_mcu7t5v0__nand2_1_204 vdd vss gf180mcu_fd_sc_mcu7t5v0__mux2_1_4/I1
+ gf180mcu_fd_sc_mcu7t5v0__inv_8_0/I gf180mcu_fd_sc_mcu7t5v0__xnor2_1_25/A1 vdd vss
+ gf180mcu_fd_sc_mcu7t5v0__nand2_1
Xgf180mcu_fd_sc_mcu7t5v0__nand2_1_215 vdd vss gf180mcu_fd_sc_mcu7t5v0__aoi222_2_4/C1
+ gf180mcu_fd_sc_mcu7t5v0__aoi22_1_43/ZN gf180mcu_fd_sc_mcu7t5v0__nand2_1_215/A2 vdd
+ vss gf180mcu_fd_sc_mcu7t5v0__nand2_1
Xgf180mcu_fd_sc_mcu7t5v0__nand2_1_226 vdd vss gf180mcu_fd_sc_mcu7t5v0__aoi222_2_1/A2
+ gf180mcu_fd_sc_mcu7t5v0__aoi22_1_55/ZN gf180mcu_fd_sc_mcu7t5v0__aoi22_1_54/ZN vdd
+ vss gf180mcu_fd_sc_mcu7t5v0__nand2_1
Xgf180mcu_fd_sc_mcu7t5v0__nand2_1_237 vdd vss gf180mcu_fd_sc_mcu7t5v0__aoi222_2_1/B1
+ gf180mcu_fd_sc_mcu7t5v0__aoi22_1_71/ZN gf180mcu_fd_sc_mcu7t5v0__aoi22_1_35/ZN vdd
+ vss gf180mcu_fd_sc_mcu7t5v0__nand2_1
Xgf180mcu_fd_sc_mcu7t5v0__nand2_1_248 vdd vss gf180mcu_fd_sc_mcu7t5v0__aoi222_1_0/B1
+ gf180mcu_fd_sc_mcu7t5v0__nand2_1_248/A1 gf180mcu_fd_sc_mcu7t5v0__nand2_1_248/A2
+ vdd vss gf180mcu_fd_sc_mcu7t5v0__nand2_1
Xgf180mcu_fd_sc_mcu7t5v0__nand2_1_259 vdd vss gf180mcu_fd_sc_mcu7t5v0__nand2_1_259/ZN
+ gf180mcu_fd_sc_mcu7t5v0__oai32_1_3/B2 gf180mcu_fd_sc_mcu7t5v0__oai221_1_5/B2 vdd
+ vss gf180mcu_fd_sc_mcu7t5v0__nand2_1
Xgf180mcu_fd_sc_mcu7t5v0__aoi21_1_16 gf180mcu_fd_sc_mcu7t5v0__xor2_1_14/Z vdd vss
+ gf180mcu_fd_sc_mcu7t5v0__nor3_1_3/A2 gf180mcu_fd_sc_mcu7t5v0__nand3_1_4/A1 gf180mcu_fd_sc_mcu7t5v0__nand3_1_4/A2
+ vdd vss gf180mcu_fd_sc_mcu7t5v0__aoi21_1
Xgf180mcu_fd_sc_mcu7t5v0__aoi21_1_27 gf180mcu_fd_sc_mcu7t5v0__nor2_2_3/ZN vdd vss
+ gf180mcu_fd_sc_mcu7t5v0__aoi21_1_27/ZN gf180mcu_fd_sc_mcu7t5v0__oai22_1_2/B2 gf180mcu_fd_sc_mcu7t5v0__oai21_1_16/A1
+ vdd vss gf180mcu_fd_sc_mcu7t5v0__aoi21_1
Xgf180mcu_fd_sc_mcu7t5v0__aoi21_1_38 gf180mcu_fd_sc_mcu7t5v0__or2_4_4/Z vdd vss gf180mcu_fd_sc_mcu7t5v0__aoi22_1_7/B2
+ gf180mcu_fd_sc_mcu7t5v0__nor2_4_38/ZN gf180mcu_fd_sc_mcu7t5v0__xor3_1_23/Z vdd vss
+ gf180mcu_fd_sc_mcu7t5v0__aoi21_1
Xgf180mcu_fd_sc_mcu7t5v0__aoi21_1_49 gf180mcu_fd_sc_mcu7t5v0__nor2_1_64/ZN vdd vss
+ gf180mcu_fd_sc_mcu7t5v0__or2_1_12/A1 gf180mcu_fd_sc_mcu7t5v0__aoi21_1_49/A1 gf180mcu_fd_sc_mcu7t5v0__nand2_1_95/ZN
+ vdd vss gf180mcu_fd_sc_mcu7t5v0__aoi21_1
Xgf180mcu_fd_sc_mcu7t5v0__nor2_2_13 vdd vss gf180mcu_fd_sc_mcu7t5v0__xor3_2_0/A1 gf180mcu_fd_sc_mcu7t5v0__oai32_1_3/B1
+ gf180mcu_fd_sc_mcu7t5v0__nor3_4_1/A3 vdd vss gf180mcu_fd_sc_mcu7t5v0__nor2_2
Xgf180mcu_fd_sc_mcu7t5v0__nor2_2_24 vdd vss gf180mcu_fd_sc_mcu7t5v0__mux2_1_8/I1 gf180mcu_fd_sc_mcu7t5v0__inv_2_9/I
+ gf180mcu_fd_sc_mcu7t5v0__and3_2_3/A3 vdd vss gf180mcu_fd_sc_mcu7t5v0__nor2_2
Xgf180mcu_fd_sc_mcu7t5v0__nor2_2_35 vdd vss gf180mcu_fd_sc_mcu7t5v0__aoi21_4_7/B gf180mcu_fd_sc_mcu7t5v0__or2_1_39/A1
+ gf180mcu_fd_sc_mcu7t5v0__or2_1_36/Z vdd vss gf180mcu_fd_sc_mcu7t5v0__nor2_2
Xgf180mcu_fd_sc_mcu7t5v0__nor2_2_46 vdd vss gf180mcu_fd_sc_mcu7t5v0__nor2_2_46/ZN
+ gf180mcu_fd_sc_mcu7t5v0__inv_3_4/I gf180mcu_fd_sc_mcu7t5v0__nor2_2_46/A2 vdd vss
+ gf180mcu_fd_sc_mcu7t5v0__nor2_2
Xgf180mcu_fd_sc_mcu7t5v0__nor2_2_57 vdd vss gf180mcu_fd_sc_mcu7t5v0__nor2_2_57/ZN
+ gf180mcu_fd_sc_mcu7t5v0__nor3_1_41/A1 gf180mcu_fd_sc_mcu7t5v0__nor3_1_41/A2 vdd
+ vss gf180mcu_fd_sc_mcu7t5v0__nor2_2
Xgf180mcu_fd_sc_mcu7t5v0__dffq_1_301 vdd gf180mcu_fd_sc_mcu7t5v0__dffq_1_301/Q gf180mcu_fd_sc_mcu7t5v0__dffq_4_9/CLK
+ vss gf180mcu_fd_sc_mcu7t5v0__dffq_1_301/D vdd vss gf180mcu_fd_sc_mcu7t5v0__dffq_1
Xgf180mcu_fd_sc_mcu7t5v0__dffq_1_312 vdd gf180mcu_fd_sc_mcu7t5v0__dffq_1_312/Q gf180mcu_fd_sc_mcu7t5v0__dffq_4_9/CLK
+ vss gf180mcu_fd_sc_mcu7t5v0__dffq_1_312/D vdd vss gf180mcu_fd_sc_mcu7t5v0__dffq_1
Xgf180mcu_fd_sc_mcu7t5v0__dffq_1_323 vdd gf180mcu_fd_sc_mcu7t5v0__dffq_1_323/Q gf180mcu_fd_sc_mcu7t5v0__dffq_2_58/CLK
+ vss gf180mcu_fd_sc_mcu7t5v0__dffq_1_323/D vdd vss gf180mcu_fd_sc_mcu7t5v0__dffq_1
Xgf180mcu_fd_sc_mcu7t5v0__dffq_1_334 vdd gf180mcu_fd_sc_mcu7t5v0__dffq_1_334/Q gf180mcu_fd_sc_mcu7t5v0__dffq_2_58/CLK
+ vss gf180mcu_fd_sc_mcu7t5v0__dffq_1_334/D vdd vss gf180mcu_fd_sc_mcu7t5v0__dffq_1
Xgf180mcu_fd_sc_mcu7t5v0__dffq_1_345 vdd gf180mcu_fd_sc_mcu7t5v0__dffq_1_345/Q gf180mcu_fd_sc_mcu7t5v0__dffq_4_15/CLK
+ vss gf180mcu_fd_sc_mcu7t5v0__dffq_1_345/D vdd vss gf180mcu_fd_sc_mcu7t5v0__dffq_1
Xgf180mcu_fd_sc_mcu7t5v0__dffq_1_356 vdd gf180mcu_fd_sc_mcu7t5v0__nor4_1_2/A4 gf180mcu_fd_sc_mcu7t5v0__dffq_4_15/CLK
+ vss gf180mcu_fd_sc_mcu7t5v0__dffq_1_356/D vdd vss gf180mcu_fd_sc_mcu7t5v0__dffq_1
Xgf180mcu_fd_sc_mcu7t5v0__dffq_1_367 vdd gf180mcu_fd_sc_mcu7t5v0__dffq_1_367/Q gf180mcu_fd_sc_mcu7t5v0__dffq_4_15/CLK
+ vss gf180mcu_fd_sc_mcu7t5v0__dffq_1_367/D vdd vss gf180mcu_fd_sc_mcu7t5v0__dffq_1
Xgf180mcu_fd_sc_mcu7t5v0__oai22_1_13 gf180mcu_fd_sc_mcu7t5v0__nand2_4_2/ZN gf180mcu_fd_sc_mcu7t5v0__oai22_1_29/B1
+ gf180mcu_fd_sc_mcu7t5v0__oai22_1_13/B2 vdd vss gf180mcu_fd_sc_mcu7t5v0__dffq_1_18/D
+ gf180mcu_fd_sc_mcu7t5v0__aoi21_4_1/ZN vdd vss gf180mcu_fd_sc_mcu7t5v0__oai22_1
Xgf180mcu_fd_sc_mcu7t5v0__dffq_1_378 vdd gf180mcu_fd_sc_mcu7t5v0__or4_1_2/A1 gf180mcu_fd_sc_mcu7t5v0__dffq_4_15/CLK
+ vss gf180mcu_fd_sc_mcu7t5v0__nor3_1_18/ZN vdd vss gf180mcu_fd_sc_mcu7t5v0__dffq_1
Xgf180mcu_fd_sc_mcu7t5v0__oai22_1_24 gf180mcu_fd_sc_mcu7t5v0__nand2_4_3/ZN gf180mcu_fd_sc_mcu7t5v0__oai22_1_45/B1
+ gf180mcu_fd_sc_mcu7t5v0__oai22_1_24/B2 vdd vss gf180mcu_fd_sc_mcu7t5v0__dffq_1_51/D
+ gf180mcu_fd_sc_mcu7t5v0__oai22_1_98/A1 vdd vss gf180mcu_fd_sc_mcu7t5v0__oai22_1
Xgf180mcu_fd_sc_mcu7t5v0__dffq_1_389 vdd gf180mcu_fd_sc_mcu7t5v0__nand4_1_8/A2 gf180mcu_fd_sc_mcu7t5v0__dffq_4_21/CLK
+ vss gf180mcu_fd_sc_mcu7t5v0__nor3_1_22/ZN vdd vss gf180mcu_fd_sc_mcu7t5v0__dffq_1
Xgf180mcu_fd_sc_mcu7t5v0__oai22_1_35 gf180mcu_fd_sc_mcu7t5v0__oai22_1_48/A2 gf180mcu_fd_sc_mcu7t5v0__oai21_4_9/ZN
+ gf180mcu_fd_sc_mcu7t5v0__nand2_4_5/ZN vdd vss gf180mcu_fd_sc_mcu7t5v0__dffq_1_53/D
+ gf180mcu_fd_sc_mcu7t5v0__oai22_1_35/A1 vdd vss gf180mcu_fd_sc_mcu7t5v0__oai22_1
Xgf180mcu_fd_sc_mcu7t5v0__oai22_1_46 gf180mcu_fd_sc_mcu7t5v0__oai22_1_48/A2 gf180mcu_fd_sc_mcu7t5v0__oai22_1_88/A1
+ gf180mcu_fd_sc_mcu7t5v0__nand2_4_5/ZN vdd vss gf180mcu_fd_sc_mcu7t5v0__dffq_1_43/D
+ gf180mcu_fd_sc_mcu7t5v0__oai22_1_46/A1 vdd vss gf180mcu_fd_sc_mcu7t5v0__oai22_1
Xgf180mcu_fd_sc_mcu7t5v0__oai22_1_57 gf180mcu_fd_sc_mcu7t5v0__oai22_1_62/A2 gf180mcu_fd_sc_mcu7t5v0__oai22_1_62/B1
+ gf180mcu_fd_sc_mcu7t5v0__oai22_1_57/B2 vdd vss gf180mcu_fd_sc_mcu7t5v0__dffq_1_65/D
+ gf180mcu_fd_sc_mcu7t5v0__aoi21_4_4/ZN vdd vss gf180mcu_fd_sc_mcu7t5v0__oai22_1
Xgf180mcu_fd_sc_mcu7t5v0__oai22_1_68 gf180mcu_fd_sc_mcu7t5v0__oai22_1_90/A2 gf180mcu_fd_sc_mcu7t5v0__oai22_1_90/B1
+ gf180mcu_fd_sc_mcu7t5v0__oai22_1_68/B2 vdd vss gf180mcu_fd_sc_mcu7t5v0__dffq_1_73/D
+ gf180mcu_fd_sc_mcu7t5v0__aoi21_4_3/ZN vdd vss gf180mcu_fd_sc_mcu7t5v0__oai22_1
Xgf180mcu_fd_sc_mcu7t5v0__oai22_1_79 gf180mcu_fd_sc_mcu7t5v0__nand2_4_7/ZN gf180mcu_fd_sc_mcu7t5v0__oai22_1_94/B1
+ gf180mcu_fd_sc_mcu7t5v0__oai22_1_79/B2 vdd vss gf180mcu_fd_sc_mcu7t5v0__dffq_1_79/D
+ gf180mcu_fd_sc_mcu7t5v0__oai22_1_98/A1 vdd vss gf180mcu_fd_sc_mcu7t5v0__oai22_1
Xgf180mcu_fd_sc_mcu7t5v0__and2_1_90 vdd vss gf180mcu_fd_sc_mcu7t5v0__and2_1_90/Z gf180mcu_fd_sc_mcu7t5v0__inv_1_3/I
+ gf180mcu_fd_sc_mcu7t5v0__or2_1_40/A2 vdd vss gf180mcu_fd_sc_mcu7t5v0__and2_1
Xgf180mcu_fd_sc_mcu7t5v0__clkinv_1_206 vdd vss gf180mcu_fd_sc_mcu7t5v0__and2_2_3/Z
+ gf180mcu_fd_sc_mcu7t5v0__xor2_1_68/A1 vdd vss gf180mcu_fd_sc_mcu7t5v0__clkinv_1
Xgf180mcu_fd_sc_mcu7t5v0__clkinv_1_217 vdd vss gf180mcu_fd_sc_mcu7t5v0__dffq_1_203/Q
+ gf180mcu_fd_sc_mcu7t5v0__oai22_1_207/B2 vdd vss gf180mcu_fd_sc_mcu7t5v0__clkinv_1
Xgf180mcu_fd_sc_mcu7t5v0__clkinv_1_228 vdd vss gf180mcu_fd_sc_mcu7t5v0__dffq_1_206/Q
+ gf180mcu_fd_sc_mcu7t5v0__oai22_1_215/B2 vdd vss gf180mcu_fd_sc_mcu7t5v0__clkinv_1
Xgf180mcu_fd_sc_mcu7t5v0__clkinv_1_239 vdd vss gf180mcu_fd_sc_mcu7t5v0__dffq_1_251/Q
+ gf180mcu_fd_sc_mcu7t5v0__oai22_1_231/B2 vdd vss gf180mcu_fd_sc_mcu7t5v0__clkinv_1
Xgf180mcu_fd_sc_mcu7t5v0__aoi211_1_80 gf180mcu_fd_sc_mcu7t5v0__nor2_1_334/ZN gf180mcu_fd_sc_mcu7t5v0__or2_1_23/A1
+ vdd vss gf180mcu_fd_sc_mcu7t5v0__dffq_1_439/D gf180mcu_fd_sc_mcu7t5v0__nor2_1_144/A1
+ gf180mcu_fd_sc_mcu7t5v0__nor2_4_27/ZN vdd vss gf180mcu_fd_sc_mcu7t5v0__aoi211_1
Xgf180mcu_fd_sc_mcu7t5v0__oai221_1_12 gf180mcu_fd_sc_mcu7t5v0__oai221_1_12/B1 gf180mcu_fd_sc_mcu7t5v0__oai221_1_12/C
+ vdd vss gf180mcu_fd_sc_mcu7t5v0__aoi211_1_69/B gf180mcu_fd_sc_mcu7t5v0__oai21_1_28/A1
+ gf180mcu_fd_sc_mcu7t5v0__and2_1_42/A1 gf180mcu_fd_sc_mcu7t5v0__nor2_1_314/ZN vdd
+ vss gf180mcu_fd_sc_mcu7t5v0__oai221_1
Xgf180mcu_fd_sc_mcu7t5v0__dffq_2_109 gf180mcu_fd_sc_mcu7t5v0__dffq_2_109/D vdd vss
+ gf180mcu_fd_sc_mcu7t5v0__dffq_4_44/CLK gf180mcu_fd_sc_mcu7t5v0__or3_2_3/A3 vdd vss
+ gf180mcu_fd_sc_mcu7t5v0__dffq_2
Xgf180mcu_fd_sc_mcu7t5v0__aoi21_1_290 gf180mcu_fd_sc_mcu7t5v0__aoi21_1_290/B vdd vss
+ gf180mcu_fd_sc_mcu7t5v0__dffq_1_425/D gf180mcu_fd_sc_mcu7t5v0__inv_1_18/ZN gf180mcu_fd_sc_mcu7t5v0__buf_20_0/I
+ vdd vss gf180mcu_fd_sc_mcu7t5v0__aoi21_1
Xgf180mcu_fd_sc_mcu7t5v0__aoi22_2_5 gf180mcu_fd_sc_mcu7t5v0__nor2_2_4/ZN gf180mcu_fd_sc_mcu7t5v0__mux4_4_19/I1
+ vdd vss gf180mcu_fd_sc_mcu7t5v0__nor4_2_0/A4 gf180mcu_fd_sc_mcu7t5v0__inv_1_1/I
+ gf180mcu_fd_sc_mcu7t5v0__and2_2_7/Z vdd vss gf180mcu_fd_sc_mcu7t5v0__aoi22_2
Xgf180mcu_fd_sc_mcu7t5v0__oai21_4_0 gf180mcu_fd_sc_mcu7t5v0__oai21_4_0/B vdd vss gf180mcu_fd_sc_mcu7t5v0__inv_2_0/I
+ gf180mcu_fd_sc_mcu7t5v0__and2_2_2/A2 gf180mcu_fd_sc_mcu7t5v0__oai21_4_0/A2 vdd vss
+ gf180mcu_fd_sc_mcu7t5v0__oai21_4
Xgf180mcu_fd_sc_mcu7t5v0__oai22_1_200 gf180mcu_fd_sc_mcu7t5v0__nand2_4_32/ZN gf180mcu_fd_sc_mcu7t5v0__nand2_2_33/ZN
+ gf180mcu_fd_sc_mcu7t5v0__oai22_1_200/B2 vdd vss gf180mcu_fd_sc_mcu7t5v0__dffq_1_204/D
+ gf180mcu_fd_sc_mcu7t5v0__oai22_1_88/A1 vdd vss gf180mcu_fd_sc_mcu7t5v0__oai22_1
Xgf180mcu_fd_sc_mcu7t5v0__oai22_1_211 gf180mcu_fd_sc_mcu7t5v0__nand2_4_26/ZN gf180mcu_fd_sc_mcu7t5v0__nand2_2_38/ZN
+ gf180mcu_fd_sc_mcu7t5v0__oai22_1_211/B2 vdd vss gf180mcu_fd_sc_mcu7t5v0__dffq_1_277/D
+ gf180mcu_fd_sc_mcu7t5v0__aoi21_4_1/ZN vdd vss gf180mcu_fd_sc_mcu7t5v0__oai22_1
Xgf180mcu_fd_sc_mcu7t5v0__oai22_1_222 gf180mcu_fd_sc_mcu7t5v0__nand2_4_27/ZN gf180mcu_fd_sc_mcu7t5v0__nand2_2_43/ZN
+ gf180mcu_fd_sc_mcu7t5v0__oai22_1_222/B2 vdd vss gf180mcu_fd_sc_mcu7t5v0__dffq_1_211/D
+ gf180mcu_fd_sc_mcu7t5v0__oai22_1_98/A1 vdd vss gf180mcu_fd_sc_mcu7t5v0__oai22_1
Xgf180mcu_fd_sc_mcu7t5v0__oai21_1_90 vdd gf180mcu_fd_sc_mcu7t5v0__buf_8_4/Z gf180mcu_fd_sc_mcu7t5v0__buf_20_0/Z
+ gf180mcu_fd_sc_mcu7t5v0__oai21_1_90/ZN gf180mcu_fd_sc_mcu7t5v0__dffq_1_281/Q vss
+ vdd vss gf180mcu_fd_sc_mcu7t5v0__oai21_1
Xgf180mcu_fd_sc_mcu7t5v0__oai22_1_233 gf180mcu_fd_sc_mcu7t5v0__nand2_4_27/ZN gf180mcu_fd_sc_mcu7t5v0__nand2_2_43/ZN
+ gf180mcu_fd_sc_mcu7t5v0__oai22_1_233/B2 vdd vss gf180mcu_fd_sc_mcu7t5v0__dffq_1_224/D
+ gf180mcu_fd_sc_mcu7t5v0__oai21_4_9/ZN vdd vss gf180mcu_fd_sc_mcu7t5v0__oai22_1
Xgf180mcu_fd_sc_mcu7t5v0__oai22_1_244 gf180mcu_fd_sc_mcu7t5v0__nand2_4_29/ZN gf180mcu_fd_sc_mcu7t5v0__nand2_2_39/ZN
+ gf180mcu_fd_sc_mcu7t5v0__oai22_1_244/B2 vdd vss gf180mcu_fd_sc_mcu7t5v0__dffq_1_234/D
+ gf180mcu_fd_sc_mcu7t5v0__aoi21_4_5/ZN vdd vss gf180mcu_fd_sc_mcu7t5v0__oai22_1
Xgf180mcu_fd_sc_mcu7t5v0__oai22_1_255 gf180mcu_fd_sc_mcu7t5v0__nand2_4_32/ZN gf180mcu_fd_sc_mcu7t5v0__nand2_2_33/ZN
+ gf180mcu_fd_sc_mcu7t5v0__oai22_1_255/B2 vdd vss gf180mcu_fd_sc_mcu7t5v0__dffq_1_255/D
+ gf180mcu_fd_sc_mcu7t5v0__oai22_1_98/A1 vdd vss gf180mcu_fd_sc_mcu7t5v0__oai22_1
Xgf180mcu_fd_sc_mcu7t5v0__oai22_1_266 gf180mcu_fd_sc_mcu7t5v0__xor2_1_114/A1 gf180mcu_fd_sc_mcu7t5v0__and2_1_92/Z
+ gf180mcu_fd_sc_mcu7t5v0__xor3_1_86/A3 vdd vss gf180mcu_fd_sc_mcu7t5v0__xor3_1_85/A1
+ gf180mcu_fd_sc_mcu7t5v0__xnor2_1_43/A2 vdd vss gf180mcu_fd_sc_mcu7t5v0__oai22_1
Xgf180mcu_fd_sc_mcu7t5v0__oai22_1_277 gf180mcu_fd_sc_mcu7t5v0__nand3_1_91/A3 gf180mcu_fd_sc_mcu7t5v0__mux2_1_11/Z
+ gf180mcu_fd_sc_mcu7t5v0__oai22_1_277/B2 vdd vss gf180mcu_fd_sc_mcu7t5v0__nand4_1_21/A3
+ gf180mcu_fd_sc_mcu7t5v0__inv_8_1/I vdd vss gf180mcu_fd_sc_mcu7t5v0__oai22_1
Xgf180mcu_fd_sc_mcu7t5v0__oai22_1_288 gf180mcu_fd_sc_mcu7t5v0__nand2_4_24/ZN gf180mcu_fd_sc_mcu7t5v0__nand2_2_52/ZN
+ gf180mcu_fd_sc_mcu7t5v0__oai22_1_288/B2 vdd vss gf180mcu_fd_sc_mcu7t5v0__dffq_1_323/D
+ gf180mcu_fd_sc_mcu7t5v0__aoi21_4_5/ZN vdd vss gf180mcu_fd_sc_mcu7t5v0__oai22_1
Xgf180mcu_fd_sc_mcu7t5v0__dffq_1_120 vdd gf180mcu_fd_sc_mcu7t5v0__dffq_1_120/Q gf180mcu_fd_sc_mcu7t5v0__dffq_1_96/CLK
+ vss gf180mcu_fd_sc_mcu7t5v0__dffq_1_120/D vdd vss gf180mcu_fd_sc_mcu7t5v0__dffq_1
Xgf180mcu_fd_sc_mcu7t5v0__dffq_1_131 vdd gf180mcu_fd_sc_mcu7t5v0__dffq_1_131/Q gf180mcu_fd_sc_mcu7t5v0__dffq_1_96/CLK
+ vss gf180mcu_fd_sc_mcu7t5v0__dffq_1_131/D vdd vss gf180mcu_fd_sc_mcu7t5v0__dffq_1
Xgf180mcu_fd_sc_mcu7t5v0__nor2_1_320 vdd vss gf180mcu_fd_sc_mcu7t5v0__nor2_1_320/ZN
+ gf180mcu_fd_sc_mcu7t5v0__dffq_1_427/Q gf180mcu_fd_sc_mcu7t5v0__and3_2_2/Z vdd vss
+ gf180mcu_fd_sc_mcu7t5v0__nor2_1
Xgf180mcu_fd_sc_mcu7t5v0__dffq_1_142 vdd gf180mcu_fd_sc_mcu7t5v0__dffq_1_142/Q gf180mcu_fd_sc_mcu7t5v0__dffq_1_96/CLK
+ vss gf180mcu_fd_sc_mcu7t5v0__dffq_1_142/D vdd vss gf180mcu_fd_sc_mcu7t5v0__dffq_1
Xgf180mcu_fd_sc_mcu7t5v0__dffq_1_153 vdd gf180mcu_fd_sc_mcu7t5v0__dffq_1_153/Q gf180mcu_fd_sc_mcu7t5v0__dffq_2_26/CLK
+ vss gf180mcu_fd_sc_mcu7t5v0__dffq_1_153/D vdd vss gf180mcu_fd_sc_mcu7t5v0__dffq_1
Xgf180mcu_fd_sc_mcu7t5v0__nor2_1_331 vdd vss gf180mcu_fd_sc_mcu7t5v0__nor2_1_331/ZN
+ gf180mcu_fd_sc_mcu7t5v0__dffq_1_432/Q gf180mcu_fd_sc_mcu7t5v0__nor2_4_24/ZN vdd
+ vss gf180mcu_fd_sc_mcu7t5v0__nor2_1
Xgf180mcu_fd_sc_mcu7t5v0__nor2_1_342 vdd vss gf180mcu_fd_sc_mcu7t5v0__nor2_1_342/ZN
+ gf180mcu_fd_sc_mcu7t5v0__mux4_4_7/I0 gf180mcu_fd_sc_mcu7t5v0__xor2_1_173/Z vdd vss
+ gf180mcu_fd_sc_mcu7t5v0__nor2_1
Xgf180mcu_fd_sc_mcu7t5v0__dffq_1_164 vdd gf180mcu_fd_sc_mcu7t5v0__dffq_1_164/Q gf180mcu_fd_sc_mcu7t5v0__dffq_2_26/CLK
+ vss gf180mcu_fd_sc_mcu7t5v0__dffq_1_164/D vdd vss gf180mcu_fd_sc_mcu7t5v0__dffq_1
Xgf180mcu_fd_sc_mcu7t5v0__nor2_1_353 vdd vss gf180mcu_fd_sc_mcu7t5v0__nor2_1_353/ZN
+ gf180mcu_fd_sc_mcu7t5v0__xor3_1_125/A2 gf180mcu_fd_sc_mcu7t5v0__xor3_1_118/Z vdd
+ vss gf180mcu_fd_sc_mcu7t5v0__nor2_1
Xgf180mcu_fd_sc_mcu7t5v0__dffq_1_175 vdd gf180mcu_fd_sc_mcu7t5v0__dffq_1_175/Q gf180mcu_fd_sc_mcu7t5v0__dffq_2_26/CLK
+ vss gf180mcu_fd_sc_mcu7t5v0__dffq_1_175/D vdd vss gf180mcu_fd_sc_mcu7t5v0__dffq_1
Xgf180mcu_fd_sc_mcu7t5v0__nor2_1_364 vdd vss gf180mcu_fd_sc_mcu7t5v0__xor2_1_168/A1
+ gf180mcu_fd_sc_mcu7t5v0__xor2_1_170/A1 gf180mcu_fd_sc_mcu7t5v0__or2_1_47/Z vdd vss
+ gf180mcu_fd_sc_mcu7t5v0__nor2_1
Xgf180mcu_fd_sc_mcu7t5v0__clkinv_3_7 vdd gf180mcu_fd_sc_mcu7t5v0__nor2_4_45/A2 gf180mcu_fd_sc_mcu7t5v0__mux4_4_2/Z
+ vss vdd vss gf180mcu_fd_sc_mcu7t5v0__clkinv_3
Xgf180mcu_fd_sc_mcu7t5v0__dffq_1_186 vdd gf180mcu_fd_sc_mcu7t5v0__dffq_1_186/Q gf180mcu_fd_sc_mcu7t5v0__dffq_2_26/CLK
+ vss gf180mcu_fd_sc_mcu7t5v0__dffq_1_186/D vdd vss gf180mcu_fd_sc_mcu7t5v0__dffq_1
Xgf180mcu_fd_sc_mcu7t5v0__nor2_1_375 vdd vss gf180mcu_fd_sc_mcu7t5v0__xor3_1_133/A1
+ gf180mcu_fd_sc_mcu7t5v0__inv_8_0/ZN gf180mcu_fd_sc_mcu7t5v0__xor3_1_140/A2 vdd vss
+ gf180mcu_fd_sc_mcu7t5v0__nor2_1
Xgf180mcu_fd_sc_mcu7t5v0__dffq_1_197 vdd gf180mcu_fd_sc_mcu7t5v0__dffq_1_197/Q gf180mcu_fd_sc_mcu7t5v0__dffq_4_8/CLK
+ vss gf180mcu_fd_sc_mcu7t5v0__dffq_1_197/D vdd vss gf180mcu_fd_sc_mcu7t5v0__dffq_1
Xgf180mcu_fd_sc_mcu7t5v0__nor2_1_386 vdd vss gf180mcu_fd_sc_mcu7t5v0__nor2_1_386/ZN
+ gf180mcu_fd_sc_mcu7t5v0__nor2_2_54/A1 gf180mcu_fd_sc_mcu7t5v0__dffq_2_93/Q vdd vss
+ gf180mcu_fd_sc_mcu7t5v0__nor2_1
Xgf180mcu_fd_sc_mcu7t5v0__nor2_1_397 vdd vss gf180mcu_fd_sc_mcu7t5v0__nor2_1_397/ZN
+ gf180mcu_fd_sc_mcu7t5v0__nor3_1_41/A3 gf180mcu_fd_sc_mcu7t5v0__and2_1_150/Z vdd
+ vss gf180mcu_fd_sc_mcu7t5v0__nor2_1
Xgf180mcu_fd_sc_mcu7t5v0__nand2_1_590 vdd vss gf180mcu_fd_sc_mcu7t5v0__and3_1_21/A1
+ gf180mcu_fd_sc_mcu7t5v0__dffq_4_37/Q gf180mcu_fd_sc_mcu7t5v0__xor2_1_164/A2 vdd
+ vss gf180mcu_fd_sc_mcu7t5v0__nand2_1
Xgf180mcu_fd_sc_mcu7t5v0__clkbuf_16_10 vdd vss gf180mcu_fd_sc_mcu7t5v0__dffq_4_21/CLK
+ gf180mcu_fd_sc_mcu7t5v0__clkbuf_16_9/I vdd vss gf180mcu_fd_sc_mcu7t5v0__clkbuf_16
Xgf180mcu_fd_sc_mcu7t5v0__clkbuf_16_3 vdd vss gf180mcu_fd_sc_mcu7t5v0__dffq_2_26/CLK
+ gf180mcu_fd_sc_mcu7t5v0__clkbuf_16_9/I vdd vss gf180mcu_fd_sc_mcu7t5v0__clkbuf_16
Xgf180mcu_fd_sc_mcu7t5v0__nand2_1_1 vdd vss gf180mcu_fd_sc_mcu7t5v0__xnor3_1_0/A2
+ gf180mcu_fd_sc_mcu7t5v0__or4_1_0/A1 gf180mcu_fd_sc_mcu7t5v0__and2_4_0/Z vdd vss
+ gf180mcu_fd_sc_mcu7t5v0__nand2_1
Xgf180mcu_fd_sc_mcu7t5v0__or3_2_4 gf180mcu_fd_sc_mcu7t5v0__or3_2_4/A3 vdd vss gf180mcu_fd_sc_mcu7t5v0__or3_2_4/Z
+ gf180mcu_fd_sc_mcu7t5v0__or3_2_4/A1 gf180mcu_fd_sc_mcu7t5v0__or3_2_4/A2 vdd vss
+ gf180mcu_fd_sc_mcu7t5v0__or3_2
Xgf180mcu_fd_sc_mcu7t5v0__inv_2_8 vss gf180mcu_fd_sc_mcu7t5v0__inv_2_8/ZN gf180mcu_fd_sc_mcu7t5v0__inv_2_8/I
+ vdd vdd vss gf180mcu_fd_sc_mcu7t5v0__inv_2
Xgf180mcu_fd_sc_mcu7t5v0__dffq_1_5 vdd gf180mcu_fd_sc_mcu7t5v0__dffq_1_5/Q gf180mcu_fd_sc_mcu7t5v0__dffq_4_6/CLK
+ vss gf180mcu_fd_sc_mcu7t5v0__dffq_1_5/D vdd vss gf180mcu_fd_sc_mcu7t5v0__dffq_1
Xgf180mcu_fd_sc_mcu7t5v0__nor2_1_150 vdd vss gf180mcu_fd_sc_mcu7t5v0__dffq_2_44/D
+ gf180mcu_fd_sc_mcu7t5v0__or2_1_23/A1 gf180mcu_fd_sc_mcu7t5v0__nor2_4_32/ZN vdd vss
+ gf180mcu_fd_sc_mcu7t5v0__nor2_1
Xgf180mcu_fd_sc_mcu7t5v0__clkinv_1_4 vdd vss gf180mcu_fd_sc_mcu7t5v0__xor3_1_8/A1
+ gf180mcu_fd_sc_mcu7t5v0__oai32_1_0/A1 vdd vss gf180mcu_fd_sc_mcu7t5v0__clkinv_1
Xgf180mcu_fd_sc_mcu7t5v0__nor2_1_161 vdd vss gf180mcu_fd_sc_mcu7t5v0__nor2_1_161/ZN
+ gf180mcu_fd_sc_mcu7t5v0__nor2_1_161/A1 gf180mcu_fd_sc_mcu7t5v0__xor2_2_2/Z vdd vss
+ gf180mcu_fd_sc_mcu7t5v0__nor2_1
Xgf180mcu_fd_sc_mcu7t5v0__nor2_1_172 vdd vss gf180mcu_fd_sc_mcu7t5v0__nor2_1_172/ZN
+ gf180mcu_fd_sc_mcu7t5v0__or3_2_3/A3 gf180mcu_fd_sc_mcu7t5v0__xnor3_1_20/A3 vdd vss
+ gf180mcu_fd_sc_mcu7t5v0__nor2_1
Xgf180mcu_fd_sc_mcu7t5v0__xor3_1_140 gf180mcu_fd_sc_mcu7t5v0__xor3_1_140/A3 vdd vss
+ gf180mcu_fd_sc_mcu7t5v0__xor3_1_140/Z gf180mcu_fd_sc_mcu7t5v0__inv_8_0/ZN gf180mcu_fd_sc_mcu7t5v0__xor3_1_140/A2
+ vdd vss gf180mcu_fd_sc_mcu7t5v0__xor3_1
Xgf180mcu_fd_sc_mcu7t5v0__nor2_1_183 vdd vss gf180mcu_fd_sc_mcu7t5v0__nor3_1_11/A1
+ gf180mcu_fd_sc_mcu7t5v0__dffq_1_351/Q gf180mcu_fd_sc_mcu7t5v0__and3_1_10/Z vdd vss
+ gf180mcu_fd_sc_mcu7t5v0__nor2_1
Xgf180mcu_fd_sc_mcu7t5v0__xor3_1_151 gf180mcu_fd_sc_mcu7t5v0__xor3_1_148/Z vdd vss
+ gf180mcu_fd_sc_mcu7t5v0__xor3_1_151/Z gf180mcu_fd_sc_mcu7t5v0__xor3_1_151/A1 gf180mcu_fd_sc_mcu7t5v0__xor3_1_151/A2
+ vdd vss gf180mcu_fd_sc_mcu7t5v0__xor3_1
Xgf180mcu_fd_sc_mcu7t5v0__nor2_1_194 vdd vss gf180mcu_fd_sc_mcu7t5v0__nor3_1_19/A3
+ gf180mcu_fd_sc_mcu7t5v0__nor4_1_2/A2 gf180mcu_fd_sc_mcu7t5v0__and2_1_63/Z vdd vss
+ gf180mcu_fd_sc_mcu7t5v0__nor2_1
Xgf180mcu_fd_sc_mcu7t5v0__aoi22_1_109 gf180mcu_fd_sc_mcu7t5v0__nor2_4_9/ZN gf180mcu_fd_sc_mcu7t5v0__dffq_1_255/Q
+ vdd vss gf180mcu_fd_sc_mcu7t5v0__nand2_1_268/A1 gf180mcu_fd_sc_mcu7t5v0__dffq_1_248/Q
+ gf180mcu_fd_sc_mcu7t5v0__nor2_4_8/ZN vdd vss gf180mcu_fd_sc_mcu7t5v0__aoi22_1
Xgf180mcu_fd_sc_mcu7t5v0__xor3_1_162 gf180mcu_fd_sc_mcu7t5v0__xor3_1_162/A3 vdd vss
+ gf180mcu_fd_sc_mcu7t5v0__xor3_1_162/Z gf180mcu_fd_sc_mcu7t5v0__inv_8_0/I gf180mcu_fd_sc_mcu7t5v0__xor3_1_162/A2
+ vdd vss gf180mcu_fd_sc_mcu7t5v0__xor3_1
Xgf180mcu_fd_sc_mcu7t5v0__xor3_1_173 gf180mcu_fd_sc_mcu7t5v0__xor3_1_173/A3 vdd vss
+ gf180mcu_fd_sc_mcu7t5v0__xor3_1_173/Z gf180mcu_fd_sc_mcu7t5v0__xor3_1_173/A1 gf180mcu_fd_sc_mcu7t5v0__or2_1_56/A2
+ vdd vss gf180mcu_fd_sc_mcu7t5v0__xor3_1
Xgf180mcu_fd_sc_mcu7t5v0__oai211_1_11 gf180mcu_fd_sc_mcu7t5v0__or2_1_34/A2 gf180mcu_fd_sc_mcu7t5v0__oai211_1_11/C
+ vdd vss gf180mcu_fd_sc_mcu7t5v0__oai211_1_10/C gf180mcu_fd_sc_mcu7t5v0__nor2_1_72/ZN
+ gf180mcu_fd_sc_mcu7t5v0__oai211_1_11/A2 vdd vss gf180mcu_fd_sc_mcu7t5v0__oai211_1
Xgf180mcu_fd_sc_mcu7t5v0__oai211_1_22 gf180mcu_fd_sc_mcu7t5v0__aoi22_4_8/B1 gf180mcu_fd_sc_mcu7t5v0__buf_8_8/Z
+ vdd vss gf180mcu_fd_sc_mcu7t5v0__aoi21_1_172/B gf180mcu_fd_sc_mcu7t5v0__nand4_2_1/A2
+ gf180mcu_fd_sc_mcu7t5v0__aoi211_4_0/ZN vdd vss gf180mcu_fd_sc_mcu7t5v0__oai211_1
Xgf180mcu_fd_sc_mcu7t5v0__oai211_1_33 gf180mcu_fd_sc_mcu7t5v0__oai211_1_33/B gf180mcu_fd_sc_mcu7t5v0__xor3_1_100/Z
+ vdd vss gf180mcu_fd_sc_mcu7t5v0__xor2_1_140/A1 gf180mcu_fd_sc_mcu7t5v0__xnor2_1_48/A2
+ gf180mcu_fd_sc_mcu7t5v0__xor2_1_139/A1 vdd vss gf180mcu_fd_sc_mcu7t5v0__oai211_1
Xgf180mcu_fd_sc_mcu7t5v0__oai211_1_44 gf180mcu_fd_sc_mcu7t5v0__oai211_1_44/B gf180mcu_fd_sc_mcu7t5v0__or2_1_34/A2
+ vdd vss gf180mcu_fd_sc_mcu7t5v0__oai211_1_44/ZN gf180mcu_fd_sc_mcu7t5v0__oai211_1_43/C
+ gf180mcu_fd_sc_mcu7t5v0__xor3_1_112/Z vdd vss gf180mcu_fd_sc_mcu7t5v0__oai211_1
Xgf180mcu_fd_sc_mcu7t5v0__nand3_4_20 gf180mcu_fd_sc_mcu7t5v0__or2_1_36/A2 vdd vss
+ gf180mcu_fd_sc_mcu7t5v0__and2_2_9/A1 gf180mcu_fd_sc_mcu7t5v0__inv_2_5/ZN gf180mcu_fd_sc_mcu7t5v0__inv_4_4/ZN
+ vdd vss gf180mcu_fd_sc_mcu7t5v0__nand3_4
Xgf180mcu_fd_sc_mcu7t5v0__oai211_1_55 gf180mcu_fd_sc_mcu7t5v0__oai211_1_55/B gf180mcu_fd_sc_mcu7t5v0__or2_1_34/A2
+ vdd vss gf180mcu_fd_sc_mcu7t5v0__aoi21_1_74/A2 gf180mcu_fd_sc_mcu7t5v0__oai31_1_14/B
+ gf180mcu_fd_sc_mcu7t5v0__nor2_1_80/ZN vdd vss gf180mcu_fd_sc_mcu7t5v0__oai211_1
Xgf180mcu_fd_sc_mcu7t5v0__oai21_1_210 vdd gf180mcu_fd_sc_mcu7t5v0__oai21_1_210/B gf180mcu_fd_sc_mcu7t5v0__nor2_1_260/ZN
+ gf180mcu_fd_sc_mcu7t5v0__or2_1_29/A1 gf180mcu_fd_sc_mcu7t5v0__and2_1_153/Z vss vdd
+ vss gf180mcu_fd_sc_mcu7t5v0__oai21_1
Xgf180mcu_fd_sc_mcu7t5v0__oai21_1_221 vdd gf180mcu_fd_sc_mcu7t5v0__oai21_1_221/B gf180mcu_fd_sc_mcu7t5v0__xnor2_1_47/A1
+ gf180mcu_fd_sc_mcu7t5v0__nand4_1_13/A4 gf180mcu_fd_sc_mcu7t5v0__dffq_4_37/Q vss
+ vdd vss gf180mcu_fd_sc_mcu7t5v0__oai21_1
Xgf180mcu_fd_sc_mcu7t5v0__oai21_1_232 vdd gf180mcu_fd_sc_mcu7t5v0__nor3_1_33/A1 gf180mcu_fd_sc_mcu7t5v0__oai221_1_11/ZN
+ gf180mcu_fd_sc_mcu7t5v0__oai21_1_232/ZN gf180mcu_fd_sc_mcu7t5v0__oai32_1_6/ZN vss
+ vdd vss gf180mcu_fd_sc_mcu7t5v0__oai21_1
Xgf180mcu_fd_sc_mcu7t5v0__oai21_1_243 vdd gf180mcu_fd_sc_mcu7t5v0__oai21_1_243/B gf180mcu_fd_sc_mcu7t5v0__nor2_1_309/ZN
+ gf180mcu_fd_sc_mcu7t5v0__xor3_1_111/A2 gf180mcu_fd_sc_mcu7t5v0__and2_1_114/Z vss
+ vdd vss gf180mcu_fd_sc_mcu7t5v0__oai21_1
Xgf180mcu_fd_sc_mcu7t5v0__oai21_1_254 vdd gf180mcu_fd_sc_mcu7t5v0__oai21_1_254/B gf180mcu_fd_sc_mcu7t5v0__mux4_4_0/Z
+ gf180mcu_fd_sc_mcu7t5v0__nand4_1_17/A4 gf180mcu_fd_sc_mcu7t5v0__inv_8_2/I vss vdd
+ vss gf180mcu_fd_sc_mcu7t5v0__oai21_1
Xgf180mcu_fd_sc_mcu7t5v0__oai21_1_265 vdd gf180mcu_fd_sc_mcu7t5v0__buf_12_0/Z gf180mcu_fd_sc_mcu7t5v0__buf_20_0/Z
+ gf180mcu_fd_sc_mcu7t5v0__aoi21_1_304/B gf180mcu_fd_sc_mcu7t5v0__dffq_2_27/Q vss
+ vdd vss gf180mcu_fd_sc_mcu7t5v0__oai21_1
Xgf180mcu_fd_sc_mcu7t5v0__oai21_1_276 vdd gf180mcu_fd_sc_mcu7t5v0__buf_12_0/Z gf180mcu_fd_sc_mcu7t5v0__buf_20_0/I
+ gf180mcu_fd_sc_mcu7t5v0__aoi21_1_350/B gf180mcu_fd_sc_mcu7t5v0__dffq_1_431/Q vss
+ vdd vss gf180mcu_fd_sc_mcu7t5v0__oai21_1
Xgf180mcu_fd_sc_mcu7t5v0__oai21_1_287 vdd gf180mcu_fd_sc_mcu7t5v0__oai21_1_287/B gf180mcu_fd_sc_mcu7t5v0__nor2_1_343/ZN
+ gf180mcu_fd_sc_mcu7t5v0__xor3_1_113/A2 gf180mcu_fd_sc_mcu7t5v0__xor3_1_164/A2 vss
+ vdd vss gf180mcu_fd_sc_mcu7t5v0__oai21_1
Xgf180mcu_fd_sc_mcu7t5v0__oai21_1_298 vdd gf180mcu_fd_sc_mcu7t5v0__oai21_1_298/B gf180mcu_fd_sc_mcu7t5v0__nand3_1_93/ZN
+ gf180mcu_fd_sc_mcu7t5v0__xor2_1_181/A2 gf180mcu_fd_sc_mcu7t5v0__mux4_4_15/Z vss
+ vdd vss gf180mcu_fd_sc_mcu7t5v0__oai21_1
Xgf180mcu_fd_sc_mcu7t5v0__aoi221_1_0 gf180mcu_fd_sc_mcu7t5v0__aoi21_1_9/ZN gf180mcu_fd_sc_mcu7t5v0__aoi21_1_7/B
+ vdd vss gf180mcu_fd_sc_mcu7t5v0__dffq_2_2/D gf180mcu_fd_sc_mcu7t5v0__inv_1_1/ZN
+ gf180mcu_fd_sc_mcu7t5v0__or2_4_4/Z gf180mcu_fd_sc_mcu7t5v0__oai31_1_0/ZN vdd vss
+ gf180mcu_fd_sc_mcu7t5v0__aoi221_1
Xgf180mcu_fd_sc_mcu7t5v0__nor2_1_2 vdd vss gf180mcu_fd_sc_mcu7t5v0__xor3_1_1/A1 gf180mcu_fd_sc_mcu7t5v0__xor3_1_0/A2
+ gf180mcu_fd_sc_mcu7t5v0__xor3_1_48/Z vdd vss gf180mcu_fd_sc_mcu7t5v0__nor2_1
Xgf180mcu_fd_sc_mcu7t5v0__xor2_1_10 vdd vss gf180mcu_fd_sc_mcu7t5v0__xor3_1_7/A3 gf180mcu_fd_sc_mcu7t5v0__nor3_2_1/ZN
+ gf180mcu_fd_sc_mcu7t5v0__oai21_2_1/B vdd vss gf180mcu_fd_sc_mcu7t5v0__xor2_1
Xgf180mcu_fd_sc_mcu7t5v0__xor2_1_21 vdd vss gf180mcu_fd_sc_mcu7t5v0__or2_1_5/A2 gf180mcu_fd_sc_mcu7t5v0__xor2_1_21/A1
+ gf180mcu_fd_sc_mcu7t5v0__xor3_1_165/Z vdd vss gf180mcu_fd_sc_mcu7t5v0__xor2_1
Xgf180mcu_fd_sc_mcu7t5v0__xor2_1_32 vdd vss gf180mcu_fd_sc_mcu7t5v0__xor2_1_32/Z gf180mcu_fd_sc_mcu7t5v0__xor2_1_32/A1
+ gf180mcu_fd_sc_mcu7t5v0__xor3_1_25/Z vdd vss gf180mcu_fd_sc_mcu7t5v0__xor2_1
Xgf180mcu_fd_sc_mcu7t5v0__xor2_1_43 vdd vss gf180mcu_fd_sc_mcu7t5v0__xor2_1_43/Z gf180mcu_fd_sc_mcu7t5v0__xor2_1_43/A1
+ gf180mcu_fd_sc_mcu7t5v0__xor2_1_43/A2 vdd vss gf180mcu_fd_sc_mcu7t5v0__xor2_1
Xgf180mcu_fd_sc_mcu7t5v0__xor2_1_54 vdd vss gf180mcu_fd_sc_mcu7t5v0__xor2_1_54/Z gf180mcu_fd_sc_mcu7t5v0__and4_1_0/A4
+ gf180mcu_fd_sc_mcu7t5v0__xor2_1_54/A2 vdd vss gf180mcu_fd_sc_mcu7t5v0__xor2_1
Xgf180mcu_fd_sc_mcu7t5v0__xor2_1_65 vdd vss gf180mcu_fd_sc_mcu7t5v0__xor2_1_65/Z gf180mcu_fd_sc_mcu7t5v0__xor3_1_59/A2
+ gf180mcu_fd_sc_mcu7t5v0__xor3_1_1/Z vdd vss gf180mcu_fd_sc_mcu7t5v0__xor2_1
Xgf180mcu_fd_sc_mcu7t5v0__xor2_1_76 vdd vss gf180mcu_fd_sc_mcu7t5v0__xor2_1_76/Z gf180mcu_fd_sc_mcu7t5v0__xor2_1_76/A1
+ gf180mcu_fd_sc_mcu7t5v0__xor2_1_77/Z vdd vss gf180mcu_fd_sc_mcu7t5v0__xor2_1
Xgf180mcu_fd_sc_mcu7t5v0__xor2_1_87 vdd vss gf180mcu_fd_sc_mcu7t5v0__xor2_1_87/Z gf180mcu_fd_sc_mcu7t5v0__xor2_1_87/A1
+ gf180mcu_fd_sc_mcu7t5v0__xor2_1_87/A2 vdd vss gf180mcu_fd_sc_mcu7t5v0__xor2_1
Xgf180mcu_fd_sc_mcu7t5v0__xor2_1_98 vdd vss gf180mcu_fd_sc_mcu7t5v0__xor2_1_98/Z gf180mcu_fd_sc_mcu7t5v0__xor2_1_98/A1
+ gf180mcu_fd_sc_mcu7t5v0__xor2_1_98/A2 vdd vss gf180mcu_fd_sc_mcu7t5v0__xor2_1
Xgf180mcu_fd_sc_mcu7t5v0__xor2_1_150 vdd vss gf180mcu_fd_sc_mcu7t5v0__xor2_1_150/Z
+ gf180mcu_fd_sc_mcu7t5v0__or3_1_9/A2 gf180mcu_fd_sc_mcu7t5v0__and2_1_117/Z vdd vss
+ gf180mcu_fd_sc_mcu7t5v0__xor2_1
Xgf180mcu_fd_sc_mcu7t5v0__aoi21_1_108 gf180mcu_fd_sc_mcu7t5v0__nor2_1_144/ZN vdd vss
+ gf180mcu_fd_sc_mcu7t5v0__aoi21_1_157/A2 gf180mcu_fd_sc_mcu7t5v0__dffq_1_293/Q gf180mcu_fd_sc_mcu7t5v0__inv_2_8/I
+ vdd vss gf180mcu_fd_sc_mcu7t5v0__aoi21_1
Xgf180mcu_fd_sc_mcu7t5v0__xor2_1_161 vdd vss gf180mcu_fd_sc_mcu7t5v0__xor2_1_161/Z
+ gf180mcu_fd_sc_mcu7t5v0__inv_4_6/ZN gf180mcu_fd_sc_mcu7t5v0__xor2_1_162/Z vdd vss
+ gf180mcu_fd_sc_mcu7t5v0__xor2_1
Xgf180mcu_fd_sc_mcu7t5v0__aoi21_1_119 gf180mcu_fd_sc_mcu7t5v0__aoi21_1_119/B vdd vss
+ gf180mcu_fd_sc_mcu7t5v0__dffq_1_317/D gf180mcu_fd_sc_mcu7t5v0__and3_1_13/A3 gf180mcu_fd_sc_mcu7t5v0__nor2_4_31/ZN
+ vdd vss gf180mcu_fd_sc_mcu7t5v0__aoi21_1
Xgf180mcu_fd_sc_mcu7t5v0__xor2_1_172 vdd vss gf180mcu_fd_sc_mcu7t5v0__xor2_1_172/Z
+ gf180mcu_fd_sc_mcu7t5v0__xor2_1_172/A1 gf180mcu_fd_sc_mcu7t5v0__xor2_1_172/A2 vdd
+ vss gf180mcu_fd_sc_mcu7t5v0__xor2_1
Xgf180mcu_fd_sc_mcu7t5v0__xor2_1_183 vdd vss gf180mcu_fd_sc_mcu7t5v0__xor2_1_183/Z
+ gf180mcu_fd_sc_mcu7t5v0__or3_1_24/A2 gf180mcu_fd_sc_mcu7t5v0__and2_1_129/Z vdd vss
+ gf180mcu_fd_sc_mcu7t5v0__xor2_1
Xgf180mcu_fd_sc_mcu7t5v0__xor2_1_194 vdd vss gf180mcu_fd_sc_mcu7t5v0__xor2_1_194/Z
+ gf180mcu_fd_sc_mcu7t5v0__nor3_2_13/A1 gf180mcu_fd_sc_mcu7t5v0__xor2_1_195/Z vdd
+ vss gf180mcu_fd_sc_mcu7t5v0__xor2_1
Xgf180mcu_fd_sc_mcu7t5v0__and2_1_108 vdd vss gf180mcu_fd_sc_mcu7t5v0__oai22_2_1/B1
+ gf180mcu_fd_sc_mcu7t5v0__or2_1_38/A2 gf180mcu_fd_sc_mcu7t5v0__xnor3_1_33/A3 vdd
+ vss gf180mcu_fd_sc_mcu7t5v0__and2_1
Xgf180mcu_fd_sc_mcu7t5v0__and2_1_119 vdd vss gf180mcu_fd_sc_mcu7t5v0__nor3_2_9/A2
+ gf180mcu_fd_sc_mcu7t5v0__mux4_4_1/I0 gf180mcu_fd_sc_mcu7t5v0__aoi22_2_8/B2 vdd vss
+ gf180mcu_fd_sc_mcu7t5v0__and2_1
Xgf180mcu_fd_sc_mcu7t5v0__nand3_1_10 gf180mcu_fd_sc_mcu7t5v0__nand3_1_9/A2 vdd vss
+ gf180mcu_fd_sc_mcu7t5v0__nand4_1_0/A3 gf180mcu_fd_sc_mcu7t5v0__and3_1_24/Z gf180mcu_fd_sc_mcu7t5v0__or3_1_2/Z
+ vdd vss gf180mcu_fd_sc_mcu7t5v0__nand3_1
Xgf180mcu_fd_sc_mcu7t5v0__nand3_1_21 gf180mcu_fd_sc_mcu7t5v0__and2_2_4/A2 vdd vss
+ gf180mcu_fd_sc_mcu7t5v0__nor2_2_0/A1 gf180mcu_fd_sc_mcu7t5v0__inv_8_1/I gf180mcu_fd_sc_mcu7t5v0__and2_2_4/A1
+ vdd vss gf180mcu_fd_sc_mcu7t5v0__nand3_1
Xgf180mcu_fd_sc_mcu7t5v0__nand3_1_32 gf180mcu_fd_sc_mcu7t5v0__nor2_1_94/A1 vdd vss
+ gf180mcu_fd_sc_mcu7t5v0__oai31_1_3/B gf180mcu_fd_sc_mcu7t5v0__oai31_1_3/A1 gf180mcu_fd_sc_mcu7t5v0__nand3_1_35/ZN
+ vdd vss gf180mcu_fd_sc_mcu7t5v0__nand3_1
Xgf180mcu_fd_sc_mcu7t5v0__nand3_1_43 gf180mcu_fd_sc_mcu7t5v0__nand3_1_43/A3 vdd vss
+ gf180mcu_fd_sc_mcu7t5v0__nand3_1_43/ZN gf180mcu_fd_sc_mcu7t5v0__nand3_1_43/A1 gf180mcu_fd_sc_mcu7t5v0__nand3_1_43/A2
+ vdd vss gf180mcu_fd_sc_mcu7t5v0__nand3_1
Xgf180mcu_fd_sc_mcu7t5v0__nand3_1_54 gf180mcu_fd_sc_mcu7t5v0__nand3_1_54/A3 vdd vss
+ gf180mcu_fd_sc_mcu7t5v0__oai21_1_148/B gf180mcu_fd_sc_mcu7t5v0__buf_8_8/I gf180mcu_fd_sc_mcu7t5v0__or2_1_20/A1
+ vdd vss gf180mcu_fd_sc_mcu7t5v0__nand3_1
Xgf180mcu_fd_sc_mcu7t5v0__nand3_1_65 gf180mcu_fd_sc_mcu7t5v0__nand3_1_66/A2 vdd vss
+ gf180mcu_fd_sc_mcu7t5v0__nand3_1_65/ZN gf180mcu_fd_sc_mcu7t5v0__and3_2_3/Z gf180mcu_fd_sc_mcu7t5v0__or2_1_29/Z
+ vdd vss gf180mcu_fd_sc_mcu7t5v0__nand3_1
Xgf180mcu_fd_sc_mcu7t5v0__nand3_1_76 gf180mcu_fd_sc_mcu7t5v0__xnor3_1_32/A2 vdd vss
+ gf180mcu_fd_sc_mcu7t5v0__nand3_1_76/ZN gf180mcu_fd_sc_mcu7t5v0__inv_4_6/I gf180mcu_fd_sc_mcu7t5v0__nor4_2_5/A1
+ vdd vss gf180mcu_fd_sc_mcu7t5v0__nand3_1
Xgf180mcu_fd_sc_mcu7t5v0__nand3_1_87 gf180mcu_fd_sc_mcu7t5v0__or2_1_51/Z vdd vss gf180mcu_fd_sc_mcu7t5v0__nand4_1_21/A2
+ gf180mcu_fd_sc_mcu7t5v0__nor3_4_20/ZN gf180mcu_fd_sc_mcu7t5v0__nand3_1_87/A2 vdd
+ vss gf180mcu_fd_sc_mcu7t5v0__nand3_1
Xgf180mcu_fd_sc_mcu7t5v0__nand3_1_98 gf180mcu_fd_sc_mcu7t5v0__xor2_1_201/Z vdd vss
+ gf180mcu_fd_sc_mcu7t5v0__oai21_1_328/B gf180mcu_fd_sc_mcu7t5v0__nor2_2_58/ZN gf180mcu_fd_sc_mcu7t5v0__xor2_1_204/Z
+ vdd vss gf180mcu_fd_sc_mcu7t5v0__nand3_1
Xgf180mcu_fd_sc_mcu7t5v0__nand2_1_408 vdd vss gf180mcu_fd_sc_mcu7t5v0__nand2_1_408/ZN
+ gf180mcu_fd_sc_mcu7t5v0__xor3_1_83/A2 gf180mcu_fd_sc_mcu7t5v0__xor3_1_83/A3 vdd
+ vss gf180mcu_fd_sc_mcu7t5v0__nand2_1
Xgf180mcu_fd_sc_mcu7t5v0__oai32_1_0 gf180mcu_fd_sc_mcu7t5v0__and2_1_4/Z gf180mcu_fd_sc_mcu7t5v0__xnor3_1_6/ZN
+ gf180mcu_fd_sc_mcu7t5v0__xor3_1_3/A2 vdd vss gf180mcu_fd_sc_mcu7t5v0__xor2_1_8/A1
+ gf180mcu_fd_sc_mcu7t5v0__oai32_1_0/A1 gf180mcu_fd_sc_mcu7t5v0__oai32_1_0/A2 vdd
+ vss gf180mcu_fd_sc_mcu7t5v0__oai32_1
Xgf180mcu_fd_sc_mcu7t5v0__nand2_1_419 vdd vss gf180mcu_fd_sc_mcu7t5v0__xor2_1_112/A1
+ gf180mcu_fd_sc_mcu7t5v0__xor2_1_111/A1 gf180mcu_fd_sc_mcu7t5v0__xor2_1_217/Z vdd
+ vss gf180mcu_fd_sc_mcu7t5v0__nand2_1
Xgf180mcu_fd_sc_mcu7t5v0__aoi221_1_60 gf180mcu_fd_sc_mcu7t5v0__nor2_2_57/ZN gf180mcu_fd_sc_mcu7t5v0__nor2_2_54/ZN
+ vdd vss gf180mcu_fd_sc_mcu7t5v0__oai21_1_319/B gf180mcu_fd_sc_mcu7t5v0__dffq_4_37/Q
+ gf180mcu_fd_sc_mcu7t5v0__nor2_2_55/ZN gf180mcu_fd_sc_mcu7t5v0__oai21_1_319/A2 vdd
+ vss gf180mcu_fd_sc_mcu7t5v0__aoi221_1
Xgf180mcu_fd_sc_mcu7t5v0__nor3_4_0 gf180mcu_fd_sc_mcu7t5v0__nor3_4_0/A3 vdd vss gf180mcu_fd_sc_mcu7t5v0__xor3_1_6/A1
+ gf180mcu_fd_sc_mcu7t5v0__or3_1_24/A1 gf180mcu_fd_sc_mcu7t5v0__nor3_4_0/A2 vdd vss
+ gf180mcu_fd_sc_mcu7t5v0__nor3_4
Xgf180mcu_fd_sc_mcu7t5v0__dffq_2_16 gf180mcu_fd_sc_mcu7t5v0__dffq_2_16/D vdd vss gf180mcu_fd_sc_mcu7t5v0__dffq_4_6/CLK
+ gf180mcu_fd_sc_mcu7t5v0__nor3_4_3/A1 vdd vss gf180mcu_fd_sc_mcu7t5v0__dffq_2
Xgf180mcu_fd_sc_mcu7t5v0__dffq_2_27 gf180mcu_fd_sc_mcu7t5v0__dffq_2_27/D vdd vss gf180mcu_fd_sc_mcu7t5v0__dffq_2_58/CLK
+ gf180mcu_fd_sc_mcu7t5v0__dffq_2_27/Q vdd vss gf180mcu_fd_sc_mcu7t5v0__dffq_2
Xgf180mcu_fd_sc_mcu7t5v0__dffq_2_38 gf180mcu_fd_sc_mcu7t5v0__dffq_2_38/D vdd vss gf180mcu_fd_sc_mcu7t5v0__dffq_4_44/CLK
+ gf180mcu_fd_sc_mcu7t5v0__mux4_4_1/I0 vdd vss gf180mcu_fd_sc_mcu7t5v0__dffq_2
Xgf180mcu_fd_sc_mcu7t5v0__dffq_2_49 gf180mcu_fd_sc_mcu7t5v0__dffq_2_49/D vdd vss gf180mcu_fd_sc_mcu7t5v0__dffq_4_15/CLK
+ uart_tx_OUT vdd vss gf180mcu_fd_sc_mcu7t5v0__dffq_2
Xgf180mcu_fd_sc_mcu7t5v0__inv_2_10 vss gf180mcu_fd_sc_mcu7t5v0__or2_1_17/A1 gf180mcu_fd_sc_mcu7t5v0__inv_2_10/I
+ vdd vdd vss gf180mcu_fd_sc_mcu7t5v0__inv_2
Xgf180mcu_fd_sc_mcu7t5v0__and3_1_14 gf180mcu_fd_sc_mcu7t5v0__or2_1_34/Z vdd vss gf180mcu_fd_sc_mcu7t5v0__dffq_2_63/D
+ gf180mcu_fd_sc_mcu7t5v0__and2_4_3/Z gf180mcu_fd_sc_mcu7t5v0__and3_1_14/A2 vdd vss
+ gf180mcu_fd_sc_mcu7t5v0__and3_1
Xgf180mcu_fd_sc_mcu7t5v0__and2_1_1 vdd vss gf180mcu_fd_sc_mcu7t5v0__and2_1_1/Z gf180mcu_fd_sc_mcu7t5v0__xor3_1_2/A1
+ gf180mcu_fd_sc_mcu7t5v0__xor2_1_2/Z vdd vss gf180mcu_fd_sc_mcu7t5v0__and2_1
Xgf180mcu_fd_sc_mcu7t5v0__aoi22_4_9 gf180mcu_fd_sc_mcu7t5v0__nor2_2_36/ZN gf180mcu_fd_sc_mcu7t5v0__aoi22_4_9/B1
+ gf180mcu_fd_sc_mcu7t5v0__oai21_2_9/ZN vdd vss gf180mcu_fd_sc_mcu7t5v0__oai32_1_8/B1
+ gf180mcu_fd_sc_mcu7t5v0__aoi22_4_9/A1 vdd vss gf180mcu_fd_sc_mcu7t5v0__aoi22_4
Xgf180mcu_fd_sc_mcu7t5v0__nand2_1_205 vdd vss gf180mcu_fd_sc_mcu7t5v0__oai21_1_48/B
+ gf180mcu_fd_sc_mcu7t5v0__dffq_2_4/Q gf180mcu_fd_sc_mcu7t5v0__xor2_2_0/Z vdd vss
+ gf180mcu_fd_sc_mcu7t5v0__nand2_1
Xgf180mcu_fd_sc_mcu7t5v0__nand2_1_216 vdd vss gf180mcu_fd_sc_mcu7t5v0__aoi222_2_5/A2
+ gf180mcu_fd_sc_mcu7t5v0__aoi22_1_31/ZN gf180mcu_fd_sc_mcu7t5v0__aoi22_1_17/ZN vdd
+ vss gf180mcu_fd_sc_mcu7t5v0__nand2_1
Xgf180mcu_fd_sc_mcu7t5v0__nand2_1_227 vdd vss gf180mcu_fd_sc_mcu7t5v0__aoi222_1_0/C2
+ gf180mcu_fd_sc_mcu7t5v0__aoi22_1_44/ZN gf180mcu_fd_sc_mcu7t5v0__aoi22_1_42/ZN vdd
+ vss gf180mcu_fd_sc_mcu7t5v0__nand2_1
Xgf180mcu_fd_sc_mcu7t5v0__nand2_1_238 vdd vss gf180mcu_fd_sc_mcu7t5v0__aoi222_1_2/B1
+ gf180mcu_fd_sc_mcu7t5v0__aoi22_1_84/ZN gf180mcu_fd_sc_mcu7t5v0__aoi22_1_72/ZN vdd
+ vss gf180mcu_fd_sc_mcu7t5v0__nand2_1
Xgf180mcu_fd_sc_mcu7t5v0__nand2_1_249 vdd vss gf180mcu_fd_sc_mcu7t5v0__aoi222_1_6/B1
+ gf180mcu_fd_sc_mcu7t5v0__nand2_1_249/A1 gf180mcu_fd_sc_mcu7t5v0__aoi22_1_91/ZN vdd
+ vss gf180mcu_fd_sc_mcu7t5v0__nand2_1
Xgf180mcu_fd_sc_mcu7t5v0__aoi21_1_17 gf180mcu_fd_sc_mcu7t5v0__aoi21_1_17/B vdd vss
+ gf180mcu_fd_sc_mcu7t5v0__oai31_1_0/A2 gf180mcu_fd_sc_mcu7t5v0__or4_1_0/A2 gf180mcu_fd_sc_mcu7t5v0__nor3_4_0/A2
+ vdd vss gf180mcu_fd_sc_mcu7t5v0__aoi21_1
Xgf180mcu_fd_sc_mcu7t5v0__aoi21_1_28 gf180mcu_fd_sc_mcu7t5v0__and3_1_0/Z vdd vss gf180mcu_fd_sc_mcu7t5v0__xor3_1_14/A2
+ gf180mcu_fd_sc_mcu7t5v0__xor2_1_23/A1 gf180mcu_fd_sc_mcu7t5v0__xor2_1_23/A2 vdd
+ vss gf180mcu_fd_sc_mcu7t5v0__aoi21_1
Xgf180mcu_fd_sc_mcu7t5v0__aoi21_1_39 gf180mcu_fd_sc_mcu7t5v0__aoi21_1_39/B vdd vss
+ gf180mcu_fd_sc_mcu7t5v0__oai21_1_24/B gf180mcu_fd_sc_mcu7t5v0__nor2_1_315/A2 gf180mcu_fd_sc_mcu7t5v0__xor3_1_19/Z
+ vdd vss gf180mcu_fd_sc_mcu7t5v0__aoi21_1
Xgf180mcu_fd_sc_mcu7t5v0__nor2_2_14 vdd vss gf180mcu_fd_sc_mcu7t5v0__nor2_2_14/ZN
+ gf180mcu_fd_sc_mcu7t5v0__nor2_2_14/A1 gf180mcu_fd_sc_mcu7t5v0__nor2_2_15/A2 vdd
+ vss gf180mcu_fd_sc_mcu7t5v0__nor2_2
Xgf180mcu_fd_sc_mcu7t5v0__nor2_2_25 vdd vss gf180mcu_fd_sc_mcu7t5v0__mux2_1_8/I0 gf180mcu_fd_sc_mcu7t5v0__dffq_2_98/Q
+ gf180mcu_fd_sc_mcu7t5v0__nor2_2_31/A2 vdd vss gf180mcu_fd_sc_mcu7t5v0__nor2_2
Xgf180mcu_fd_sc_mcu7t5v0__nor2_2_36 vdd vss gf180mcu_fd_sc_mcu7t5v0__nor2_2_36/ZN
+ gf180mcu_fd_sc_mcu7t5v0__inv_4_4/I gf180mcu_fd_sc_mcu7t5v0__or2_1_36/A2 vdd vss
+ gf180mcu_fd_sc_mcu7t5v0__nor2_2
Xgf180mcu_fd_sc_mcu7t5v0__nor2_2_47 vdd vss gf180mcu_fd_sc_mcu7t5v0__nor2_2_47/ZN
+ gf180mcu_fd_sc_mcu7t5v0__nor2_4_41/A1 gf180mcu_fd_sc_mcu7t5v0__dffq_2_87/Q vdd vss
+ gf180mcu_fd_sc_mcu7t5v0__nor2_2
Xgf180mcu_fd_sc_mcu7t5v0__nor2_2_58 vdd vss gf180mcu_fd_sc_mcu7t5v0__nor2_2_58/ZN
+ gf180mcu_fd_sc_mcu7t5v0__nor2_2_58/A1 gf180mcu_fd_sc_mcu7t5v0__nor2_2_58/A2 vdd
+ vss gf180mcu_fd_sc_mcu7t5v0__nor2_2
Xgf180mcu_fd_sc_mcu7t5v0__dffq_1_302 vdd gf180mcu_fd_sc_mcu7t5v0__dffq_1_302/Q gf180mcu_fd_sc_mcu7t5v0__dffq_4_9/CLK
+ vss gf180mcu_fd_sc_mcu7t5v0__dffq_1_302/D vdd vss gf180mcu_fd_sc_mcu7t5v0__dffq_1
Xgf180mcu_fd_sc_mcu7t5v0__dffq_1_313 vdd gf180mcu_fd_sc_mcu7t5v0__dffq_1_313/Q gf180mcu_fd_sc_mcu7t5v0__dffq_2_58/CLK
+ vss gf180mcu_fd_sc_mcu7t5v0__dffq_1_313/D vdd vss gf180mcu_fd_sc_mcu7t5v0__dffq_1
Xgf180mcu_fd_sc_mcu7t5v0__dffq_1_324 vdd gf180mcu_fd_sc_mcu7t5v0__dffq_1_324/Q gf180mcu_fd_sc_mcu7t5v0__dffq_2_58/CLK
+ vss gf180mcu_fd_sc_mcu7t5v0__dffq_1_324/D vdd vss gf180mcu_fd_sc_mcu7t5v0__dffq_1
Xgf180mcu_fd_sc_mcu7t5v0__dffq_1_335 vdd gf180mcu_fd_sc_mcu7t5v0__dffq_1_335/Q gf180mcu_fd_sc_mcu7t5v0__dffq_2_58/CLK
+ vss gf180mcu_fd_sc_mcu7t5v0__dffq_1_335/D vdd vss gf180mcu_fd_sc_mcu7t5v0__dffq_1
Xgf180mcu_fd_sc_mcu7t5v0__dffq_1_346 vdd gf180mcu_fd_sc_mcu7t5v0__oai31_2_0/A2 gf180mcu_fd_sc_mcu7t5v0__dffq_4_15/CLK
+ vss gf180mcu_fd_sc_mcu7t5v0__and2_1_57/Z vdd vss gf180mcu_fd_sc_mcu7t5v0__dffq_1
Xgf180mcu_fd_sc_mcu7t5v0__dffq_1_357 vdd gf180mcu_fd_sc_mcu7t5v0__nor3_1_17/A2 gf180mcu_fd_sc_mcu7t5v0__dffq_4_15/CLK
+ vss gf180mcu_fd_sc_mcu7t5v0__dffq_1_357/D vdd vss gf180mcu_fd_sc_mcu7t5v0__dffq_1
Xgf180mcu_fd_sc_mcu7t5v0__dffq_1_368 vdd gf180mcu_fd_sc_mcu7t5v0__inv_1_9/I gf180mcu_fd_sc_mcu7t5v0__dffq_4_15/CLK
+ vss gf180mcu_fd_sc_mcu7t5v0__dffq_1_368/D vdd vss gf180mcu_fd_sc_mcu7t5v0__dffq_1
Xgf180mcu_fd_sc_mcu7t5v0__oai22_1_14 gf180mcu_fd_sc_mcu7t5v0__nand2_4_2/ZN gf180mcu_fd_sc_mcu7t5v0__oai22_1_29/B1
+ gf180mcu_fd_sc_mcu7t5v0__oai22_1_14/B2 vdd vss gf180mcu_fd_sc_mcu7t5v0__dffq_1_17/D
+ gf180mcu_fd_sc_mcu7t5v0__aoi21_4_3/ZN vdd vss gf180mcu_fd_sc_mcu7t5v0__oai22_1
Xgf180mcu_fd_sc_mcu7t5v0__dffq_1_379 vdd gf180mcu_fd_sc_mcu7t5v0__nor3_1_13/A1 gf180mcu_fd_sc_mcu7t5v0__dffq_4_15/CLK
+ vss gf180mcu_fd_sc_mcu7t5v0__nor3_1_20/ZN vdd vss gf180mcu_fd_sc_mcu7t5v0__dffq_1
Xgf180mcu_fd_sc_mcu7t5v0__oai22_1_25 gf180mcu_fd_sc_mcu7t5v0__oai22_1_28/A2 gf180mcu_fd_sc_mcu7t5v0__oai22_1_28/B1
+ gf180mcu_fd_sc_mcu7t5v0__oai22_1_25/B2 vdd vss gf180mcu_fd_sc_mcu7t5v0__dffq_1_27/D
+ gf180mcu_fd_sc_mcu7t5v0__aoi21_4_1/ZN vdd vss gf180mcu_fd_sc_mcu7t5v0__oai22_1
Xgf180mcu_fd_sc_mcu7t5v0__oai22_1_36 gf180mcu_fd_sc_mcu7t5v0__nand2_4_3/ZN gf180mcu_fd_sc_mcu7t5v0__oai22_1_45/B1
+ gf180mcu_fd_sc_mcu7t5v0__oai22_1_36/B2 vdd vss gf180mcu_fd_sc_mcu7t5v0__dffq_1_37/D
+ gf180mcu_fd_sc_mcu7t5v0__aoi21_4_3/ZN vdd vss gf180mcu_fd_sc_mcu7t5v0__oai22_1
Xgf180mcu_fd_sc_mcu7t5v0__oai22_1_47 gf180mcu_fd_sc_mcu7t5v0__oai22_1_48/A2 gf180mcu_fd_sc_mcu7t5v0__aoi21_4_2/ZN
+ gf180mcu_fd_sc_mcu7t5v0__nand2_4_5/ZN vdd vss gf180mcu_fd_sc_mcu7t5v0__dffq_1_44/D
+ gf180mcu_fd_sc_mcu7t5v0__oai22_1_47/A1 vdd vss gf180mcu_fd_sc_mcu7t5v0__oai22_1
Xgf180mcu_fd_sc_mcu7t5v0__oai22_1_58 gf180mcu_fd_sc_mcu7t5v0__oai22_1_62/A2 gf180mcu_fd_sc_mcu7t5v0__oai22_1_62/B1
+ gf180mcu_fd_sc_mcu7t5v0__oai22_1_58/B2 vdd vss gf180mcu_fd_sc_mcu7t5v0__dffq_1_64/D
+ gf180mcu_fd_sc_mcu7t5v0__oai21_4_9/ZN vdd vss gf180mcu_fd_sc_mcu7t5v0__oai22_1
Xgf180mcu_fd_sc_mcu7t5v0__oai22_1_69 gf180mcu_fd_sc_mcu7t5v0__oai22_1_90/A2 gf180mcu_fd_sc_mcu7t5v0__oai22_1_90/B1
+ gf180mcu_fd_sc_mcu7t5v0__oai22_1_69/B2 vdd vss gf180mcu_fd_sc_mcu7t5v0__dffq_1_72/D
+ gf180mcu_fd_sc_mcu7t5v0__oai21_4_9/ZN vdd vss gf180mcu_fd_sc_mcu7t5v0__oai22_1
Xgf180mcu_fd_sc_mcu7t5v0__and2_1_80 vdd vss gf180mcu_fd_sc_mcu7t5v0__and2_1_80/Z gf180mcu_fd_sc_mcu7t5v0__nor2_2_22/ZN
+ gf180mcu_fd_sc_mcu7t5v0__and2_1_84/Z vdd vss gf180mcu_fd_sc_mcu7t5v0__and2_1
Xgf180mcu_fd_sc_mcu7t5v0__and2_1_91 vdd vss gf180mcu_fd_sc_mcu7t5v0__and2_1_91/Z gf180mcu_fd_sc_mcu7t5v0__inv_8_1/I
+ gf180mcu_fd_sc_mcu7t5v0__mux4_4_19/Z vdd vss gf180mcu_fd_sc_mcu7t5v0__and2_1
Xgf180mcu_fd_sc_mcu7t5v0__clkinv_1_207 vdd vss gf180mcu_fd_sc_mcu7t5v0__xor2_1_213/Z
+ gf180mcu_fd_sc_mcu7t5v0__aoi21_1_93/B vdd vss gf180mcu_fd_sc_mcu7t5v0__clkinv_1
Xgf180mcu_fd_sc_mcu7t5v0__clkinv_1_218 vdd vss gf180mcu_fd_sc_mcu7t5v0__dffq_1_198/Q
+ gf180mcu_fd_sc_mcu7t5v0__oai22_1_208/B2 vdd vss gf180mcu_fd_sc_mcu7t5v0__clkinv_1
Xgf180mcu_fd_sc_mcu7t5v0__clkinv_1_229 vdd vss gf180mcu_fd_sc_mcu7t5v0__dffq_1_207/Q
+ gf180mcu_fd_sc_mcu7t5v0__oai22_1_217/B2 vdd vss gf180mcu_fd_sc_mcu7t5v0__clkinv_1
Xgf180mcu_fd_sc_mcu7t5v0__aoi211_1_70 gf180mcu_fd_sc_mcu7t5v0__nor2_1_317/ZN gf180mcu_fd_sc_mcu7t5v0__or2_1_23/A1
+ vdd vss gf180mcu_fd_sc_mcu7t5v0__dffq_1_426/D gf180mcu_fd_sc_mcu7t5v0__inv_4_2/ZN
+ gf180mcu_fd_sc_mcu7t5v0__and3_2_2/Z vdd vss gf180mcu_fd_sc_mcu7t5v0__aoi211_1
Xgf180mcu_fd_sc_mcu7t5v0__aoi211_1_81 gf180mcu_fd_sc_mcu7t5v0__and3_1_20/Z gf180mcu_fd_sc_mcu7t5v0__aoi211_1_81/C
+ vdd vss gf180mcu_fd_sc_mcu7t5v0__nor2_1_335/A2 gf180mcu_fd_sc_mcu7t5v0__nor3_4_22/ZN
+ gf180mcu_fd_sc_mcu7t5v0__xor3_2_2/Z vdd vss gf180mcu_fd_sc_mcu7t5v0__aoi211_1
Xgf180mcu_fd_sc_mcu7t5v0__oai221_1_13 gf180mcu_fd_sc_mcu7t5v0__oai221_1_13/B1 gf180mcu_fd_sc_mcu7t5v0__oai221_1_13/C
+ vdd vss gf180mcu_fd_sc_mcu7t5v0__aoi211_1_81/C gf180mcu_fd_sc_mcu7t5v0__nand2_2_74/ZN
+ gf180mcu_fd_sc_mcu7t5v0__xor3_1_124/A1 gf180mcu_fd_sc_mcu7t5v0__nor2_1_359/ZN vdd
+ vss gf180mcu_fd_sc_mcu7t5v0__oai221_1
Xgf180mcu_fd_sc_mcu7t5v0__aoi21_1_280 gf180mcu_fd_sc_mcu7t5v0__or2_1_23/A1 vdd vss
+ gf180mcu_fd_sc_mcu7t5v0__dffq_2_67/D gf180mcu_fd_sc_mcu7t5v0__nand2_1_556/ZN gf180mcu_fd_sc_mcu7t5v0__nand2_1_544/ZN
+ vdd vss gf180mcu_fd_sc_mcu7t5v0__aoi21_1
Xgf180mcu_fd_sc_mcu7t5v0__aoi21_1_291 gf180mcu_fd_sc_mcu7t5v0__aoi21_1_291/B vdd vss
+ gf180mcu_fd_sc_mcu7t5v0__dffq_4_33/D gf180mcu_fd_sc_mcu7t5v0__nor3_2_11/A2 gf180mcu_fd_sc_mcu7t5v0__buf_20_0/I
+ vdd vss gf180mcu_fd_sc_mcu7t5v0__aoi21_1
Xgf180mcu_fd_sc_mcu7t5v0__aoi22_2_6 gf180mcu_fd_sc_mcu7t5v0__aoi22_2_6/B1 gf180mcu_fd_sc_mcu7t5v0__nor4_4_1/ZN
+ vdd vss gf180mcu_fd_sc_mcu7t5v0__aoi22_2_6/ZN gf180mcu_fd_sc_mcu7t5v0__dffq_2_57/Q
+ gf180mcu_fd_sc_mcu7t5v0__nor3_4_13/ZN vdd vss gf180mcu_fd_sc_mcu7t5v0__aoi22_2
Xgf180mcu_fd_sc_mcu7t5v0__oai21_4_1 gf180mcu_fd_sc_mcu7t5v0__oai21_4_1/B vdd vss gf180mcu_fd_sc_mcu7t5v0__inv_2_0/I
+ gf180mcu_fd_sc_mcu7t5v0__and2_4_2/A2 gf180mcu_fd_sc_mcu7t5v0__oai21_4_1/A2 vdd vss
+ gf180mcu_fd_sc_mcu7t5v0__oai21_4
Xgf180mcu_fd_sc_mcu7t5v0__oai22_1_201 gf180mcu_fd_sc_mcu7t5v0__nand2_4_32/ZN gf180mcu_fd_sc_mcu7t5v0__nand2_2_33/ZN
+ gf180mcu_fd_sc_mcu7t5v0__oai22_1_201/B2 vdd vss gf180mcu_fd_sc_mcu7t5v0__dffq_1_202/D
+ gf180mcu_fd_sc_mcu7t5v0__aoi21_4_3/ZN vdd vss gf180mcu_fd_sc_mcu7t5v0__oai22_1
Xgf180mcu_fd_sc_mcu7t5v0__oai22_1_212 gf180mcu_fd_sc_mcu7t5v0__oai22_1_28/A2 gf180mcu_fd_sc_mcu7t5v0__oai22_1_28/B1
+ gf180mcu_fd_sc_mcu7t5v0__oai22_1_212/B2 vdd vss gf180mcu_fd_sc_mcu7t5v0__dffq_1_217/D
+ gf180mcu_fd_sc_mcu7t5v0__aoi21_4_3/ZN vdd vss gf180mcu_fd_sc_mcu7t5v0__oai22_1
Xgf180mcu_fd_sc_mcu7t5v0__oai21_1_80 vdd gf180mcu_fd_sc_mcu7t5v0__xor2_1_71/Z gf180mcu_fd_sc_mcu7t5v0__and2_1_36/Z
+ gf180mcu_fd_sc_mcu7t5v0__oai21_1_80/ZN gf180mcu_fd_sc_mcu7t5v0__and2_1_37/Z vss
+ vdd vss gf180mcu_fd_sc_mcu7t5v0__oai21_1
Xgf180mcu_fd_sc_mcu7t5v0__oai21_1_91 vdd gf180mcu_fd_sc_mcu7t5v0__buf_8_4/Z gf180mcu_fd_sc_mcu7t5v0__buf_20_0/Z
+ gf180mcu_fd_sc_mcu7t5v0__oai21_1_91/ZN gf180mcu_fd_sc_mcu7t5v0__dffq_1_282/Q vss
+ vdd vss gf180mcu_fd_sc_mcu7t5v0__oai21_1
Xgf180mcu_fd_sc_mcu7t5v0__oai22_1_223 gf180mcu_fd_sc_mcu7t5v0__nand2_4_27/ZN gf180mcu_fd_sc_mcu7t5v0__nand2_2_43/ZN
+ gf180mcu_fd_sc_mcu7t5v0__oai22_1_223/B2 vdd vss gf180mcu_fd_sc_mcu7t5v0__dffq_1_212/D
+ gf180mcu_fd_sc_mcu7t5v0__aoi21_4_1/ZN vdd vss gf180mcu_fd_sc_mcu7t5v0__oai22_1
Xgf180mcu_fd_sc_mcu7t5v0__oai22_1_234 gf180mcu_fd_sc_mcu7t5v0__nand2_4_28/ZN gf180mcu_fd_sc_mcu7t5v0__nand2_2_44/ZN
+ gf180mcu_fd_sc_mcu7t5v0__oai22_1_234/B2 vdd vss gf180mcu_fd_sc_mcu7t5v0__dffq_1_250/D
+ gf180mcu_fd_sc_mcu7t5v0__oai21_4_9/ZN vdd vss gf180mcu_fd_sc_mcu7t5v0__oai22_1
Xgf180mcu_fd_sc_mcu7t5v0__oai22_1_245 gf180mcu_fd_sc_mcu7t5v0__nand2_4_29/ZN gf180mcu_fd_sc_mcu7t5v0__nand2_2_39/ZN
+ gf180mcu_fd_sc_mcu7t5v0__oai22_1_245/B2 vdd vss gf180mcu_fd_sc_mcu7t5v0__dffq_1_249/D
+ gf180mcu_fd_sc_mcu7t5v0__oai22_1_88/A1 vdd vss gf180mcu_fd_sc_mcu7t5v0__oai22_1
Xgf180mcu_fd_sc_mcu7t5v0__oai22_1_256 gf180mcu_fd_sc_mcu7t5v0__nand2_4_32/ZN gf180mcu_fd_sc_mcu7t5v0__nand2_2_33/ZN
+ gf180mcu_fd_sc_mcu7t5v0__oai22_1_256/B2 vdd vss gf180mcu_fd_sc_mcu7t5v0__dffq_1_256/D
+ gf180mcu_fd_sc_mcu7t5v0__aoi21_4_5/ZN vdd vss gf180mcu_fd_sc_mcu7t5v0__oai22_1
Xgf180mcu_fd_sc_mcu7t5v0__oai22_1_267 gf180mcu_fd_sc_mcu7t5v0__mux4_4_9/Z gf180mcu_fd_sc_mcu7t5v0__nor3_1_27/ZN
+ gf180mcu_fd_sc_mcu7t5v0__nor2_2_26/ZN vdd vss gf180mcu_fd_sc_mcu7t5v0__nand4_1_11/A3
+ gf180mcu_fd_sc_mcu7t5v0__inv_8_0/I vdd vss gf180mcu_fd_sc_mcu7t5v0__oai22_1
Xgf180mcu_fd_sc_mcu7t5v0__oai22_1_278 gf180mcu_fd_sc_mcu7t5v0__xor2_1_192/A1 gf180mcu_fd_sc_mcu7t5v0__nor3_1_41/ZN
+ gf180mcu_fd_sc_mcu7t5v0__nor2_2_54/ZN vdd vss gf180mcu_fd_sc_mcu7t5v0__oai22_1_278/ZN
+ gf180mcu_fd_sc_mcu7t5v0__or4_1_0/A1 vdd vss gf180mcu_fd_sc_mcu7t5v0__oai22_1
Xgf180mcu_fd_sc_mcu7t5v0__oai22_1_289 gf180mcu_fd_sc_mcu7t5v0__nand2_4_24/ZN gf180mcu_fd_sc_mcu7t5v0__nand2_2_52/ZN
+ gf180mcu_fd_sc_mcu7t5v0__oai22_1_289/B2 vdd vss gf180mcu_fd_sc_mcu7t5v0__dffq_1_190/D
+ gf180mcu_fd_sc_mcu7t5v0__oai22_1_88/A1 vdd vss gf180mcu_fd_sc_mcu7t5v0__oai22_1
Xgf180mcu_fd_sc_mcu7t5v0__dffq_1_110 vdd gf180mcu_fd_sc_mcu7t5v0__dffq_1_110/Q gf180mcu_fd_sc_mcu7t5v0__dffq_2_26/CLK
+ vss gf180mcu_fd_sc_mcu7t5v0__dffq_1_110/D vdd vss gf180mcu_fd_sc_mcu7t5v0__dffq_1
Xgf180mcu_fd_sc_mcu7t5v0__dffq_1_121 vdd gf180mcu_fd_sc_mcu7t5v0__dffq_1_121/Q gf180mcu_fd_sc_mcu7t5v0__dffq_1_96/CLK
+ vss gf180mcu_fd_sc_mcu7t5v0__dffq_1_121/D vdd vss gf180mcu_fd_sc_mcu7t5v0__dffq_1
Xgf180mcu_fd_sc_mcu7t5v0__nor2_1_310 vdd vss gf180mcu_fd_sc_mcu7t5v0__nor3_1_32/A1
+ gf180mcu_fd_sc_mcu7t5v0__inv_8_0/ZN gf180mcu_fd_sc_mcu7t5v0__xor2_1_149/Z vdd vss
+ gf180mcu_fd_sc_mcu7t5v0__nor2_1
Xgf180mcu_fd_sc_mcu7t5v0__dffq_1_132 vdd gf180mcu_fd_sc_mcu7t5v0__dffq_1_132/Q gf180mcu_fd_sc_mcu7t5v0__dffq_1_96/CLK
+ vss gf180mcu_fd_sc_mcu7t5v0__dffq_1_132/D vdd vss gf180mcu_fd_sc_mcu7t5v0__dffq_1
Xgf180mcu_fd_sc_mcu7t5v0__nor2_1_321 vdd vss gf180mcu_fd_sc_mcu7t5v0__nor2_1_321/ZN
+ gf180mcu_fd_sc_mcu7t5v0__nor2_1_321/A1 gf180mcu_fd_sc_mcu7t5v0__nor2_1_321/A2 vdd
+ vss gf180mcu_fd_sc_mcu7t5v0__nor2_1
Xgf180mcu_fd_sc_mcu7t5v0__dffq_1_143 vdd gf180mcu_fd_sc_mcu7t5v0__dffq_1_143/Q gf180mcu_fd_sc_mcu7t5v0__dffq_1_96/CLK
+ vss gf180mcu_fd_sc_mcu7t5v0__dffq_1_143/D vdd vss gf180mcu_fd_sc_mcu7t5v0__dffq_1
Xgf180mcu_fd_sc_mcu7t5v0__nor2_1_332 vdd vss gf180mcu_fd_sc_mcu7t5v0__nor2_1_332/ZN
+ gf180mcu_fd_sc_mcu7t5v0__dffq_1_431/Q gf180mcu_fd_sc_mcu7t5v0__nor2_4_27/ZN vdd
+ vss gf180mcu_fd_sc_mcu7t5v0__nor2_1
Xgf180mcu_fd_sc_mcu7t5v0__dffq_1_154 vdd gf180mcu_fd_sc_mcu7t5v0__dffq_1_154/Q gf180mcu_fd_sc_mcu7t5v0__dffq_4_15/CLK
+ vss gf180mcu_fd_sc_mcu7t5v0__dffq_1_154/D vdd vss gf180mcu_fd_sc_mcu7t5v0__dffq_1
Xgf180mcu_fd_sc_mcu7t5v0__nor2_1_343 vdd vss gf180mcu_fd_sc_mcu7t5v0__nor2_1_343/ZN
+ gf180mcu_fd_sc_mcu7t5v0__mux4_4_8/I0 gf180mcu_fd_sc_mcu7t5v0__xor3_2_2/Z vdd vss
+ gf180mcu_fd_sc_mcu7t5v0__nor2_1
Xgf180mcu_fd_sc_mcu7t5v0__dffq_1_165 vdd gf180mcu_fd_sc_mcu7t5v0__dffq_1_165/Q gf180mcu_fd_sc_mcu7t5v0__dffq_2_26/CLK
+ vss gf180mcu_fd_sc_mcu7t5v0__dffq_1_165/D vdd vss gf180mcu_fd_sc_mcu7t5v0__dffq_1
Xgf180mcu_fd_sc_mcu7t5v0__dffq_1_176 vdd gf180mcu_fd_sc_mcu7t5v0__dffq_1_176/Q gf180mcu_fd_sc_mcu7t5v0__dffq_1_96/CLK
+ vss gf180mcu_fd_sc_mcu7t5v0__dffq_1_176/D vdd vss gf180mcu_fd_sc_mcu7t5v0__dffq_1
Xgf180mcu_fd_sc_mcu7t5v0__nor2_1_354 vdd vss gf180mcu_fd_sc_mcu7t5v0__xor2_1_160/A2
+ gf180mcu_fd_sc_mcu7t5v0__nor3_2_5/A1 gf180mcu_fd_sc_mcu7t5v0__oai32_4_0/ZN vdd vss
+ gf180mcu_fd_sc_mcu7t5v0__nor2_1
Xgf180mcu_fd_sc_mcu7t5v0__clkinv_3_8 vdd gf180mcu_fd_sc_mcu7t5v0__nor2_4_30/A1 gf180mcu_fd_sc_mcu7t5v0__dffq_2_42/Q
+ vss vdd vss gf180mcu_fd_sc_mcu7t5v0__clkinv_3
Xgf180mcu_fd_sc_mcu7t5v0__nor2_1_365 vdd vss gf180mcu_fd_sc_mcu7t5v0__mux2_1_12/S
+ gf180mcu_fd_sc_mcu7t5v0__nor3_1_40/A2 gf180mcu_fd_sc_mcu7t5v0__xor3_1_122/A1 vdd
+ vss gf180mcu_fd_sc_mcu7t5v0__nor2_1
Xgf180mcu_fd_sc_mcu7t5v0__dffq_1_187 vdd gf180mcu_fd_sc_mcu7t5v0__dffq_1_187/Q gf180mcu_fd_sc_mcu7t5v0__dffq_2_26/CLK
+ vss gf180mcu_fd_sc_mcu7t5v0__dffq_1_187/D vdd vss gf180mcu_fd_sc_mcu7t5v0__dffq_1
Xgf180mcu_fd_sc_mcu7t5v0__nor2_1_376 vdd vss gf180mcu_fd_sc_mcu7t5v0__xor3_1_135/A2
+ gf180mcu_fd_sc_mcu7t5v0__nor3_1_40/ZN gf180mcu_fd_sc_mcu7t5v0__oai32_1_9/A2 vdd
+ vss gf180mcu_fd_sc_mcu7t5v0__nor2_1
Xgf180mcu_fd_sc_mcu7t5v0__dffq_1_198 vdd gf180mcu_fd_sc_mcu7t5v0__dffq_1_198/Q gf180mcu_fd_sc_mcu7t5v0__dffq_4_8/CLK
+ vss gf180mcu_fd_sc_mcu7t5v0__dffq_1_198/D vdd vss gf180mcu_fd_sc_mcu7t5v0__dffq_1
Xgf180mcu_fd_sc_mcu7t5v0__nor2_1_387 vdd vss gf180mcu_fd_sc_mcu7t5v0__nor2_1_387/ZN
+ gf180mcu_fd_sc_mcu7t5v0__nor2_2_54/A1 gf180mcu_fd_sc_mcu7t5v0__nor2_4_42/A2 vdd
+ vss gf180mcu_fd_sc_mcu7t5v0__nor2_1
Xgf180mcu_fd_sc_mcu7t5v0__nor2_1_398 vdd vss gf180mcu_fd_sc_mcu7t5v0__xor3_1_145/A1
+ gf180mcu_fd_sc_mcu7t5v0__xnor2_1_73/A1 gf180mcu_fd_sc_mcu7t5v0__xnor2_1_73/A2 vdd
+ vss gf180mcu_fd_sc_mcu7t5v0__nor2_1
Xgf180mcu_fd_sc_mcu7t5v0__nand2_1_580 vdd vss gf180mcu_fd_sc_mcu7t5v0__xnor3_1_49/A2
+ gf180mcu_fd_sc_mcu7t5v0__inv_8_1/I gf180mcu_fd_sc_mcu7t5v0__inv_1_23/I vdd vss gf180mcu_fd_sc_mcu7t5v0__nand2_1
Xgf180mcu_fd_sc_mcu7t5v0__nand2_1_591 vdd vss gf180mcu_fd_sc_mcu7t5v0__nand3_1_85/A2
+ gf180mcu_fd_sc_mcu7t5v0__nor3_4_20/ZN gf180mcu_fd_sc_mcu7t5v0__xor2_1_165/Z vdd
+ vss gf180mcu_fd_sc_mcu7t5v0__nand2_1
Xgf180mcu_fd_sc_mcu7t5v0__clkbuf_16_11 vdd vss gf180mcu_fd_sc_mcu7t5v0__dffq_2_58/CLK
+ gf180mcu_fd_sc_mcu7t5v0__clkbuf_16_8/I vdd vss gf180mcu_fd_sc_mcu7t5v0__clkbuf_16
Xgf180mcu_fd_sc_mcu7t5v0__clkbuf_16_4 vdd vss gf180mcu_fd_sc_mcu7t5v0__dffq_1_96/CLK
+ gf180mcu_fd_sc_mcu7t5v0__clkbuf_16_9/I vdd vss gf180mcu_fd_sc_mcu7t5v0__clkbuf_16
Xgf180mcu_fd_sc_mcu7t5v0__nand2_1_2 vdd vss gf180mcu_fd_sc_mcu7t5v0__nor2_1_3/A1 gf180mcu_fd_sc_mcu7t5v0__inv_8_2/I
+ gf180mcu_fd_sc_mcu7t5v0__and2_4_0/Z vdd vss gf180mcu_fd_sc_mcu7t5v0__nand2_1
Xgf180mcu_fd_sc_mcu7t5v0__inv_2_9 vss gf180mcu_fd_sc_mcu7t5v0__inv_2_9/ZN gf180mcu_fd_sc_mcu7t5v0__inv_2_9/I
+ vdd vdd vss gf180mcu_fd_sc_mcu7t5v0__inv_2
Xgf180mcu_fd_sc_mcu7t5v0__dffq_1_6 vdd gf180mcu_fd_sc_mcu7t5v0__dffq_1_6/Q gf180mcu_fd_sc_mcu7t5v0__dffq_4_6/CLK
+ vss gf180mcu_fd_sc_mcu7t5v0__dffq_1_6/D vdd vss gf180mcu_fd_sc_mcu7t5v0__dffq_1
Xgf180mcu_fd_sc_mcu7t5v0__nor2_1_140 vdd vss gf180mcu_fd_sc_mcu7t5v0__xor2_1_87/A1
+ gf180mcu_fd_sc_mcu7t5v0__oai31_1_8/A2 gf180mcu_fd_sc_mcu7t5v0__xor3_1_68/A1 vdd
+ vss gf180mcu_fd_sc_mcu7t5v0__nor2_1
Xgf180mcu_fd_sc_mcu7t5v0__nor2_1_151 vdd vss gf180mcu_fd_sc_mcu7t5v0__dffq_1_306/D
+ gf180mcu_fd_sc_mcu7t5v0__or2_1_23/A1 gf180mcu_fd_sc_mcu7t5v0__nor2_1_151/A2 vdd
+ vss gf180mcu_fd_sc_mcu7t5v0__nor2_1
Xgf180mcu_fd_sc_mcu7t5v0__nor2_1_162 vdd vss gf180mcu_fd_sc_mcu7t5v0__nor2_1_162/ZN
+ gf180mcu_fd_sc_mcu7t5v0__dffq_1_445/Q gf180mcu_fd_sc_mcu7t5v0__nor2_4_20/ZN vdd
+ vss gf180mcu_fd_sc_mcu7t5v0__nor2_1
Xgf180mcu_fd_sc_mcu7t5v0__clkinv_1_5 vdd vss gf180mcu_fd_sc_mcu7t5v0__dffq_2_9/Q gf180mcu_fd_sc_mcu7t5v0__nor3_1_5/A1
+ vdd vss gf180mcu_fd_sc_mcu7t5v0__clkinv_1
Xgf180mcu_fd_sc_mcu7t5v0__xor3_1_130 gf180mcu_fd_sc_mcu7t5v0__xor3_1_131/A3 vdd vss
+ gf180mcu_fd_sc_mcu7t5v0__xor3_1_130/Z gf180mcu_fd_sc_mcu7t5v0__or3_1_24/Z gf180mcu_fd_sc_mcu7t5v0__oai33_2_4/A1
+ vdd vss gf180mcu_fd_sc_mcu7t5v0__xor3_1
Xgf180mcu_fd_sc_mcu7t5v0__xor3_1_141 gf180mcu_fd_sc_mcu7t5v0__xor3_1_117/Z vdd vss
+ gf180mcu_fd_sc_mcu7t5v0__xor3_1_141/Z gf180mcu_fd_sc_mcu7t5v0__xor3_1_141/A1 gf180mcu_fd_sc_mcu7t5v0__xor3_1_141/A2
+ vdd vss gf180mcu_fd_sc_mcu7t5v0__xor3_1
Xgf180mcu_fd_sc_mcu7t5v0__nor2_1_173 vdd vss gf180mcu_fd_sc_mcu7t5v0__dffq_1_319/D
+ gf180mcu_fd_sc_mcu7t5v0__or2_1_23/A1 gf180mcu_fd_sc_mcu7t5v0__nor2_1_173/A2 vdd
+ vss gf180mcu_fd_sc_mcu7t5v0__nor2_1
Xgf180mcu_fd_sc_mcu7t5v0__xor3_1_152 gf180mcu_fd_sc_mcu7t5v0__or2_1_53/A2 vdd vss
+ gf180mcu_fd_sc_mcu7t5v0__xor3_1_152/Z gf180mcu_fd_sc_mcu7t5v0__or2_1_53/A1 gf180mcu_fd_sc_mcu7t5v0__xor3_1_152/A2
+ vdd vss gf180mcu_fd_sc_mcu7t5v0__xor3_1
Xgf180mcu_fd_sc_mcu7t5v0__nor2_1_184 vdd vss gf180mcu_fd_sc_mcu7t5v0__dffq_1_341/D
+ gf180mcu_fd_sc_mcu7t5v0__and2_1_54/Z gf180mcu_fd_sc_mcu7t5v0__nor2_1_184/A2 vdd
+ vss gf180mcu_fd_sc_mcu7t5v0__nor2_1
Xgf180mcu_fd_sc_mcu7t5v0__nor2_1_195 vdd vss gf180mcu_fd_sc_mcu7t5v0__dffq_1_355/D
+ gf180mcu_fd_sc_mcu7t5v0__and2_1_64/Z gf180mcu_fd_sc_mcu7t5v0__nor2_1_195/A2 vdd
+ vss gf180mcu_fd_sc_mcu7t5v0__nor2_1
Xgf180mcu_fd_sc_mcu7t5v0__xor3_1_163 gf180mcu_fd_sc_mcu7t5v0__nor4_4_4/ZN vdd vss
+ gf180mcu_fd_sc_mcu7t5v0__xor3_1_163/Z gf180mcu_fd_sc_mcu7t5v0__or4_1_0/A2 gf180mcu_fd_sc_mcu7t5v0__and4_1_3/A4
+ vdd vss gf180mcu_fd_sc_mcu7t5v0__xor3_1
Xgf180mcu_fd_sc_mcu7t5v0__xor3_1_174 gf180mcu_fd_sc_mcu7t5v0__xor3_1_174/A3 vdd vss
+ gf180mcu_fd_sc_mcu7t5v0__xor3_1_174/Z gf180mcu_fd_sc_mcu7t5v0__or4_1_0/A1 gf180mcu_fd_sc_mcu7t5v0__mux4_4_3/Z
+ vdd vss gf180mcu_fd_sc_mcu7t5v0__xor3_1
Xgf180mcu_fd_sc_mcu7t5v0__oai211_1_12 gf180mcu_fd_sc_mcu7t5v0__oai211_1_12/B gf180mcu_fd_sc_mcu7t5v0__nand3_4_7/ZN
+ vdd vss gf180mcu_fd_sc_mcu7t5v0__aoi221_1_11/C gf180mcu_fd_sc_mcu7t5v0__nand3_1_35/ZN
+ gf180mcu_fd_sc_mcu7t5v0__or2_1_9/A1 vdd vss gf180mcu_fd_sc_mcu7t5v0__oai211_1
Xgf180mcu_fd_sc_mcu7t5v0__oai211_1_23 gf180mcu_fd_sc_mcu7t5v0__oai211_1_23/B gf180mcu_fd_sc_mcu7t5v0__oai211_1_23/C
+ vdd vss gf180mcu_fd_sc_mcu7t5v0__oai21_1_124/B gf180mcu_fd_sc_mcu7t5v0__and2_1_78/Z
+ gf180mcu_fd_sc_mcu7t5v0__oai21_1_172/ZN vdd vss gf180mcu_fd_sc_mcu7t5v0__oai211_1
Xgf180mcu_fd_sc_mcu7t5v0__nand3_4_10 gf180mcu_fd_sc_mcu7t5v0__or3_4_0/A3 vdd vss gf180mcu_fd_sc_mcu7t5v0__buf_20_0/I
+ gf180mcu_fd_sc_mcu7t5v0__nand3_4_10/A1 gf180mcu_fd_sc_mcu7t5v0__or3_4_0/A2 vdd vss
+ gf180mcu_fd_sc_mcu7t5v0__nand3_4
Xgf180mcu_fd_sc_mcu7t5v0__oai211_1_34 gf180mcu_fd_sc_mcu7t5v0__oai211_1_34/B gf180mcu_fd_sc_mcu7t5v0__or2_1_34/A2
+ vdd vss gf180mcu_fd_sc_mcu7t5v0__oai211_1_34/ZN gf180mcu_fd_sc_mcu7t5v0__oai31_1_14/B
+ gf180mcu_fd_sc_mcu7t5v0__xor2_1_146/Z vdd vss gf180mcu_fd_sc_mcu7t5v0__oai211_1
Xgf180mcu_fd_sc_mcu7t5v0__oai211_1_45 gf180mcu_fd_sc_mcu7t5v0__dffq_2_86/Q gf180mcu_fd_sc_mcu7t5v0__inv_3_4/I
+ vdd vss gf180mcu_fd_sc_mcu7t5v0__oai221_1_13/C gf180mcu_fd_sc_mcu7t5v0__or4_1_0/A1
+ gf180mcu_fd_sc_mcu7t5v0__nor3_4_22/A3 vdd vss gf180mcu_fd_sc_mcu7t5v0__oai211_1
Xgf180mcu_fd_sc_mcu7t5v0__nand3_4_21 gf180mcu_fd_sc_mcu7t5v0__inv_4_5/ZN vdd vss gf180mcu_fd_sc_mcu7t5v0__oai21_4_12/B
+ gf180mcu_fd_sc_mcu7t5v0__inv_1_18/ZN gf180mcu_fd_sc_mcu7t5v0__nor3_2_11/A2 vdd vss
+ gf180mcu_fd_sc_mcu7t5v0__nand3_4
Xgf180mcu_fd_sc_mcu7t5v0__oai211_1_56 gf180mcu_fd_sc_mcu7t5v0__oai211_1_56/B gf180mcu_fd_sc_mcu7t5v0__oai211_1_56/C
+ vdd vss gf180mcu_fd_sc_mcu7t5v0__oai211_1_56/ZN gf180mcu_fd_sc_mcu7t5v0__nor2_1_81/ZN
+ gf180mcu_fd_sc_mcu7t5v0__oai211_1_56/A2 vdd vss gf180mcu_fd_sc_mcu7t5v0__oai211_1
Xgf180mcu_fd_sc_mcu7t5v0__oai21_1_200 vdd gf180mcu_fd_sc_mcu7t5v0__xor2_1_224/A2 gf180mcu_fd_sc_mcu7t5v0__oai32_4_0/ZN
+ gf180mcu_fd_sc_mcu7t5v0__xor3_1_177/A3 gf180mcu_fd_sc_mcu7t5v0__or3_1_12/A3 vss
+ vdd vss gf180mcu_fd_sc_mcu7t5v0__oai21_1
Xgf180mcu_fd_sc_mcu7t5v0__oai21_1_211 vdd gf180mcu_fd_sc_mcu7t5v0__or3_1_16/A3 gf180mcu_fd_sc_mcu7t5v0__or3_1_16/A2
+ gf180mcu_fd_sc_mcu7t5v0__nand3_1_68/A3 gf180mcu_fd_sc_mcu7t5v0__or3_1_16/A1 vss
+ vdd vss gf180mcu_fd_sc_mcu7t5v0__oai21_1
Xgf180mcu_fd_sc_mcu7t5v0__oai21_1_222 vdd gf180mcu_fd_sc_mcu7t5v0__oai21_1_222/B gf180mcu_fd_sc_mcu7t5v0__nor2_1_275/ZN
+ gf180mcu_fd_sc_mcu7t5v0__xor2_1_207/A1 gf180mcu_fd_sc_mcu7t5v0__xor3_1_155/A2 vss
+ vdd vss gf180mcu_fd_sc_mcu7t5v0__oai21_1
Xgf180mcu_fd_sc_mcu7t5v0__oai21_1_233 vdd gf180mcu_fd_sc_mcu7t5v0__buf_12_0/Z gf180mcu_fd_sc_mcu7t5v0__buf_20_0/Z
+ gf180mcu_fd_sc_mcu7t5v0__aoi21_1_259/B gf180mcu_fd_sc_mcu7t5v0__dffq_1_422/Q vss
+ vdd vss gf180mcu_fd_sc_mcu7t5v0__oai21_1
Xgf180mcu_fd_sc_mcu7t5v0__oai21_1_244 vdd gf180mcu_fd_sc_mcu7t5v0__oai21_1_244/B gf180mcu_fd_sc_mcu7t5v0__nor2_1_308/ZN
+ gf180mcu_fd_sc_mcu7t5v0__xor3_1_172/A2 gf180mcu_fd_sc_mcu7t5v0__xor3_1_110/A2 vss
+ vdd vss gf180mcu_fd_sc_mcu7t5v0__oai21_1
Xgf180mcu_fd_sc_mcu7t5v0__oai21_1_255 vdd gf180mcu_fd_sc_mcu7t5v0__buf_12_0/Z gf180mcu_fd_sc_mcu7t5v0__buf_20_0/I
+ gf180mcu_fd_sc_mcu7t5v0__aoi21_1_283/B gf180mcu_fd_sc_mcu7t5v0__dffq_2_57/Q vss
+ vdd vss gf180mcu_fd_sc_mcu7t5v0__oai21_1
Xgf180mcu_fd_sc_mcu7t5v0__oai21_1_266 vdd gf180mcu_fd_sc_mcu7t5v0__buf_12_0/Z gf180mcu_fd_sc_mcu7t5v0__buf_20_0/I
+ gf180mcu_fd_sc_mcu7t5v0__aoi21_1_305/B gf180mcu_fd_sc_mcu7t5v0__dffq_1_429/Q vss
+ vdd vss gf180mcu_fd_sc_mcu7t5v0__oai21_1
Xgf180mcu_fd_sc_mcu7t5v0__oai21_1_277 vdd gf180mcu_fd_sc_mcu7t5v0__oai21_1_277/B gf180mcu_fd_sc_mcu7t5v0__xor3_1_164/Z
+ gf180mcu_fd_sc_mcu7t5v0__oai21_1_277/ZN gf180mcu_fd_sc_mcu7t5v0__oai211_1_43/C vss
+ vdd vss gf180mcu_fd_sc_mcu7t5v0__oai21_1
Xgf180mcu_fd_sc_mcu7t5v0__oai21_1_288 vdd gf180mcu_fd_sc_mcu7t5v0__oai21_1_288/B gf180mcu_fd_sc_mcu7t5v0__nor3_4_20/ZN
+ gf180mcu_fd_sc_mcu7t5v0__nand3_1_86/A2 gf180mcu_fd_sc_mcu7t5v0__nor3_4_21/ZN vss
+ vdd vss gf180mcu_fd_sc_mcu7t5v0__oai21_1
Xgf180mcu_fd_sc_mcu7t5v0__oai21_1_299 vdd gf180mcu_fd_sc_mcu7t5v0__oai21_1_299/B gf180mcu_fd_sc_mcu7t5v0__nor2_1_363/ZN
+ gf180mcu_fd_sc_mcu7t5v0__xor2_1_169/A1 gf180mcu_fd_sc_mcu7t5v0__oai21_1_299/A1 vss
+ vdd vss gf180mcu_fd_sc_mcu7t5v0__oai21_1
Xgf180mcu_fd_sc_mcu7t5v0__nand3_4_0 gf180mcu_fd_sc_mcu7t5v0__and2_4_0/A2 vdd vss gf180mcu_fd_sc_mcu7t5v0__nor3_4_0/A3
+ gf180mcu_fd_sc_mcu7t5v0__inv_8_0/I gf180mcu_fd_sc_mcu7t5v0__and2_4_0/A1 vdd vss
+ gf180mcu_fd_sc_mcu7t5v0__nand3_4
Xgf180mcu_fd_sc_mcu7t5v0__aoi221_1_1 gf180mcu_fd_sc_mcu7t5v0__nor2_1_55/ZN gf180mcu_fd_sc_mcu7t5v0__or2_4_4/Z
+ vdd vss gf180mcu_fd_sc_mcu7t5v0__nor2_1_54/A1 gf180mcu_fd_sc_mcu7t5v0__oai31_1_0/B
+ gf180mcu_fd_sc_mcu7t5v0__nand2_1_20/ZN gf180mcu_fd_sc_mcu7t5v0__nor2_1_21/A1 vdd
+ vss gf180mcu_fd_sc_mcu7t5v0__aoi221_1
Xgf180mcu_fd_sc_mcu7t5v0__nor2_1_3 vdd vss gf180mcu_fd_sc_mcu7t5v0__nor2_1_3/ZN gf180mcu_fd_sc_mcu7t5v0__nor2_1_3/A1
+ gf180mcu_fd_sc_mcu7t5v0__xor2_1_1/Z vdd vss gf180mcu_fd_sc_mcu7t5v0__nor2_1
Xgf180mcu_fd_sc_mcu7t5v0__xor2_1_11 vdd vss gf180mcu_fd_sc_mcu7t5v0__xor2_1_11/Z gf180mcu_fd_sc_mcu7t5v0__or2_1_1/Z
+ gf180mcu_fd_sc_mcu7t5v0__xor3_1_60/Z vdd vss gf180mcu_fd_sc_mcu7t5v0__xor2_1
Xgf180mcu_fd_sc_mcu7t5v0__xor2_1_22 vdd vss gf180mcu_fd_sc_mcu7t5v0__or3_1_2/A3 gf180mcu_fd_sc_mcu7t5v0__inv_4_6/I
+ gf180mcu_fd_sc_mcu7t5v0__xor2_1_20/Z vdd vss gf180mcu_fd_sc_mcu7t5v0__xor2_1
Xgf180mcu_fd_sc_mcu7t5v0__xor2_1_33 vdd vss gf180mcu_fd_sc_mcu7t5v0__xor2_1_33/Z gf180mcu_fd_sc_mcu7t5v0__xor2_1_33/A1
+ gf180mcu_fd_sc_mcu7t5v0__xor2_1_34/Z vdd vss gf180mcu_fd_sc_mcu7t5v0__xor2_1
Xgf180mcu_fd_sc_mcu7t5v0__xor2_1_44 vdd vss gf180mcu_fd_sc_mcu7t5v0__xor2_1_44/Z gf180mcu_fd_sc_mcu7t5v0__xor2_1_44/A1
+ gf180mcu_fd_sc_mcu7t5v0__xor2_1_44/A2 vdd vss gf180mcu_fd_sc_mcu7t5v0__xor2_1
Xgf180mcu_fd_sc_mcu7t5v0__xor2_1_55 vdd vss gf180mcu_fd_sc_mcu7t5v0__xor2_1_55/Z gf180mcu_fd_sc_mcu7t5v0__inv_4_6/I
+ gf180mcu_fd_sc_mcu7t5v0__xor2_1_55/A2 vdd vss gf180mcu_fd_sc_mcu7t5v0__xor2_1
Xgf180mcu_fd_sc_mcu7t5v0__xor2_1_66 vdd vss gf180mcu_fd_sc_mcu7t5v0__xor2_1_66/Z gf180mcu_fd_sc_mcu7t5v0__xor2_1_66/A1
+ gf180mcu_fd_sc_mcu7t5v0__xor2_1_66/A2 vdd vss gf180mcu_fd_sc_mcu7t5v0__xor2_1
Xgf180mcu_fd_sc_mcu7t5v0__xor2_1_77 vdd vss gf180mcu_fd_sc_mcu7t5v0__xor2_1_77/Z gf180mcu_fd_sc_mcu7t5v0__xor2_1_77/A1
+ gf180mcu_fd_sc_mcu7t5v0__or3_1_9/A3 vdd vss gf180mcu_fd_sc_mcu7t5v0__xor2_1
Xgf180mcu_fd_sc_mcu7t5v0__xor2_1_140 vdd vss gf180mcu_fd_sc_mcu7t5v0__xor3_1_94/A2
+ gf180mcu_fd_sc_mcu7t5v0__xor2_1_140/A1 gf180mcu_fd_sc_mcu7t5v0__xor3_1_93/Z vdd
+ vss gf180mcu_fd_sc_mcu7t5v0__xor2_1
Xgf180mcu_fd_sc_mcu7t5v0__xor2_1_88 vdd vss gf180mcu_fd_sc_mcu7t5v0__xor2_1_88/Z gf180mcu_fd_sc_mcu7t5v0__xor2_1_88/A1
+ gf180mcu_fd_sc_mcu7t5v0__xor2_1_88/A2 vdd vss gf180mcu_fd_sc_mcu7t5v0__xor2_1
Xgf180mcu_fd_sc_mcu7t5v0__xor2_1_99 vdd vss gf180mcu_fd_sc_mcu7t5v0__xor2_1_99/Z gf180mcu_fd_sc_mcu7t5v0__nor3_2_4/ZN
+ gf180mcu_fd_sc_mcu7t5v0__xor3_1_73/A3 vdd vss gf180mcu_fd_sc_mcu7t5v0__xor2_1
Xgf180mcu_fd_sc_mcu7t5v0__xor2_1_151 vdd vss gf180mcu_fd_sc_mcu7t5v0__xor2_1_151/Z
+ gf180mcu_fd_sc_mcu7t5v0__inv_8_2/ZN gf180mcu_fd_sc_mcu7t5v0__xor2_1_221/Z vdd vss
+ gf180mcu_fd_sc_mcu7t5v0__xor2_1
Xgf180mcu_fd_sc_mcu7t5v0__xor2_1_162 vdd vss gf180mcu_fd_sc_mcu7t5v0__xor2_1_162/Z
+ gf180mcu_fd_sc_mcu7t5v0__xor2_1_162/A1 gf180mcu_fd_sc_mcu7t5v0__xor2_1_162/A2 vdd
+ vss gf180mcu_fd_sc_mcu7t5v0__xor2_1
Xgf180mcu_fd_sc_mcu7t5v0__aoi21_1_109 gf180mcu_fd_sc_mcu7t5v0__oai21_1_95/ZN vdd vss
+ gf180mcu_fd_sc_mcu7t5v0__dffq_1_293/D gf180mcu_fd_sc_mcu7t5v0__aoi22_4_8/ZN gf180mcu_fd_sc_mcu7t5v0__aoi21_1_115/ZN
+ vdd vss gf180mcu_fd_sc_mcu7t5v0__aoi21_1
Xgf180mcu_fd_sc_mcu7t5v0__xor2_1_173 vdd vss gf180mcu_fd_sc_mcu7t5v0__xor2_1_173/Z
+ gf180mcu_fd_sc_mcu7t5v0__oai33_2_4/ZN gf180mcu_fd_sc_mcu7t5v0__xor2_1_174/Z vdd
+ vss gf180mcu_fd_sc_mcu7t5v0__xor2_1
Xgf180mcu_fd_sc_mcu7t5v0__xor2_1_184 vdd vss gf180mcu_fd_sc_mcu7t5v0__xor2_1_184/Z
+ gf180mcu_fd_sc_mcu7t5v0__xor2_1_184/A1 gf180mcu_fd_sc_mcu7t5v0__xor2_1_205/Z vdd
+ vss gf180mcu_fd_sc_mcu7t5v0__xor2_1
Xgf180mcu_fd_sc_mcu7t5v0__xor2_1_195 vdd vss gf180mcu_fd_sc_mcu7t5v0__xor2_1_195/Z
+ gf180mcu_fd_sc_mcu7t5v0__xor2_1_195/A1 gf180mcu_fd_sc_mcu7t5v0__xor2_1_206/Z vdd
+ vss gf180mcu_fd_sc_mcu7t5v0__xor2_1
Xgf180mcu_fd_sc_mcu7t5v0__and2_1_109 vdd vss gf180mcu_fd_sc_mcu7t5v0__and2_1_109/Z
+ gf180mcu_fd_sc_mcu7t5v0__xor3_1_99/Z gf180mcu_fd_sc_mcu7t5v0__xor3_1_156/A3 vdd
+ vss gf180mcu_fd_sc_mcu7t5v0__and2_1
Xgf180mcu_fd_sc_mcu7t5v0__nand3_1_11 gf180mcu_fd_sc_mcu7t5v0__and2_4_2/A2 vdd vss
+ gf180mcu_fd_sc_mcu7t5v0__xnor2_1_80/A1 gf180mcu_fd_sc_mcu7t5v0__inv_8_1/I gf180mcu_fd_sc_mcu7t5v0__or3_2_2/Z
+ vdd vss gf180mcu_fd_sc_mcu7t5v0__nand3_1
Xgf180mcu_fd_sc_mcu7t5v0__nand3_1_22 gf180mcu_fd_sc_mcu7t5v0__and3_1_4/A3 vdd vss
+ gf180mcu_fd_sc_mcu7t5v0__nand4_1_3/A2 gf180mcu_fd_sc_mcu7t5v0__nor2_2_6/ZN gf180mcu_fd_sc_mcu7t5v0__or3_1_5/Z
+ vdd vss gf180mcu_fd_sc_mcu7t5v0__nand3_1
Xgf180mcu_fd_sc_mcu7t5v0__nand3_1_33 gf180mcu_fd_sc_mcu7t5v0__or2_1_16/A2 vdd vss
+ gf180mcu_fd_sc_mcu7t5v0__oai211_1_16/B gf180mcu_fd_sc_mcu7t5v0__or2_1_7/A1 gf180mcu_fd_sc_mcu7t5v0__nor2_2_9/ZN
+ vdd vss gf180mcu_fd_sc_mcu7t5v0__nand3_1
Xgf180mcu_fd_sc_mcu7t5v0__nand3_1_44 gf180mcu_fd_sc_mcu7t5v0__nand3_1_44/A3 vdd vss
+ gf180mcu_fd_sc_mcu7t5v0__nand3_1_44/ZN gf180mcu_fd_sc_mcu7t5v0__nand3_1_44/A1 gf180mcu_fd_sc_mcu7t5v0__nand3_1_44/A2
+ vdd vss gf180mcu_fd_sc_mcu7t5v0__nand3_1
Xgf180mcu_fd_sc_mcu7t5v0__nand3_1_55 gf180mcu_fd_sc_mcu7t5v0__nand3_1_55/A3 vdd vss
+ gf180mcu_fd_sc_mcu7t5v0__dffq_1_387/D gf180mcu_fd_sc_mcu7t5v0__buf_8_8/Z gf180mcu_fd_sc_mcu7t5v0__nand3_1_55/A2
+ vdd vss gf180mcu_fd_sc_mcu7t5v0__nand3_1
Xgf180mcu_fd_sc_mcu7t5v0__nand3_1_66 gf180mcu_fd_sc_mcu7t5v0__xor2_1_121/Z vdd vss
+ gf180mcu_fd_sc_mcu7t5v0__nand3_1_66/ZN gf180mcu_fd_sc_mcu7t5v0__nand3_1_66/A1 gf180mcu_fd_sc_mcu7t5v0__nand3_1_66/A2
+ vdd vss gf180mcu_fd_sc_mcu7t5v0__nand3_1
Xgf180mcu_fd_sc_mcu7t5v0__nand3_1_77 gf180mcu_fd_sc_mcu7t5v0__oai22_2_1/ZN vdd vss
+ gf180mcu_fd_sc_mcu7t5v0__nand3_1_77/ZN gf180mcu_fd_sc_mcu7t5v0__dffq_4_37/Q gf180mcu_fd_sc_mcu7t5v0__and2_2_9/Z
+ vdd vss gf180mcu_fd_sc_mcu7t5v0__nand3_1
Xgf180mcu_fd_sc_mcu7t5v0__nand3_1_88 gf180mcu_fd_sc_mcu7t5v0__or4_1_3/A1 vdd vss gf180mcu_fd_sc_mcu7t5v0__oai211_1_42/B
+ gf180mcu_fd_sc_mcu7t5v0__inv_8_0/I gf180mcu_fd_sc_mcu7t5v0__inv_3_4/I vdd vss gf180mcu_fd_sc_mcu7t5v0__nand3_1
Xgf180mcu_fd_sc_mcu7t5v0__nand3_1_99 gf180mcu_fd_sc_mcu7t5v0__xnor3_1_49/ZN vdd vss
+ gf180mcu_fd_sc_mcu7t5v0__nand3_1_99/ZN gf180mcu_fd_sc_mcu7t5v0__mux4_4_6/I0 gf180mcu_fd_sc_mcu7t5v0__nor2_2_52/ZN
+ vdd vss gf180mcu_fd_sc_mcu7t5v0__nand3_1
Xgf180mcu_fd_sc_mcu7t5v0__nand2_1_409 vdd vss gf180mcu_fd_sc_mcu7t5v0__oai21_1_201/B
+ gf180mcu_fd_sc_mcu7t5v0__xnor2_1_37/A1 gf180mcu_fd_sc_mcu7t5v0__xor2_1_109/Z vdd
+ vss gf180mcu_fd_sc_mcu7t5v0__nand2_1
Xgf180mcu_fd_sc_mcu7t5v0__oai32_1_1 gf180mcu_fd_sc_mcu7t5v0__and2_1_21/Z gf180mcu_fd_sc_mcu7t5v0__oai32_1_1/B1
+ gf180mcu_fd_sc_mcu7t5v0__xor3_1_59/A2 vdd vss gf180mcu_fd_sc_mcu7t5v0__xor2_1_38/A1
+ gf180mcu_fd_sc_mcu7t5v0__oai32_1_1/A1 gf180mcu_fd_sc_mcu7t5v0__oai32_1_1/A2 vdd
+ vss gf180mcu_fd_sc_mcu7t5v0__oai32_1
Xgf180mcu_fd_sc_mcu7t5v0__aoi221_1_50 gf180mcu_fd_sc_mcu7t5v0__nor2_1_322/ZN gf180mcu_fd_sc_mcu7t5v0__aoi21_1_7/B
+ vdd vss gf180mcu_fd_sc_mcu7t5v0__dffq_1_421/D gf180mcu_fd_sc_mcu7t5v0__xor2_1_157/A1
+ gf180mcu_fd_sc_mcu7t5v0__or2_4_4/Z gf180mcu_fd_sc_mcu7t5v0__oai21_1_232/ZN vdd vss
+ gf180mcu_fd_sc_mcu7t5v0__aoi221_1
Xgf180mcu_fd_sc_mcu7t5v0__aoi221_1_61 gf180mcu_fd_sc_mcu7t5v0__nor2_2_57/ZN gf180mcu_fd_sc_mcu7t5v0__nor2_2_54/ZN
+ vdd vss gf180mcu_fd_sc_mcu7t5v0__oai21_1_322/B gf180mcu_fd_sc_mcu7t5v0__inv_4_6/I
+ gf180mcu_fd_sc_mcu7t5v0__nor2_2_55/ZN gf180mcu_fd_sc_mcu7t5v0__oai21_1_322/A2 vdd
+ vss gf180mcu_fd_sc_mcu7t5v0__aoi221_1
Xgf180mcu_fd_sc_mcu7t5v0__nor3_4_1 gf180mcu_fd_sc_mcu7t5v0__nor3_4_1/A3 vdd vss gf180mcu_fd_sc_mcu7t5v0__xor3_1_2/A1
+ gf180mcu_fd_sc_mcu7t5v0__or3_1_24/A1 gf180mcu_fd_sc_mcu7t5v0__nor3_4_1/A2 vdd vss
+ gf180mcu_fd_sc_mcu7t5v0__nor3_4
Xgf180mcu_fd_sc_mcu7t5v0__dffq_2_17 gf180mcu_fd_sc_mcu7t5v0__dffq_2_17/D vdd vss gf180mcu_fd_sc_mcu7t5v0__dffq_4_6/CLK
+ gf180mcu_fd_sc_mcu7t5v0__nor2_2_8/A2 vdd vss gf180mcu_fd_sc_mcu7t5v0__dffq_2
Xgf180mcu_fd_sc_mcu7t5v0__dffq_2_28 gf180mcu_fd_sc_mcu7t5v0__dffq_2_28/D vdd vss gf180mcu_fd_sc_mcu7t5v0__dffq_4_9/CLK
+ gf180mcu_fd_sc_mcu7t5v0__or3_4_0/A2 vdd vss gf180mcu_fd_sc_mcu7t5v0__dffq_2
Xgf180mcu_fd_sc_mcu7t5v0__dffq_2_39 gf180mcu_fd_sc_mcu7t5v0__dffq_2_39/D vdd vss gf180mcu_fd_sc_mcu7t5v0__dffq_4_21/CLK
+ gf180mcu_fd_sc_mcu7t5v0__inv_1_7/I vdd vss gf180mcu_fd_sc_mcu7t5v0__dffq_2
Xgf180mcu_fd_sc_mcu7t5v0__inv_2_11 vss gf180mcu_fd_sc_mcu7t5v0__inv_2_11/ZN gf180mcu_fd_sc_mcu7t5v0__inv_2_11/I
+ vdd vdd vss gf180mcu_fd_sc_mcu7t5v0__inv_2
Xgf180mcu_fd_sc_mcu7t5v0__and3_1_15 gf180mcu_fd_sc_mcu7t5v0__xor2_1_138/Z vdd vss
+ gf180mcu_fd_sc_mcu7t5v0__or3_1_18/A3 gf180mcu_fd_sc_mcu7t5v0__and3_1_15/A1 gf180mcu_fd_sc_mcu7t5v0__and3_1_15/A2
+ vdd vss gf180mcu_fd_sc_mcu7t5v0__and3_1
Xgf180mcu_fd_sc_mcu7t5v0__and2_1_2 vdd vss gf180mcu_fd_sc_mcu7t5v0__or3_1_0/A2 gf180mcu_fd_sc_mcu7t5v0__xor2_1_7/A1
+ gf180mcu_fd_sc_mcu7t5v0__xor3_1_3/Z vdd vss gf180mcu_fd_sc_mcu7t5v0__and2_1
Xgf180mcu_fd_sc_mcu7t5v0__nand2_1_206 vdd vss gf180mcu_fd_sc_mcu7t5v0__oai221_2_0/C
+ gf180mcu_fd_sc_mcu7t5v0__or4_1_0/A1 gf180mcu_fd_sc_mcu7t5v0__nor2_4_1/ZN vdd vss
+ gf180mcu_fd_sc_mcu7t5v0__nand2_1
Xgf180mcu_fd_sc_mcu7t5v0__nand2_1_217 vdd vss gf180mcu_fd_sc_mcu7t5v0__aoi222_1_6/C2
+ gf180mcu_fd_sc_mcu7t5v0__aoi22_1_45/ZN gf180mcu_fd_sc_mcu7t5v0__aoi22_1_49/ZN vdd
+ vss gf180mcu_fd_sc_mcu7t5v0__nand2_1
Xgf180mcu_fd_sc_mcu7t5v0__nand2_1_228 vdd vss gf180mcu_fd_sc_mcu7t5v0__aoi22_1_67/B1
+ gf180mcu_fd_sc_mcu7t5v0__aoi22_1_46/ZN gf180mcu_fd_sc_mcu7t5v0__aoi22_1_47/ZN vdd
+ vss gf180mcu_fd_sc_mcu7t5v0__nand2_1
Xgf180mcu_fd_sc_mcu7t5v0__nand2_1_239 vdd vss gf180mcu_fd_sc_mcu7t5v0__aoi222_1_2/C1
+ gf180mcu_fd_sc_mcu7t5v0__aoi22_1_74/ZN gf180mcu_fd_sc_mcu7t5v0__aoi22_1_36/ZN vdd
+ vss gf180mcu_fd_sc_mcu7t5v0__nand2_1
Xgf180mcu_fd_sc_mcu7t5v0__aoi21_1_18 gf180mcu_fd_sc_mcu7t5v0__nor2_1_56/ZN vdd vss
+ gf180mcu_fd_sc_mcu7t5v0__xor2_1_19/A2 gf180mcu_fd_sc_mcu7t5v0__nor2_1_24/ZN gf180mcu_fd_sc_mcu7t5v0__nand2_1_30/ZN
+ vdd vss gf180mcu_fd_sc_mcu7t5v0__aoi21_1
Xgf180mcu_fd_sc_mcu7t5v0__aoi21_1_29 gf180mcu_fd_sc_mcu7t5v0__aoi21_1_7/B vdd vss
+ gf180mcu_fd_sc_mcu7t5v0__dffq_2_7/D gf180mcu_fd_sc_mcu7t5v0__nand2_1_33/ZN gf180mcu_fd_sc_mcu7t5v0__oai211_1_6/ZN
+ vdd vss gf180mcu_fd_sc_mcu7t5v0__aoi21_1
Xgf180mcu_fd_sc_mcu7t5v0__nor2_2_15 vdd vss gf180mcu_fd_sc_mcu7t5v0__nor2_2_15/ZN
+ gf180mcu_fd_sc_mcu7t5v0__dffq_4_7/Q gf180mcu_fd_sc_mcu7t5v0__nor2_2_15/A2 vdd vss
+ gf180mcu_fd_sc_mcu7t5v0__nor2_2
Xgf180mcu_fd_sc_mcu7t5v0__nor2_2_26 vdd vss gf180mcu_fd_sc_mcu7t5v0__nor2_2_26/ZN
+ gf180mcu_fd_sc_mcu7t5v0__dffq_2_98/Q gf180mcu_fd_sc_mcu7t5v0__and3_2_3/A1 vdd vss
+ gf180mcu_fd_sc_mcu7t5v0__nor2_2
Xgf180mcu_fd_sc_mcu7t5v0__nor2_2_37 vdd vss gf180mcu_fd_sc_mcu7t5v0__nor2_2_37/ZN
+ gf180mcu_fd_sc_mcu7t5v0__oai32_1_6/A2 gf180mcu_fd_sc_mcu7t5v0__oai32_1_6/A3 vdd
+ vss gf180mcu_fd_sc_mcu7t5v0__nor2_2
Xgf180mcu_fd_sc_mcu7t5v0__nor2_2_48 vdd vss gf180mcu_fd_sc_mcu7t5v0__or4_1_3/A2 gf180mcu_fd_sc_mcu7t5v0__inv_3_4/I
+ gf180mcu_fd_sc_mcu7t5v0__nor2_2_48/A2 vdd vss gf180mcu_fd_sc_mcu7t5v0__nor2_2
Xgf180mcu_fd_sc_mcu7t5v0__nor2_2_59 vdd vss gf180mcu_fd_sc_mcu7t5v0__nor4_4_4/A2 gf180mcu_fd_sc_mcu7t5v0__inv_4_7/ZN
+ gf180mcu_fd_sc_mcu7t5v0__mux4_4_6/I0 vdd vss gf180mcu_fd_sc_mcu7t5v0__nor2_2
Xgf180mcu_fd_sc_mcu7t5v0__dffq_1_303 vdd gf180mcu_fd_sc_mcu7t5v0__dffq_1_303/Q gf180mcu_fd_sc_mcu7t5v0__dffq_4_21/CLK
+ vss gf180mcu_fd_sc_mcu7t5v0__dffq_1_303/D vdd vss gf180mcu_fd_sc_mcu7t5v0__dffq_1
Xgf180mcu_fd_sc_mcu7t5v0__dffq_1_314 vdd gf180mcu_fd_sc_mcu7t5v0__dffq_1_314/Q gf180mcu_fd_sc_mcu7t5v0__dffq_2_58/CLK
+ vss gf180mcu_fd_sc_mcu7t5v0__dffq_1_314/D vdd vss gf180mcu_fd_sc_mcu7t5v0__dffq_1
Xgf180mcu_fd_sc_mcu7t5v0__dffq_1_325 vdd gf180mcu_fd_sc_mcu7t5v0__dffq_1_325/Q gf180mcu_fd_sc_mcu7t5v0__dffq_2_58/CLK
+ vss gf180mcu_fd_sc_mcu7t5v0__dffq_1_325/D vdd vss gf180mcu_fd_sc_mcu7t5v0__dffq_1
Xgf180mcu_fd_sc_mcu7t5v0__dffq_1_336 vdd gf180mcu_fd_sc_mcu7t5v0__dffq_1_336/Q gf180mcu_fd_sc_mcu7t5v0__dffq_2_58/CLK
+ vss gf180mcu_fd_sc_mcu7t5v0__dffq_1_336/D vdd vss gf180mcu_fd_sc_mcu7t5v0__dffq_1
Xgf180mcu_fd_sc_mcu7t5v0__dffq_1_347 vdd gf180mcu_fd_sc_mcu7t5v0__or2_1_23/A2 gf180mcu_fd_sc_mcu7t5v0__dffq_4_15/CLK
+ vss gf180mcu_fd_sc_mcu7t5v0__or2_1_22/Z vdd vss gf180mcu_fd_sc_mcu7t5v0__dffq_1
Xgf180mcu_fd_sc_mcu7t5v0__dffq_1_358 vdd gf180mcu_fd_sc_mcu7t5v0__dffq_1_358/Q gf180mcu_fd_sc_mcu7t5v0__dffq_4_15/CLK
+ vss gf180mcu_fd_sc_mcu7t5v0__dffq_1_358/D vdd vss gf180mcu_fd_sc_mcu7t5v0__dffq_1
Xgf180mcu_fd_sc_mcu7t5v0__dffq_1_369 vdd gf180mcu_fd_sc_mcu7t5v0__nand4_2_1/A1 gf180mcu_fd_sc_mcu7t5v0__dffq_4_15/CLK
+ vss gf180mcu_fd_sc_mcu7t5v0__dffq_1_369/D vdd vss gf180mcu_fd_sc_mcu7t5v0__dffq_1
Xgf180mcu_fd_sc_mcu7t5v0__oai22_1_15 gf180mcu_fd_sc_mcu7t5v0__nand2_4_3/ZN gf180mcu_fd_sc_mcu7t5v0__oai22_1_45/B1
+ gf180mcu_fd_sc_mcu7t5v0__oai22_1_15/B2 vdd vss gf180mcu_fd_sc_mcu7t5v0__dffq_1_50/D
+ gf180mcu_fd_sc_mcu7t5v0__oai21_4_9/ZN vdd vss gf180mcu_fd_sc_mcu7t5v0__oai22_1
Xgf180mcu_fd_sc_mcu7t5v0__oai22_1_26 gf180mcu_fd_sc_mcu7t5v0__nand2_4_2/ZN gf180mcu_fd_sc_mcu7t5v0__oai22_1_29/B1
+ gf180mcu_fd_sc_mcu7t5v0__oai22_1_26/B2 vdd vss gf180mcu_fd_sc_mcu7t5v0__dffq_1_28/D
+ gf180mcu_fd_sc_mcu7t5v0__aoi21_4_4/ZN vdd vss gf180mcu_fd_sc_mcu7t5v0__oai22_1
Xgf180mcu_fd_sc_mcu7t5v0__oai22_1_37 gf180mcu_fd_sc_mcu7t5v0__nand2_4_3/ZN gf180mcu_fd_sc_mcu7t5v0__oai22_1_45/B1
+ gf180mcu_fd_sc_mcu7t5v0__oai22_1_37/B2 vdd vss gf180mcu_fd_sc_mcu7t5v0__dffq_1_38/D
+ gf180mcu_fd_sc_mcu7t5v0__aoi21_4_1/ZN vdd vss gf180mcu_fd_sc_mcu7t5v0__oai22_1
Xgf180mcu_fd_sc_mcu7t5v0__oai22_1_48 gf180mcu_fd_sc_mcu7t5v0__oai22_1_48/A2 gf180mcu_fd_sc_mcu7t5v0__oai22_1_98/A1
+ gf180mcu_fd_sc_mcu7t5v0__nand2_4_5/ZN vdd vss gf180mcu_fd_sc_mcu7t5v0__dffq_1_40/D
+ gf180mcu_fd_sc_mcu7t5v0__oai22_1_48/A1 vdd vss gf180mcu_fd_sc_mcu7t5v0__oai22_1
Xgf180mcu_fd_sc_mcu7t5v0__oai22_1_59 gf180mcu_fd_sc_mcu7t5v0__nand2_4_6/ZN gf180mcu_fd_sc_mcu7t5v0__oai22_1_96/B1
+ gf180mcu_fd_sc_mcu7t5v0__oai22_1_59/B2 vdd vss gf180mcu_fd_sc_mcu7t5v0__dffq_1_63/D
+ gf180mcu_fd_sc_mcu7t5v0__aoi21_4_4/ZN vdd vss gf180mcu_fd_sc_mcu7t5v0__oai22_1
Xgf180mcu_fd_sc_mcu7t5v0__and2_1_70 vdd vss gf180mcu_fd_sc_mcu7t5v0__and2_1_70/Z gf180mcu_fd_sc_mcu7t5v0__buf_8_8/Z
+ gf180mcu_fd_sc_mcu7t5v0__nor4_1_3/A1 vdd vss gf180mcu_fd_sc_mcu7t5v0__and2_1
Xgf180mcu_fd_sc_mcu7t5v0__and2_1_81 vdd vss gf180mcu_fd_sc_mcu7t5v0__and2_1_81/Z gf180mcu_fd_sc_mcu7t5v0__mux4_4_3/I0
+ gf180mcu_fd_sc_mcu7t5v0__xor3_1_73/Z vdd vss gf180mcu_fd_sc_mcu7t5v0__and2_1
Xgf180mcu_fd_sc_mcu7t5v0__and2_1_92 vdd vss gf180mcu_fd_sc_mcu7t5v0__and2_1_92/Z gf180mcu_fd_sc_mcu7t5v0__xor3_1_86/A1
+ gf180mcu_fd_sc_mcu7t5v0__xor3_1_86/A2 vdd vss gf180mcu_fd_sc_mcu7t5v0__and2_1
Xgf180mcu_fd_sc_mcu7t5v0__clkinv_1_208 vdd vss gf180mcu_fd_sc_mcu7t5v0__dffq_1_201/Q
+ gf180mcu_fd_sc_mcu7t5v0__oai22_1_198/B2 vdd vss gf180mcu_fd_sc_mcu7t5v0__clkinv_1
Xgf180mcu_fd_sc_mcu7t5v0__clkinv_1_219 vdd vss gf180mcu_fd_sc_mcu7t5v0__dffq_1_197/Q
+ gf180mcu_fd_sc_mcu7t5v0__oai22_1_206/B2 vdd vss gf180mcu_fd_sc_mcu7t5v0__clkinv_1
Xgf180mcu_fd_sc_mcu7t5v0__aoi211_1_60 gf180mcu_fd_sc_mcu7t5v0__nor2_1_306/ZN gf180mcu_fd_sc_mcu7t5v0__or2_1_23/A1
+ vdd vss gf180mcu_fd_sc_mcu7t5v0__dffq_1_417/D gf180mcu_fd_sc_mcu7t5v0__inv_4_2/ZN
+ gf180mcu_fd_sc_mcu7t5v0__nor2_4_18/ZN vdd vss gf180mcu_fd_sc_mcu7t5v0__aoi211_1
Xgf180mcu_fd_sc_mcu7t5v0__aoi211_1_71 gf180mcu_fd_sc_mcu7t5v0__nor2_1_401/ZN gf180mcu_fd_sc_mcu7t5v0__or2_1_23/A1
+ vdd vss gf180mcu_fd_sc_mcu7t5v0__dffq_1_428/D gf180mcu_fd_sc_mcu7t5v0__nor2_1_144/A1
+ gf180mcu_fd_sc_mcu7t5v0__and3_2_2/Z vdd vss gf180mcu_fd_sc_mcu7t5v0__aoi211_1
Xgf180mcu_fd_sc_mcu7t5v0__aoi211_1_82 gf180mcu_fd_sc_mcu7t5v0__nor2_1_349/ZN gf180mcu_fd_sc_mcu7t5v0__or2_1_23/A1
+ vdd vss gf180mcu_fd_sc_mcu7t5v0__dffq_1_441/D gf180mcu_fd_sc_mcu7t5v0__nor2_1_411/A1
+ gf180mcu_fd_sc_mcu7t5v0__and3_2_2/Z vdd vss gf180mcu_fd_sc_mcu7t5v0__aoi211_1
Xgf180mcu_fd_sc_mcu7t5v0__oai221_1_14 gf180mcu_fd_sc_mcu7t5v0__nor2_1_393/ZN gf180mcu_fd_sc_mcu7t5v0__oai221_1_14/C
+ vdd vss gf180mcu_fd_sc_mcu7t5v0__oai21_1_312/B gf180mcu_fd_sc_mcu7t5v0__and2_1_142/Z
+ gf180mcu_fd_sc_mcu7t5v0__oai221_1_14/A2 gf180mcu_fd_sc_mcu7t5v0__oai221_1_14/B2
+ vdd vss gf180mcu_fd_sc_mcu7t5v0__oai221_1
Xgf180mcu_fd_sc_mcu7t5v0__aoi21_1_270 gf180mcu_fd_sc_mcu7t5v0__inv_1_16/I vdd vss
+ gf180mcu_fd_sc_mcu7t5v0__oai32_2_2/B2 gf180mcu_fd_sc_mcu7t5v0__xor3_1_92/A1 gf180mcu_fd_sc_mcu7t5v0__mux4_4_9/S0
+ vdd vss gf180mcu_fd_sc_mcu7t5v0__aoi21_1
Xgf180mcu_fd_sc_mcu7t5v0__aoi21_1_281 gf180mcu_fd_sc_mcu7t5v0__or2_4_4/Z vdd vss gf180mcu_fd_sc_mcu7t5v0__nor2_1_316/A1
+ gf180mcu_fd_sc_mcu7t5v0__oai21_1_246/ZN gf180mcu_fd_sc_mcu7t5v0__nand2_1_538/ZN
+ vdd vss gf180mcu_fd_sc_mcu7t5v0__aoi21_1
Xgf180mcu_fd_sc_mcu7t5v0__aoi21_1_292 gf180mcu_fd_sc_mcu7t5v0__xor2_1_154/A2 vdd vss
+ gf180mcu_fd_sc_mcu7t5v0__aoi21_1_382/B gf180mcu_fd_sc_mcu7t5v0__nand2_1_707/ZN gf180mcu_fd_sc_mcu7t5v0__or2_1_57/Z
+ vdd vss gf180mcu_fd_sc_mcu7t5v0__aoi21_1
Xgf180mcu_fd_sc_mcu7t5v0__aoi22_2_7 gf180mcu_fd_sc_mcu7t5v0__or3_1_9/A2 gf180mcu_fd_sc_mcu7t5v0__nor2_4_45/A2
+ vdd vss gf180mcu_fd_sc_mcu7t5v0__aoi22_2_7/ZN gf180mcu_fd_sc_mcu7t5v0__inv_2_12/I
+ gf180mcu_fd_sc_mcu7t5v0__nor2_2_43/ZN vdd vss gf180mcu_fd_sc_mcu7t5v0__aoi22_2
Xgf180mcu_fd_sc_mcu7t5v0__oai21_4_2 gf180mcu_fd_sc_mcu7t5v0__oai21_4_2/B vdd vss gf180mcu_fd_sc_mcu7t5v0__inv_2_11/ZN
+ gf180mcu_fd_sc_mcu7t5v0__or4_1_1/A3 gf180mcu_fd_sc_mcu7t5v0__or2_4_0/Z vdd vss gf180mcu_fd_sc_mcu7t5v0__oai21_4
Xgf180mcu_fd_sc_mcu7t5v0__oai22_1_202 gf180mcu_fd_sc_mcu7t5v0__oai22_1_43/A2 gf180mcu_fd_sc_mcu7t5v0__oai22_1_43/B1
+ gf180mcu_fd_sc_mcu7t5v0__oai22_1_202/B2 vdd vss gf180mcu_fd_sc_mcu7t5v0__dffq_1_193/D
+ gf180mcu_fd_sc_mcu7t5v0__oai21_4_9/ZN vdd vss gf180mcu_fd_sc_mcu7t5v0__oai22_1
Xgf180mcu_fd_sc_mcu7t5v0__oai22_1_213 gf180mcu_fd_sc_mcu7t5v0__nand2_4_26/ZN gf180mcu_fd_sc_mcu7t5v0__nand2_2_38/ZN
+ gf180mcu_fd_sc_mcu7t5v0__oai22_1_213/B2 vdd vss gf180mcu_fd_sc_mcu7t5v0__dffq_1_205/D
+ gf180mcu_fd_sc_mcu7t5v0__aoi21_4_3/ZN vdd vss gf180mcu_fd_sc_mcu7t5v0__oai22_1
Xgf180mcu_fd_sc_mcu7t5v0__oai21_1_70 vdd gf180mcu_fd_sc_mcu7t5v0__or3_1_6/A3 gf180mcu_fd_sc_mcu7t5v0__or3_1_6/A2
+ gf180mcu_fd_sc_mcu7t5v0__and3_1_6/A2 gf180mcu_fd_sc_mcu7t5v0__or3_1_6/A1 vss vdd
+ vss gf180mcu_fd_sc_mcu7t5v0__oai21_1
Xgf180mcu_fd_sc_mcu7t5v0__oai22_1_224 gf180mcu_fd_sc_mcu7t5v0__nand2_4_29/ZN gf180mcu_fd_sc_mcu7t5v0__nand2_2_39/ZN
+ gf180mcu_fd_sc_mcu7t5v0__oai22_1_224/B2 vdd vss gf180mcu_fd_sc_mcu7t5v0__dffq_1_216/D
+ gf180mcu_fd_sc_mcu7t5v0__aoi21_4_1/ZN vdd vss gf180mcu_fd_sc_mcu7t5v0__oai22_1
Xgf180mcu_fd_sc_mcu7t5v0__oai21_1_81 vdd gf180mcu_fd_sc_mcu7t5v0__or3_1_9/Z gf180mcu_fd_sc_mcu7t5v0__xor2_1_77/Z
+ gf180mcu_fd_sc_mcu7t5v0__xor3_1_63/A2 gf180mcu_fd_sc_mcu7t5v0__xor2_1_76/A1 vss
+ vdd vss gf180mcu_fd_sc_mcu7t5v0__oai21_1
Xgf180mcu_fd_sc_mcu7t5v0__oai21_1_92 vdd gf180mcu_fd_sc_mcu7t5v0__buf_8_4/Z gf180mcu_fd_sc_mcu7t5v0__buf_20_0/Z
+ gf180mcu_fd_sc_mcu7t5v0__oai21_1_92/ZN gf180mcu_fd_sc_mcu7t5v0__dffq_1_283/Q vss
+ vdd vss gf180mcu_fd_sc_mcu7t5v0__oai21_1
Xgf180mcu_fd_sc_mcu7t5v0__oai22_1_235 gf180mcu_fd_sc_mcu7t5v0__nand2_4_29/ZN gf180mcu_fd_sc_mcu7t5v0__nand2_2_39/ZN
+ gf180mcu_fd_sc_mcu7t5v0__oai22_1_235/B2 vdd vss gf180mcu_fd_sc_mcu7t5v0__dffq_1_227/D
+ gf180mcu_fd_sc_mcu7t5v0__aoi21_4_2/ZN vdd vss gf180mcu_fd_sc_mcu7t5v0__oai22_1
Xgf180mcu_fd_sc_mcu7t5v0__oai22_1_246 gf180mcu_fd_sc_mcu7t5v0__nand2_4_27/ZN gf180mcu_fd_sc_mcu7t5v0__nand2_2_43/ZN
+ gf180mcu_fd_sc_mcu7t5v0__oai22_1_246/B2 vdd vss gf180mcu_fd_sc_mcu7t5v0__dffq_1_239/D
+ gf180mcu_fd_sc_mcu7t5v0__aoi21_4_2/ZN vdd vss gf180mcu_fd_sc_mcu7t5v0__oai22_1
Xgf180mcu_fd_sc_mcu7t5v0__oai22_1_257 gf180mcu_fd_sc_mcu7t5v0__oai22_1_43/A2 gf180mcu_fd_sc_mcu7t5v0__oai22_1_43/B1
+ gf180mcu_fd_sc_mcu7t5v0__oai22_1_257/B2 vdd vss gf180mcu_fd_sc_mcu7t5v0__dffq_1_49/D
+ gf180mcu_fd_sc_mcu7t5v0__aoi21_4_5/ZN vdd vss gf180mcu_fd_sc_mcu7t5v0__oai22_1
Xgf180mcu_fd_sc_mcu7t5v0__oai22_1_268 gf180mcu_fd_sc_mcu7t5v0__nor4_2_5/A4 gf180mcu_fd_sc_mcu7t5v0__nor2_1_268/ZN
+ gf180mcu_fd_sc_mcu7t5v0__oai32_1_8/A1 vdd vss gf180mcu_fd_sc_mcu7t5v0__nand4_1_15/A2
+ gf180mcu_fd_sc_mcu7t5v0__or4_1_0/A1 vdd vss gf180mcu_fd_sc_mcu7t5v0__oai22_1
Xgf180mcu_fd_sc_mcu7t5v0__oai22_1_279 gf180mcu_fd_sc_mcu7t5v0__xor3_1_147/A1 gf180mcu_fd_sc_mcu7t5v0__oai22_1_279/B1
+ gf180mcu_fd_sc_mcu7t5v0__nor2_1_395/ZN vdd vss gf180mcu_fd_sc_mcu7t5v0__aoi221_1_62/C
+ gf180mcu_fd_sc_mcu7t5v0__nor2_1_389/A1 vdd vss gf180mcu_fd_sc_mcu7t5v0__oai22_1
Xgf180mcu_fd_sc_mcu7t5v0__dffq_1_100 vdd gf180mcu_fd_sc_mcu7t5v0__dffq_1_100/Q gf180mcu_fd_sc_mcu7t5v0__dffq_1_96/CLK
+ vss gf180mcu_fd_sc_mcu7t5v0__dffq_1_100/D vdd vss gf180mcu_fd_sc_mcu7t5v0__dffq_1
Xgf180mcu_fd_sc_mcu7t5v0__dffq_1_111 vdd gf180mcu_fd_sc_mcu7t5v0__dffq_1_111/Q gf180mcu_fd_sc_mcu7t5v0__dffq_1_96/CLK
+ vss gf180mcu_fd_sc_mcu7t5v0__dffq_1_111/D vdd vss gf180mcu_fd_sc_mcu7t5v0__dffq_1
Xgf180mcu_fd_sc_mcu7t5v0__nor2_1_300 vdd vss gf180mcu_fd_sc_mcu7t5v0__nor2_1_300/ZN
+ gf180mcu_fd_sc_mcu7t5v0__nor2_1_300/A1 gf180mcu_fd_sc_mcu7t5v0__inv_1_16/ZN vdd
+ vss gf180mcu_fd_sc_mcu7t5v0__nor2_1
Xgf180mcu_fd_sc_mcu7t5v0__dffq_1_122 vdd gf180mcu_fd_sc_mcu7t5v0__dffq_1_122/Q gf180mcu_fd_sc_mcu7t5v0__dffq_1_96/CLK
+ vss gf180mcu_fd_sc_mcu7t5v0__dffq_1_122/D vdd vss gf180mcu_fd_sc_mcu7t5v0__dffq_1
Xgf180mcu_fd_sc_mcu7t5v0__nor2_1_311 vdd vss gf180mcu_fd_sc_mcu7t5v0__xnor2_1_55/A2
+ gf180mcu_fd_sc_mcu7t5v0__nor3_2_5/A1 gf180mcu_fd_sc_mcu7t5v0__or3_1_9/A2 vdd vss
+ gf180mcu_fd_sc_mcu7t5v0__nor2_1
Xgf180mcu_fd_sc_mcu7t5v0__dffq_1_133 vdd gf180mcu_fd_sc_mcu7t5v0__dffq_1_133/Q gf180mcu_fd_sc_mcu7t5v0__dffq_1_96/CLK
+ vss gf180mcu_fd_sc_mcu7t5v0__dffq_1_133/D vdd vss gf180mcu_fd_sc_mcu7t5v0__dffq_1
Xgf180mcu_fd_sc_mcu7t5v0__dffq_1_144 vdd gf180mcu_fd_sc_mcu7t5v0__dffq_1_144/Q gf180mcu_fd_sc_mcu7t5v0__dffq_2_26/CLK
+ vss gf180mcu_fd_sc_mcu7t5v0__dffq_1_144/D vdd vss gf180mcu_fd_sc_mcu7t5v0__dffq_1
Xgf180mcu_fd_sc_mcu7t5v0__nor2_1_322 vdd vss gf180mcu_fd_sc_mcu7t5v0__nor2_1_322/ZN
+ gf180mcu_fd_sc_mcu7t5v0__or2_4_4/Z gf180mcu_fd_sc_mcu7t5v0__nor3_1_33/ZN vdd vss
+ gf180mcu_fd_sc_mcu7t5v0__nor2_1
Xgf180mcu_fd_sc_mcu7t5v0__nor2_1_333 vdd vss gf180mcu_fd_sc_mcu7t5v0__nor2_1_333/ZN
+ gf180mcu_fd_sc_mcu7t5v0__dffq_1_440/Q gf180mcu_fd_sc_mcu7t5v0__nor2_4_27/ZN vdd
+ vss gf180mcu_fd_sc_mcu7t5v0__nor2_1
Xgf180mcu_fd_sc_mcu7t5v0__dffq_1_155 vdd gf180mcu_fd_sc_mcu7t5v0__dffq_1_155/Q gf180mcu_fd_sc_mcu7t5v0__dffq_1_96/CLK
+ vss gf180mcu_fd_sc_mcu7t5v0__dffq_1_155/D vdd vss gf180mcu_fd_sc_mcu7t5v0__dffq_1
Xgf180mcu_fd_sc_mcu7t5v0__nor2_1_344 vdd vss gf180mcu_fd_sc_mcu7t5v0__nor2_1_344/ZN
+ gf180mcu_fd_sc_mcu7t5v0__dffq_1_442/Q gf180mcu_fd_sc_mcu7t5v0__and3_2_2/Z vdd vss
+ gf180mcu_fd_sc_mcu7t5v0__nor2_1
Xgf180mcu_fd_sc_mcu7t5v0__dffq_1_166 vdd gf180mcu_fd_sc_mcu7t5v0__dffq_1_166/Q gf180mcu_fd_sc_mcu7t5v0__dffq_2_26/CLK
+ vss gf180mcu_fd_sc_mcu7t5v0__dffq_1_166/D vdd vss gf180mcu_fd_sc_mcu7t5v0__dffq_1
Xgf180mcu_fd_sc_mcu7t5v0__nor2_1_355 vdd vss gf180mcu_fd_sc_mcu7t5v0__xor3_1_125/A1
+ gf180mcu_fd_sc_mcu7t5v0__xor3_1_141/A1 gf180mcu_fd_sc_mcu7t5v0__nor2_1_355/A2 vdd
+ vss gf180mcu_fd_sc_mcu7t5v0__nor2_1
Xgf180mcu_fd_sc_mcu7t5v0__dffq_1_177 vdd gf180mcu_fd_sc_mcu7t5v0__dffq_1_177/Q gf180mcu_fd_sc_mcu7t5v0__dffq_1_96/CLK
+ vss gf180mcu_fd_sc_mcu7t5v0__dffq_1_177/D vdd vss gf180mcu_fd_sc_mcu7t5v0__dffq_1
Xgf180mcu_fd_sc_mcu7t5v0__nor2_1_366 vdd vss gf180mcu_fd_sc_mcu7t5v0__xnor2_1_62/A1
+ gf180mcu_fd_sc_mcu7t5v0__nor3_1_40/A1 gf180mcu_fd_sc_mcu7t5v0__nor3_1_40/A2 vdd
+ vss gf180mcu_fd_sc_mcu7t5v0__nor2_1
Xgf180mcu_fd_sc_mcu7t5v0__clkinv_3_9 vdd gf180mcu_fd_sc_mcu7t5v0__clkinv_3_9/ZN gf180mcu_fd_sc_mcu7t5v0__nor3_4_12/ZN
+ vss vdd vss gf180mcu_fd_sc_mcu7t5v0__clkinv_3
Xgf180mcu_fd_sc_mcu7t5v0__dffq_1_188 vdd gf180mcu_fd_sc_mcu7t5v0__dffq_1_188/Q gf180mcu_fd_sc_mcu7t5v0__dffq_2_26/CLK
+ vss gf180mcu_fd_sc_mcu7t5v0__dffq_1_188/D vdd vss gf180mcu_fd_sc_mcu7t5v0__dffq_1
Xgf180mcu_fd_sc_mcu7t5v0__dffq_1_199 vdd gf180mcu_fd_sc_mcu7t5v0__dffq_1_199/Q gf180mcu_fd_sc_mcu7t5v0__dffq_4_8/CLK
+ vss gf180mcu_fd_sc_mcu7t5v0__dffq_1_199/D vdd vss gf180mcu_fd_sc_mcu7t5v0__dffq_1
Xgf180mcu_fd_sc_mcu7t5v0__nor2_1_377 vdd vss gf180mcu_fd_sc_mcu7t5v0__oai32_1_9/A3
+ gf180mcu_fd_sc_mcu7t5v0__xor3_1_137/Z gf180mcu_fd_sc_mcu7t5v0__xor3_1_136/A3 vdd
+ vss gf180mcu_fd_sc_mcu7t5v0__nor2_1
Xgf180mcu_fd_sc_mcu7t5v0__nor2_1_388 vdd vss gf180mcu_fd_sc_mcu7t5v0__nor2_2_56/A1
+ gf180mcu_fd_sc_mcu7t5v0__nor2_4_42/A1 gf180mcu_fd_sc_mcu7t5v0__dffq_2_93/Q vdd vss
+ gf180mcu_fd_sc_mcu7t5v0__nor2_1
Xgf180mcu_fd_sc_mcu7t5v0__nor2_1_399 vdd vss gf180mcu_fd_sc_mcu7t5v0__nor2_1_399/ZN
+ gf180mcu_fd_sc_mcu7t5v0__dffq_2_91/Q gf180mcu_fd_sc_mcu7t5v0__xor3_1_148/Z vdd vss
+ gf180mcu_fd_sc_mcu7t5v0__nor2_1
Xgf180mcu_fd_sc_mcu7t5v0__nand2_1_570 vdd vss gf180mcu_fd_sc_mcu7t5v0__nand4_1_19/A2
+ gf180mcu_fd_sc_mcu7t5v0__nor3_4_22/ZN gf180mcu_fd_sc_mcu7t5v0__xor2_1_173/Z vdd
+ vss gf180mcu_fd_sc_mcu7t5v0__nand2_1
Xgf180mcu_fd_sc_mcu7t5v0__nand2_1_581 vdd vss gf180mcu_fd_sc_mcu7t5v0__nor2_2_48/A2
+ gf180mcu_fd_sc_mcu7t5v0__dffq_2_86/Q gf180mcu_fd_sc_mcu7t5v0__nor3_4_22/A3 vdd vss
+ gf180mcu_fd_sc_mcu7t5v0__nand2_1
Xgf180mcu_fd_sc_mcu7t5v0__nand2_1_592 vdd vss gf180mcu_fd_sc_mcu7t5v0__xor3_1_121/A2
+ gf180mcu_fd_sc_mcu7t5v0__dffq_4_37/Q gf180mcu_fd_sc_mcu7t5v0__inv_1_14/I vdd vss
+ gf180mcu_fd_sc_mcu7t5v0__nand2_1
Xgf180mcu_fd_sc_mcu7t5v0__clkbuf_16_12 vdd vss gf180mcu_fd_sc_mcu7t5v0__dffq_4_1/CLK
+ gf180mcu_fd_sc_mcu7t5v0__clkbuf_16_8/I vdd vss gf180mcu_fd_sc_mcu7t5v0__clkbuf_16
Xgf180mcu_fd_sc_mcu7t5v0__clkbuf_16_5 vdd vss gf180mcu_fd_sc_mcu7t5v0__dffq_4_8/CLK
+ gf180mcu_fd_sc_mcu7t5v0__clkbuf_16_9/I vdd vss gf180mcu_fd_sc_mcu7t5v0__clkbuf_16
Xgf180mcu_fd_sc_mcu7t5v0__nand2_1_3 vdd vss gf180mcu_fd_sc_mcu7t5v0__xor2_1_5/A1 gf180mcu_fd_sc_mcu7t5v0__or4_1_0/A1
+ gf180mcu_fd_sc_mcu7t5v0__and2_4_1/Z vdd vss gf180mcu_fd_sc_mcu7t5v0__nand2_1
Xgf180mcu_fd_sc_mcu7t5v0__dffq_1_7 vdd gf180mcu_fd_sc_mcu7t5v0__dffq_1_7/Q gf180mcu_fd_sc_mcu7t5v0__dffq_4_6/CLK
+ vss gf180mcu_fd_sc_mcu7t5v0__dffq_1_7/D vdd vss gf180mcu_fd_sc_mcu7t5v0__dffq_1
Xgf180mcu_fd_sc_mcu7t5v0__nor2_1_130 vdd vss gf180mcu_fd_sc_mcu7t5v0__nor2_1_130/ZN
+ gf180mcu_fd_sc_mcu7t5v0__or4_1_0/A2 gf180mcu_fd_sc_mcu7t5v0__or3_1_9/A2 vdd vss
+ gf180mcu_fd_sc_mcu7t5v0__nor2_1
Xgf180mcu_fd_sc_mcu7t5v0__nor2_1_141 vdd vss gf180mcu_fd_sc_mcu7t5v0__nor2_1_141/ZN
+ gf180mcu_fd_sc_mcu7t5v0__dffq_1_284/Q gf180mcu_fd_sc_mcu7t5v0__nor2_4_22/ZN vdd
+ vss gf180mcu_fd_sc_mcu7t5v0__nor2_1
Xgf180mcu_fd_sc_mcu7t5v0__xor3_1_120 gf180mcu_fd_sc_mcu7t5v0__and2_1_129/Z vdd vss
+ gf180mcu_fd_sc_mcu7t5v0__or2_1_51/A2 gf180mcu_fd_sc_mcu7t5v0__inv_8_1/I gf180mcu_fd_sc_mcu7t5v0__or3_1_24/A2
+ vdd vss gf180mcu_fd_sc_mcu7t5v0__xor3_1
Xgf180mcu_fd_sc_mcu7t5v0__nor2_1_152 vdd vss gf180mcu_fd_sc_mcu7t5v0__nor2_1_152/ZN
+ gf180mcu_fd_sc_mcu7t5v0__dffq_1_295/Q gf180mcu_fd_sc_mcu7t5v0__nor2_1_152/A2 vdd
+ vss gf180mcu_fd_sc_mcu7t5v0__nor2_1
Xgf180mcu_fd_sc_mcu7t5v0__clkinv_1_6 vdd vss gf180mcu_fd_sc_mcu7t5v0__nor3_4_18/ZN
+ gf180mcu_fd_sc_mcu7t5v0__oai21_1_24/A1 vdd vss gf180mcu_fd_sc_mcu7t5v0__clkinv_1
Xgf180mcu_fd_sc_mcu7t5v0__nor2_1_163 vdd vss gf180mcu_fd_sc_mcu7t5v0__nor2_1_163/ZN
+ gf180mcu_fd_sc_mcu7t5v0__dffq_1_308/Q gf180mcu_fd_sc_mcu7t5v0__nor2_4_28/ZN vdd
+ vss gf180mcu_fd_sc_mcu7t5v0__nor2_1
Xgf180mcu_fd_sc_mcu7t5v0__xor3_1_131 gf180mcu_fd_sc_mcu7t5v0__xor3_1_131/A3 vdd vss
+ gf180mcu_fd_sc_mcu7t5v0__xor3_1_131/Z gf180mcu_fd_sc_mcu7t5v0__nor3_1_39/ZN gf180mcu_fd_sc_mcu7t5v0__oai33_2_4/A1
+ vdd vss gf180mcu_fd_sc_mcu7t5v0__xor3_1
Xgf180mcu_fd_sc_mcu7t5v0__nor2_1_174 vdd vss gf180mcu_fd_sc_mcu7t5v0__nor2_1_174/ZN
+ gf180mcu_fd_sc_mcu7t5v0__or2_4_3/Z gf180mcu_fd_sc_mcu7t5v0__nor2_1_174/A2 vdd vss
+ gf180mcu_fd_sc_mcu7t5v0__nor2_1
Xgf180mcu_fd_sc_mcu7t5v0__xor3_1_142 gf180mcu_fd_sc_mcu7t5v0__xor3_1_156/Z vdd vss
+ gf180mcu_fd_sc_mcu7t5v0__xor2_2_4/A2 gf180mcu_fd_sc_mcu7t5v0__xor3_1_142/A1 gf180mcu_fd_sc_mcu7t5v0__xor3_1_142/A2
+ vdd vss gf180mcu_fd_sc_mcu7t5v0__xor3_1
Xgf180mcu_fd_sc_mcu7t5v0__nor2_1_185 vdd vss gf180mcu_fd_sc_mcu7t5v0__dffq_1_342/D
+ gf180mcu_fd_sc_mcu7t5v0__and2_1_55/Z gf180mcu_fd_sc_mcu7t5v0__nor2_1_185/A2 vdd
+ vss gf180mcu_fd_sc_mcu7t5v0__nor2_1
Xgf180mcu_fd_sc_mcu7t5v0__xor3_1_153 gf180mcu_fd_sc_mcu7t5v0__xor3_1_153/A3 vdd vss
+ gf180mcu_fd_sc_mcu7t5v0__xor3_1_153/Z gf180mcu_fd_sc_mcu7t5v0__xor3_1_153/A1 gf180mcu_fd_sc_mcu7t5v0__nor2_2_58/ZN
+ vdd vss gf180mcu_fd_sc_mcu7t5v0__xor3_1
Xgf180mcu_fd_sc_mcu7t5v0__xor3_1_164 gf180mcu_fd_sc_mcu7t5v0__xor3_2_2/Z vdd vss gf180mcu_fd_sc_mcu7t5v0__xor3_1_164/Z
+ gf180mcu_fd_sc_mcu7t5v0__aoi21_4_9/A1 gf180mcu_fd_sc_mcu7t5v0__xor3_1_164/A2 vdd
+ vss gf180mcu_fd_sc_mcu7t5v0__xor3_1
Xgf180mcu_fd_sc_mcu7t5v0__nor2_1_196 vdd vss gf180mcu_fd_sc_mcu7t5v0__dffq_1_356/D
+ gf180mcu_fd_sc_mcu7t5v0__and2_1_67/Z gf180mcu_fd_sc_mcu7t5v0__nor2_1_196/A2 vdd
+ vss gf180mcu_fd_sc_mcu7t5v0__nor2_1
Xgf180mcu_fd_sc_mcu7t5v0__oai211_1_13 gf180mcu_fd_sc_mcu7t5v0__nand4_1_4/ZN gf180mcu_fd_sc_mcu7t5v0__or2_1_34/A2
+ vdd vss gf180mcu_fd_sc_mcu7t5v0__aoi21_1_66/A2 gf180mcu_fd_sc_mcu7t5v0__nand3_4_7/ZN
+ gf180mcu_fd_sc_mcu7t5v0__nor2_1_95/ZN vdd vss gf180mcu_fd_sc_mcu7t5v0__oai211_1
Xgf180mcu_fd_sc_mcu7t5v0__xor3_1_175 gf180mcu_fd_sc_mcu7t5v0__aoi22_2_7/ZN vdd vss
+ gf180mcu_fd_sc_mcu7t5v0__xor3_1_175/Z gf180mcu_fd_sc_mcu7t5v0__inv_8_0/ZN gf180mcu_fd_sc_mcu7t5v0__inv_1_5/ZN
+ vdd vss gf180mcu_fd_sc_mcu7t5v0__xor3_1
Xgf180mcu_fd_sc_mcu7t5v0__oai211_1_24 gf180mcu_fd_sc_mcu7t5v0__oai211_1_24/B gf180mcu_fd_sc_mcu7t5v0__oai221_1_8/A1
+ vdd vss gf180mcu_fd_sc_mcu7t5v0__aoi21_1_182/B gf180mcu_fd_sc_mcu7t5v0__oai32_1_4/B2
+ gf180mcu_fd_sc_mcu7t5v0__xnor3_1_22/A1 vdd vss gf180mcu_fd_sc_mcu7t5v0__oai211_1
Xgf180mcu_fd_sc_mcu7t5v0__oai211_1_35 gf180mcu_fd_sc_mcu7t5v0__oai211_1_35/B gf180mcu_fd_sc_mcu7t5v0__oai211_1_35/C
+ vdd vss gf180mcu_fd_sc_mcu7t5v0__oai211_1_36/B gf180mcu_fd_sc_mcu7t5v0__nor2_4_45/ZN
+ gf180mcu_fd_sc_mcu7t5v0__nor2_1_315/ZN vdd vss gf180mcu_fd_sc_mcu7t5v0__oai211_1
Xgf180mcu_fd_sc_mcu7t5v0__nand3_4_11 gf180mcu_fd_sc_mcu7t5v0__and3_2_1/Z vdd vss gf180mcu_fd_sc_mcu7t5v0__nor2_4_21/A2
+ gf180mcu_fd_sc_mcu7t5v0__nor4_4_0/A1 gf180mcu_fd_sc_mcu7t5v0__inv_2_7/I vdd vss
+ gf180mcu_fd_sc_mcu7t5v0__nand3_4
Xgf180mcu_fd_sc_mcu7t5v0__oai211_1_46 gf180mcu_fd_sc_mcu7t5v0__oai211_1_46/B gf180mcu_fd_sc_mcu7t5v0__or2_1_34/A2
+ vdd vss gf180mcu_fd_sc_mcu7t5v0__oai211_1_46/ZN gf180mcu_fd_sc_mcu7t5v0__oai211_1_53/C
+ gf180mcu_fd_sc_mcu7t5v0__xor2_1_184/Z vdd vss gf180mcu_fd_sc_mcu7t5v0__oai211_1
Xgf180mcu_fd_sc_mcu7t5v0__nand3_4_22 gf180mcu_fd_sc_mcu7t5v0__inv_4_5/ZN vdd vss gf180mcu_fd_sc_mcu7t5v0__oai21_4_13/B
+ gf180mcu_fd_sc_mcu7t5v0__inv_1_17/ZN gf180mcu_fd_sc_mcu7t5v0__nor3_2_11/A2 vdd vss
+ gf180mcu_fd_sc_mcu7t5v0__nand3_4
Xgf180mcu_fd_sc_mcu7t5v0__oai211_1_57 gf180mcu_fd_sc_mcu7t5v0__oai211_1_57/B gf180mcu_fd_sc_mcu7t5v0__or2_1_34/A2
+ vdd vss gf180mcu_fd_sc_mcu7t5v0__oai211_1_57/ZN gf180mcu_fd_sc_mcu7t5v0__nand4_1_1/A1
+ gf180mcu_fd_sc_mcu7t5v0__xor3_1_172/Z vdd vss gf180mcu_fd_sc_mcu7t5v0__oai211_1
Xgf180mcu_fd_sc_mcu7t5v0__oai21_1_201 vdd gf180mcu_fd_sc_mcu7t5v0__oai21_1_201/B gf180mcu_fd_sc_mcu7t5v0__xor2_1_108/A2
+ gf180mcu_fd_sc_mcu7t5v0__xor3_1_82/A1 gf180mcu_fd_sc_mcu7t5v0__xor2_1_108/A1 vss
+ vdd vss gf180mcu_fd_sc_mcu7t5v0__oai21_1
Xgf180mcu_fd_sc_mcu7t5v0__oai21_1_212 vdd gf180mcu_fd_sc_mcu7t5v0__xor2_1_123/A2 gf180mcu_fd_sc_mcu7t5v0__oai32_2_2/ZN
+ gf180mcu_fd_sc_mcu7t5v0__xor3_1_159/A3 gf180mcu_fd_sc_mcu7t5v0__and2_1_94/Z vss
+ vdd vss gf180mcu_fd_sc_mcu7t5v0__oai21_1
Xgf180mcu_fd_sc_mcu7t5v0__oai21_1_223 vdd gf180mcu_fd_sc_mcu7t5v0__xor2_1_129/Z gf180mcu_fd_sc_mcu7t5v0__or3_1_18/A2
+ gf180mcu_fd_sc_mcu7t5v0__nand3_1_70/A2 gf180mcu_fd_sc_mcu7t5v0__nor3_1_42/A1 vss
+ vdd vss gf180mcu_fd_sc_mcu7t5v0__oai21_1
Xgf180mcu_fd_sc_mcu7t5v0__oai21_1_234 vdd gf180mcu_fd_sc_mcu7t5v0__buf_12_0/Z gf180mcu_fd_sc_mcu7t5v0__buf_20_0/Z
+ gf180mcu_fd_sc_mcu7t5v0__aoi21_1_260/B gf180mcu_fd_sc_mcu7t5v0__dffq_1_446/Q vss
+ vdd vss gf180mcu_fd_sc_mcu7t5v0__oai21_1
Xgf180mcu_fd_sc_mcu7t5v0__oai21_1_245 vdd gf180mcu_fd_sc_mcu7t5v0__xor3_1_174/Z gf180mcu_fd_sc_mcu7t5v0__nor3_1_32/A2
+ gf180mcu_fd_sc_mcu7t5v0__and3_1_16/A2 gf180mcu_fd_sc_mcu7t5v0__nor3_1_32/A1 vss
+ vdd vss gf180mcu_fd_sc_mcu7t5v0__oai21_1
Xgf180mcu_fd_sc_mcu7t5v0__oai21_1_256 vdd gf180mcu_fd_sc_mcu7t5v0__buf_8_4/Z gf180mcu_fd_sc_mcu7t5v0__buf_20_0/I
+ gf180mcu_fd_sc_mcu7t5v0__aoi21_1_290/B gf180mcu_fd_sc_mcu7t5v0__dffq_2_111/Q vss
+ vdd vss gf180mcu_fd_sc_mcu7t5v0__oai21_1
Xgf180mcu_fd_sc_mcu7t5v0__oai21_1_267 vdd gf180mcu_fd_sc_mcu7t5v0__buf_12_0/Z gf180mcu_fd_sc_mcu7t5v0__buf_20_0/I
+ gf180mcu_fd_sc_mcu7t5v0__aoi21_1_308/B gf180mcu_fd_sc_mcu7t5v0__dffq_1_430/Q vss
+ vdd vss gf180mcu_fd_sc_mcu7t5v0__oai21_1
Xgf180mcu_fd_sc_mcu7t5v0__oai21_1_278 vdd gf180mcu_fd_sc_mcu7t5v0__and2_4_3/Z gf180mcu_fd_sc_mcu7t5v0__or2_1_34/A2
+ gf180mcu_fd_sc_mcu7t5v0__nor2_1_336/A2 gf180mcu_fd_sc_mcu7t5v0__mux4_2_1/I2 vss
+ vdd vss gf180mcu_fd_sc_mcu7t5v0__oai21_1
Xgf180mcu_fd_sc_mcu7t5v0__oai21_1_289 vdd gf180mcu_fd_sc_mcu7t5v0__xnor3_1_49/A2 gf180mcu_fd_sc_mcu7t5v0__or3_1_24/A2
+ gf180mcu_fd_sc_mcu7t5v0__nand3_1_90/A3 gf180mcu_fd_sc_mcu7t5v0__nor3_2_5/A1 vss
+ vdd vss gf180mcu_fd_sc_mcu7t5v0__oai21_1
Xgf180mcu_fd_sc_mcu7t5v0__nand3_4_1 gf180mcu_fd_sc_mcu7t5v0__nor2_2_6/A1 vdd vss gf180mcu_fd_sc_mcu7t5v0__oai31_1_0/B
+ gf180mcu_fd_sc_mcu7t5v0__dffq_4_3/Q gf180mcu_fd_sc_mcu7t5v0__inv_2_1/I vdd vss gf180mcu_fd_sc_mcu7t5v0__nand3_4
Xgf180mcu_fd_sc_mcu7t5v0__aoi221_1_2 gf180mcu_fd_sc_mcu7t5v0__and3_2_0/Z gf180mcu_fd_sc_mcu7t5v0__aoi221_1_2/C
+ vdd vss gf180mcu_fd_sc_mcu7t5v0__aoi221_1_2/ZN gf180mcu_fd_sc_mcu7t5v0__nor2_2_6/ZN
+ gf180mcu_fd_sc_mcu7t5v0__xor2_1_11/Z gf180mcu_fd_sc_mcu7t5v0__xor2_1_17/Z vdd vss
+ gf180mcu_fd_sc_mcu7t5v0__aoi221_1
Xgf180mcu_fd_sc_mcu7t5v0__nor2_1_4 vdd vss gf180mcu_fd_sc_mcu7t5v0__nor2_1_4/ZN gf180mcu_fd_sc_mcu7t5v0__xor3_1_2/A1
+ gf180mcu_fd_sc_mcu7t5v0__xor3_1_5/Z vdd vss gf180mcu_fd_sc_mcu7t5v0__nor2_1
Xgf180mcu_fd_sc_mcu7t5v0__xor2_1_12 vdd vss gf180mcu_fd_sc_mcu7t5v0__or3_1_1/A3 gf180mcu_fd_sc_mcu7t5v0__or3_2_1/A1
+ gf180mcu_fd_sc_mcu7t5v0__xor2_1_11/Z vdd vss gf180mcu_fd_sc_mcu7t5v0__xor2_1
Xgf180mcu_fd_sc_mcu7t5v0__xor2_1_23 vdd vss gf180mcu_fd_sc_mcu7t5v0__xor2_1_23/Z gf180mcu_fd_sc_mcu7t5v0__xor2_1_23/A1
+ gf180mcu_fd_sc_mcu7t5v0__xor2_1_23/A2 vdd vss gf180mcu_fd_sc_mcu7t5v0__xor2_1
Xgf180mcu_fd_sc_mcu7t5v0__xor2_1_34 vdd vss gf180mcu_fd_sc_mcu7t5v0__xor2_1_34/Z gf180mcu_fd_sc_mcu7t5v0__xor2_1_34/A1
+ gf180mcu_fd_sc_mcu7t5v0__xor3_1_35/Z vdd vss gf180mcu_fd_sc_mcu7t5v0__xor2_1
Xgf180mcu_fd_sc_mcu7t5v0__xor2_1_45 vdd vss gf180mcu_fd_sc_mcu7t5v0__xor2_1_45/Z gf180mcu_fd_sc_mcu7t5v0__inv_2_5/I
+ gf180mcu_fd_sc_mcu7t5v0__and2_1_23/Z vdd vss gf180mcu_fd_sc_mcu7t5v0__xor2_1
Xgf180mcu_fd_sc_mcu7t5v0__xor2_1_56 vdd vss gf180mcu_fd_sc_mcu7t5v0__xor2_1_56/Z gf180mcu_fd_sc_mcu7t5v0__inv_8_2/ZN
+ gf180mcu_fd_sc_mcu7t5v0__xor2_1_54/Z vdd vss gf180mcu_fd_sc_mcu7t5v0__xor2_1
Xgf180mcu_fd_sc_mcu7t5v0__xor2_1_67 vdd vss gf180mcu_fd_sc_mcu7t5v0__xor2_1_67/Z gf180mcu_fd_sc_mcu7t5v0__and2_2_4/Z
+ gf180mcu_fd_sc_mcu7t5v0__xor2_1_67/A2 vdd vss gf180mcu_fd_sc_mcu7t5v0__xor2_1
Xgf180mcu_fd_sc_mcu7t5v0__xor2_1_130 vdd vss gf180mcu_fd_sc_mcu7t5v0__xor2_1_130/Z
+ gf180mcu_fd_sc_mcu7t5v0__oai32_1_7/B1 gf180mcu_fd_sc_mcu7t5v0__xor2_1_130/A2 vdd
+ vss gf180mcu_fd_sc_mcu7t5v0__xor2_1
Xgf180mcu_fd_sc_mcu7t5v0__xor2_1_78 vdd vss gf180mcu_fd_sc_mcu7t5v0__xor2_1_78/Z gf180mcu_fd_sc_mcu7t5v0__xor2_1_76/Z
+ gf180mcu_fd_sc_mcu7t5v0__xor2_1_78/A2 vdd vss gf180mcu_fd_sc_mcu7t5v0__xor2_1
Xgf180mcu_fd_sc_mcu7t5v0__xor2_1_89 vdd vss gf180mcu_fd_sc_mcu7t5v0__xor2_1_89/Z gf180mcu_fd_sc_mcu7t5v0__mux4_4_2/I0
+ gf180mcu_fd_sc_mcu7t5v0__xor2_1_89/A2 vdd vss gf180mcu_fd_sc_mcu7t5v0__xor2_1
Xgf180mcu_fd_sc_mcu7t5v0__xor2_1_141 vdd vss gf180mcu_fd_sc_mcu7t5v0__xor3_1_84/A3
+ gf180mcu_fd_sc_mcu7t5v0__nor3_1_26/ZN gf180mcu_fd_sc_mcu7t5v0__xor3_1_85/Z vdd vss
+ gf180mcu_fd_sc_mcu7t5v0__xor2_1
Xgf180mcu_fd_sc_mcu7t5v0__xor2_1_152 vdd vss gf180mcu_fd_sc_mcu7t5v0__xor2_1_152/Z
+ gf180mcu_fd_sc_mcu7t5v0__mux4_4_6/I3 gf180mcu_fd_sc_mcu7t5v0__nor2_4_45/ZN vdd vss
+ gf180mcu_fd_sc_mcu7t5v0__xor2_1
Xgf180mcu_fd_sc_mcu7t5v0__xor2_1_163 vdd vss gf180mcu_fd_sc_mcu7t5v0__or4_1_3/A4 gf180mcu_fd_sc_mcu7t5v0__xor2_1_163/A1
+ gf180mcu_fd_sc_mcu7t5v0__xor2_1_180/Z vdd vss gf180mcu_fd_sc_mcu7t5v0__xor2_1
Xgf180mcu_fd_sc_mcu7t5v0__xor2_1_174 vdd vss gf180mcu_fd_sc_mcu7t5v0__xor2_1_174/Z
+ gf180mcu_fd_sc_mcu7t5v0__xor2_1_174/A1 gf180mcu_fd_sc_mcu7t5v0__xor2_1_174/A2 vdd
+ vss gf180mcu_fd_sc_mcu7t5v0__xor2_1
Xgf180mcu_fd_sc_mcu7t5v0__xor2_1_185 vdd vss gf180mcu_fd_sc_mcu7t5v0__or2_1_53/A2
+ gf180mcu_fd_sc_mcu7t5v0__nor3_2_13/ZN gf180mcu_fd_sc_mcu7t5v0__xor3_1_153/Z vdd
+ vss gf180mcu_fd_sc_mcu7t5v0__xor2_1
Xgf180mcu_fd_sc_mcu7t5v0__xor2_1_196 vdd vss gf180mcu_fd_sc_mcu7t5v0__xor2_1_196/Z
+ gf180mcu_fd_sc_mcu7t5v0__xor2_1_196/A1 gf180mcu_fd_sc_mcu7t5v0__xor3_1_162/Z vdd
+ vss gf180mcu_fd_sc_mcu7t5v0__xor2_1
Xgf180mcu_fd_sc_mcu7t5v0__nand3_1_12 gf180mcu_fd_sc_mcu7t5v0__oai31_1_5/B vdd vss
+ gf180mcu_fd_sc_mcu7t5v0__xor2_1_74/A2 gf180mcu_fd_sc_mcu7t5v0__or3_2_2/Z gf180mcu_fd_sc_mcu7t5v0__and2_4_2/A2
+ vdd vss gf180mcu_fd_sc_mcu7t5v0__nand3_1
Xgf180mcu_fd_sc_mcu7t5v0__nand3_1_23 gf180mcu_fd_sc_mcu7t5v0__and2_2_4/A2 vdd vss
+ gf180mcu_fd_sc_mcu7t5v0__oai22_1_6/B2 gf180mcu_fd_sc_mcu7t5v0__or4_1_0/A1 gf180mcu_fd_sc_mcu7t5v0__and2_2_4/A1
+ vdd vss gf180mcu_fd_sc_mcu7t5v0__nand3_1
Xgf180mcu_fd_sc_mcu7t5v0__nand3_1_34 gf180mcu_fd_sc_mcu7t5v0__or3_1_7/Z vdd vss gf180mcu_fd_sc_mcu7t5v0__nand4_1_4/A2
+ gf180mcu_fd_sc_mcu7t5v0__and2_2_8/Z gf180mcu_fd_sc_mcu7t5v0__oai21_1_69/ZN vdd vss
+ gf180mcu_fd_sc_mcu7t5v0__nand3_1
Xgf180mcu_fd_sc_mcu7t5v0__nand3_1_45 gf180mcu_fd_sc_mcu7t5v0__nand3_1_45/A3 vdd vss
+ gf180mcu_fd_sc_mcu7t5v0__and2_1_40/A2 gf180mcu_fd_sc_mcu7t5v0__nand3_1_45/A1 gf180mcu_fd_sc_mcu7t5v0__nand3_1_45/A2
+ vdd vss gf180mcu_fd_sc_mcu7t5v0__nand3_1
Xgf180mcu_fd_sc_mcu7t5v0__nand3_1_56 gf180mcu_fd_sc_mcu7t5v0__dffq_1_352/Q vdd vss
+ gf180mcu_fd_sc_mcu7t5v0__nor3_1_13/A3 gf180mcu_fd_sc_mcu7t5v0__xor2_1_94/A1 gf180mcu_fd_sc_mcu7t5v0__dffq_1_354/Q
+ vdd vss gf180mcu_fd_sc_mcu7t5v0__nand3_1
Xgf180mcu_fd_sc_mcu7t5v0__nand3_1_67 gf180mcu_fd_sc_mcu7t5v0__or2_1_15/Z vdd vss gf180mcu_fd_sc_mcu7t5v0__oai211_1_56/C
+ gf180mcu_fd_sc_mcu7t5v0__and3_2_3/Z gf180mcu_fd_sc_mcu7t5v0__nand3_1_67/A2 vdd vss
+ gf180mcu_fd_sc_mcu7t5v0__nand3_1
Xgf180mcu_fd_sc_mcu7t5v0__nand3_1_78 gf180mcu_fd_sc_mcu7t5v0__xor3_1_99/A2 vdd vss
+ gf180mcu_fd_sc_mcu7t5v0__nand3_1_78/ZN gf180mcu_fd_sc_mcu7t5v0__or2_1_38/Z gf180mcu_fd_sc_mcu7t5v0__or3_1_19/Z
+ vdd vss gf180mcu_fd_sc_mcu7t5v0__nand3_1
Xgf180mcu_fd_sc_mcu7t5v0__nand3_1_89 gf180mcu_fd_sc_mcu7t5v0__nand3_1_89/A3 vdd vss
+ gf180mcu_fd_sc_mcu7t5v0__nand3_1_89/ZN gf180mcu_fd_sc_mcu7t5v0__xor3_1_159/A1 gf180mcu_fd_sc_mcu7t5v0__nand3_2_28/ZN
+ vdd vss gf180mcu_fd_sc_mcu7t5v0__nand3_1
Xgf180mcu_fd_sc_mcu7t5v0__oai32_1_2 gf180mcu_fd_sc_mcu7t5v0__oai32_1_2/A3 gf180mcu_fd_sc_mcu7t5v0__and4_1_0/A4
+ gf180mcu_fd_sc_mcu7t5v0__inv_8_2/I vdd vss gf180mcu_fd_sc_mcu7t5v0__oai32_1_2/ZN
+ gf180mcu_fd_sc_mcu7t5v0__nor3_4_3/ZN gf180mcu_fd_sc_mcu7t5v0__oai32_1_2/A2 vdd vss
+ gf180mcu_fd_sc_mcu7t5v0__oai32_1
Xgf180mcu_fd_sc_mcu7t5v0__aoi222_4_0 gf180mcu_fd_sc_mcu7t5v0__dffq_1_287/Q gf180mcu_fd_sc_mcu7t5v0__nor2_1_203/A1
+ vss vdd gf180mcu_fd_sc_mcu7t5v0__nor4_4_1/ZN gf180mcu_fd_sc_mcu7t5v0__aoi222_4_0/C1
+ gf180mcu_fd_sc_mcu7t5v0__dffq_2_27/Q gf180mcu_fd_sc_mcu7t5v0__nor3_4_13/ZN gf180mcu_fd_sc_mcu7t5v0__nor4_4_0/ZN
+ vdd vss gf180mcu_fd_sc_mcu7t5v0__aoi222_4
Xgf180mcu_fd_sc_mcu7t5v0__aoi221_1_40 gf180mcu_fd_sc_mcu7t5v0__aoi221_1_40/B2 gf180mcu_fd_sc_mcu7t5v0__aoi21_1_7/B
+ vdd vss gf180mcu_fd_sc_mcu7t5v0__dffq_2_62/D gf180mcu_fd_sc_mcu7t5v0__inv_1_15/ZN
+ gf180mcu_fd_sc_mcu7t5v0__or2_4_4/Z gf180mcu_fd_sc_mcu7t5v0__oai211_1_29/ZN vdd vss
+ gf180mcu_fd_sc_mcu7t5v0__aoi221_1
Xgf180mcu_fd_sc_mcu7t5v0__aoi221_1_51 gf180mcu_fd_sc_mcu7t5v0__aoi221_1_54/ZN gf180mcu_fd_sc_mcu7t5v0__or2_4_4/Z
+ vdd vss gf180mcu_fd_sc_mcu7t5v0__aoi21_1_314/B gf180mcu_fd_sc_mcu7t5v0__nor2_1_345/ZN
+ gf180mcu_fd_sc_mcu7t5v0__xnor3_1_35/ZN gf180mcu_fd_sc_mcu7t5v0__oai22_1_274/ZN vdd
+ vss gf180mcu_fd_sc_mcu7t5v0__aoi221_1
Xgf180mcu_fd_sc_mcu7t5v0__aoi221_1_62 gf180mcu_fd_sc_mcu7t5v0__nor2_2_53/ZN gf180mcu_fd_sc_mcu7t5v0__aoi221_1_62/C
+ vdd vss gf180mcu_fd_sc_mcu7t5v0__oai31_1_18/B gf180mcu_fd_sc_mcu7t5v0__inv_8_0/I
+ gf180mcu_fd_sc_mcu7t5v0__nor2_2_55/ZN gf180mcu_fd_sc_mcu7t5v0__xor3_1_143/A3 vdd
+ vss gf180mcu_fd_sc_mcu7t5v0__aoi221_1
Xgf180mcu_fd_sc_mcu7t5v0__nor3_4_2 gf180mcu_fd_sc_mcu7t5v0__dffq_4_0/Q vdd vss gf180mcu_fd_sc_mcu7t5v0__nor3_4_2/ZN
+ gf180mcu_fd_sc_mcu7t5v0__nor3_4_2/A1 gf180mcu_fd_sc_mcu7t5v0__inv_2_1/ZN vdd vss
+ gf180mcu_fd_sc_mcu7t5v0__nor3_4
Xgf180mcu_fd_sc_mcu7t5v0__xnor3_1_0 gf180mcu_fd_sc_mcu7t5v0__nor3_1_0/A3 vdd vss gf180mcu_fd_sc_mcu7t5v0__oai21_2_1/B
+ gf180mcu_fd_sc_mcu7t5v0__xnor3_1_0/A1 gf180mcu_fd_sc_mcu7t5v0__xnor3_1_0/A2 vdd
+ vss gf180mcu_fd_sc_mcu7t5v0__xnor3_1
Xgf180mcu_fd_sc_mcu7t5v0__dffq_2_18 gf180mcu_fd_sc_mcu7t5v0__dffq_2_18/D vdd vss gf180mcu_fd_sc_mcu7t5v0__dffq_4_6/CLK
+ gf180mcu_fd_sc_mcu7t5v0__inv_2_4/I vdd vss gf180mcu_fd_sc_mcu7t5v0__dffq_2
Xgf180mcu_fd_sc_mcu7t5v0__dffq_2_29 gf180mcu_fd_sc_mcu7t5v0__dffq_2_29/D vdd vss gf180mcu_fd_sc_mcu7t5v0__dffq_2_58/CLK
+ gf180mcu_fd_sc_mcu7t5v0__dffq_2_29/Q vdd vss gf180mcu_fd_sc_mcu7t5v0__dffq_2
Xgf180mcu_fd_sc_mcu7t5v0__inv_2_12 vss gf180mcu_fd_sc_mcu7t5v0__inv_2_12/ZN gf180mcu_fd_sc_mcu7t5v0__inv_2_12/I
+ vdd vdd vss gf180mcu_fd_sc_mcu7t5v0__inv_2
Xgf180mcu_fd_sc_mcu7t5v0__and3_1_16 gf180mcu_fd_sc_mcu7t5v0__xor2_1_151/Z vdd vss
+ gf180mcu_fd_sc_mcu7t5v0__and3_1_16/Z gf180mcu_fd_sc_mcu7t5v0__and3_1_16/A1 gf180mcu_fd_sc_mcu7t5v0__and3_1_16/A2
+ vdd vss gf180mcu_fd_sc_mcu7t5v0__and3_1
Xgf180mcu_fd_sc_mcu7t5v0__and2_1_3 vdd vss gf180mcu_fd_sc_mcu7t5v0__and2_1_3/Z gf180mcu_fd_sc_mcu7t5v0__and2_1_3/A1
+ gf180mcu_fd_sc_mcu7t5v0__nor3_4_0/A3 vdd vss gf180mcu_fd_sc_mcu7t5v0__and2_1
Xgf180mcu_fd_sc_mcu7t5v0__nand2_1_207 vdd vss gf180mcu_fd_sc_mcu7t5v0__nand3_1_4/A1
+ gf180mcu_fd_sc_mcu7t5v0__inv_8_0/I gf180mcu_fd_sc_mcu7t5v0__xor2_1_67/Z vdd vss
+ gf180mcu_fd_sc_mcu7t5v0__nand2_1
Xgf180mcu_fd_sc_mcu7t5v0__nand2_1_218 vdd vss gf180mcu_fd_sc_mcu7t5v0__aoi222_1_1/C1
+ gf180mcu_fd_sc_mcu7t5v0__aoi22_1_33/ZN gf180mcu_fd_sc_mcu7t5v0__aoi22_1_21/ZN vdd
+ vss gf180mcu_fd_sc_mcu7t5v0__nand2_1
Xgf180mcu_fd_sc_mcu7t5v0__nand2_1_229 vdd vss gf180mcu_fd_sc_mcu7t5v0__aoi22_1_59/A2
+ gf180mcu_fd_sc_mcu7t5v0__aoi22_1_50/ZN gf180mcu_fd_sc_mcu7t5v0__aoi22_1_48/ZN vdd
+ vss gf180mcu_fd_sc_mcu7t5v0__nand2_1
Xgf180mcu_fd_sc_mcu7t5v0__aoi21_1_19 gf180mcu_fd_sc_mcu7t5v0__aoi21_1_7/B vdd vss
+ gf180mcu_fd_sc_mcu7t5v0__dffq_2_6/D gf180mcu_fd_sc_mcu7t5v0__nand2_1_31/ZN gf180mcu_fd_sc_mcu7t5v0__oai211_1_0/ZN
+ vdd vss gf180mcu_fd_sc_mcu7t5v0__aoi21_1
Xgf180mcu_fd_sc_mcu7t5v0__nor2_2_16 vdd vss gf180mcu_fd_sc_mcu7t5v0__nor2_4_14/A2
+ gf180mcu_fd_sc_mcu7t5v0__or3_4_0/A1 gf180mcu_fd_sc_mcu7t5v0__nor3_1_10/A3 vdd vss
+ gf180mcu_fd_sc_mcu7t5v0__nor2_2
Xgf180mcu_fd_sc_mcu7t5v0__nor2_2_27 vdd vss gf180mcu_fd_sc_mcu7t5v0__nor2_2_27/ZN
+ gf180mcu_fd_sc_mcu7t5v0__nor2_2_29/A1 gf180mcu_fd_sc_mcu7t5v0__inv_2_9/ZN vdd vss
+ gf180mcu_fd_sc_mcu7t5v0__nor2_2
Xgf180mcu_fd_sc_mcu7t5v0__nor2_2_38 vdd vss gf180mcu_fd_sc_mcu7t5v0__nor2_2_38/ZN
+ gf180mcu_fd_sc_mcu7t5v0__inv_4_4/I gf180mcu_fd_sc_mcu7t5v0__oai22_4_3/A1 vdd vss
+ gf180mcu_fd_sc_mcu7t5v0__nor2_2
Xgf180mcu_fd_sc_mcu7t5v0__nor2_2_49 vdd vss gf180mcu_fd_sc_mcu7t5v0__or2_1_45/A1 gf180mcu_fd_sc_mcu7t5v0__or3_1_24/A1
+ gf180mcu_fd_sc_mcu7t5v0__nor2_2_49/A2 vdd vss gf180mcu_fd_sc_mcu7t5v0__nor2_2
Xgf180mcu_fd_sc_mcu7t5v0__dffq_1_304 vdd gf180mcu_fd_sc_mcu7t5v0__dffq_1_304/Q gf180mcu_fd_sc_mcu7t5v0__dffq_4_21/CLK
+ vss gf180mcu_fd_sc_mcu7t5v0__dffq_1_304/D vdd vss gf180mcu_fd_sc_mcu7t5v0__dffq_1
Xgf180mcu_fd_sc_mcu7t5v0__dffq_1_315 vdd gf180mcu_fd_sc_mcu7t5v0__dffq_1_315/Q gf180mcu_fd_sc_mcu7t5v0__dffq_4_9/CLK
+ vss gf180mcu_fd_sc_mcu7t5v0__dffq_1_315/D vdd vss gf180mcu_fd_sc_mcu7t5v0__dffq_1
Xgf180mcu_fd_sc_mcu7t5v0__dffq_1_326 vdd gf180mcu_fd_sc_mcu7t5v0__dffq_1_326/Q gf180mcu_fd_sc_mcu7t5v0__dffq_2_58/CLK
+ vss gf180mcu_fd_sc_mcu7t5v0__dffq_1_326/D vdd vss gf180mcu_fd_sc_mcu7t5v0__dffq_1
Xgf180mcu_fd_sc_mcu7t5v0__dffq_1_337 vdd gf180mcu_fd_sc_mcu7t5v0__dffq_1_337/Q gf180mcu_fd_sc_mcu7t5v0__dffq_2_58/CLK
+ vss gf180mcu_fd_sc_mcu7t5v0__dffq_1_337/D vdd vss gf180mcu_fd_sc_mcu7t5v0__dffq_1
Xgf180mcu_fd_sc_mcu7t5v0__dffq_1_348 vdd gf180mcu_fd_sc_mcu7t5v0__nor4_1_1/A3 gf180mcu_fd_sc_mcu7t5v0__dffq_4_15/CLK
+ vss gf180mcu_fd_sc_mcu7t5v0__dffq_1_348/D vdd vss gf180mcu_fd_sc_mcu7t5v0__dffq_1
Xgf180mcu_fd_sc_mcu7t5v0__aoi21_4_0 gf180mcu_fd_sc_mcu7t5v0__inv_3_0/I gf180mcu_fd_sc_mcu7t5v0__inv_4_1/I
+ vdd vss gf180mcu_fd_sc_mcu7t5v0__aoi21_4_0/ZN gf180mcu_fd_sc_mcu7t5v0__inv_3_3/ZN
+ vdd vss gf180mcu_fd_sc_mcu7t5v0__aoi21_4
Xgf180mcu_fd_sc_mcu7t5v0__dffq_1_359 vdd gf180mcu_fd_sc_mcu7t5v0__or4_1_2/A3 gf180mcu_fd_sc_mcu7t5v0__dffq_4_15/CLK
+ vss gf180mcu_fd_sc_mcu7t5v0__dffq_1_359/D vdd vss gf180mcu_fd_sc_mcu7t5v0__dffq_1
Xgf180mcu_fd_sc_mcu7t5v0__oai22_1_16 gf180mcu_fd_sc_mcu7t5v0__nand2_4_2/ZN gf180mcu_fd_sc_mcu7t5v0__oai22_1_29/B1
+ gf180mcu_fd_sc_mcu7t5v0__oai22_1_16/B2 vdd vss gf180mcu_fd_sc_mcu7t5v0__dffq_1_23/D
+ gf180mcu_fd_sc_mcu7t5v0__aoi21_4_5/ZN vdd vss gf180mcu_fd_sc_mcu7t5v0__oai22_1
Xgf180mcu_fd_sc_mcu7t5v0__oai22_1_27 gf180mcu_fd_sc_mcu7t5v0__nand2_4_2/ZN gf180mcu_fd_sc_mcu7t5v0__oai22_1_29/B1
+ gf180mcu_fd_sc_mcu7t5v0__oai22_1_27/B2 vdd vss gf180mcu_fd_sc_mcu7t5v0__dffq_1_19/D
+ gf180mcu_fd_sc_mcu7t5v0__oai22_1_88/A1 vdd vss gf180mcu_fd_sc_mcu7t5v0__oai22_1
Xgf180mcu_fd_sc_mcu7t5v0__oai22_1_38 gf180mcu_fd_sc_mcu7t5v0__oai22_1_48/A2 gf180mcu_fd_sc_mcu7t5v0__aoi21_4_1/ZN
+ gf180mcu_fd_sc_mcu7t5v0__nand2_4_5/ZN vdd vss gf180mcu_fd_sc_mcu7t5v0__dffq_1_36/D
+ gf180mcu_fd_sc_mcu7t5v0__oai22_1_38/A1 vdd vss gf180mcu_fd_sc_mcu7t5v0__oai22_1
Xgf180mcu_fd_sc_mcu7t5v0__oai22_1_49 gf180mcu_fd_sc_mcu7t5v0__oai22_1_62/A2 gf180mcu_fd_sc_mcu7t5v0__oai22_1_62/B1
+ gf180mcu_fd_sc_mcu7t5v0__oai22_1_49/B2 vdd vss gf180mcu_fd_sc_mcu7t5v0__dffq_1_57/D
+ gf180mcu_fd_sc_mcu7t5v0__aoi21_4_5/ZN vdd vss gf180mcu_fd_sc_mcu7t5v0__oai22_1
Xgf180mcu_fd_sc_mcu7t5v0__and2_1_60 vdd vss gf180mcu_fd_sc_mcu7t5v0__and2_1_60/Z gf180mcu_fd_sc_mcu7t5v0__nor4_1_2/A1
+ gf180mcu_fd_sc_mcu7t5v0__and2_1_61/Z vdd vss gf180mcu_fd_sc_mcu7t5v0__and2_1
Xgf180mcu_fd_sc_mcu7t5v0__and2_1_71 vdd vss gf180mcu_fd_sc_mcu7t5v0__and2_1_71/Z gf180mcu_fd_sc_mcu7t5v0__buf_8_7/Z
+ gf180mcu_fd_sc_mcu7t5v0__or3_2_4/A2 vdd vss gf180mcu_fd_sc_mcu7t5v0__and2_1
Xgf180mcu_fd_sc_mcu7t5v0__and2_1_82 vdd vss gf180mcu_fd_sc_mcu7t5v0__and2_1_82/Z gf180mcu_fd_sc_mcu7t5v0__and2_1_82/A1
+ gf180mcu_fd_sc_mcu7t5v0__and2_1_82/A2 vdd vss gf180mcu_fd_sc_mcu7t5v0__and2_1
Xgf180mcu_fd_sc_mcu7t5v0__and2_1_93 vdd vss gf180mcu_fd_sc_mcu7t5v0__or3_1_16/A1 gf180mcu_fd_sc_mcu7t5v0__inv_8_2/I
+ gf180mcu_fd_sc_mcu7t5v0__xor2_1_118/Z vdd vss gf180mcu_fd_sc_mcu7t5v0__and2_1
Xgf180mcu_fd_sc_mcu7t5v0__clkinv_1_209 vdd vss gf180mcu_fd_sc_mcu7t5v0__dffq_1_256/Q
+ gf180mcu_fd_sc_mcu7t5v0__oai22_1_256/B2 vdd vss gf180mcu_fd_sc_mcu7t5v0__clkinv_1
Xgf180mcu_fd_sc_mcu7t5v0__aoi211_1_50 gf180mcu_fd_sc_mcu7t5v0__aoi211_1_50/B gf180mcu_fd_sc_mcu7t5v0__or2_1_23/A1
+ vdd vss gf180mcu_fd_sc_mcu7t5v0__dffq_1_386/D gf180mcu_fd_sc_mcu7t5v0__aoi211_1_50/A1
+ gf180mcu_fd_sc_mcu7t5v0__nand2_4_40/ZN vdd vss gf180mcu_fd_sc_mcu7t5v0__aoi211_1
Xgf180mcu_fd_sc_mcu7t5v0__aoi211_1_61 gf180mcu_fd_sc_mcu7t5v0__nor2_1_302/ZN gf180mcu_fd_sc_mcu7t5v0__or2_1_23/A1
+ vdd vss gf180mcu_fd_sc_mcu7t5v0__dffq_1_418/D gf180mcu_fd_sc_mcu7t5v0__inv_4_3/ZN
+ gf180mcu_fd_sc_mcu7t5v0__nor2_4_18/ZN vdd vss gf180mcu_fd_sc_mcu7t5v0__aoi211_1
Xgf180mcu_fd_sc_mcu7t5v0__aoi211_1_72 gf180mcu_fd_sc_mcu7t5v0__nor2_1_320/ZN gf180mcu_fd_sc_mcu7t5v0__or2_1_23/A1
+ vdd vss gf180mcu_fd_sc_mcu7t5v0__dffq_1_427/D gf180mcu_fd_sc_mcu7t5v0__inv_4_3/ZN
+ gf180mcu_fd_sc_mcu7t5v0__and3_2_2/Z vdd vss gf180mcu_fd_sc_mcu7t5v0__aoi211_1
Xgf180mcu_fd_sc_mcu7t5v0__aoi211_1_83 gf180mcu_fd_sc_mcu7t5v0__nor2_1_344/ZN gf180mcu_fd_sc_mcu7t5v0__or2_1_23/A1
+ vdd vss gf180mcu_fd_sc_mcu7t5v0__dffq_1_442/D gf180mcu_fd_sc_mcu7t5v0__nor2_1_236/A1
+ gf180mcu_fd_sc_mcu7t5v0__and3_2_2/Z vdd vss gf180mcu_fd_sc_mcu7t5v0__aoi211_1
Xgf180mcu_fd_sc_mcu7t5v0__oai211_4_0 gf180mcu_fd_sc_mcu7t5v0__oai211_4_1/B gf180mcu_fd_sc_mcu7t5v0__inv_12_1/I
+ vdd vss gf180mcu_fd_sc_mcu7t5v0__or2_1_14/A1 gf180mcu_fd_sc_mcu7t5v0__and2_2_5/Z
+ gf180mcu_fd_sc_mcu7t5v0__aoi21_4_0/ZN vdd vss gf180mcu_fd_sc_mcu7t5v0__oai211_4
Xgf180mcu_fd_sc_mcu7t5v0__mux2_4_0 gf180mcu_fd_sc_mcu7t5v0__or3_4_0/Z vdd vss gf180mcu_fd_sc_mcu7t5v0__or2_2_0/A2
+ gf180mcu_fd_sc_mcu7t5v0__or2_4_2/A1 gf180mcu_fd_sc_mcu7t5v0__mux2_4_0/I1 vdd vss
+ gf180mcu_fd_sc_mcu7t5v0__mux2_4
Xgf180mcu_fd_sc_mcu7t5v0__oai221_1_15 gf180mcu_fd_sc_mcu7t5v0__nor3_1_7/ZN gf180mcu_fd_sc_mcu7t5v0__oai221_1_15/C
+ vdd vss gf180mcu_fd_sc_mcu7t5v0__or2_1_4/A2 gf180mcu_fd_sc_mcu7t5v0__oai221_1_5/B2
+ gf180mcu_fd_sc_mcu7t5v0__or2_1_3/Z gf180mcu_fd_sc_mcu7t5v0__oai221_1_15/B2 vdd vss
+ gf180mcu_fd_sc_mcu7t5v0__oai221_1
Xgf180mcu_fd_sc_mcu7t5v0__aoi21_1_260 gf180mcu_fd_sc_mcu7t5v0__aoi21_1_260/B vdd vss
+ gf180mcu_fd_sc_mcu7t5v0__dffq_1_444/D gf180mcu_fd_sc_mcu7t5v0__nor2_2_29/A1 gf180mcu_fd_sc_mcu7t5v0__buf_20_0/Z
+ vdd vss gf180mcu_fd_sc_mcu7t5v0__aoi21_1
Xgf180mcu_fd_sc_mcu7t5v0__aoi21_1_271 gf180mcu_fd_sc_mcu7t5v0__aoi21_1_271/B vdd vss
+ gf180mcu_fd_sc_mcu7t5v0__nor2_1_307/A2 gf180mcu_fd_sc_mcu7t5v0__mux4_4_9/I3 gf180mcu_fd_sc_mcu7t5v0__or2_4_4/Z
+ vdd vss gf180mcu_fd_sc_mcu7t5v0__aoi21_1
Xgf180mcu_fd_sc_mcu7t5v0__aoi21_1_282 gf180mcu_fd_sc_mcu7t5v0__or2_1_23/A1 vdd vss
+ gf180mcu_fd_sc_mcu7t5v0__dffq_2_69/D gf180mcu_fd_sc_mcu7t5v0__nand2_1_542/ZN gf180mcu_fd_sc_mcu7t5v0__nand2_1_541/ZN
+ vdd vss gf180mcu_fd_sc_mcu7t5v0__aoi21_1
Xgf180mcu_fd_sc_mcu7t5v0__aoi21_1_293 gf180mcu_fd_sc_mcu7t5v0__aoi21_1_293/B vdd vss
+ gf180mcu_fd_sc_mcu7t5v0__dffq_1_424/D gf180mcu_fd_sc_mcu7t5v0__inv_1_17/ZN gf180mcu_fd_sc_mcu7t5v0__buf_20_0/I
+ vdd vss gf180mcu_fd_sc_mcu7t5v0__aoi21_1
Xgf180mcu_fd_sc_mcu7t5v0__aoi22_2_8 gf180mcu_fd_sc_mcu7t5v0__mux4_2_0/I0 gf180mcu_fd_sc_mcu7t5v0__aoi22_2_8/B2
+ vdd vss gf180mcu_fd_sc_mcu7t5v0__aoi22_2_8/ZN gf180mcu_fd_sc_mcu7t5v0__or2_1_34/A1
+ gf180mcu_fd_sc_mcu7t5v0__aoi22_2_8/A2 vdd vss gf180mcu_fd_sc_mcu7t5v0__aoi22_2
Xgf180mcu_fd_sc_mcu7t5v0__oai21_4_3 gf180mcu_fd_sc_mcu7t5v0__oai21_4_3/B vdd vss gf180mcu_fd_sc_mcu7t5v0__inv_2_13/ZN
+ gf180mcu_fd_sc_mcu7t5v0__or4_1_1/A4 gf180mcu_fd_sc_mcu7t5v0__or2_4_0/Z vdd vss gf180mcu_fd_sc_mcu7t5v0__oai21_4
Xgf180mcu_fd_sc_mcu7t5v0__oai21_1_60 vdd gf180mcu_fd_sc_mcu7t5v0__or3_1_8/A3 gf180mcu_fd_sc_mcu7t5v0__or3_1_8/A2
+ gf180mcu_fd_sc_mcu7t5v0__and2_1_29/A2 gf180mcu_fd_sc_mcu7t5v0__or3_1_8/A1 vss vdd
+ vss gf180mcu_fd_sc_mcu7t5v0__oai21_1
Xgf180mcu_fd_sc_mcu7t5v0__oai22_1_203 gf180mcu_fd_sc_mcu7t5v0__oai22_1_43/A2 gf180mcu_fd_sc_mcu7t5v0__oai22_1_43/B1
+ gf180mcu_fd_sc_mcu7t5v0__oai22_1_203/B2 vdd vss gf180mcu_fd_sc_mcu7t5v0__dffq_1_248/D
+ gf180mcu_fd_sc_mcu7t5v0__oai22_1_98/A1 vdd vss gf180mcu_fd_sc_mcu7t5v0__oai22_1
Xgf180mcu_fd_sc_mcu7t5v0__oai21_1_71 vdd gf180mcu_fd_sc_mcu7t5v0__oai21_1_71/B gf180mcu_fd_sc_mcu7t5v0__xor2_1_64/A1
+ gf180mcu_fd_sc_mcu7t5v0__nand4_1_3/A4 gf180mcu_fd_sc_mcu7t5v0__inv_4_6/I vss vdd
+ vss gf180mcu_fd_sc_mcu7t5v0__oai21_1
Xgf180mcu_fd_sc_mcu7t5v0__oai22_1_214 gf180mcu_fd_sc_mcu7t5v0__nand2_4_26/ZN gf180mcu_fd_sc_mcu7t5v0__nand2_2_38/ZN
+ gf180mcu_fd_sc_mcu7t5v0__oai22_1_214/B2 vdd vss gf180mcu_fd_sc_mcu7t5v0__dffq_1_219/D
+ gf180mcu_fd_sc_mcu7t5v0__oai22_1_98/A1 vdd vss gf180mcu_fd_sc_mcu7t5v0__oai22_1
Xgf180mcu_fd_sc_mcu7t5v0__oai21_1_82 vdd gf180mcu_fd_sc_mcu7t5v0__buf_8_5/Z gf180mcu_fd_sc_mcu7t5v0__buf_20_0/Z
+ gf180mcu_fd_sc_mcu7t5v0__aoi21_1_98/B gf180mcu_fd_sc_mcu7t5v0__dffq_1_242/Q vss
+ vdd vss gf180mcu_fd_sc_mcu7t5v0__oai21_1
Xgf180mcu_fd_sc_mcu7t5v0__oai22_1_225 gf180mcu_fd_sc_mcu7t5v0__oai22_1_28/A2 gf180mcu_fd_sc_mcu7t5v0__oai22_1_28/B1
+ gf180mcu_fd_sc_mcu7t5v0__oai22_1_225/B2 vdd vss gf180mcu_fd_sc_mcu7t5v0__dffq_1_213/D
+ gf180mcu_fd_sc_mcu7t5v0__oai22_1_98/A1 vdd vss gf180mcu_fd_sc_mcu7t5v0__oai22_1
Xgf180mcu_fd_sc_mcu7t5v0__oai21_1_93 vdd gf180mcu_fd_sc_mcu7t5v0__buf_8_5/Z gf180mcu_fd_sc_mcu7t5v0__oai21_1_94/A2
+ gf180mcu_fd_sc_mcu7t5v0__oai21_1_93/ZN gf180mcu_fd_sc_mcu7t5v0__mux2_4_2/I1 vss
+ vdd vss gf180mcu_fd_sc_mcu7t5v0__oai21_1
Xgf180mcu_fd_sc_mcu7t5v0__oai22_1_236 gf180mcu_fd_sc_mcu7t5v0__nand2_4_31/ZN gf180mcu_fd_sc_mcu7t5v0__nand2_2_42/ZN
+ gf180mcu_fd_sc_mcu7t5v0__oai22_1_236/B2 vdd vss gf180mcu_fd_sc_mcu7t5v0__dffq_1_225/D
+ gf180mcu_fd_sc_mcu7t5v0__aoi21_4_2/ZN vdd vss gf180mcu_fd_sc_mcu7t5v0__oai22_1
Xgf180mcu_fd_sc_mcu7t5v0__oai22_1_247 gf180mcu_fd_sc_mcu7t5v0__nand2_4_28/ZN gf180mcu_fd_sc_mcu7t5v0__nand2_2_44/ZN
+ gf180mcu_fd_sc_mcu7t5v0__oai22_1_247/B2 vdd vss gf180mcu_fd_sc_mcu7t5v0__dffq_1_245/D
+ gf180mcu_fd_sc_mcu7t5v0__aoi21_4_3/ZN vdd vss gf180mcu_fd_sc_mcu7t5v0__oai22_1
Xgf180mcu_fd_sc_mcu7t5v0__oai22_1_258 gf180mcu_fd_sc_mcu7t5v0__oai22_1_99/A2 gf180mcu_fd_sc_mcu7t5v0__oai22_1_99/B1
+ gf180mcu_fd_sc_mcu7t5v0__oai22_1_258/B2 vdd vss gf180mcu_fd_sc_mcu7t5v0__dffq_1_99/D
+ gf180mcu_fd_sc_mcu7t5v0__oai21_4_9/ZN vdd vss gf180mcu_fd_sc_mcu7t5v0__oai22_1
Xgf180mcu_fd_sc_mcu7t5v0__oai22_1_269 gf180mcu_fd_sc_mcu7t5v0__or3_1_19/A1 gf180mcu_fd_sc_mcu7t5v0__oai22_1_269/B1
+ gf180mcu_fd_sc_mcu7t5v0__nor2_1_281/ZN vdd vss gf180mcu_fd_sc_mcu7t5v0__aoi221_1_42/C
+ gf180mcu_fd_sc_mcu7t5v0__mux2_1_9/I0 vdd vss gf180mcu_fd_sc_mcu7t5v0__oai22_1
Xgf180mcu_fd_sc_mcu7t5v0__dffq_1_101 vdd gf180mcu_fd_sc_mcu7t5v0__dffq_1_101/Q gf180mcu_fd_sc_mcu7t5v0__dffq_1_96/CLK
+ vss gf180mcu_fd_sc_mcu7t5v0__dffq_1_101/D vdd vss gf180mcu_fd_sc_mcu7t5v0__dffq_1
Xgf180mcu_fd_sc_mcu7t5v0__dffq_1_112 vdd gf180mcu_fd_sc_mcu7t5v0__dffq_1_112/Q gf180mcu_fd_sc_mcu7t5v0__dffq_1_96/CLK
+ vss gf180mcu_fd_sc_mcu7t5v0__dffq_1_112/D vdd vss gf180mcu_fd_sc_mcu7t5v0__dffq_1
Xgf180mcu_fd_sc_mcu7t5v0__nor2_1_301 vdd vss gf180mcu_fd_sc_mcu7t5v0__dffq_2_65/D
+ gf180mcu_fd_sc_mcu7t5v0__aoi21_1_7/B gf180mcu_fd_sc_mcu7t5v0__nor2_1_301/A2 vdd
+ vss gf180mcu_fd_sc_mcu7t5v0__nor2_1
Xgf180mcu_fd_sc_mcu7t5v0__dffq_1_123 vdd gf180mcu_fd_sc_mcu7t5v0__dffq_1_123/Q gf180mcu_fd_sc_mcu7t5v0__dffq_1_96/CLK
+ vss gf180mcu_fd_sc_mcu7t5v0__dffq_1_123/D vdd vss gf180mcu_fd_sc_mcu7t5v0__dffq_1
Xgf180mcu_fd_sc_mcu7t5v0__nor2_1_312 vdd vss gf180mcu_fd_sc_mcu7t5v0__nor2_1_312/ZN
+ gf180mcu_fd_sc_mcu7t5v0__nor2_1_312/A1 gf180mcu_fd_sc_mcu7t5v0__xor3_1_176/Z vdd
+ vss gf180mcu_fd_sc_mcu7t5v0__nor2_1
Xgf180mcu_fd_sc_mcu7t5v0__dffq_1_134 vdd gf180mcu_fd_sc_mcu7t5v0__dffq_1_134/Q gf180mcu_fd_sc_mcu7t5v0__dffq_1_96/CLK
+ vss gf180mcu_fd_sc_mcu7t5v0__dffq_1_134/D vdd vss gf180mcu_fd_sc_mcu7t5v0__dffq_1
Xgf180mcu_fd_sc_mcu7t5v0__nor2_1_323 vdd vss gf180mcu_fd_sc_mcu7t5v0__nor2_1_323/ZN
+ gf180mcu_fd_sc_mcu7t5v0__dffq_1_436/Q gf180mcu_fd_sc_mcu7t5v0__nor2_4_24/ZN vdd
+ vss gf180mcu_fd_sc_mcu7t5v0__nor2_1
Xgf180mcu_fd_sc_mcu7t5v0__dffq_1_145 vdd gf180mcu_fd_sc_mcu7t5v0__dffq_1_145/Q gf180mcu_fd_sc_mcu7t5v0__dffq_1_96/CLK
+ vss gf180mcu_fd_sc_mcu7t5v0__dffq_1_145/D vdd vss gf180mcu_fd_sc_mcu7t5v0__dffq_1
Xgf180mcu_fd_sc_mcu7t5v0__nor2_1_334 vdd vss gf180mcu_fd_sc_mcu7t5v0__nor2_1_334/ZN
+ gf180mcu_fd_sc_mcu7t5v0__dffq_1_439/Q gf180mcu_fd_sc_mcu7t5v0__nor2_4_27/ZN vdd
+ vss gf180mcu_fd_sc_mcu7t5v0__nor2_1
Xgf180mcu_fd_sc_mcu7t5v0__dffq_1_156 vdd gf180mcu_fd_sc_mcu7t5v0__dffq_1_156/Q gf180mcu_fd_sc_mcu7t5v0__dffq_2_26/CLK
+ vss gf180mcu_fd_sc_mcu7t5v0__dffq_1_156/D vdd vss gf180mcu_fd_sc_mcu7t5v0__dffq_1
Xgf180mcu_fd_sc_mcu7t5v0__dffq_1_167 vdd gf180mcu_fd_sc_mcu7t5v0__dffq_1_167/Q gf180mcu_fd_sc_mcu7t5v0__dffq_2_58/CLK
+ vss gf180mcu_fd_sc_mcu7t5v0__dffq_1_167/D vdd vss gf180mcu_fd_sc_mcu7t5v0__dffq_1
Xgf180mcu_fd_sc_mcu7t5v0__nor2_1_345 vdd vss gf180mcu_fd_sc_mcu7t5v0__nor2_1_345/ZN
+ gf180mcu_fd_sc_mcu7t5v0__inv_3_4/ZN gf180mcu_fd_sc_mcu7t5v0__nor2_2_48/A2 vdd vss
+ gf180mcu_fd_sc_mcu7t5v0__nor2_1
Xgf180mcu_fd_sc_mcu7t5v0__nor2_1_356 vdd vss gf180mcu_fd_sc_mcu7t5v0__nor2_1_356/ZN
+ gf180mcu_fd_sc_mcu7t5v0__xor3_1_118/A2 gf180mcu_fd_sc_mcu7t5v0__xor3_1_118/A3 vdd
+ vss gf180mcu_fd_sc_mcu7t5v0__nor2_1
Xgf180mcu_fd_sc_mcu7t5v0__dffq_1_178 vdd gf180mcu_fd_sc_mcu7t5v0__dffq_1_178/Q gf180mcu_fd_sc_mcu7t5v0__dffq_1_96/CLK
+ vss gf180mcu_fd_sc_mcu7t5v0__dffq_1_178/D vdd vss gf180mcu_fd_sc_mcu7t5v0__dffq_1
Xgf180mcu_fd_sc_mcu7t5v0__nor2_1_367 vdd vss gf180mcu_fd_sc_mcu7t5v0__oai33_2_4/A3
+ gf180mcu_fd_sc_mcu7t5v0__or3_1_24/Z gf180mcu_fd_sc_mcu7t5v0__xor3_1_131/A3 vdd vss
+ gf180mcu_fd_sc_mcu7t5v0__nor2_1
Xgf180mcu_fd_sc_mcu7t5v0__dffq_1_189 vdd gf180mcu_fd_sc_mcu7t5v0__dffq_1_189/Q gf180mcu_fd_sc_mcu7t5v0__dffq_2_26/CLK
+ vss gf180mcu_fd_sc_mcu7t5v0__dffq_1_189/D vdd vss gf180mcu_fd_sc_mcu7t5v0__dffq_1
Xgf180mcu_fd_sc_mcu7t5v0__nor2_1_378 vdd vss gf180mcu_fd_sc_mcu7t5v0__nor2_1_378/ZN
+ gf180mcu_fd_sc_mcu7t5v0__xor2_1_174/A1 gf180mcu_fd_sc_mcu7t5v0__xor2_1_174/A2 vdd
+ vss gf180mcu_fd_sc_mcu7t5v0__nor2_1
Xgf180mcu_fd_sc_mcu7t5v0__nor2_1_389 vdd vss gf180mcu_fd_sc_mcu7t5v0__nor2_1_389/ZN
+ gf180mcu_fd_sc_mcu7t5v0__nor2_1_389/A1 gf180mcu_fd_sc_mcu7t5v0__xnor3_1_43/A1 vdd
+ vss gf180mcu_fd_sc_mcu7t5v0__nor2_1
Xgf180mcu_fd_sc_mcu7t5v0__nand2_1_560 vdd vss gf180mcu_fd_sc_mcu7t5v0__mux2_1_13/S
+ gf180mcu_fd_sc_mcu7t5v0__or2_1_7/A1 gf180mcu_fd_sc_mcu7t5v0__xor3_1_119/A2 vdd vss
+ gf180mcu_fd_sc_mcu7t5v0__nand2_1
Xgf180mcu_fd_sc_mcu7t5v0__nand2_1_571 vdd vss gf180mcu_fd_sc_mcu7t5v0__nand3_1_87/A2
+ gf180mcu_fd_sc_mcu7t5v0__or2_1_51/A1 gf180mcu_fd_sc_mcu7t5v0__or2_1_51/A2 vdd vss
+ gf180mcu_fd_sc_mcu7t5v0__nand2_1
Xgf180mcu_fd_sc_mcu7t5v0__nand2_1_582 vdd vss gf180mcu_fd_sc_mcu7t5v0__aoi21_2_20/A2
+ gf180mcu_fd_sc_mcu7t5v0__or2_1_46/Z gf180mcu_fd_sc_mcu7t5v0__xor3_1_178/A3 vdd vss
+ gf180mcu_fd_sc_mcu7t5v0__nand2_1
Xgf180mcu_fd_sc_mcu7t5v0__nand2_1_593 vdd vss gf180mcu_fd_sc_mcu7t5v0__xor3_1_122/A3
+ gf180mcu_fd_sc_mcu7t5v0__inv_12_1/I gf180mcu_fd_sc_mcu7t5v0__xor3_1_119/A2 vdd vss
+ gf180mcu_fd_sc_mcu7t5v0__nand2_1
Xgf180mcu_fd_sc_mcu7t5v0__clkbuf_16_13 vdd vss gf180mcu_fd_sc_mcu7t5v0__dffq_4_44/CLK
+ gf180mcu_fd_sc_mcu7t5v0__clkbuf_16_8/I vdd vss gf180mcu_fd_sc_mcu7t5v0__clkbuf_16
Xgf180mcu_fd_sc_mcu7t5v0__clkbuf_16_6 vdd vss gf180mcu_fd_sc_mcu7t5v0__clkbuf_16_9/I
+ gf180mcu_fd_sc_mcu7t5v0__clkbuf_16_7/Z vdd vss gf180mcu_fd_sc_mcu7t5v0__clkbuf_16
Xgf180mcu_fd_sc_mcu7t5v0__clkinv_8_0 vdd vss gf180mcu_fd_sc_mcu7t5v0__nor2_1_236/A1
+ gf180mcu_fd_sc_mcu7t5v0__dffq_2_43/Q vdd vss gf180mcu_fd_sc_mcu7t5v0__clkinv_8
Xgf180mcu_fd_sc_mcu7t5v0__nand2_1_4 vdd vss gf180mcu_fd_sc_mcu7t5v0__nor2_1_6/A1 gf180mcu_fd_sc_mcu7t5v0__inv_8_2/I
+ gf180mcu_fd_sc_mcu7t5v0__and2_4_2/Z vdd vss gf180mcu_fd_sc_mcu7t5v0__nand2_1
Xgf180mcu_fd_sc_mcu7t5v0__mux4_4_10 gf180mcu_fd_sc_mcu7t5v0__mux4_4_13/I0 vss vdd
+ gf180mcu_fd_sc_mcu7t5v0__or2_1_42/A1 gf180mcu_fd_sc_mcu7t5v0__mux4_4_9/I3 gf180mcu_fd_sc_mcu7t5v0__inv_4_5/I
+ gf180mcu_fd_sc_mcu7t5v0__mux4_4_5/I3 gf180mcu_fd_sc_mcu7t5v0__or2_2_1/A1 gf180mcu_fd_sc_mcu7t5v0__inv_1_14/I
+ vdd vss gf180mcu_fd_sc_mcu7t5v0__mux4_4
Xgf180mcu_fd_sc_mcu7t5v0__dffq_1_8 vdd gf180mcu_fd_sc_mcu7t5v0__dffq_1_8/Q gf180mcu_fd_sc_mcu7t5v0__dffq_4_6/CLK
+ vss gf180mcu_fd_sc_mcu7t5v0__dffq_1_8/D vdd vss gf180mcu_fd_sc_mcu7t5v0__dffq_1
Xgf180mcu_fd_sc_mcu7t5v0__oai21_2_0 gf180mcu_fd_sc_mcu7t5v0__xor2_1_4/A1 gf180mcu_fd_sc_mcu7t5v0__xor3_1_2/A2
+ gf180mcu_fd_sc_mcu7t5v0__xor3_2_0/A1 vss gf180mcu_fd_sc_mcu7t5v0__xor2_1_4/A2 vdd
+ vdd vss gf180mcu_fd_sc_mcu7t5v0__oai21_2
Xgf180mcu_fd_sc_mcu7t5v0__nor2_1_120 vdd vss gf180mcu_fd_sc_mcu7t5v0__aoi21_4_1/B
+ gf180mcu_fd_sc_mcu7t5v0__nor2_1_144/A1 gf180mcu_fd_sc_mcu7t5v0__or3_4_0/Z vdd vss
+ gf180mcu_fd_sc_mcu7t5v0__nor2_1
Xgf180mcu_fd_sc_mcu7t5v0__nor2_1_131 vdd vss gf180mcu_fd_sc_mcu7t5v0__xor2_1_86/A1
+ gf180mcu_fd_sc_mcu7t5v0__mux2_1_10/S gf180mcu_fd_sc_mcu7t5v0__oai31_1_8/A2 vdd vss
+ gf180mcu_fd_sc_mcu7t5v0__nor2_1
Xgf180mcu_fd_sc_mcu7t5v0__nor2_1_142 vdd vss gf180mcu_fd_sc_mcu7t5v0__nor2_1_142/ZN
+ gf180mcu_fd_sc_mcu7t5v0__dffq_1_449/Q gf180mcu_fd_sc_mcu7t5v0__nor2_4_22/ZN vdd
+ vss gf180mcu_fd_sc_mcu7t5v0__nor2_1
Xgf180mcu_fd_sc_mcu7t5v0__nor2_1_153 vdd vss gf180mcu_fd_sc_mcu7t5v0__dffq_2_36/D
+ gf180mcu_fd_sc_mcu7t5v0__or2_1_23/A1 gf180mcu_fd_sc_mcu7t5v0__nor2_1_153/A2 vdd
+ vss gf180mcu_fd_sc_mcu7t5v0__nor2_1
Xgf180mcu_fd_sc_mcu7t5v0__xor3_1_110 gf180mcu_fd_sc_mcu7t5v0__xor2_1_222/Z vdd vss
+ gf180mcu_fd_sc_mcu7t5v0__xor3_1_110/Z gf180mcu_fd_sc_mcu7t5v0__dffq_2_65/Q gf180mcu_fd_sc_mcu7t5v0__xor3_1_110/A2
+ vdd vss gf180mcu_fd_sc_mcu7t5v0__xor3_1
Xgf180mcu_fd_sc_mcu7t5v0__xor3_1_121 gf180mcu_fd_sc_mcu7t5v0__xor3_1_121/A3 vdd vss
+ gf180mcu_fd_sc_mcu7t5v0__xor3_1_121/Z gf180mcu_fd_sc_mcu7t5v0__xor3_1_116/Z gf180mcu_fd_sc_mcu7t5v0__xor3_1_121/A2
+ vdd vss gf180mcu_fd_sc_mcu7t5v0__xor3_1
Xgf180mcu_fd_sc_mcu7t5v0__clkinv_1_7 vdd vss gf180mcu_fd_sc_mcu7t5v0__or2_4_0/A1 gf180mcu_fd_sc_mcu7t5v0__clkinv_1_7/ZN
+ vdd vss gf180mcu_fd_sc_mcu7t5v0__clkinv_1
Xgf180mcu_fd_sc_mcu7t5v0__xor3_1_132 gf180mcu_fd_sc_mcu7t5v0__nor3_1_38/A3 vdd vss
+ gf180mcu_fd_sc_mcu7t5v0__xor3_1_132/Z gf180mcu_fd_sc_mcu7t5v0__xor3_1_132/A1 gf180mcu_fd_sc_mcu7t5v0__xor3_1_132/A2
+ vdd vss gf180mcu_fd_sc_mcu7t5v0__xor3_1
Xgf180mcu_fd_sc_mcu7t5v0__nor2_1_164 vdd vss gf180mcu_fd_sc_mcu7t5v0__dffq_2_43/D
+ gf180mcu_fd_sc_mcu7t5v0__or2_1_23/A1 gf180mcu_fd_sc_mcu7t5v0__nor2_1_164/A2 vdd
+ vss gf180mcu_fd_sc_mcu7t5v0__nor2_1
Xgf180mcu_fd_sc_mcu7t5v0__nor2_1_175 vdd vss gf180mcu_fd_sc_mcu7t5v0__dffq_1_384/D
+ gf180mcu_fd_sc_mcu7t5v0__nor2_1_176/A1 gf180mcu_fd_sc_mcu7t5v0__nor2_1_175/A2 vdd
+ vss gf180mcu_fd_sc_mcu7t5v0__nor2_1
Xgf180mcu_fd_sc_mcu7t5v0__xor3_1_143 gf180mcu_fd_sc_mcu7t5v0__xor3_1_143/A3 vdd vss
+ gf180mcu_fd_sc_mcu7t5v0__xor3_1_143/Z gf180mcu_fd_sc_mcu7t5v0__dffq_2_96/Q gf180mcu_fd_sc_mcu7t5v0__xor3_1_143/A2
+ vdd vss gf180mcu_fd_sc_mcu7t5v0__xor3_1
Xgf180mcu_fd_sc_mcu7t5v0__nor2_1_186 vdd vss gf180mcu_fd_sc_mcu7t5v0__dffq_1_343/D
+ gf180mcu_fd_sc_mcu7t5v0__and2_1_56/Z gf180mcu_fd_sc_mcu7t5v0__nor2_1_186/A2 vdd
+ vss gf180mcu_fd_sc_mcu7t5v0__nor2_1
Xgf180mcu_fd_sc_mcu7t5v0__xor3_1_154 gf180mcu_fd_sc_mcu7t5v0__xor3_1_154/A3 vdd vss
+ gf180mcu_fd_sc_mcu7t5v0__xor3_1_154/Z gf180mcu_fd_sc_mcu7t5v0__aoi22_4_9/A1 gf180mcu_fd_sc_mcu7t5v0__xor3_1_154/A2
+ vdd vss gf180mcu_fd_sc_mcu7t5v0__xor3_1
Xgf180mcu_fd_sc_mcu7t5v0__nor2_1_197 vdd vss gf180mcu_fd_sc_mcu7t5v0__dffq_1_362/D
+ gf180mcu_fd_sc_mcu7t5v0__and2_1_68/Z gf180mcu_fd_sc_mcu7t5v0__nor2_1_197/A2 vdd
+ vss gf180mcu_fd_sc_mcu7t5v0__nor2_1
Xgf180mcu_fd_sc_mcu7t5v0__xor3_1_165 gf180mcu_fd_sc_mcu7t5v0__nor3_2_14/A3 vdd vss
+ gf180mcu_fd_sc_mcu7t5v0__xor3_1_165/Z gf180mcu_fd_sc_mcu7t5v0__oai32_1_3/B1 gf180mcu_fd_sc_mcu7t5v0__nor3_4_1/A3
+ vdd vss gf180mcu_fd_sc_mcu7t5v0__xor3_1
Xgf180mcu_fd_sc_mcu7t5v0__xor3_1_176 gf180mcu_fd_sc_mcu7t5v0__and2_1_117/Z vdd vss
+ gf180mcu_fd_sc_mcu7t5v0__xor3_1_176/Z gf180mcu_fd_sc_mcu7t5v0__inv_8_1/I gf180mcu_fd_sc_mcu7t5v0__or3_1_9/A2
+ vdd vss gf180mcu_fd_sc_mcu7t5v0__xor3_1
Xgf180mcu_fd_sc_mcu7t5v0__oai211_1_14 gf180mcu_fd_sc_mcu7t5v0__oai211_1_14/B gf180mcu_fd_sc_mcu7t5v0__nand3_4_7/ZN
+ vdd vss gf180mcu_fd_sc_mcu7t5v0__oai22_1_11/A2 gf180mcu_fd_sc_mcu7t5v0__nor2_1_98/ZN
+ gf180mcu_fd_sc_mcu7t5v0__oai211_1_14/A2 vdd vss gf180mcu_fd_sc_mcu7t5v0__oai211_1
Xgf180mcu_fd_sc_mcu7t5v0__oai211_1_25 gf180mcu_fd_sc_mcu7t5v0__oai211_1_25/B gf180mcu_fd_sc_mcu7t5v0__or2_1_34/A2
+ vdd vss gf180mcu_fd_sc_mcu7t5v0__oai211_1_25/ZN gf180mcu_fd_sc_mcu7t5v0__oai31_1_14/B
+ gf180mcu_fd_sc_mcu7t5v0__xor3_1_106/Z vdd vss gf180mcu_fd_sc_mcu7t5v0__oai211_1
Xgf180mcu_fd_sc_mcu7t5v0__oai211_1_36 gf180mcu_fd_sc_mcu7t5v0__oai211_1_36/B gf180mcu_fd_sc_mcu7t5v0__nand4_1_1/A1
+ vdd vss gf180mcu_fd_sc_mcu7t5v0__oai211_1_36/ZN gf180mcu_fd_sc_mcu7t5v0__inv_12_1/I
+ gf180mcu_fd_sc_mcu7t5v0__mux4_4_2/Z vdd vss gf180mcu_fd_sc_mcu7t5v0__oai211_1
Xgf180mcu_fd_sc_mcu7t5v0__nand3_4_12 gf180mcu_fd_sc_mcu7t5v0__nor2_2_22/A1 vdd vss
+ gf180mcu_fd_sc_mcu7t5v0__oai32_1_4/B2 gf180mcu_fd_sc_mcu7t5v0__nor2_4_30/A1 gf180mcu_fd_sc_mcu7t5v0__inv_1_7/I
+ vdd vss gf180mcu_fd_sc_mcu7t5v0__nand3_4
Xgf180mcu_fd_sc_mcu7t5v0__oai211_1_47 gf180mcu_fd_sc_mcu7t5v0__oai211_1_47/B gf180mcu_fd_sc_mcu7t5v0__or2_1_34/A2
+ vdd vss gf180mcu_fd_sc_mcu7t5v0__oai211_1_47/ZN gf180mcu_fd_sc_mcu7t5v0__oai211_1_53/C
+ gf180mcu_fd_sc_mcu7t5v0__xor3_1_151/Z vdd vss gf180mcu_fd_sc_mcu7t5v0__oai211_1
Xgf180mcu_fd_sc_mcu7t5v0__nand3_4_23 gf180mcu_fd_sc_mcu7t5v0__nor2_2_53/A1 vdd vss
+ gf180mcu_fd_sc_mcu7t5v0__oai211_1_53/C gf180mcu_fd_sc_mcu7t5v0__nor2_2_54/A1 gf180mcu_fd_sc_mcu7t5v0__dffq_2_93/Q
+ vdd vss gf180mcu_fd_sc_mcu7t5v0__nand3_4
Xgf180mcu_fd_sc_mcu7t5v0__nand2_1_390 vdd vss gf180mcu_fd_sc_mcu7t5v0__and2_1_78/A1
+ gf180mcu_fd_sc_mcu7t5v0__nor3_2_5/A1 gf180mcu_fd_sc_mcu7t5v0__inv_1_13/ZN vdd vss
+ gf180mcu_fd_sc_mcu7t5v0__nand2_1
Xgf180mcu_fd_sc_mcu7t5v0__oai21_1_202 vdd gf180mcu_fd_sc_mcu7t5v0__or3_1_27/A3 gf180mcu_fd_sc_mcu7t5v0__or3_1_27/A2
+ gf180mcu_fd_sc_mcu7t5v0__oai21_1_202/ZN gf180mcu_fd_sc_mcu7t5v0__or3_1_27/A1 vss
+ vdd vss gf180mcu_fd_sc_mcu7t5v0__oai21_1
Xgf180mcu_fd_sc_mcu7t5v0__oai21_1_213 vdd gf180mcu_fd_sc_mcu7t5v0__and3_2_3/Z gf180mcu_fd_sc_mcu7t5v0__xor2_1_122/Z
+ gf180mcu_fd_sc_mcu7t5v0__oai21_1_213/ZN gf180mcu_fd_sc_mcu7t5v0__and2_1_95/A1 vss
+ vdd vss gf180mcu_fd_sc_mcu7t5v0__oai21_1
Xgf180mcu_fd_sc_mcu7t5v0__oai21_1_224 vdd gf180mcu_fd_sc_mcu7t5v0__or2_1_34/A2 gf180mcu_fd_sc_mcu7t5v0__oai21_1_224/A2
+ gf180mcu_fd_sc_mcu7t5v0__aoi21_1_237/B gf180mcu_fd_sc_mcu7t5v0__nor2_4_34/ZN vss
+ vdd vss gf180mcu_fd_sc_mcu7t5v0__oai21_1
Xgf180mcu_fd_sc_mcu7t5v0__oai21_1_235 vdd gf180mcu_fd_sc_mcu7t5v0__buf_12_0/Z gf180mcu_fd_sc_mcu7t5v0__buf_20_0/Z
+ gf180mcu_fd_sc_mcu7t5v0__aoi21_1_261/B gf180mcu_fd_sc_mcu7t5v0__dffq_1_416/Q vss
+ vdd vss gf180mcu_fd_sc_mcu7t5v0__oai21_1
Xgf180mcu_fd_sc_mcu7t5v0__oai21_1_246 vdd gf180mcu_fd_sc_mcu7t5v0__oai21_1_246/B gf180mcu_fd_sc_mcu7t5v0__oai21_1_246/A2
+ gf180mcu_fd_sc_mcu7t5v0__oai21_1_246/ZN gf180mcu_fd_sc_mcu7t5v0__nor2_1_312/ZN vss
+ vdd vss gf180mcu_fd_sc_mcu7t5v0__oai21_1
Xgf180mcu_fd_sc_mcu7t5v0__oai21_1_257 vdd gf180mcu_fd_sc_mcu7t5v0__buf_8_4/Z gf180mcu_fd_sc_mcu7t5v0__buf_20_0/I
+ gf180mcu_fd_sc_mcu7t5v0__aoi21_1_286/B gf180mcu_fd_sc_mcu7t5v0__mux4_4_2/I3 vss
+ vdd vss gf180mcu_fd_sc_mcu7t5v0__oai21_1
Xgf180mcu_fd_sc_mcu7t5v0__oai21_1_268 vdd gf180mcu_fd_sc_mcu7t5v0__oai21_4_5/A1 gf180mcu_fd_sc_mcu7t5v0__or2_1_37/A2
+ gf180mcu_fd_sc_mcu7t5v0__oai21_1_268/ZN gf180mcu_fd_sc_mcu7t5v0__or2_1_37/A1 vss
+ vdd vss gf180mcu_fd_sc_mcu7t5v0__oai21_1
Xgf180mcu_fd_sc_mcu7t5v0__oai21_1_279 vdd gf180mcu_fd_sc_mcu7t5v0__or3_1_24/A3 gf180mcu_fd_sc_mcu7t5v0__or3_1_24/A2
+ gf180mcu_fd_sc_mcu7t5v0__and4_1_1/A3 gf180mcu_fd_sc_mcu7t5v0__or4_1_0/A2 vss vdd
+ vss gf180mcu_fd_sc_mcu7t5v0__oai21_1
Xgf180mcu_fd_sc_mcu7t5v0__nand3_4_2 gf180mcu_fd_sc_mcu7t5v0__nor2_2_6/A1 vdd vss gf180mcu_fd_sc_mcu7t5v0__mux2_1_2/I0
+ gf180mcu_fd_sc_mcu7t5v0__nor3_4_2/A1 gf180mcu_fd_sc_mcu7t5v0__inv_2_1/I vdd vss
+ gf180mcu_fd_sc_mcu7t5v0__nand3_4
Xgf180mcu_fd_sc_mcu7t5v0__clkinv_3_20 vdd gf180mcu_fd_sc_mcu7t5v0__nor2_2_53/A1 gf180mcu_fd_sc_mcu7t5v0__nor3_1_41/A1
+ vss vdd vss gf180mcu_fd_sc_mcu7t5v0__clkinv_3
Xgf180mcu_fd_sc_mcu7t5v0__aoi221_1_3 gf180mcu_fd_sc_mcu7t5v0__nor2_2_15/ZN gf180mcu_fd_sc_mcu7t5v0__oai22_1_1/B2
+ vdd vss gf180mcu_fd_sc_mcu7t5v0__oai21_1_18/B gf180mcu_fd_sc_mcu7t5v0__dffq_4_37/Q
+ gf180mcu_fd_sc_mcu7t5v0__nor2_4_44/ZN gf180mcu_fd_sc_mcu7t5v0__oai21_1_18/A2 vdd
+ vss gf180mcu_fd_sc_mcu7t5v0__aoi221_1
Xgf180mcu_fd_sc_mcu7t5v0__nor2_1_5 vdd vss gf180mcu_fd_sc_mcu7t5v0__xor3_1_8/A1 gf180mcu_fd_sc_mcu7t5v0__xor3_1_5/A2
+ gf180mcu_fd_sc_mcu7t5v0__xor3_1_62/Z vdd vss gf180mcu_fd_sc_mcu7t5v0__nor2_1
Xgf180mcu_fd_sc_mcu7t5v0__xor2_1_13 vdd vss gf180mcu_fd_sc_mcu7t5v0__xor2_1_13/Z gf180mcu_fd_sc_mcu7t5v0__inv_1_1/I
+ gf180mcu_fd_sc_mcu7t5v0__xor2_1_13/A2 vdd vss gf180mcu_fd_sc_mcu7t5v0__xor2_1
Xgf180mcu_fd_sc_mcu7t5v0__xor2_1_24 vdd vss gf180mcu_fd_sc_mcu7t5v0__xor2_1_24/Z gf180mcu_fd_sc_mcu7t5v0__inv_4_6/ZN
+ gf180mcu_fd_sc_mcu7t5v0__xor2_1_25/Z vdd vss gf180mcu_fd_sc_mcu7t5v0__xor2_1
Xgf180mcu_fd_sc_mcu7t5v0__xor2_1_35 vdd vss gf180mcu_fd_sc_mcu7t5v0__xor2_1_35/Z gf180mcu_fd_sc_mcu7t5v0__xor2_1_35/A1
+ gf180mcu_fd_sc_mcu7t5v0__xor2_1_35/A2 vdd vss gf180mcu_fd_sc_mcu7t5v0__xor2_1
Xgf180mcu_fd_sc_mcu7t5v0__xor2_1_46 vdd vss gf180mcu_fd_sc_mcu7t5v0__or3_1_8/A3 gf180mcu_fd_sc_mcu7t5v0__dffq_2_21/Q
+ gf180mcu_fd_sc_mcu7t5v0__xor2_1_37/Z vdd vss gf180mcu_fd_sc_mcu7t5v0__xor2_1
Xgf180mcu_fd_sc_mcu7t5v0__xor2_1_57 vdd vss gf180mcu_fd_sc_mcu7t5v0__or3_1_7/A3 gf180mcu_fd_sc_mcu7t5v0__dffq_4_37/Q
+ gf180mcu_fd_sc_mcu7t5v0__xor2_1_58/Z vdd vss gf180mcu_fd_sc_mcu7t5v0__xor2_1
Xgf180mcu_fd_sc_mcu7t5v0__xor2_1_120 vdd vss gf180mcu_fd_sc_mcu7t5v0__or2_1_29/A2
+ gf180mcu_fd_sc_mcu7t5v0__or4_1_0/A1 gf180mcu_fd_sc_mcu7t5v0__xor2_1_120/A2 vdd vss
+ gf180mcu_fd_sc_mcu7t5v0__xor2_1
Xgf180mcu_fd_sc_mcu7t5v0__xor2_1_68 vdd vss gf180mcu_fd_sc_mcu7t5v0__xor2_1_68/Z gf180mcu_fd_sc_mcu7t5v0__xor2_1_68/A1
+ gf180mcu_fd_sc_mcu7t5v0__xor2_1_68/A2 vdd vss gf180mcu_fd_sc_mcu7t5v0__xor2_1
Xgf180mcu_fd_sc_mcu7t5v0__xor2_1_131 vdd vss gf180mcu_fd_sc_mcu7t5v0__xor2_1_131/Z
+ gf180mcu_fd_sc_mcu7t5v0__xor2_1_131/A1 gf180mcu_fd_sc_mcu7t5v0__xor2_1_136/Z vdd
+ vss gf180mcu_fd_sc_mcu7t5v0__xor2_1
Xgf180mcu_fd_sc_mcu7t5v0__xor2_1_79 vdd vss gf180mcu_fd_sc_mcu7t5v0__xor2_1_79/Z gf180mcu_fd_sc_mcu7t5v0__xor2_1_79/A1
+ gf180mcu_fd_sc_mcu7t5v0__xor2_1_79/A2 vdd vss gf180mcu_fd_sc_mcu7t5v0__xor2_1
Xgf180mcu_fd_sc_mcu7t5v0__xor2_1_142 vdd vss gf180mcu_fd_sc_mcu7t5v0__xor2_1_142/Z
+ gf180mcu_fd_sc_mcu7t5v0__xor2_1_142/A1 gf180mcu_fd_sc_mcu7t5v0__xor2_1_142/A2 vdd
+ vss gf180mcu_fd_sc_mcu7t5v0__xor2_1
Xgf180mcu_fd_sc_mcu7t5v0__xor2_1_153 vdd vss gf180mcu_fd_sc_mcu7t5v0__xor2_1_153/Z
+ gf180mcu_fd_sc_mcu7t5v0__xor2_1_153/A1 gf180mcu_fd_sc_mcu7t5v0__xor2_1_148/Z vdd
+ vss gf180mcu_fd_sc_mcu7t5v0__xor2_1
Xgf180mcu_fd_sc_mcu7t5v0__xor2_1_164 vdd vss gf180mcu_fd_sc_mcu7t5v0__or3_1_22/A3
+ gf180mcu_fd_sc_mcu7t5v0__dffq_4_37/Q gf180mcu_fd_sc_mcu7t5v0__xor2_1_164/A2 vdd
+ vss gf180mcu_fd_sc_mcu7t5v0__xor2_1
Xgf180mcu_fd_sc_mcu7t5v0__xor2_1_175 vdd vss gf180mcu_fd_sc_mcu7t5v0__xor2_1_175/Z
+ gf180mcu_fd_sc_mcu7t5v0__xor3_1_138/Z gf180mcu_fd_sc_mcu7t5v0__xor3_1_133/Z vdd
+ vss gf180mcu_fd_sc_mcu7t5v0__xor2_1
Xgf180mcu_fd_sc_mcu7t5v0__xor2_1_186 vdd vss gf180mcu_fd_sc_mcu7t5v0__xor2_1_186/Z
+ gf180mcu_fd_sc_mcu7t5v0__and2_1_140/Z gf180mcu_fd_sc_mcu7t5v0__xor2_1_187/Z vdd
+ vss gf180mcu_fd_sc_mcu7t5v0__xor2_1
Xgf180mcu_fd_sc_mcu7t5v0__xor2_1_197 vdd vss gf180mcu_fd_sc_mcu7t5v0__xor2_1_197/Z
+ gf180mcu_fd_sc_mcu7t5v0__xor2_1_197/A1 gf180mcu_fd_sc_mcu7t5v0__xor2_1_197/A2 vdd
+ vss gf180mcu_fd_sc_mcu7t5v0__xor2_1
Xgf180mcu_fd_sc_mcu7t5v0__nand3_1_13 gf180mcu_fd_sc_mcu7t5v0__and2_2_3/A2 vdd vss
+ gf180mcu_fd_sc_mcu7t5v0__xnor3_1_8/A2 gf180mcu_fd_sc_mcu7t5v0__inv_8_0/I gf180mcu_fd_sc_mcu7t5v0__and2_2_3/A1
+ vdd vss gf180mcu_fd_sc_mcu7t5v0__nand3_1
Xgf180mcu_fd_sc_mcu7t5v0__nand3_1_24 gf180mcu_fd_sc_mcu7t5v0__and2_2_4/A2 vdd vss
+ gf180mcu_fd_sc_mcu7t5v0__oai22_1_5/B2 gf180mcu_fd_sc_mcu7t5v0__inv_8_2/I gf180mcu_fd_sc_mcu7t5v0__and2_2_4/A1
+ vdd vss gf180mcu_fd_sc_mcu7t5v0__nand3_1
Xgf180mcu_fd_sc_mcu7t5v0__nand3_1_35 gf180mcu_fd_sc_mcu7t5v0__inv_4_0/ZN vdd vss gf180mcu_fd_sc_mcu7t5v0__nand3_1_35/ZN
+ gf180mcu_fd_sc_mcu7t5v0__nor3_4_4/A1 gf180mcu_fd_sc_mcu7t5v0__inv_2_4/I vdd vss
+ gf180mcu_fd_sc_mcu7t5v0__nand3_1
Xgf180mcu_fd_sc_mcu7t5v0__nand3_1_46 gf180mcu_fd_sc_mcu7t5v0__nand3_1_46/A3 vdd vss
+ gf180mcu_fd_sc_mcu7t5v0__and2_1_46/A2 gf180mcu_fd_sc_mcu7t5v0__nand3_1_46/A1 gf180mcu_fd_sc_mcu7t5v0__nand3_1_46/A2
+ vdd vss gf180mcu_fd_sc_mcu7t5v0__nand3_1
Xgf180mcu_fd_sc_mcu7t5v0__nand3_1_57 gf180mcu_fd_sc_mcu7t5v0__aoi21_2_6/B vdd vss
+ gf180mcu_fd_sc_mcu7t5v0__nand3_1_57/ZN gf180mcu_fd_sc_mcu7t5v0__buf_8_8/Z gf180mcu_fd_sc_mcu7t5v0__inv_2_8/I
+ vdd vss gf180mcu_fd_sc_mcu7t5v0__nand3_1
Xgf180mcu_fd_sc_mcu7t5v0__nand3_1_68 gf180mcu_fd_sc_mcu7t5v0__nand3_1_68/A3 vdd vss
+ gf180mcu_fd_sc_mcu7t5v0__nand4_1_12/A3 gf180mcu_fd_sc_mcu7t5v0__and3_2_3/Z gf180mcu_fd_sc_mcu7t5v0__or3_1_16/Z
+ vdd vss gf180mcu_fd_sc_mcu7t5v0__nand3_1
Xgf180mcu_fd_sc_mcu7t5v0__nand3_1_79 gf180mcu_fd_sc_mcu7t5v0__and2_2_11/A2 vdd vss
+ gf180mcu_fd_sc_mcu7t5v0__xor3_1_100/A3 gf180mcu_fd_sc_mcu7t5v0__inv_8_2/I gf180mcu_fd_sc_mcu7t5v0__and2_2_11/A1
+ vdd vss gf180mcu_fd_sc_mcu7t5v0__nand3_1
Xgf180mcu_fd_sc_mcu7t5v0__oai32_1_3 gf180mcu_fd_sc_mcu7t5v0__oai32_1_3/A3 gf180mcu_fd_sc_mcu7t5v0__oai32_1_3/B1
+ gf180mcu_fd_sc_mcu7t5v0__oai32_1_3/B2 vdd vss gf180mcu_fd_sc_mcu7t5v0__oai32_1_3/ZN
+ gf180mcu_fd_sc_mcu7t5v0__or4_1_0/A2 gf180mcu_fd_sc_mcu7t5v0__nor3_4_5/A1 vdd vss
+ gf180mcu_fd_sc_mcu7t5v0__oai32_1
Xgf180mcu_fd_sc_mcu7t5v0__aoi222_4_1 gf180mcu_fd_sc_mcu7t5v0__nor4_4_1/ZN gf180mcu_fd_sc_mcu7t5v0__and3_1_13/A3
+ vss vdd gf180mcu_fd_sc_mcu7t5v0__dffq_2_30/Q gf180mcu_fd_sc_mcu7t5v0__nor3_4_13/ZN
+ gf180mcu_fd_sc_mcu7t5v0__nor4_4_0/ZN gf180mcu_fd_sc_mcu7t5v0__or3_4_0/Z gf180mcu_fd_sc_mcu7t5v0__inv_1_10/ZN
+ vdd vss gf180mcu_fd_sc_mcu7t5v0__aoi222_4
Xgf180mcu_fd_sc_mcu7t5v0__aoi221_1_30 gf180mcu_fd_sc_mcu7t5v0__oai31_1_9/A3 gf180mcu_fd_sc_mcu7t5v0__aoi221_1_30/C
+ vdd vss gf180mcu_fd_sc_mcu7t5v0__nand2_1_392/A2 gf180mcu_fd_sc_mcu7t5v0__nor2_2_22/ZN
+ gf180mcu_fd_sc_mcu7t5v0__xnor2_1_33/ZN gf180mcu_fd_sc_mcu7t5v0__xor2_1_227/Z vdd
+ vss gf180mcu_fd_sc_mcu7t5v0__aoi221_1
Xgf180mcu_fd_sc_mcu7t5v0__aoi221_1_41 gf180mcu_fd_sc_mcu7t5v0__oai21_1_208/A2 gf180mcu_fd_sc_mcu7t5v0__nor2_2_26/ZN
+ vdd vss gf180mcu_fd_sc_mcu7t5v0__oai21_1_208/B gf180mcu_fd_sc_mcu7t5v0__dffq_4_37/Q
+ gf180mcu_fd_sc_mcu7t5v0__nor2_2_27/ZN gf180mcu_fd_sc_mcu7t5v0__mux2_1_8/I1 vdd vss
+ gf180mcu_fd_sc_mcu7t5v0__aoi221_1
Xgf180mcu_fd_sc_mcu7t5v0__aoi221_1_52 gf180mcu_fd_sc_mcu7t5v0__oai21_1_281/A2 gf180mcu_fd_sc_mcu7t5v0__nor2_2_46/ZN
+ vdd vss gf180mcu_fd_sc_mcu7t5v0__oai21_1_281/B gf180mcu_fd_sc_mcu7t5v0__dffq_4_37/Q
+ gf180mcu_fd_sc_mcu7t5v0__or4_1_3/A1 gf180mcu_fd_sc_mcu7t5v0__nor3_4_21/ZN vdd vss
+ gf180mcu_fd_sc_mcu7t5v0__aoi221_1
Xgf180mcu_fd_sc_mcu7t5v0__aoi221_1_63 gf180mcu_fd_sc_mcu7t5v0__aoi221_1_63/B2 gf180mcu_fd_sc_mcu7t5v0__aoi21_1_7/B
+ vdd vss gf180mcu_fd_sc_mcu7t5v0__dffq_2_95/D gf180mcu_fd_sc_mcu7t5v0__xor3_1_149/A1
+ gf180mcu_fd_sc_mcu7t5v0__or2_4_4/Z gf180mcu_fd_sc_mcu7t5v0__nand2_1_642/ZN vdd vss
+ gf180mcu_fd_sc_mcu7t5v0__aoi221_1
Xgf180mcu_fd_sc_mcu7t5v0__nor3_4_3 gf180mcu_fd_sc_mcu7t5v0__inv_4_0/ZN vdd vss gf180mcu_fd_sc_mcu7t5v0__nor3_4_3/ZN
+ gf180mcu_fd_sc_mcu7t5v0__nor3_4_3/A1 gf180mcu_fd_sc_mcu7t5v0__inv_2_4/ZN vdd vss
+ gf180mcu_fd_sc_mcu7t5v0__nor3_4
Xgf180mcu_fd_sc_mcu7t5v0__xnor3_1_1 gf180mcu_fd_sc_mcu7t5v0__nor2_1_3/A1 vdd vss gf180mcu_fd_sc_mcu7t5v0__xor3_1_0/A2
+ gf180mcu_fd_sc_mcu7t5v0__xor2_1_1/A1 gf180mcu_fd_sc_mcu7t5v0__xor2_1_1/A2 vdd vss
+ gf180mcu_fd_sc_mcu7t5v0__xnor3_1
Xgf180mcu_fd_sc_mcu7t5v0__dffq_2_19 gf180mcu_fd_sc_mcu7t5v0__dffq_2_19/D vdd vss gf180mcu_fd_sc_mcu7t5v0__dffq_4_6/CLK
+ gf180mcu_fd_sc_mcu7t5v0__inv_4_0/I vdd vss gf180mcu_fd_sc_mcu7t5v0__dffq_2
Xgf180mcu_fd_sc_mcu7t5v0__nand2_1_90 vdd vss gf180mcu_fd_sc_mcu7t5v0__and2_1_6/A2
+ gf180mcu_fd_sc_mcu7t5v0__inv_12_1/I gf180mcu_fd_sc_mcu7t5v0__xor2_1_20/A1 vdd vss
+ gf180mcu_fd_sc_mcu7t5v0__nand2_1
Xgf180mcu_fd_sc_mcu7t5v0__inv_2_13 vss gf180mcu_fd_sc_mcu7t5v0__inv_2_13/ZN gf180mcu_fd_sc_mcu7t5v0__inv_2_13/I
+ vdd vdd vss gf180mcu_fd_sc_mcu7t5v0__inv_2
Xgf180mcu_fd_sc_mcu7t5v0__and3_1_17 gf180mcu_fd_sc_mcu7t5v0__inv_4_5/I vdd vss gf180mcu_fd_sc_mcu7t5v0__and3_1_17/Z
+ gf180mcu_fd_sc_mcu7t5v0__mux4_4_1/I3 gf180mcu_fd_sc_mcu7t5v0__or2_2_1/A1 vdd vss
+ gf180mcu_fd_sc_mcu7t5v0__and3_1
Xgf180mcu_fd_sc_mcu7t5v0__and2_1_4 vdd vss gf180mcu_fd_sc_mcu7t5v0__and2_1_4/Z gf180mcu_fd_sc_mcu7t5v0__xor3_1_4/Z
+ gf180mcu_fd_sc_mcu7t5v0__xor3_1_8/A3 vdd vss gf180mcu_fd_sc_mcu7t5v0__and2_1
Xgf180mcu_fd_sc_mcu7t5v0__nand2_1_208 vdd vss gf180mcu_fd_sc_mcu7t5v0__xnor3_1_0/A1
+ gf180mcu_fd_sc_mcu7t5v0__inv_8_0/I gf180mcu_fd_sc_mcu7t5v0__and2_2_0/Z vdd vss gf180mcu_fd_sc_mcu7t5v0__nand2_1
Xgf180mcu_fd_sc_mcu7t5v0__nand2_1_219 vdd vss gf180mcu_fd_sc_mcu7t5v0__aoi222_1_2/A2
+ gf180mcu_fd_sc_mcu7t5v0__aoi22_1_30/ZN gf180mcu_fd_sc_mcu7t5v0__aoi22_1_25/ZN vdd
+ vss gf180mcu_fd_sc_mcu7t5v0__nand2_1
Xgf180mcu_fd_sc_mcu7t5v0__nor2_2_17 vdd vss gf180mcu_fd_sc_mcu7t5v0__and3_2_1/A3 gf180mcu_fd_sc_mcu7t5v0__nor4_4_1/A1
+ gf180mcu_fd_sc_mcu7t5v0__nor4_4_1/A4 vdd vss gf180mcu_fd_sc_mcu7t5v0__nor2_2
Xgf180mcu_fd_sc_mcu7t5v0__nor2_2_28 vdd vss gf180mcu_fd_sc_mcu7t5v0__nor2_2_28/ZN
+ gf180mcu_fd_sc_mcu7t5v0__nor2_2_31/A1 gf180mcu_fd_sc_mcu7t5v0__and3_2_3/A1 vdd vss
+ gf180mcu_fd_sc_mcu7t5v0__nor2_2
Xgf180mcu_fd_sc_mcu7t5v0__nor2_2_39 vdd vss gf180mcu_fd_sc_mcu7t5v0__nor2_2_39/ZN
+ gf180mcu_fd_sc_mcu7t5v0__nor2_2_39/A1 gf180mcu_fd_sc_mcu7t5v0__nor3_1_30/ZN vdd
+ vss gf180mcu_fd_sc_mcu7t5v0__nor2_2
Xgf180mcu_fd_sc_mcu7t5v0__nor3_2_0 gf180mcu_fd_sc_mcu7t5v0__xor3_1_2/Z vdd vss gf180mcu_fd_sc_mcu7t5v0__or2_1_3/A1
+ gf180mcu_fd_sc_mcu7t5v0__nor3_2_0/A1 gf180mcu_fd_sc_mcu7t5v0__nor3_2_0/A2 vdd vss
+ gf180mcu_fd_sc_mcu7t5v0__nor3_2
Xgf180mcu_fd_sc_mcu7t5v0__dffq_1_305 vdd gf180mcu_fd_sc_mcu7t5v0__dffq_1_305/Q gf180mcu_fd_sc_mcu7t5v0__dffq_4_21/CLK
+ vss gf180mcu_fd_sc_mcu7t5v0__dffq_1_305/D vdd vss gf180mcu_fd_sc_mcu7t5v0__dffq_1
Xgf180mcu_fd_sc_mcu7t5v0__dffq_1_316 vdd gf180mcu_fd_sc_mcu7t5v0__dffq_1_316/Q gf180mcu_fd_sc_mcu7t5v0__dffq_4_9/CLK
+ vss gf180mcu_fd_sc_mcu7t5v0__dffq_1_316/D vdd vss gf180mcu_fd_sc_mcu7t5v0__dffq_1
Xgf180mcu_fd_sc_mcu7t5v0__dffq_1_327 vdd gf180mcu_fd_sc_mcu7t5v0__dffq_1_327/Q gf180mcu_fd_sc_mcu7t5v0__dffq_4_15/CLK
+ vss gf180mcu_fd_sc_mcu7t5v0__dffq_1_327/D vdd vss gf180mcu_fd_sc_mcu7t5v0__dffq_1
Xgf180mcu_fd_sc_mcu7t5v0__dffq_1_338 vdd gf180mcu_fd_sc_mcu7t5v0__nor4_1_0/A1 gf180mcu_fd_sc_mcu7t5v0__dffq_4_15/CLK
+ vss gf180mcu_fd_sc_mcu7t5v0__dffq_1_338/D vdd vss gf180mcu_fd_sc_mcu7t5v0__dffq_1
Xgf180mcu_fd_sc_mcu7t5v0__dffq_1_349 vdd gf180mcu_fd_sc_mcu7t5v0__nor4_1_1/A4 gf180mcu_fd_sc_mcu7t5v0__dffq_4_15/CLK
+ vss gf180mcu_fd_sc_mcu7t5v0__dffq_1_349/D vdd vss gf180mcu_fd_sc_mcu7t5v0__dffq_1
Xgf180mcu_fd_sc_mcu7t5v0__aoi21_4_1 gf180mcu_fd_sc_mcu7t5v0__or3_4_0/Z gf180mcu_fd_sc_mcu7t5v0__aoi21_4_1/B
+ vdd vss gf180mcu_fd_sc_mcu7t5v0__aoi21_4_1/ZN gf180mcu_fd_sc_mcu7t5v0__mux4_4_5/I0
+ vdd vss gf180mcu_fd_sc_mcu7t5v0__aoi21_4
Xgf180mcu_fd_sc_mcu7t5v0__oai22_1_17 gf180mcu_fd_sc_mcu7t5v0__nand2_4_2/ZN gf180mcu_fd_sc_mcu7t5v0__oai22_1_29/B1
+ gf180mcu_fd_sc_mcu7t5v0__oai22_1_17/B2 vdd vss gf180mcu_fd_sc_mcu7t5v0__dffq_1_22/D
+ gf180mcu_fd_sc_mcu7t5v0__oai21_4_9/ZN vdd vss gf180mcu_fd_sc_mcu7t5v0__oai22_1
Xgf180mcu_fd_sc_mcu7t5v0__oai22_1_28 gf180mcu_fd_sc_mcu7t5v0__oai22_1_28/A2 gf180mcu_fd_sc_mcu7t5v0__oai22_1_28/B1
+ gf180mcu_fd_sc_mcu7t5v0__oai22_1_28/B2 vdd vss gf180mcu_fd_sc_mcu7t5v0__dffq_1_30/D
+ gf180mcu_fd_sc_mcu7t5v0__oai22_1_88/A1 vdd vss gf180mcu_fd_sc_mcu7t5v0__oai22_1
Xgf180mcu_fd_sc_mcu7t5v0__oai22_1_39 gf180mcu_fd_sc_mcu7t5v0__oai22_1_48/A2 gf180mcu_fd_sc_mcu7t5v0__aoi21_4_3/ZN
+ gf180mcu_fd_sc_mcu7t5v0__nand2_4_5/ZN vdd vss gf180mcu_fd_sc_mcu7t5v0__dffq_1_41/D
+ gf180mcu_fd_sc_mcu7t5v0__oai22_1_39/A1 vdd vss gf180mcu_fd_sc_mcu7t5v0__oai22_1
Xgf180mcu_fd_sc_mcu7t5v0__nand2_1_720 vdd vss gf180mcu_fd_sc_mcu7t5v0__xor2_1_221/A2
+ gf180mcu_fd_sc_mcu7t5v0__oai31_1_1/B gf180mcu_fd_sc_mcu7t5v0__oai31_1_1/A2 vdd vss
+ gf180mcu_fd_sc_mcu7t5v0__nand2_1
Xgf180mcu_fd_sc_mcu7t5v0__and2_1_50 vdd vss gf180mcu_fd_sc_mcu7t5v0__dffq_2_58/D gf180mcu_fd_sc_mcu7t5v0__buf_8_5/I
+ gf180mcu_fd_sc_mcu7t5v0__and2_1_50/A2 vdd vss gf180mcu_fd_sc_mcu7t5v0__and2_1
Xgf180mcu_fd_sc_mcu7t5v0__and2_1_61 vdd vss gf180mcu_fd_sc_mcu7t5v0__and2_1_61/Z gf180mcu_fd_sc_mcu7t5v0__dffq_1_354/Q
+ gf180mcu_fd_sc_mcu7t5v0__and2_1_77/Z vdd vss gf180mcu_fd_sc_mcu7t5v0__and2_1
Xgf180mcu_fd_sc_mcu7t5v0__and2_1_72 vdd vss gf180mcu_fd_sc_mcu7t5v0__and2_1_72/Z gf180mcu_fd_sc_mcu7t5v0__buf_8_8/Z
+ gf180mcu_fd_sc_mcu7t5v0__nor4_4_2/A1 vdd vss gf180mcu_fd_sc_mcu7t5v0__and2_1
Xgf180mcu_fd_sc_mcu7t5v0__and2_1_83 vdd vss gf180mcu_fd_sc_mcu7t5v0__and2_1_83/Z gf180mcu_fd_sc_mcu7t5v0__inv_8_0/I
+ gf180mcu_fd_sc_mcu7t5v0__xor2_1_100/Z vdd vss gf180mcu_fd_sc_mcu7t5v0__and2_1
Xgf180mcu_fd_sc_mcu7t5v0__and2_1_94 vdd vss gf180mcu_fd_sc_mcu7t5v0__and2_1_94/Z gf180mcu_fd_sc_mcu7t5v0__inv_2_9/I
+ gf180mcu_fd_sc_mcu7t5v0__and2_1_94/A2 vdd vss gf180mcu_fd_sc_mcu7t5v0__and2_1
Xgf180mcu_fd_sc_mcu7t5v0__aoi211_1_40 gf180mcu_fd_sc_mcu7t5v0__nor2_1_143/ZN gf180mcu_fd_sc_mcu7t5v0__or2_1_23/A1
+ vdd vss gf180mcu_fd_sc_mcu7t5v0__dffq_1_288/D gf180mcu_fd_sc_mcu7t5v0__nor2_1_236/A1
+ gf180mcu_fd_sc_mcu7t5v0__nor2_4_22/ZN vdd vss gf180mcu_fd_sc_mcu7t5v0__aoi211_1
Xgf180mcu_fd_sc_mcu7t5v0__aoi211_1_51 gf180mcu_fd_sc_mcu7t5v0__aoi211_1_51/B gf180mcu_fd_sc_mcu7t5v0__aoi211_1_51/C
+ vdd vss gf180mcu_fd_sc_mcu7t5v0__dffq_1_337/D gf180mcu_fd_sc_mcu7t5v0__oai21_1_154/B
+ gf180mcu_fd_sc_mcu7t5v0__or2_1_21/A2 vdd vss gf180mcu_fd_sc_mcu7t5v0__aoi211_1
Xgf180mcu_fd_sc_mcu7t5v0__aoi211_1_62 gf180mcu_fd_sc_mcu7t5v0__nor2_1_298/ZN gf180mcu_fd_sc_mcu7t5v0__or2_1_23/A1
+ vdd vss gf180mcu_fd_sc_mcu7t5v0__dffq_1_447/D gf180mcu_fd_sc_mcu7t5v0__inv_4_3/ZN
+ gf180mcu_fd_sc_mcu7t5v0__nor2_4_16/ZN vdd vss gf180mcu_fd_sc_mcu7t5v0__aoi211_1
Xgf180mcu_fd_sc_mcu7t5v0__aoi211_1_73 gf180mcu_fd_sc_mcu7t5v0__nor2_1_327/ZN gf180mcu_fd_sc_mcu7t5v0__or2_1_23/A1
+ vdd vss gf180mcu_fd_sc_mcu7t5v0__dffq_1_420/D gf180mcu_fd_sc_mcu7t5v0__inv_4_3/ZN
+ gf180mcu_fd_sc_mcu7t5v0__nor2_4_24/ZN vdd vss gf180mcu_fd_sc_mcu7t5v0__aoi211_1
Xgf180mcu_fd_sc_mcu7t5v0__aoi211_1_84 gf180mcu_fd_sc_mcu7t5v0__nor2_1_389/ZN gf180mcu_fd_sc_mcu7t5v0__nor2_2_54/ZN
+ vdd vss gf180mcu_fd_sc_mcu7t5v0__oai221_1_14/B2 gf180mcu_fd_sc_mcu7t5v0__nor2_2_57/ZN
+ gf180mcu_fd_sc_mcu7t5v0__xnor3_1_43/A1 vdd vss gf180mcu_fd_sc_mcu7t5v0__aoi211_1
Xgf180mcu_fd_sc_mcu7t5v0__oai211_4_1 gf180mcu_fd_sc_mcu7t5v0__oai211_4_1/B gf180mcu_fd_sc_mcu7t5v0__or4_1_0/A1
+ vdd vss gf180mcu_fd_sc_mcu7t5v0__and2_1_22/A1 gf180mcu_fd_sc_mcu7t5v0__and2_2_5/Z
+ gf180mcu_fd_sc_mcu7t5v0__aoi21_4_0/ZN vdd vss gf180mcu_fd_sc_mcu7t5v0__oai211_4
Xgf180mcu_fd_sc_mcu7t5v0__mux2_4_1 gf180mcu_fd_sc_mcu7t5v0__or3_4_0/Z vdd vss gf180mcu_fd_sc_mcu7t5v0__inv_3_2/I
+ gf180mcu_fd_sc_mcu7t5v0__inv_2_7/I gf180mcu_fd_sc_mcu7t5v0__mux2_4_1/I1 vdd vss
+ gf180mcu_fd_sc_mcu7t5v0__mux2_4
Xgf180mcu_fd_sc_mcu7t5v0__aoi21_1_250 gf180mcu_fd_sc_mcu7t5v0__xnor2_1_47/A2 vdd vss
+ gf180mcu_fd_sc_mcu7t5v0__xor2_1_130/A2 gf180mcu_fd_sc_mcu7t5v0__oai31_1_16/B gf180mcu_fd_sc_mcu7t5v0__xnor2_1_47/A1
+ vdd vss gf180mcu_fd_sc_mcu7t5v0__aoi21_1
Xgf180mcu_fd_sc_mcu7t5v0__aoi21_1_261 gf180mcu_fd_sc_mcu7t5v0__aoi21_1_261/B vdd vss
+ gf180mcu_fd_sc_mcu7t5v0__dffq_2_99/D gf180mcu_fd_sc_mcu7t5v0__inv_2_9/ZN gf180mcu_fd_sc_mcu7t5v0__buf_20_0/Z
+ vdd vss gf180mcu_fd_sc_mcu7t5v0__aoi21_1
Xgf180mcu_fd_sc_mcu7t5v0__aoi21_1_272 gf180mcu_fd_sc_mcu7t5v0__and2_1_116/Z vdd vss
+ gf180mcu_fd_sc_mcu7t5v0__xor3_1_110/A2 gf180mcu_fd_sc_mcu7t5v0__xor3_1_111/A2 gf180mcu_fd_sc_mcu7t5v0__or2_1_41/Z
+ vdd vss gf180mcu_fd_sc_mcu7t5v0__aoi21_1
Xgf180mcu_fd_sc_mcu7t5v0__aoi21_1_283 gf180mcu_fd_sc_mcu7t5v0__aoi21_1_283/B vdd vss
+ gf180mcu_fd_sc_mcu7t5v0__dffq_1_437/D gf180mcu_fd_sc_mcu7t5v0__inv_1_22/ZN gf180mcu_fd_sc_mcu7t5v0__buf_20_0/I
+ vdd vss gf180mcu_fd_sc_mcu7t5v0__aoi21_1
Xgf180mcu_fd_sc_mcu7t5v0__aoi21_1_294 gf180mcu_fd_sc_mcu7t5v0__aoi21_1_294/B vdd vss
+ gf180mcu_fd_sc_mcu7t5v0__dffq_4_31/D gf180mcu_fd_sc_mcu7t5v0__inv_1_20/ZN gf180mcu_fd_sc_mcu7t5v0__buf_20_0/I
+ vdd vss gf180mcu_fd_sc_mcu7t5v0__aoi21_1
Xgf180mcu_fd_sc_mcu7t5v0__aoi22_2_9 gf180mcu_fd_sc_mcu7t5v0__nor2_2_45/ZN gf180mcu_fd_sc_mcu7t5v0__mux4_4_16/I0
+ vdd vss gf180mcu_fd_sc_mcu7t5v0__aoi22_2_9/ZN gf180mcu_fd_sc_mcu7t5v0__mux4_4_7/I1
+ gf180mcu_fd_sc_mcu7t5v0__nor2_4_40/ZN vdd vss gf180mcu_fd_sc_mcu7t5v0__aoi22_2
Xgf180mcu_fd_sc_mcu7t5v0__oai21_1_50 vdd gf180mcu_fd_sc_mcu7t5v0__or2_1_14/Z gf180mcu_fd_sc_mcu7t5v0__or3_1_4/A2
+ gf180mcu_fd_sc_mcu7t5v0__xor3_1_47/A3 gf180mcu_fd_sc_mcu7t5v0__or3_1_4/A1 vss vdd
+ vss gf180mcu_fd_sc_mcu7t5v0__oai21_1
Xgf180mcu_fd_sc_mcu7t5v0__oai21_4_4 gf180mcu_fd_sc_mcu7t5v0__oai21_4_4/B vdd vss gf180mcu_fd_sc_mcu7t5v0__inv_4_1/I
+ gf180mcu_fd_sc_mcu7t5v0__and2_2_4/A2 gf180mcu_fd_sc_mcu7t5v0__oai21_4_4/A2 vdd vss
+ gf180mcu_fd_sc_mcu7t5v0__oai21_4
Xgf180mcu_fd_sc_mcu7t5v0__oai22_1_204 gf180mcu_fd_sc_mcu7t5v0__nand2_4_32/ZN gf180mcu_fd_sc_mcu7t5v0__nand2_2_33/ZN
+ gf180mcu_fd_sc_mcu7t5v0__oai22_1_204/B2 vdd vss gf180mcu_fd_sc_mcu7t5v0__dffq_1_194/D
+ gf180mcu_fd_sc_mcu7t5v0__aoi21_4_1/ZN vdd vss gf180mcu_fd_sc_mcu7t5v0__oai22_1
Xgf180mcu_fd_sc_mcu7t5v0__oai21_1_61 vdd gf180mcu_fd_sc_mcu7t5v0__oai31_1_2/B gf180mcu_fd_sc_mcu7t5v0__or4_1_1/A2
+ gf180mcu_fd_sc_mcu7t5v0__xor2_1_49/A2 gf180mcu_fd_sc_mcu7t5v0__or4_1_1/A1 vss vdd
+ vss gf180mcu_fd_sc_mcu7t5v0__oai21_1
Xgf180mcu_fd_sc_mcu7t5v0__oai22_1_215 gf180mcu_fd_sc_mcu7t5v0__nand2_4_26/ZN gf180mcu_fd_sc_mcu7t5v0__nand2_2_38/ZN
+ gf180mcu_fd_sc_mcu7t5v0__oai22_1_215/B2 vdd vss gf180mcu_fd_sc_mcu7t5v0__dffq_1_206/D
+ gf180mcu_fd_sc_mcu7t5v0__oai21_4_9/ZN vdd vss gf180mcu_fd_sc_mcu7t5v0__oai22_1
Xgf180mcu_fd_sc_mcu7t5v0__oai21_1_72 vdd gf180mcu_fd_sc_mcu7t5v0__oai21_1_72/B gf180mcu_fd_sc_mcu7t5v0__oai21_1_72/A2
+ gf180mcu_fd_sc_mcu7t5v0__oai21_1_71/B gf180mcu_fd_sc_mcu7t5v0__mux2_1_2/I0 vss vdd
+ vss gf180mcu_fd_sc_mcu7t5v0__oai21_1
Xgf180mcu_fd_sc_mcu7t5v0__oai21_1_83 vdd gf180mcu_fd_sc_mcu7t5v0__oai21_1_83/B gf180mcu_fd_sc_mcu7t5v0__oai21_1_83/A2
+ gf180mcu_fd_sc_mcu7t5v0__xnor2_1_26/A1 gf180mcu_fd_sc_mcu7t5v0__xor3_1_65/A2 vss
+ vdd vss gf180mcu_fd_sc_mcu7t5v0__oai21_1
Xgf180mcu_fd_sc_mcu7t5v0__oai21_1_94 vdd gf180mcu_fd_sc_mcu7t5v0__buf_8_5/I gf180mcu_fd_sc_mcu7t5v0__oai21_1_94/A2
+ gf180mcu_fd_sc_mcu7t5v0__oai21_1_94/ZN gf180mcu_fd_sc_mcu7t5v0__mux2_4_1/I1 vss
+ vdd vss gf180mcu_fd_sc_mcu7t5v0__oai21_1
Xgf180mcu_fd_sc_mcu7t5v0__oai22_1_226 gf180mcu_fd_sc_mcu7t5v0__nand2_4_29/ZN gf180mcu_fd_sc_mcu7t5v0__nand2_2_39/ZN
+ gf180mcu_fd_sc_mcu7t5v0__oai22_1_226/B2 vdd vss gf180mcu_fd_sc_mcu7t5v0__dffq_1_210/D
+ gf180mcu_fd_sc_mcu7t5v0__aoi21_4_4/ZN vdd vss gf180mcu_fd_sc_mcu7t5v0__oai22_1
Xgf180mcu_fd_sc_mcu7t5v0__oai22_1_237 gf180mcu_fd_sc_mcu7t5v0__nand2_4_29/ZN gf180mcu_fd_sc_mcu7t5v0__nand2_2_39/ZN
+ gf180mcu_fd_sc_mcu7t5v0__oai22_1_237/B2 vdd vss gf180mcu_fd_sc_mcu7t5v0__dffq_1_226/D
+ gf180mcu_fd_sc_mcu7t5v0__oai21_4_9/ZN vdd vss gf180mcu_fd_sc_mcu7t5v0__oai22_1
Xgf180mcu_fd_sc_mcu7t5v0__oai22_1_248 gf180mcu_fd_sc_mcu7t5v0__nand2_4_28/ZN gf180mcu_fd_sc_mcu7t5v0__nand2_2_44/ZN
+ gf180mcu_fd_sc_mcu7t5v0__oai22_1_248/B2 vdd vss gf180mcu_fd_sc_mcu7t5v0__dffq_1_240/D
+ gf180mcu_fd_sc_mcu7t5v0__aoi21_4_2/ZN vdd vss gf180mcu_fd_sc_mcu7t5v0__oai22_1
Xgf180mcu_fd_sc_mcu7t5v0__oai22_1_259 gf180mcu_fd_sc_mcu7t5v0__oai22_1_90/A2 gf180mcu_fd_sc_mcu7t5v0__oai22_1_90/B1
+ gf180mcu_fd_sc_mcu7t5v0__oai22_1_259/B2 vdd vss gf180mcu_fd_sc_mcu7t5v0__dffq_1_265/D
+ gf180mcu_fd_sc_mcu7t5v0__aoi21_4_5/ZN vdd vss gf180mcu_fd_sc_mcu7t5v0__oai22_1
Xgf180mcu_fd_sc_mcu7t5v0__or2_4_0 vdd vss gf180mcu_fd_sc_mcu7t5v0__or2_4_0/Z gf180mcu_fd_sc_mcu7t5v0__or2_4_0/A1
+ gf180mcu_fd_sc_mcu7t5v0__or2_4_0/A2 vdd vss gf180mcu_fd_sc_mcu7t5v0__or2_4
Xgf180mcu_fd_sc_mcu7t5v0__dffq_1_102 vdd gf180mcu_fd_sc_mcu7t5v0__dffq_1_102/Q gf180mcu_fd_sc_mcu7t5v0__dffq_1_96/CLK
+ vss gf180mcu_fd_sc_mcu7t5v0__dffq_1_102/D vdd vss gf180mcu_fd_sc_mcu7t5v0__dffq_1
Xgf180mcu_fd_sc_mcu7t5v0__dffq_1_113 vdd gf180mcu_fd_sc_mcu7t5v0__dffq_1_113/Q gf180mcu_fd_sc_mcu7t5v0__dffq_2_26/CLK
+ vss gf180mcu_fd_sc_mcu7t5v0__dffq_1_113/D vdd vss gf180mcu_fd_sc_mcu7t5v0__dffq_1
Xgf180mcu_fd_sc_mcu7t5v0__nor2_1_302 vdd vss gf180mcu_fd_sc_mcu7t5v0__nor2_1_302/ZN
+ gf180mcu_fd_sc_mcu7t5v0__dffq_1_418/Q gf180mcu_fd_sc_mcu7t5v0__nor2_4_18/ZN vdd
+ vss gf180mcu_fd_sc_mcu7t5v0__nor2_1
Xgf180mcu_fd_sc_mcu7t5v0__dffq_1_124 vdd gf180mcu_fd_sc_mcu7t5v0__dffq_1_124/Q gf180mcu_fd_sc_mcu7t5v0__dffq_1_96/CLK
+ vss gf180mcu_fd_sc_mcu7t5v0__dffq_1_124/D vdd vss gf180mcu_fd_sc_mcu7t5v0__dffq_1
Xgf180mcu_fd_sc_mcu7t5v0__dffq_1_135 vdd gf180mcu_fd_sc_mcu7t5v0__dffq_1_135/Q gf180mcu_fd_sc_mcu7t5v0__dffq_1_96/CLK
+ vss gf180mcu_fd_sc_mcu7t5v0__dffq_1_135/D vdd vss gf180mcu_fd_sc_mcu7t5v0__dffq_1
Xgf180mcu_fd_sc_mcu7t5v0__nor2_1_313 vdd vss gf180mcu_fd_sc_mcu7t5v0__nor2_1_313/ZN
+ gf180mcu_fd_sc_mcu7t5v0__and3_1_16/Z gf180mcu_fd_sc_mcu7t5v0__or3_1_28/A2 vdd vss
+ gf180mcu_fd_sc_mcu7t5v0__nor2_1
Xgf180mcu_fd_sc_mcu7t5v0__nor2_1_324 vdd vss gf180mcu_fd_sc_mcu7t5v0__or3_1_20/A1
+ gf180mcu_fd_sc_mcu7t5v0__xor2_1_157/A1 gf180mcu_fd_sc_mcu7t5v0__xor2_1_157/A2 vdd
+ vss gf180mcu_fd_sc_mcu7t5v0__nor2_1
Xgf180mcu_fd_sc_mcu7t5v0__dffq_1_146 vdd gf180mcu_fd_sc_mcu7t5v0__dffq_1_146/Q gf180mcu_fd_sc_mcu7t5v0__dffq_1_96/CLK
+ vss gf180mcu_fd_sc_mcu7t5v0__dffq_1_146/D vdd vss gf180mcu_fd_sc_mcu7t5v0__dffq_1
Xgf180mcu_fd_sc_mcu7t5v0__nor2_1_335 vdd vss gf180mcu_fd_sc_mcu7t5v0__oai21_1_277/B
+ gf180mcu_fd_sc_mcu7t5v0__or2_4_4/Z gf180mcu_fd_sc_mcu7t5v0__nor2_1_335/A2 vdd vss
+ gf180mcu_fd_sc_mcu7t5v0__nor2_1
Xgf180mcu_fd_sc_mcu7t5v0__dffq_1_157 vdd gf180mcu_fd_sc_mcu7t5v0__dffq_1_157/Q gf180mcu_fd_sc_mcu7t5v0__dffq_2_26/CLK
+ vss gf180mcu_fd_sc_mcu7t5v0__dffq_1_157/D vdd vss gf180mcu_fd_sc_mcu7t5v0__dffq_1
Xgf180mcu_fd_sc_mcu7t5v0__nor2_1_346 vdd vss gf180mcu_fd_sc_mcu7t5v0__xor3_1_116/A2
+ gf180mcu_fd_sc_mcu7t5v0__inv_8_2/ZN gf180mcu_fd_sc_mcu7t5v0__nor2_2_49/A2 vdd vss
+ gf180mcu_fd_sc_mcu7t5v0__nor2_1
Xgf180mcu_fd_sc_mcu7t5v0__dffq_1_168 vdd gf180mcu_fd_sc_mcu7t5v0__dffq_1_168/Q gf180mcu_fd_sc_mcu7t5v0__dffq_2_26/CLK
+ vss gf180mcu_fd_sc_mcu7t5v0__dffq_1_168/D vdd vss gf180mcu_fd_sc_mcu7t5v0__dffq_1
Xgf180mcu_fd_sc_mcu7t5v0__nor2_1_357 vdd vss gf180mcu_fd_sc_mcu7t5v0__nor2_1_357/ZN
+ gf180mcu_fd_sc_mcu7t5v0__and3_1_21/Z gf180mcu_fd_sc_mcu7t5v0__nor2_1_357/A2 vdd
+ vss gf180mcu_fd_sc_mcu7t5v0__nor2_1
Xgf180mcu_fd_sc_mcu7t5v0__dffq_1_179 vdd gf180mcu_fd_sc_mcu7t5v0__dffq_1_179/Q gf180mcu_fd_sc_mcu7t5v0__dffq_1_96/CLK
+ vss gf180mcu_fd_sc_mcu7t5v0__dffq_1_179/D vdd vss gf180mcu_fd_sc_mcu7t5v0__dffq_1
Xgf180mcu_fd_sc_mcu7t5v0__nor2_1_368 vdd vss gf180mcu_fd_sc_mcu7t5v0__nor2_1_379/A2
+ gf180mcu_fd_sc_mcu7t5v0__or2_1_49/A1 gf180mcu_fd_sc_mcu7t5v0__or2_1_49/A2 vdd vss
+ gf180mcu_fd_sc_mcu7t5v0__nor2_1
Xgf180mcu_fd_sc_mcu7t5v0__nor2_1_379 vdd vss gf180mcu_fd_sc_mcu7t5v0__nor2_1_379/ZN
+ gf180mcu_fd_sc_mcu7t5v0__xor3_1_138/A1 gf180mcu_fd_sc_mcu7t5v0__nor2_1_379/A2 vdd
+ vss gf180mcu_fd_sc_mcu7t5v0__nor2_1
Xgf180mcu_fd_sc_mcu7t5v0__nand2_1_550 vdd vss gf180mcu_fd_sc_mcu7t5v0__xor2_1_154/A1
+ gf180mcu_fd_sc_mcu7t5v0__nand2_1_707/ZN gf180mcu_fd_sc_mcu7t5v0__or2_1_57/Z vdd
+ vss gf180mcu_fd_sc_mcu7t5v0__nand2_1
Xgf180mcu_fd_sc_mcu7t5v0__nand2_1_561 vdd vss gf180mcu_fd_sc_mcu7t5v0__oai211_1_39/A2
+ gf180mcu_fd_sc_mcu7t5v0__nand2_1_636/ZN gf180mcu_fd_sc_mcu7t5v0__xnor2_1_56/A1 vdd
+ vss gf180mcu_fd_sc_mcu7t5v0__nand2_1
Xgf180mcu_fd_sc_mcu7t5v0__nand2_1_572 vdd vss gf180mcu_fd_sc_mcu7t5v0__xnor2_1_66/A2
+ gf180mcu_fd_sc_mcu7t5v0__xor2_1_192/A2 gf180mcu_fd_sc_mcu7t5v0__nand2_1_704/ZN vdd
+ vss gf180mcu_fd_sc_mcu7t5v0__nand2_1
Xgf180mcu_fd_sc_mcu7t5v0__nand2_1_583 vdd vss gf180mcu_fd_sc_mcu7t5v0__aoi21_2_21/A2
+ gf180mcu_fd_sc_mcu7t5v0__or2_1_46/A2 gf180mcu_fd_sc_mcu7t5v0__xnor3_1_38/A3 vdd
+ vss gf180mcu_fd_sc_mcu7t5v0__nand2_1
Xgf180mcu_fd_sc_mcu7t5v0__nand2_1_594 vdd vss gf180mcu_fd_sc_mcu7t5v0__xor3_1_128/A2
+ gf180mcu_fd_sc_mcu7t5v0__dffq_4_37/Q gf180mcu_fd_sc_mcu7t5v0__mux4_4_13/Z vdd vss
+ gf180mcu_fd_sc_mcu7t5v0__nand2_1
Xgf180mcu_fd_sc_mcu7t5v0__clkbuf_16_14 vdd vss gf180mcu_fd_sc_mcu7t5v0__clkbuf_16_8/I
+ gf180mcu_fd_sc_mcu7t5v0__clkbuf_16_7/Z vdd vss gf180mcu_fd_sc_mcu7t5v0__clkbuf_16
Xgf180mcu_fd_sc_mcu7t5v0__clkbuf_16_7 vdd vss gf180mcu_fd_sc_mcu7t5v0__clkbuf_16_7/Z
+ clk vdd vss gf180mcu_fd_sc_mcu7t5v0__clkbuf_16
Xgf180mcu_fd_sc_mcu7t5v0__clkinv_8_1 vdd vss gf180mcu_fd_sc_mcu7t5v0__nor2_1_144/A1
+ gf180mcu_fd_sc_mcu7t5v0__dffq_2_56/Q vdd vss gf180mcu_fd_sc_mcu7t5v0__clkinv_8
Xgf180mcu_fd_sc_mcu7t5v0__nand2_1_5 vdd vss gf180mcu_fd_sc_mcu7t5v0__nand2_1_5/ZN
+ gf180mcu_fd_sc_mcu7t5v0__xor2_1_8/A1 gf180mcu_fd_sc_mcu7t5v0__xor2_1_8/A2 vdd vss
+ gf180mcu_fd_sc_mcu7t5v0__nand2_1
Xgf180mcu_fd_sc_mcu7t5v0__mux4_4_11 gf180mcu_fd_sc_mcu7t5v0__dffq_2_70/Q vss vdd gf180mcu_fd_sc_mcu7t5v0__dffq_2_94/Q
+ gf180mcu_fd_sc_mcu7t5v0__inv_1_15/I gf180mcu_fd_sc_mcu7t5v0__inv_1_20/I gf180mcu_fd_sc_mcu7t5v0__mux4_4_2/I0
+ gf180mcu_fd_sc_mcu7t5v0__dffq_4_32/Q gf180mcu_fd_sc_mcu7t5v0__inv_1_23/I vdd vss
+ gf180mcu_fd_sc_mcu7t5v0__mux4_4
Xgf180mcu_fd_sc_mcu7t5v0__dffq_1_9 vdd gf180mcu_fd_sc_mcu7t5v0__dffq_1_9/Q gf180mcu_fd_sc_mcu7t5v0__dffq_4_6/CLK
+ vss gf180mcu_fd_sc_mcu7t5v0__dffq_1_9/D vdd vss gf180mcu_fd_sc_mcu7t5v0__dffq_1
Xgf180mcu_fd_sc_mcu7t5v0__oai21_2_1 gf180mcu_fd_sc_mcu7t5v0__nor3_2_1/ZN gf180mcu_fd_sc_mcu7t5v0__xor3_1_6/A2
+ gf180mcu_fd_sc_mcu7t5v0__xor3_1_7/A1 vss gf180mcu_fd_sc_mcu7t5v0__oai21_2_1/B vdd
+ vdd vss gf180mcu_fd_sc_mcu7t5v0__oai21_2
Xgf180mcu_fd_sc_mcu7t5v0__nor2_1_110 vdd vss gf180mcu_fd_sc_mcu7t5v0__nor2_1_110/ZN
+ gf180mcu_fd_sc_mcu7t5v0__dffq_1_242/Q gf180mcu_fd_sc_mcu7t5v0__nor2_4_19/ZN vdd
+ vss gf180mcu_fd_sc_mcu7t5v0__nor2_1
Xgf180mcu_fd_sc_mcu7t5v0__nor2_1_121 vdd vss gf180mcu_fd_sc_mcu7t5v0__aoi21_4_2/B
+ gf180mcu_fd_sc_mcu7t5v0__nor2_1_236/A1 gf180mcu_fd_sc_mcu7t5v0__or3_4_0/Z vdd vss
+ gf180mcu_fd_sc_mcu7t5v0__nor2_1
Xgf180mcu_fd_sc_mcu7t5v0__xor3_1_100 gf180mcu_fd_sc_mcu7t5v0__xor3_1_100/A3 vdd vss
+ gf180mcu_fd_sc_mcu7t5v0__xor3_1_100/Z gf180mcu_fd_sc_mcu7t5v0__xor3_1_100/A1 gf180mcu_fd_sc_mcu7t5v0__oai22_2_1/A2
+ vdd vss gf180mcu_fd_sc_mcu7t5v0__xor3_1
Xgf180mcu_fd_sc_mcu7t5v0__nor2_1_132 vdd vss gf180mcu_fd_sc_mcu7t5v0__nor2_1_132/ZN
+ gf180mcu_fd_sc_mcu7t5v0__dffq_1_279/Q gf180mcu_fd_sc_mcu7t5v0__nor2_4_17/ZN vdd
+ vss gf180mcu_fd_sc_mcu7t5v0__nor2_1
Xgf180mcu_fd_sc_mcu7t5v0__nor2_1_143 vdd vss gf180mcu_fd_sc_mcu7t5v0__nor2_1_143/ZN
+ gf180mcu_fd_sc_mcu7t5v0__dffq_1_288/Q gf180mcu_fd_sc_mcu7t5v0__nor2_4_22/ZN vdd
+ vss gf180mcu_fd_sc_mcu7t5v0__nor2_1
Xgf180mcu_fd_sc_mcu7t5v0__xor3_1_111 gf180mcu_fd_sc_mcu7t5v0__xor2_1_84/Z vdd vss
+ gf180mcu_fd_sc_mcu7t5v0__xor3_1_111/Z gf180mcu_fd_sc_mcu7t5v0__or2_1_41/A1 gf180mcu_fd_sc_mcu7t5v0__xor3_1_111/A2
+ vdd vss gf180mcu_fd_sc_mcu7t5v0__xor3_1
Xgf180mcu_fd_sc_mcu7t5v0__nor2_1_154 vdd vss gf180mcu_fd_sc_mcu7t5v0__nor2_1_154/ZN
+ gf180mcu_fd_sc_mcu7t5v0__or2_4_3/Z gf180mcu_fd_sc_mcu7t5v0__nor2_1_154/A2 vdd vss
+ gf180mcu_fd_sc_mcu7t5v0__nor2_1
Xgf180mcu_fd_sc_mcu7t5v0__xor3_1_122 gf180mcu_fd_sc_mcu7t5v0__xor3_1_122/A3 vdd vss
+ gf180mcu_fd_sc_mcu7t5v0__xor3_1_122/Z gf180mcu_fd_sc_mcu7t5v0__xor3_1_122/A1 gf180mcu_fd_sc_mcu7t5v0__xor2_1_166/Z
+ vdd vss gf180mcu_fd_sc_mcu7t5v0__xor3_1
Xgf180mcu_fd_sc_mcu7t5v0__nor2_1_165 vdd vss gf180mcu_fd_sc_mcu7t5v0__nor2_1_165/ZN
+ gf180mcu_fd_sc_mcu7t5v0__dffq_1_310/Q gf180mcu_fd_sc_mcu7t5v0__nor2_4_28/ZN vdd
+ vss gf180mcu_fd_sc_mcu7t5v0__nor2_1
Xgf180mcu_fd_sc_mcu7t5v0__clkinv_1_8 vdd vss gf180mcu_fd_sc_mcu7t5v0__mux4_2_1/I1
+ gf180mcu_fd_sc_mcu7t5v0__xor3_1_22/A1 vdd vss gf180mcu_fd_sc_mcu7t5v0__clkinv_1
Xgf180mcu_fd_sc_mcu7t5v0__xor3_1_133 gf180mcu_fd_sc_mcu7t5v0__xor3_1_133/A3 vdd vss
+ gf180mcu_fd_sc_mcu7t5v0__xor3_1_133/Z gf180mcu_fd_sc_mcu7t5v0__xor3_1_133/A1 gf180mcu_fd_sc_mcu7t5v0__or2_1_49/A2
+ vdd vss gf180mcu_fd_sc_mcu7t5v0__xor3_1
Xgf180mcu_fd_sc_mcu7t5v0__nor2_1_176 vdd vss gf180mcu_fd_sc_mcu7t5v0__dffq_1_385/D
+ gf180mcu_fd_sc_mcu7t5v0__nor2_1_176/A1 gf180mcu_fd_sc_mcu7t5v0__xor2_1_90/Z vdd
+ vss gf180mcu_fd_sc_mcu7t5v0__nor2_1
Xgf180mcu_fd_sc_mcu7t5v0__xor3_1_144 gf180mcu_fd_sc_mcu7t5v0__xor3_1_144/A3 vdd vss
+ gf180mcu_fd_sc_mcu7t5v0__xor3_1_144/Z gf180mcu_fd_sc_mcu7t5v0__xor3_1_144/A1 gf180mcu_fd_sc_mcu7t5v0__xor2_1_209/Z
+ vdd vss gf180mcu_fd_sc_mcu7t5v0__xor3_1
Xgf180mcu_fd_sc_mcu7t5v0__xor3_1_155 gf180mcu_fd_sc_mcu7t5v0__xor2_2_4/Z vdd vss gf180mcu_fd_sc_mcu7t5v0__xor3_1_155/Z
+ gf180mcu_fd_sc_mcu7t5v0__mux4_4_7/I1 gf180mcu_fd_sc_mcu7t5v0__xor3_1_155/A2 vdd
+ vss gf180mcu_fd_sc_mcu7t5v0__xor3_1
Xgf180mcu_fd_sc_mcu7t5v0__nor2_1_187 vdd vss gf180mcu_fd_sc_mcu7t5v0__dffq_1_350/D
+ gf180mcu_fd_sc_mcu7t5v0__and2_1_58/Z gf180mcu_fd_sc_mcu7t5v0__nor2_1_187/A2 vdd
+ vss gf180mcu_fd_sc_mcu7t5v0__nor2_1
Xgf180mcu_fd_sc_mcu7t5v0__nor2_1_198 vdd vss gf180mcu_fd_sc_mcu7t5v0__nor3_1_18/A3
+ gf180mcu_fd_sc_mcu7t5v0__or4_1_2/A1 gf180mcu_fd_sc_mcu7t5v0__and2_1_62/Z vdd vss
+ gf180mcu_fd_sc_mcu7t5v0__nor2_1
Xgf180mcu_fd_sc_mcu7t5v0__xor3_1_166 gf180mcu_fd_sc_mcu7t5v0__xor2_1_119/Z vdd vss
+ gf180mcu_fd_sc_mcu7t5v0__xor3_1_166/Z gf180mcu_fd_sc_mcu7t5v0__inv_8_0/ZN gf180mcu_fd_sc_mcu7t5v0__and2_1_153/Z
+ vdd vss gf180mcu_fd_sc_mcu7t5v0__xor3_1
Xgf180mcu_fd_sc_mcu7t5v0__xor3_1_177 gf180mcu_fd_sc_mcu7t5v0__xor3_1_177/A3 vdd vss
+ gf180mcu_fd_sc_mcu7t5v0__xor3_1_177/Z gf180mcu_fd_sc_mcu7t5v0__xor3_1_177/A1 gf180mcu_fd_sc_mcu7t5v0__oai32_1_4/A3
+ vdd vss gf180mcu_fd_sc_mcu7t5v0__xor3_1
Xgf180mcu_fd_sc_mcu7t5v0__oai211_1_15 gf180mcu_fd_sc_mcu7t5v0__nand4_1_5/ZN gf180mcu_fd_sc_mcu7t5v0__or2_1_34/A2
+ vdd vss gf180mcu_fd_sc_mcu7t5v0__aoi21_1_83/A2 gf180mcu_fd_sc_mcu7t5v0__nand3_4_7/ZN
+ gf180mcu_fd_sc_mcu7t5v0__and2_1_29/Z vdd vss gf180mcu_fd_sc_mcu7t5v0__oai211_1
Xgf180mcu_fd_sc_mcu7t5v0__oai211_1_26 gf180mcu_fd_sc_mcu7t5v0__oai211_1_26/B gf180mcu_fd_sc_mcu7t5v0__or2_1_34/A2
+ vdd vss gf180mcu_fd_sc_mcu7t5v0__oai211_1_26/ZN gf180mcu_fd_sc_mcu7t5v0__oai31_1_14/B
+ gf180mcu_fd_sc_mcu7t5v0__xor3_1_77/Z vdd vss gf180mcu_fd_sc_mcu7t5v0__oai211_1
Xgf180mcu_fd_sc_mcu7t5v0__nand3_4_13 gf180mcu_fd_sc_mcu7t5v0__nor2_2_22/A1 vdd vss
+ gf180mcu_fd_sc_mcu7t5v0__oai221_1_8/A1 gf180mcu_fd_sc_mcu7t5v0__dffq_2_42/Q gf180mcu_fd_sc_mcu7t5v0__inv_1_7/I
+ vdd vss gf180mcu_fd_sc_mcu7t5v0__nand3_4
Xgf180mcu_fd_sc_mcu7t5v0__oai211_1_37 gf180mcu_fd_sc_mcu7t5v0__oai211_1_37/B gf180mcu_fd_sc_mcu7t5v0__nand4_1_1/A1
+ vdd vss gf180mcu_fd_sc_mcu7t5v0__aoi221_1_49/C gf180mcu_fd_sc_mcu7t5v0__oai21_1_28/A1
+ gf180mcu_fd_sc_mcu7t5v0__xor3_1_173/A1 vdd vss gf180mcu_fd_sc_mcu7t5v0__oai211_1
Xgf180mcu_fd_sc_mcu7t5v0__oai211_1_48 gf180mcu_fd_sc_mcu7t5v0__oai211_1_48/B gf180mcu_fd_sc_mcu7t5v0__or2_1_34/A2
+ vdd vss gf180mcu_fd_sc_mcu7t5v0__oai211_1_48/ZN gf180mcu_fd_sc_mcu7t5v0__oai211_1_53/C
+ gf180mcu_fd_sc_mcu7t5v0__xor3_1_152/Z vdd vss gf180mcu_fd_sc_mcu7t5v0__oai211_1
Xgf180mcu_fd_sc_mcu7t5v0__nand2_1_380 vdd vss gf180mcu_fd_sc_mcu7t5v0__nand2_1_380/ZN
+ gf180mcu_fd_sc_mcu7t5v0__mux4_4_5/I0 gf180mcu_fd_sc_mcu7t5v0__or2_4_4/Z vdd vss
+ gf180mcu_fd_sc_mcu7t5v0__nand2_1
Xgf180mcu_fd_sc_mcu7t5v0__nand3_4_24 gf180mcu_fd_sc_mcu7t5v0__nor2_2_53/A1 vdd vss
+ gf180mcu_fd_sc_mcu7t5v0__nor2_1_389/A1 gf180mcu_fd_sc_mcu7t5v0__nor2_4_42/A1 gf180mcu_fd_sc_mcu7t5v0__dffq_2_93/Q
+ vdd vss gf180mcu_fd_sc_mcu7t5v0__nand3_4
Xgf180mcu_fd_sc_mcu7t5v0__nand2_1_391 vdd vss gf180mcu_fd_sc_mcu7t5v0__oai31_1_12/A3
+ gf180mcu_fd_sc_mcu7t5v0__oai221_1_8/A1 gf180mcu_fd_sc_mcu7t5v0__oai21_1_180/ZN vdd
+ vss gf180mcu_fd_sc_mcu7t5v0__nand2_1
Xgf180mcu_fd_sc_mcu7t5v0__oai21_1_203 vdd gf180mcu_fd_sc_mcu7t5v0__oai21_1_203/B gf180mcu_fd_sc_mcu7t5v0__nor2_1_294/ZN
+ gf180mcu_fd_sc_mcu7t5v0__xor3_1_106/A2 gf180mcu_fd_sc_mcu7t5v0__xor3_1_87/A2 vss
+ vdd vss gf180mcu_fd_sc_mcu7t5v0__oai21_1
Xgf180mcu_fd_sc_mcu7t5v0__oai21_1_214 vdd gf180mcu_fd_sc_mcu7t5v0__oai21_1_214/B gf180mcu_fd_sc_mcu7t5v0__oai21_1_214/A2
+ gf180mcu_fd_sc_mcu7t5v0__oai21_1_214/ZN gf180mcu_fd_sc_mcu7t5v0__and3_2_3/A2 vss
+ vdd vss gf180mcu_fd_sc_mcu7t5v0__oai21_1
Xgf180mcu_fd_sc_mcu7t5v0__oai21_1_225 vdd gf180mcu_fd_sc_mcu7t5v0__xor2_1_136/Z gf180mcu_fd_sc_mcu7t5v0__aoi21_2_9/ZN
+ gf180mcu_fd_sc_mcu7t5v0__and3_1_15/A2 gf180mcu_fd_sc_mcu7t5v0__nor2_1_279/A1 vss
+ vdd vss gf180mcu_fd_sc_mcu7t5v0__oai21_1
Xgf180mcu_fd_sc_mcu7t5v0__oai21_1_236 vdd gf180mcu_fd_sc_mcu7t5v0__buf_12_0/Z gf180mcu_fd_sc_mcu7t5v0__buf_20_0/Z
+ gf180mcu_fd_sc_mcu7t5v0__aoi21_1_263/B gf180mcu_fd_sc_mcu7t5v0__dffq_1_417/Q vss
+ vdd vss gf180mcu_fd_sc_mcu7t5v0__oai21_1
Xgf180mcu_fd_sc_mcu7t5v0__oai21_1_247 vdd gf180mcu_fd_sc_mcu7t5v0__oai21_1_247/B gf180mcu_fd_sc_mcu7t5v0__oai21_1_247/A2
+ gf180mcu_fd_sc_mcu7t5v0__oai211_1_40/B gf180mcu_fd_sc_mcu7t5v0__nor3_1_32/ZN vss
+ vdd vss gf180mcu_fd_sc_mcu7t5v0__oai21_1
Xgf180mcu_fd_sc_mcu7t5v0__oai21_1_258 vdd gf180mcu_fd_sc_mcu7t5v0__buf_8_4/Z gf180mcu_fd_sc_mcu7t5v0__buf_20_0/I
+ gf180mcu_fd_sc_mcu7t5v0__aoi21_1_289/B gf180mcu_fd_sc_mcu7t5v0__dffq_2_30/Q vss
+ vdd vss gf180mcu_fd_sc_mcu7t5v0__oai21_1
Xgf180mcu_fd_sc_mcu7t5v0__oai21_1_269 vdd gf180mcu_fd_sc_mcu7t5v0__buf_12_0/Z gf180mcu_fd_sc_mcu7t5v0__buf_20_0/Z
+ gf180mcu_fd_sc_mcu7t5v0__aoi21_1_312/B gf180mcu_fd_sc_mcu7t5v0__dffq_1_432/Q vss
+ vdd vss gf180mcu_fd_sc_mcu7t5v0__oai21_1
Xgf180mcu_fd_sc_mcu7t5v0__nand3_4_3 gf180mcu_fd_sc_mcu7t5v0__inv_2_0/ZN vdd vss gf180mcu_fd_sc_mcu7t5v0__and2_4_1/A1
+ gf180mcu_fd_sc_mcu7t5v0__inv_1_1/ZN gf180mcu_fd_sc_mcu7t5v0__dffq_4_4/Q vdd vss
+ gf180mcu_fd_sc_mcu7t5v0__nand3_4
Xgf180mcu_fd_sc_mcu7t5v0__clkinv_1_360 vdd vss gf180mcu_fd_sc_mcu7t5v0__xor2_1_195/A1
+ gf180mcu_fd_sc_mcu7t5v0__aoi21_2_23/A1 vdd vss gf180mcu_fd_sc_mcu7t5v0__clkinv_1
Xgf180mcu_fd_sc_mcu7t5v0__clkinv_3_10 vdd gf180mcu_fd_sc_mcu7t5v0__nor2_2_22/A1 gf180mcu_fd_sc_mcu7t5v0__dffq_2_40/Q
+ vss vdd vss gf180mcu_fd_sc_mcu7t5v0__clkinv_3
Xgf180mcu_fd_sc_mcu7t5v0__clkinv_3_21 vdd gf180mcu_fd_sc_mcu7t5v0__nor2_4_42/A1 gf180mcu_fd_sc_mcu7t5v0__nor2_2_54/A1
+ vss vdd vss gf180mcu_fd_sc_mcu7t5v0__clkinv_3
Xgf180mcu_fd_sc_mcu7t5v0__aoi221_1_4 gf180mcu_fd_sc_mcu7t5v0__nor2_2_15/ZN gf180mcu_fd_sc_mcu7t5v0__oai22_1_1/B2
+ vdd vss gf180mcu_fd_sc_mcu7t5v0__oai21_1_19/B gf180mcu_fd_sc_mcu7t5v0__inv_4_6/I
+ gf180mcu_fd_sc_mcu7t5v0__nor2_4_44/ZN gf180mcu_fd_sc_mcu7t5v0__oai21_1_19/A2 vdd
+ vss gf180mcu_fd_sc_mcu7t5v0__aoi221_1
Xgf180mcu_fd_sc_mcu7t5v0__nor2_1_6 vdd vss gf180mcu_fd_sc_mcu7t5v0__nor2_1_6/ZN gf180mcu_fd_sc_mcu7t5v0__nor2_1_6/A1
+ gf180mcu_fd_sc_mcu7t5v0__xor2_1_5/Z vdd vss gf180mcu_fd_sc_mcu7t5v0__nor2_1
Xgf180mcu_fd_sc_mcu7t5v0__nand3_2_0 gf180mcu_fd_sc_mcu7t5v0__and2_2_0/A2 vdd vss gf180mcu_fd_sc_mcu7t5v0__and2_1_3/A1
+ gf180mcu_fd_sc_mcu7t5v0__inv_8_1/I gf180mcu_fd_sc_mcu7t5v0__and2_2_0/A1 vdd vss
+ gf180mcu_fd_sc_mcu7t5v0__nand3_2
Xgf180mcu_fd_sc_mcu7t5v0__xor2_1_14 vdd vss gf180mcu_fd_sc_mcu7t5v0__xor2_1_14/Z gf180mcu_fd_sc_mcu7t5v0__or3_1_24/A1
+ gf180mcu_fd_sc_mcu7t5v0__xor2_1_41/Z vdd vss gf180mcu_fd_sc_mcu7t5v0__xor2_1
Xgf180mcu_fd_sc_mcu7t5v0__xor2_1_25 vdd vss gf180mcu_fd_sc_mcu7t5v0__xor2_1_25/Z gf180mcu_fd_sc_mcu7t5v0__mux4_4_1/Z
+ gf180mcu_fd_sc_mcu7t5v0__xor2_1_25/A2 vdd vss gf180mcu_fd_sc_mcu7t5v0__xor2_1
Xgf180mcu_fd_sc_mcu7t5v0__xor2_1_36 vdd vss gf180mcu_fd_sc_mcu7t5v0__xor2_1_36/Z gf180mcu_fd_sc_mcu7t5v0__inv_2_2/ZN
+ gf180mcu_fd_sc_mcu7t5v0__xor3_1_57/Z vdd vss gf180mcu_fd_sc_mcu7t5v0__xor2_1
Xgf180mcu_fd_sc_mcu7t5v0__xor2_1_47 vdd vss gf180mcu_fd_sc_mcu7t5v0__xor2_1_47/Z gf180mcu_fd_sc_mcu7t5v0__nor2_2_8/A2
+ gf180mcu_fd_sc_mcu7t5v0__xor2_1_47/A2 vdd vss gf180mcu_fd_sc_mcu7t5v0__xor2_1
Xgf180mcu_fd_sc_mcu7t5v0__xor2_1_110 vdd vss gf180mcu_fd_sc_mcu7t5v0__xor2_1_110/Z
+ gf180mcu_fd_sc_mcu7t5v0__or2_1_28/Z gf180mcu_fd_sc_mcu7t5v0__xor2_1_216/Z vdd vss
+ gf180mcu_fd_sc_mcu7t5v0__xor2_1
Xgf180mcu_fd_sc_mcu7t5v0__xor2_1_58 vdd vss gf180mcu_fd_sc_mcu7t5v0__xor2_1_58/Z gf180mcu_fd_sc_mcu7t5v0__xor2_1_58/A1
+ gf180mcu_fd_sc_mcu7t5v0__xor2_1_58/A2 vdd vss gf180mcu_fd_sc_mcu7t5v0__xor2_1
Xgf180mcu_fd_sc_mcu7t5v0__xor2_1_121 vdd vss gf180mcu_fd_sc_mcu7t5v0__xor2_1_121/Z
+ gf180mcu_fd_sc_mcu7t5v0__inv_8_2/ZN gf180mcu_fd_sc_mcu7t5v0__xor2_1_118/Z vdd vss
+ gf180mcu_fd_sc_mcu7t5v0__xor2_1
Xgf180mcu_fd_sc_mcu7t5v0__xor2_1_69 vdd vss gf180mcu_fd_sc_mcu7t5v0__xor2_1_69/Z gf180mcu_fd_sc_mcu7t5v0__or3_1_24/A1
+ gf180mcu_fd_sc_mcu7t5v0__xor2_1_70/Z vdd vss gf180mcu_fd_sc_mcu7t5v0__xor2_1
Xgf180mcu_fd_sc_mcu7t5v0__xor2_1_132 vdd vss gf180mcu_fd_sc_mcu7t5v0__aoi21_2_9/B
+ gf180mcu_fd_sc_mcu7t5v0__or3_1_24/A1 gf180mcu_fd_sc_mcu7t5v0__xor2_1_133/Z vdd vss
+ gf180mcu_fd_sc_mcu7t5v0__xor2_1
Xgf180mcu_fd_sc_mcu7t5v0__xor2_1_143 vdd vss gf180mcu_fd_sc_mcu7t5v0__xor2_1_143/Z
+ gf180mcu_fd_sc_mcu7t5v0__xor3_1_97/Z gf180mcu_fd_sc_mcu7t5v0__xor3_1_96/A3 vdd vss
+ gf180mcu_fd_sc_mcu7t5v0__xor2_1
Xgf180mcu_fd_sc_mcu7t5v0__xor2_1_154 vdd vss gf180mcu_fd_sc_mcu7t5v0__xor2_1_154/Z
+ gf180mcu_fd_sc_mcu7t5v0__xor2_1_154/A1 gf180mcu_fd_sc_mcu7t5v0__xor2_1_154/A2 vdd
+ vss gf180mcu_fd_sc_mcu7t5v0__xor2_1
Xgf180mcu_fd_sc_mcu7t5v0__xor2_1_165 vdd vss gf180mcu_fd_sc_mcu7t5v0__xor2_1_165/Z
+ gf180mcu_fd_sc_mcu7t5v0__xor2_1_165/A1 gf180mcu_fd_sc_mcu7t5v0__xor3_1_119/Z vdd
+ vss gf180mcu_fd_sc_mcu7t5v0__xor2_1
Xgf180mcu_fd_sc_mcu7t5v0__xor2_1_176 vdd vss gf180mcu_fd_sc_mcu7t5v0__or2_1_48/A2
+ gf180mcu_fd_sc_mcu7t5v0__xor3_1_132/Z gf180mcu_fd_sc_mcu7t5v0__xor2_1_179/Z vdd
+ vss gf180mcu_fd_sc_mcu7t5v0__xor2_1
Xgf180mcu_fd_sc_mcu7t5v0__xor2_1_187 vdd vss gf180mcu_fd_sc_mcu7t5v0__xor2_1_187/Z
+ gf180mcu_fd_sc_mcu7t5v0__dffq_2_102/Q gf180mcu_fd_sc_mcu7t5v0__xor2_1_193/Z vdd
+ vss gf180mcu_fd_sc_mcu7t5v0__xor2_1
Xgf180mcu_fd_sc_mcu7t5v0__xor2_1_198 vdd vss gf180mcu_fd_sc_mcu7t5v0__xor2_1_198/Z
+ gf180mcu_fd_sc_mcu7t5v0__and2_1_151/Z gf180mcu_fd_sc_mcu7t5v0__and2_1_146/Z vdd
+ vss gf180mcu_fd_sc_mcu7t5v0__xor2_1
Xgf180mcu_fd_sc_mcu7t5v0__clkinv_1_190 vdd vss gf180mcu_fd_sc_mcu7t5v0__dffq_1_190/Q
+ gf180mcu_fd_sc_mcu7t5v0__oai22_1_289/B2 vdd vss gf180mcu_fd_sc_mcu7t5v0__clkinv_1
Xgf180mcu_fd_sc_mcu7t5v0__nand3_1_14 gf180mcu_fd_sc_mcu7t5v0__nor2_2_6/A1 vdd vss
+ gf180mcu_fd_sc_mcu7t5v0__mux2_1_2/I1 gf180mcu_fd_sc_mcu7t5v0__dffq_4_3/Q gf180mcu_fd_sc_mcu7t5v0__inv_2_1/ZN
+ vdd vss gf180mcu_fd_sc_mcu7t5v0__nand3_1
Xgf180mcu_fd_sc_mcu7t5v0__nand3_1_25 gf180mcu_fd_sc_mcu7t5v0__xor2_1_45/Z vdd vss
+ gf180mcu_fd_sc_mcu7t5v0__nand3_1_25/ZN gf180mcu_fd_sc_mcu7t5v0__inv_2_3/I gf180mcu_fd_sc_mcu7t5v0__oai31_1_3/A1
+ vdd vss gf180mcu_fd_sc_mcu7t5v0__nand3_1
Xgf180mcu_fd_sc_mcu7t5v0__nand3_1_36 gf180mcu_fd_sc_mcu7t5v0__nand3_1_36/A3 vdd vss
+ gf180mcu_fd_sc_mcu7t5v0__and2_1_39/A2 gf180mcu_fd_sc_mcu7t5v0__nand3_1_36/A1 gf180mcu_fd_sc_mcu7t5v0__nand3_1_36/A2
+ vdd vss gf180mcu_fd_sc_mcu7t5v0__nand3_1
Xgf180mcu_fd_sc_mcu7t5v0__nand3_1_47 gf180mcu_fd_sc_mcu7t5v0__xor2_1_78/Z vdd vss
+ gf180mcu_fd_sc_mcu7t5v0__oai21_1_84/B gf180mcu_fd_sc_mcu7t5v0__xor3_1_67/Z gf180mcu_fd_sc_mcu7t5v0__xor2_1_79/Z
+ vdd vss gf180mcu_fd_sc_mcu7t5v0__nand3_1
Xgf180mcu_fd_sc_mcu7t5v0__nand3_1_58 gf180mcu_fd_sc_mcu7t5v0__and4_2_0/Z vdd vss gf180mcu_fd_sc_mcu7t5v0__nand3_1_58/ZN
+ gf180mcu_fd_sc_mcu7t5v0__buf_8_8/Z gf180mcu_fd_sc_mcu7t5v0__oai31_4_2/A3 vdd vss
+ gf180mcu_fd_sc_mcu7t5v0__nand3_1
Xgf180mcu_fd_sc_mcu7t5v0__nand3_1_69 gf180mcu_fd_sc_mcu7t5v0__oai31_1_16/B vdd vss
+ gf180mcu_fd_sc_mcu7t5v0__xor3_1_88/A3 gf180mcu_fd_sc_mcu7t5v0__and2_2_10/A1 gf180mcu_fd_sc_mcu7t5v0__oai22_4_3/ZN
+ vdd vss gf180mcu_fd_sc_mcu7t5v0__nand3_1
Xgf180mcu_fd_sc_mcu7t5v0__oai32_1_4 gf180mcu_fd_sc_mcu7t5v0__oai32_1_4/A3 gf180mcu_fd_sc_mcu7t5v0__oai32_1_4/B1
+ gf180mcu_fd_sc_mcu7t5v0__oai32_1_4/B2 vdd vss gf180mcu_fd_sc_mcu7t5v0__oai32_1_4/ZN
+ gf180mcu_fd_sc_mcu7t5v0__dffq_2_40/Q gf180mcu_fd_sc_mcu7t5v0__oai32_1_5/A2 vdd vss
+ gf180mcu_fd_sc_mcu7t5v0__oai32_1
Xgf180mcu_fd_sc_mcu7t5v0__aoi221_1_20 gf180mcu_fd_sc_mcu7t5v0__inv_4_3/I gf180mcu_fd_sc_mcu7t5v0__nor2_1_225/ZN
+ vdd vss gf180mcu_fd_sc_mcu7t5v0__nor2_1_173/A2 gf180mcu_fd_sc_mcu7t5v0__dffq_1_301/Q
+ gf180mcu_fd_sc_mcu7t5v0__or2_4_3/Z gf180mcu_fd_sc_mcu7t5v0__nor2_4_32/ZN vdd vss
+ gf180mcu_fd_sc_mcu7t5v0__aoi221_1
Xgf180mcu_fd_sc_mcu7t5v0__aoi221_1_31 gf180mcu_fd_sc_mcu7t5v0__oai31_1_9/A2 gf180mcu_fd_sc_mcu7t5v0__nor2_2_20/ZN
+ vdd vss gf180mcu_fd_sc_mcu7t5v0__aoi21_1_181/B gf180mcu_fd_sc_mcu7t5v0__inv_8_2/I
+ gf180mcu_fd_sc_mcu7t5v0__oai21_1_173/ZN gf180mcu_fd_sc_mcu7t5v0__or2_1_24/Z vdd
+ vss gf180mcu_fd_sc_mcu7t5v0__aoi221_1
Xgf180mcu_fd_sc_mcu7t5v0__aoi221_1_42 gf180mcu_fd_sc_mcu7t5v0__nor2_2_33/ZN gf180mcu_fd_sc_mcu7t5v0__aoi221_1_42/C
+ vdd vss gf180mcu_fd_sc_mcu7t5v0__oai21_1_219/B gf180mcu_fd_sc_mcu7t5v0__inv_8_0/I
+ gf180mcu_fd_sc_mcu7t5v0__nor2_2_37/ZN gf180mcu_fd_sc_mcu7t5v0__xor2_1_128/Z vdd
+ vss gf180mcu_fd_sc_mcu7t5v0__aoi221_1
Xgf180mcu_fd_sc_mcu7t5v0__aoi221_1_53 gf180mcu_fd_sc_mcu7t5v0__oai21_1_285/A2 gf180mcu_fd_sc_mcu7t5v0__nor2_2_46/ZN
+ vdd vss gf180mcu_fd_sc_mcu7t5v0__oai21_1_285/B gf180mcu_fd_sc_mcu7t5v0__inv_8_2/I
+ gf180mcu_fd_sc_mcu7t5v0__or4_1_3/A1 gf180mcu_fd_sc_mcu7t5v0__nor3_4_21/ZN vdd vss
+ gf180mcu_fd_sc_mcu7t5v0__aoi221_1
Xgf180mcu_fd_sc_mcu7t5v0__aoi221_1_64 gf180mcu_fd_sc_mcu7t5v0__nor2_2_15/ZN gf180mcu_fd_sc_mcu7t5v0__oai22_1_1/B2
+ vdd vss gf180mcu_fd_sc_mcu7t5v0__oai21_1_79/B gf180mcu_fd_sc_mcu7t5v0__inv_8_2/I
+ gf180mcu_fd_sc_mcu7t5v0__nor2_4_44/ZN gf180mcu_fd_sc_mcu7t5v0__oai21_1_79/A2 vdd
+ vss gf180mcu_fd_sc_mcu7t5v0__aoi221_1
Xgf180mcu_fd_sc_mcu7t5v0__nor3_4_4 gf180mcu_fd_sc_mcu7t5v0__inv_4_0/ZN vdd vss gf180mcu_fd_sc_mcu7t5v0__nor3_4_4/ZN
+ gf180mcu_fd_sc_mcu7t5v0__nor3_4_4/A1 gf180mcu_fd_sc_mcu7t5v0__inv_2_4/ZN vdd vss
+ gf180mcu_fd_sc_mcu7t5v0__nor3_4
Xgf180mcu_fd_sc_mcu7t5v0__xnor3_1_2 gf180mcu_fd_sc_mcu7t5v0__xor3_1_5/Z vdd vss gf180mcu_fd_sc_mcu7t5v0__aoi21_1_0/B
+ gf180mcu_fd_sc_mcu7t5v0__xor3_1_2/A1 gf180mcu_fd_sc_mcu7t5v0__xor3_1_2/A2 vdd vss
+ gf180mcu_fd_sc_mcu7t5v0__xnor3_1
Xgf180mcu_fd_sc_mcu7t5v0__or4_1_0 gf180mcu_fd_sc_mcu7t5v0__or4_1_0/A3 gf180mcu_fd_sc_mcu7t5v0__or4_1_0/A4
+ vdd vss gf180mcu_fd_sc_mcu7t5v0__or4_1_0/Z gf180mcu_fd_sc_mcu7t5v0__or4_1_0/A1 gf180mcu_fd_sc_mcu7t5v0__or4_1_0/A2
+ vdd vss gf180mcu_fd_sc_mcu7t5v0__or4_1
Xgf180mcu_fd_sc_mcu7t5v0__nand2_1_80 vdd vss gf180mcu_fd_sc_mcu7t5v0__oai211_1_7/B
+ gf180mcu_fd_sc_mcu7t5v0__nor3_4_17/ZN gf180mcu_fd_sc_mcu7t5v0__and2_1_13/Z vdd vss
+ gf180mcu_fd_sc_mcu7t5v0__nand2_1
Xgf180mcu_fd_sc_mcu7t5v0__nand2_1_91 vdd vss gf180mcu_fd_sc_mcu7t5v0__xnor2_1_7/A1
+ gf180mcu_fd_sc_mcu7t5v0__inv_4_6/I gf180mcu_fd_sc_mcu7t5v0__and2_4_2/Z vdd vss gf180mcu_fd_sc_mcu7t5v0__nand2_1
Xgf180mcu_fd_sc_mcu7t5v0__and3_1_18 gf180mcu_fd_sc_mcu7t5v0__inv_1_20/I vdd vss gf180mcu_fd_sc_mcu7t5v0__nor3_2_9/A1
+ gf180mcu_fd_sc_mcu7t5v0__or2_1_33/A1 gf180mcu_fd_sc_mcu7t5v0__aoi22_2_8/A2 vdd vss
+ gf180mcu_fd_sc_mcu7t5v0__and3_1
Xgf180mcu_fd_sc_mcu7t5v0__and2_1_5 vdd vss gf180mcu_fd_sc_mcu7t5v0__and2_1_5/Z gf180mcu_fd_sc_mcu7t5v0__and2_1_5/A1
+ gf180mcu_fd_sc_mcu7t5v0__and2_1_5/A2 vdd vss gf180mcu_fd_sc_mcu7t5v0__and2_1
Xgf180mcu_fd_sc_mcu7t5v0__nand2_1_209 vdd vss gf180mcu_fd_sc_mcu7t5v0__xor3_1_61/A1
+ gf180mcu_fd_sc_mcu7t5v0__nand2_1_5/ZN gf180mcu_fd_sc_mcu7t5v0__and3_1_0/A3 vdd vss
+ gf180mcu_fd_sc_mcu7t5v0__nand2_1
Xgf180mcu_fd_sc_mcu7t5v0__nor2_2_18 vdd vss gf180mcu_fd_sc_mcu7t5v0__xor2_1_89/A2
+ gf180mcu_fd_sc_mcu7t5v0__nor3_2_5/A1 gf180mcu_fd_sc_mcu7t5v0__inv_1_13/I vdd vss
+ gf180mcu_fd_sc_mcu7t5v0__nor2_2
Xgf180mcu_fd_sc_mcu7t5v0__nor2_2_29 vdd vss gf180mcu_fd_sc_mcu7t5v0__nor2_2_29/ZN
+ gf180mcu_fd_sc_mcu7t5v0__nor2_2_29/A1 gf180mcu_fd_sc_mcu7t5v0__inv_2_9/I vdd vss
+ gf180mcu_fd_sc_mcu7t5v0__nor2_2
Xgf180mcu_fd_sc_mcu7t5v0__nor3_2_1 gf180mcu_fd_sc_mcu7t5v0__nor3_2_1/A3 vdd vss gf180mcu_fd_sc_mcu7t5v0__nor3_2_1/ZN
+ gf180mcu_fd_sc_mcu7t5v0__xor3_1_7/A1 gf180mcu_fd_sc_mcu7t5v0__and2_1_3/Z vdd vss
+ gf180mcu_fd_sc_mcu7t5v0__nor3_2
Xgf180mcu_fd_sc_mcu7t5v0__dffq_1_306 vdd gf180mcu_fd_sc_mcu7t5v0__inv_1_8/I gf180mcu_fd_sc_mcu7t5v0__dffq_4_9/CLK
+ vss gf180mcu_fd_sc_mcu7t5v0__dffq_1_306/D vdd vss gf180mcu_fd_sc_mcu7t5v0__dffq_1
Xgf180mcu_fd_sc_mcu7t5v0__dffq_1_317 vdd gf180mcu_fd_sc_mcu7t5v0__dffq_1_317/Q gf180mcu_fd_sc_mcu7t5v0__dffq_4_9/CLK
+ vss gf180mcu_fd_sc_mcu7t5v0__dffq_1_317/D vdd vss gf180mcu_fd_sc_mcu7t5v0__dffq_1
Xgf180mcu_fd_sc_mcu7t5v0__dffq_1_328 vdd gf180mcu_fd_sc_mcu7t5v0__dffq_1_328/Q gf180mcu_fd_sc_mcu7t5v0__dffq_4_15/CLK
+ vss gf180mcu_fd_sc_mcu7t5v0__dffq_1_328/D vdd vss gf180mcu_fd_sc_mcu7t5v0__dffq_1
Xgf180mcu_fd_sc_mcu7t5v0__dffq_1_339 vdd gf180mcu_fd_sc_mcu7t5v0__nor4_1_0/A2 gf180mcu_fd_sc_mcu7t5v0__dffq_4_15/CLK
+ vss gf180mcu_fd_sc_mcu7t5v0__dffq_1_339/D vdd vss gf180mcu_fd_sc_mcu7t5v0__dffq_1
Xgf180mcu_fd_sc_mcu7t5v0__aoi21_4_2 gf180mcu_fd_sc_mcu7t5v0__or3_4_0/Z gf180mcu_fd_sc_mcu7t5v0__aoi21_4_2/B
+ vdd vss gf180mcu_fd_sc_mcu7t5v0__aoi21_4_2/ZN gf180mcu_fd_sc_mcu7t5v0__mux4_4_2/I0
+ vdd vss gf180mcu_fd_sc_mcu7t5v0__aoi21_4
Xgf180mcu_fd_sc_mcu7t5v0__oai22_1_18 gf180mcu_fd_sc_mcu7t5v0__nand2_4_4/ZN gf180mcu_fd_sc_mcu7t5v0__oai22_1_33/B1
+ gf180mcu_fd_sc_mcu7t5v0__oai22_1_18/B2 vdd vss gf180mcu_fd_sc_mcu7t5v0__dffq_1_20/D
+ gf180mcu_fd_sc_mcu7t5v0__oai21_4_9/ZN vdd vss gf180mcu_fd_sc_mcu7t5v0__oai22_1
Xgf180mcu_fd_sc_mcu7t5v0__oai22_1_29 gf180mcu_fd_sc_mcu7t5v0__nand2_4_2/ZN gf180mcu_fd_sc_mcu7t5v0__oai22_1_29/B1
+ gf180mcu_fd_sc_mcu7t5v0__oai22_1_29/B2 vdd vss gf180mcu_fd_sc_mcu7t5v0__dffq_1_35/D
+ gf180mcu_fd_sc_mcu7t5v0__aoi21_4_2/ZN vdd vss gf180mcu_fd_sc_mcu7t5v0__oai22_1
Xgf180mcu_fd_sc_mcu7t5v0__nand2_1_710 vdd vss gf180mcu_fd_sc_mcu7t5v0__xnor2_1_83/A1
+ gf180mcu_fd_sc_mcu7t5v0__inv_8_0/I gf180mcu_fd_sc_mcu7t5v0__mux4_4_19/Z vdd vss
+ gf180mcu_fd_sc_mcu7t5v0__nand2_1
Xgf180mcu_fd_sc_mcu7t5v0__nand2_1_721 vdd vss gf180mcu_fd_sc_mcu7t5v0__xor3_1_174/A3
+ gf180mcu_fd_sc_mcu7t5v0__oai31_1_1/B gf180mcu_fd_sc_mcu7t5v0__nand3_1_103/ZN vdd
+ vss gf180mcu_fd_sc_mcu7t5v0__nand2_1
Xgf180mcu_fd_sc_mcu7t5v0__and2_1_40 vdd vss gf180mcu_fd_sc_mcu7t5v0__dffq_2_27/D gf180mcu_fd_sc_mcu7t5v0__buf_8_5/I
+ gf180mcu_fd_sc_mcu7t5v0__and2_1_40/A2 vdd vss gf180mcu_fd_sc_mcu7t5v0__and2_1
Xgf180mcu_fd_sc_mcu7t5v0__and2_1_51 vdd vss gf180mcu_fd_sc_mcu7t5v0__dffq_2_57/D gf180mcu_fd_sc_mcu7t5v0__buf_8_5/I
+ gf180mcu_fd_sc_mcu7t5v0__and2_1_51/A2 vdd vss gf180mcu_fd_sc_mcu7t5v0__and2_1
Xgf180mcu_fd_sc_mcu7t5v0__and2_1_62 vdd vss gf180mcu_fd_sc_mcu7t5v0__and2_1_62/Z gf180mcu_fd_sc_mcu7t5v0__nor4_1_2/A2
+ gf180mcu_fd_sc_mcu7t5v0__and2_1_63/Z vdd vss gf180mcu_fd_sc_mcu7t5v0__and2_1
Xgf180mcu_fd_sc_mcu7t5v0__and2_1_73 vdd vss gf180mcu_fd_sc_mcu7t5v0__and2_1_73/Z gf180mcu_fd_sc_mcu7t5v0__buf_8_7/Z
+ gf180mcu_fd_sc_mcu7t5v0__nor4_4_2/A2 vdd vss gf180mcu_fd_sc_mcu7t5v0__and2_1
Xgf180mcu_fd_sc_mcu7t5v0__and2_1_84 vdd vss gf180mcu_fd_sc_mcu7t5v0__and2_1_84/Z gf180mcu_fd_sc_mcu7t5v0__or3_1_15/Z
+ gf180mcu_fd_sc_mcu7t5v0__and2_1_84/A2 vdd vss gf180mcu_fd_sc_mcu7t5v0__and2_1
Xgf180mcu_fd_sc_mcu7t5v0__and2_1_95 vdd vss gf180mcu_fd_sc_mcu7t5v0__or2_1_31/A2 gf180mcu_fd_sc_mcu7t5v0__and2_1_95/A1
+ gf180mcu_fd_sc_mcu7t5v0__xor2_1_122/Z vdd vss gf180mcu_fd_sc_mcu7t5v0__and2_1
Xgf180mcu_fd_sc_mcu7t5v0__aoi211_1_30 gf180mcu_fd_sc_mcu7t5v0__nor2_1_132/ZN gf180mcu_fd_sc_mcu7t5v0__or2_1_23/A1
+ vdd vss gf180mcu_fd_sc_mcu7t5v0__dffq_1_279/D gf180mcu_fd_sc_mcu7t5v0__nor2_1_411/A1
+ gf180mcu_fd_sc_mcu7t5v0__nor2_4_17/ZN vdd vss gf180mcu_fd_sc_mcu7t5v0__aoi211_1
Xgf180mcu_fd_sc_mcu7t5v0__aoi211_1_41 gf180mcu_fd_sc_mcu7t5v0__nor2_1_135/ZN gf180mcu_fd_sc_mcu7t5v0__or2_1_23/A1
+ vdd vss gf180mcu_fd_sc_mcu7t5v0__dffq_1_315/D gf180mcu_fd_sc_mcu7t5v0__nor2_1_236/A1
+ gf180mcu_fd_sc_mcu7t5v0__nor2_4_21/ZN vdd vss gf180mcu_fd_sc_mcu7t5v0__aoi211_1
Xgf180mcu_fd_sc_mcu7t5v0__aoi211_1_52 gf180mcu_fd_sc_mcu7t5v0__aoi211_4_0/ZN gf180mcu_fd_sc_mcu7t5v0__or2_1_23/A1
+ vdd vss gf180mcu_fd_sc_mcu7t5v0__dffq_1_368/D gf180mcu_fd_sc_mcu7t5v0__inv_1_9/ZN
+ gf180mcu_fd_sc_mcu7t5v0__aoi22_4_8/B2 vdd vss gf180mcu_fd_sc_mcu7t5v0__aoi211_1
Xgf180mcu_fd_sc_mcu7t5v0__aoi211_1_63 gf180mcu_fd_sc_mcu7t5v0__nor2_1_303/ZN gf180mcu_fd_sc_mcu7t5v0__or2_1_23/A1
+ vdd vss gf180mcu_fd_sc_mcu7t5v0__dffq_1_419/D gf180mcu_fd_sc_mcu7t5v0__inv_4_2/ZN
+ gf180mcu_fd_sc_mcu7t5v0__nor2_4_24/ZN vdd vss gf180mcu_fd_sc_mcu7t5v0__aoi211_1
Xgf180mcu_fd_sc_mcu7t5v0__aoi211_1_74 gf180mcu_fd_sc_mcu7t5v0__nor2_1_331/ZN gf180mcu_fd_sc_mcu7t5v0__or2_1_23/A1
+ vdd vss gf180mcu_fd_sc_mcu7t5v0__dffq_1_432/D gf180mcu_fd_sc_mcu7t5v0__nor2_1_144/A1
+ gf180mcu_fd_sc_mcu7t5v0__nor2_4_24/ZN vdd vss gf180mcu_fd_sc_mcu7t5v0__aoi211_1
Xgf180mcu_fd_sc_mcu7t5v0__aoi211_1_85 gf180mcu_fd_sc_mcu7t5v0__nor2_1_332/ZN gf180mcu_fd_sc_mcu7t5v0__or2_1_23/A1
+ vdd vss gf180mcu_fd_sc_mcu7t5v0__dffq_1_431/D gf180mcu_fd_sc_mcu7t5v0__nor2_1_411/A1
+ gf180mcu_fd_sc_mcu7t5v0__nor2_4_27/ZN vdd vss gf180mcu_fd_sc_mcu7t5v0__aoi211_1
Xgf180mcu_fd_sc_mcu7t5v0__oai211_4_2 gf180mcu_fd_sc_mcu7t5v0__inv_8_1/I gf180mcu_fd_sc_mcu7t5v0__or3_2_3/Z
+ vdd vss gf180mcu_fd_sc_mcu7t5v0__mux2_1_10/S gf180mcu_fd_sc_mcu7t5v0__oai21_4_8/A1
+ gf180mcu_fd_sc_mcu7t5v0__oai31_4_1/ZN vdd vss gf180mcu_fd_sc_mcu7t5v0__oai211_4
Xgf180mcu_fd_sc_mcu7t5v0__mux2_4_2 gf180mcu_fd_sc_mcu7t5v0__or3_4_0/Z vdd vss gf180mcu_fd_sc_mcu7t5v0__inv_3_1/I
+ gf180mcu_fd_sc_mcu7t5v0__nor4_4_0/A1 gf180mcu_fd_sc_mcu7t5v0__mux2_4_2/I1 vdd vss
+ gf180mcu_fd_sc_mcu7t5v0__mux2_4
Xgf180mcu_fd_sc_mcu7t5v0__aoi21_1_240 gf180mcu_fd_sc_mcu7t5v0__inv_8_2/ZN vdd vss
+ gf180mcu_fd_sc_mcu7t5v0__oai32_1_8/A2 gf180mcu_fd_sc_mcu7t5v0__oai32_1_6/A3 gf180mcu_fd_sc_mcu7t5v0__nand2_1_702/ZN
+ vdd vss gf180mcu_fd_sc_mcu7t5v0__aoi21_1
Xgf180mcu_fd_sc_mcu7t5v0__aoi21_1_251 gf180mcu_fd_sc_mcu7t5v0__nor2_2_32/ZN vdd vss
+ gf180mcu_fd_sc_mcu7t5v0__oai22_1_271/B2 gf180mcu_fd_sc_mcu7t5v0__mux2_1_9/I1 gf180mcu_fd_sc_mcu7t5v0__or3_1_18/A1
+ vdd vss gf180mcu_fd_sc_mcu7t5v0__aoi21_1
Xgf180mcu_fd_sc_mcu7t5v0__aoi21_1_262 gf180mcu_fd_sc_mcu7t5v0__aoi21_1_7/B vdd vss
+ gf180mcu_fd_sc_mcu7t5v0__dffq_2_108/D gf180mcu_fd_sc_mcu7t5v0__nand2_1_719/ZN gf180mcu_fd_sc_mcu7t5v0__oai211_1_57/ZN
+ vdd vss gf180mcu_fd_sc_mcu7t5v0__aoi21_1
Xgf180mcu_fd_sc_mcu7t5v0__aoi21_1_273 gf180mcu_fd_sc_mcu7t5v0__and2_1_154/Z vdd vss
+ gf180mcu_fd_sc_mcu7t5v0__xor3_1_23/A2 gf180mcu_fd_sc_mcu7t5v0__xor3_1_172/A2 gf180mcu_fd_sc_mcu7t5v0__or2_1_55/Z
+ vdd vss gf180mcu_fd_sc_mcu7t5v0__aoi21_1
Xgf180mcu_fd_sc_mcu7t5v0__aoi21_1_284 gf180mcu_fd_sc_mcu7t5v0__or2_1_23/A1 vdd vss
+ gf180mcu_fd_sc_mcu7t5v0__dffq_2_76/D gf180mcu_fd_sc_mcu7t5v0__nand2_1_551/ZN gf180mcu_fd_sc_mcu7t5v0__nand2_1_543/ZN
+ vdd vss gf180mcu_fd_sc_mcu7t5v0__aoi21_1
Xgf180mcu_fd_sc_mcu7t5v0__aoi21_1_295 gf180mcu_fd_sc_mcu7t5v0__aoi21_1_295/B vdd vss
+ gf180mcu_fd_sc_mcu7t5v0__dffq_4_32/D gf180mcu_fd_sc_mcu7t5v0__aoi22_2_8/A2 gf180mcu_fd_sc_mcu7t5v0__buf_20_0/I
+ vdd vss gf180mcu_fd_sc_mcu7t5v0__aoi21_1
Xgf180mcu_fd_sc_mcu7t5v0__oai21_4_5 gf180mcu_fd_sc_mcu7t5v0__oai21_4_5/B vdd vss gf180mcu_fd_sc_mcu7t5v0__oai21_4_5/A1
+ gf180mcu_fd_sc_mcu7t5v0__and4_1_0/A4 gf180mcu_fd_sc_mcu7t5v0__or2_4_0/Z vdd vss
+ gf180mcu_fd_sc_mcu7t5v0__oai21_4
Xgf180mcu_fd_sc_mcu7t5v0__oai21_1_40 vdd gf180mcu_fd_sc_mcu7t5v0__oai21_1_40/B gf180mcu_fd_sc_mcu7t5v0__xor2_1_19/A2
+ gf180mcu_fd_sc_mcu7t5v0__xor3_1_10/A1 gf180mcu_fd_sc_mcu7t5v0__xor2_1_19/A1 vss
+ vdd vss gf180mcu_fd_sc_mcu7t5v0__oai21_1
Xgf180mcu_fd_sc_mcu7t5v0__oai21_1_51 vdd gf180mcu_fd_sc_mcu7t5v0__oai21_1_51/B gf180mcu_fd_sc_mcu7t5v0__aoi22_4_1/ZN
+ gf180mcu_fd_sc_mcu7t5v0__oai221_1_0/C gf180mcu_fd_sc_mcu7t5v0__inv_8_2/I vss vdd
+ vss gf180mcu_fd_sc_mcu7t5v0__oai21_1
Xgf180mcu_fd_sc_mcu7t5v0__oai21_1_62 vdd gf180mcu_fd_sc_mcu7t5v0__oai21_1_62/B gf180mcu_fd_sc_mcu7t5v0__nor2_1_86/ZN
+ gf180mcu_fd_sc_mcu7t5v0__xor2_1_50/A1 gf180mcu_fd_sc_mcu7t5v0__xor3_1_51/A2 vss
+ vdd vss gf180mcu_fd_sc_mcu7t5v0__oai21_1
Xgf180mcu_fd_sc_mcu7t5v0__oai22_1_205 gf180mcu_fd_sc_mcu7t5v0__nand2_4_32/ZN gf180mcu_fd_sc_mcu7t5v0__nand2_2_33/ZN
+ gf180mcu_fd_sc_mcu7t5v0__oai22_1_205/B2 vdd vss gf180mcu_fd_sc_mcu7t5v0__dffq_1_196/D
+ gf180mcu_fd_sc_mcu7t5v0__aoi21_4_2/ZN vdd vss gf180mcu_fd_sc_mcu7t5v0__oai22_1
Xgf180mcu_fd_sc_mcu7t5v0__oai21_1_73 vdd gf180mcu_fd_sc_mcu7t5v0__oai31_1_4/B gf180mcu_fd_sc_mcu7t5v0__and2_2_0/Z
+ gf180mcu_fd_sc_mcu7t5v0__xor2_1_67/A2 gf180mcu_fd_sc_mcu7t5v0__and2_4_0/Z vss vdd
+ vss gf180mcu_fd_sc_mcu7t5v0__oai21_1
Xgf180mcu_fd_sc_mcu7t5v0__oai22_1_216 gf180mcu_fd_sc_mcu7t5v0__nand2_4_26/ZN gf180mcu_fd_sc_mcu7t5v0__nand2_2_38/ZN
+ gf180mcu_fd_sc_mcu7t5v0__oai22_1_216/B2 vdd vss gf180mcu_fd_sc_mcu7t5v0__dffq_1_276/D
+ gf180mcu_fd_sc_mcu7t5v0__aoi21_4_5/ZN vdd vss gf180mcu_fd_sc_mcu7t5v0__oai22_1
Xgf180mcu_fd_sc_mcu7t5v0__oai22_1_227 gf180mcu_fd_sc_mcu7t5v0__nand2_4_26/ZN gf180mcu_fd_sc_mcu7t5v0__nand2_2_38/ZN
+ gf180mcu_fd_sc_mcu7t5v0__oai22_1_227/B2 vdd vss gf180mcu_fd_sc_mcu7t5v0__dffq_1_221/D
+ gf180mcu_fd_sc_mcu7t5v0__oai22_1_88/A1 vdd vss gf180mcu_fd_sc_mcu7t5v0__oai22_1
Xgf180mcu_fd_sc_mcu7t5v0__oai21_1_84 vdd gf180mcu_fd_sc_mcu7t5v0__oai21_1_84/B gf180mcu_fd_sc_mcu7t5v0__oai21_1_84/A2
+ gf180mcu_fd_sc_mcu7t5v0__xor3_1_64/A2 gf180mcu_fd_sc_mcu7t5v0__xor3_1_66/A2 vss
+ vdd vss gf180mcu_fd_sc_mcu7t5v0__oai21_1
Xgf180mcu_fd_sc_mcu7t5v0__oai21_1_95 vdd gf180mcu_fd_sc_mcu7t5v0__buf_8_6/Z gf180mcu_fd_sc_mcu7t5v0__aoi22_4_8/ZN
+ gf180mcu_fd_sc_mcu7t5v0__oai21_1_95/ZN gf180mcu_fd_sc_mcu7t5v0__dffq_1_293/Q vss
+ vdd vss gf180mcu_fd_sc_mcu7t5v0__oai21_1
Xgf180mcu_fd_sc_mcu7t5v0__oai22_1_238 gf180mcu_fd_sc_mcu7t5v0__nand2_4_31/ZN gf180mcu_fd_sc_mcu7t5v0__nand2_2_42/ZN
+ gf180mcu_fd_sc_mcu7t5v0__oai22_1_238/B2 vdd vss gf180mcu_fd_sc_mcu7t5v0__dffq_1_228/D
+ gf180mcu_fd_sc_mcu7t5v0__aoi21_4_3/ZN vdd vss gf180mcu_fd_sc_mcu7t5v0__oai22_1
Xgf180mcu_fd_sc_mcu7t5v0__oai22_1_249 gf180mcu_fd_sc_mcu7t5v0__nand2_4_27/ZN gf180mcu_fd_sc_mcu7t5v0__nand2_2_43/ZN
+ gf180mcu_fd_sc_mcu7t5v0__oai22_1_249/B2 vdd vss gf180mcu_fd_sc_mcu7t5v0__dffq_1_237/D
+ gf180mcu_fd_sc_mcu7t5v0__aoi21_4_3/ZN vdd vss gf180mcu_fd_sc_mcu7t5v0__oai22_1
Xgf180mcu_fd_sc_mcu7t5v0__or2_4_1 vdd vss gf180mcu_fd_sc_mcu7t5v0__or2_4_1/Z gf180mcu_fd_sc_mcu7t5v0__or2_4_2/A1
+ gf180mcu_fd_sc_mcu7t5v0__or2_4_1/A2 vdd vss gf180mcu_fd_sc_mcu7t5v0__or2_4
Xgf180mcu_fd_sc_mcu7t5v0__dffq_1_103 vdd gf180mcu_fd_sc_mcu7t5v0__dffq_1_103/Q gf180mcu_fd_sc_mcu7t5v0__dffq_1_96/CLK
+ vss gf180mcu_fd_sc_mcu7t5v0__dffq_1_103/D vdd vss gf180mcu_fd_sc_mcu7t5v0__dffq_1
Xgf180mcu_fd_sc_mcu7t5v0__dffq_1_114 vdd gf180mcu_fd_sc_mcu7t5v0__dffq_1_114/Q gf180mcu_fd_sc_mcu7t5v0__dffq_1_96/CLK
+ vss gf180mcu_fd_sc_mcu7t5v0__dffq_1_114/D vdd vss gf180mcu_fd_sc_mcu7t5v0__dffq_1
Xgf180mcu_fd_sc_mcu7t5v0__nor2_1_303 vdd vss gf180mcu_fd_sc_mcu7t5v0__nor2_1_303/ZN
+ gf180mcu_fd_sc_mcu7t5v0__dffq_1_419/Q gf180mcu_fd_sc_mcu7t5v0__nor2_4_24/ZN vdd
+ vss gf180mcu_fd_sc_mcu7t5v0__nor2_1
Xgf180mcu_fd_sc_mcu7t5v0__dffq_1_125 vdd gf180mcu_fd_sc_mcu7t5v0__dffq_1_125/Q gf180mcu_fd_sc_mcu7t5v0__dffq_1_96/CLK
+ vss gf180mcu_fd_sc_mcu7t5v0__dffq_1_125/D vdd vss gf180mcu_fd_sc_mcu7t5v0__dffq_1
Xgf180mcu_fd_sc_mcu7t5v0__nor2_1_314 vdd vss gf180mcu_fd_sc_mcu7t5v0__nor2_1_314/ZN
+ gf180mcu_fd_sc_mcu7t5v0__or4_1_0/A1 gf180mcu_fd_sc_mcu7t5v0__mux4_4_3/Z vdd vss
+ gf180mcu_fd_sc_mcu7t5v0__nor2_1
Xgf180mcu_fd_sc_mcu7t5v0__dffq_1_136 vdd gf180mcu_fd_sc_mcu7t5v0__dffq_1_136/Q gf180mcu_fd_sc_mcu7t5v0__dffq_1_96/CLK
+ vss gf180mcu_fd_sc_mcu7t5v0__dffq_1_136/D vdd vss gf180mcu_fd_sc_mcu7t5v0__dffq_1
Xgf180mcu_fd_sc_mcu7t5v0__nor2_1_325 vdd vss gf180mcu_fd_sc_mcu7t5v0__dffq_1_434/D
+ gf180mcu_fd_sc_mcu7t5v0__aoi21_1_7/B gf180mcu_fd_sc_mcu7t5v0__nor2_1_325/A2 vdd
+ vss gf180mcu_fd_sc_mcu7t5v0__nor2_1
Xgf180mcu_fd_sc_mcu7t5v0__dffq_1_147 vdd gf180mcu_fd_sc_mcu7t5v0__dffq_1_147/Q gf180mcu_fd_sc_mcu7t5v0__dffq_2_26/CLK
+ vss gf180mcu_fd_sc_mcu7t5v0__dffq_1_147/D vdd vss gf180mcu_fd_sc_mcu7t5v0__dffq_1
Xgf180mcu_fd_sc_mcu7t5v0__dffq_1_158 vdd gf180mcu_fd_sc_mcu7t5v0__dffq_1_158/Q gf180mcu_fd_sc_mcu7t5v0__dffq_4_15/CLK
+ vss gf180mcu_fd_sc_mcu7t5v0__dffq_1_158/D vdd vss gf180mcu_fd_sc_mcu7t5v0__dffq_1
Xgf180mcu_fd_sc_mcu7t5v0__nor2_1_336 vdd vss gf180mcu_fd_sc_mcu7t5v0__dffq_2_84/D
+ gf180mcu_fd_sc_mcu7t5v0__nor2_1_336/A1 gf180mcu_fd_sc_mcu7t5v0__nor2_1_336/A2 vdd
+ vss gf180mcu_fd_sc_mcu7t5v0__nor2_1
Xgf180mcu_fd_sc_mcu7t5v0__nor2_1_347 vdd vss gf180mcu_fd_sc_mcu7t5v0__or2_1_45/A2
+ gf180mcu_fd_sc_mcu7t5v0__inv_8_0/ZN gf180mcu_fd_sc_mcu7t5v0__or2_1_24/A2 vdd vss
+ gf180mcu_fd_sc_mcu7t5v0__nor2_1
Xgf180mcu_fd_sc_mcu7t5v0__dffq_1_169 vdd gf180mcu_fd_sc_mcu7t5v0__dffq_1_169/Q gf180mcu_fd_sc_mcu7t5v0__dffq_2_26/CLK
+ vss gf180mcu_fd_sc_mcu7t5v0__dffq_1_169/D vdd vss gf180mcu_fd_sc_mcu7t5v0__dffq_1
Xgf180mcu_fd_sc_mcu7t5v0__nor2_1_358 vdd vss gf180mcu_fd_sc_mcu7t5v0__xnor3_1_42/A3
+ gf180mcu_fd_sc_mcu7t5v0__nor3_2_5/A1 gf180mcu_fd_sc_mcu7t5v0__oai32_2_1/ZN vdd vss
+ gf180mcu_fd_sc_mcu7t5v0__nor2_1
Xgf180mcu_fd_sc_mcu7t5v0__nor2_1_369 vdd vss gf180mcu_fd_sc_mcu7t5v0__nor2_1_380/A1
+ gf180mcu_fd_sc_mcu7t5v0__or2_1_49/A2 gf180mcu_fd_sc_mcu7t5v0__xor3_1_124/A2 vdd
+ vss gf180mcu_fd_sc_mcu7t5v0__nor2_1
Xgf180mcu_fd_sc_mcu7t5v0__nand2_1_540 vdd vss gf180mcu_fd_sc_mcu7t5v0__xor2_1_153/A1
+ gf180mcu_fd_sc_mcu7t5v0__mux4_4_6/I3 gf180mcu_fd_sc_mcu7t5v0__nor2_4_45/ZN vdd vss
+ gf180mcu_fd_sc_mcu7t5v0__nand2_1
Xgf180mcu_fd_sc_mcu7t5v0__nand2_1_551 vdd vss gf180mcu_fd_sc_mcu7t5v0__nand2_1_551/ZN
+ gf180mcu_fd_sc_mcu7t5v0__dffq_2_58/Q gf180mcu_fd_sc_mcu7t5v0__nor3_4_12/ZN vdd vss
+ gf180mcu_fd_sc_mcu7t5v0__nand2_1
Xgf180mcu_fd_sc_mcu7t5v0__nand2_1_562 vdd vss gf180mcu_fd_sc_mcu7t5v0__xnor3_1_35/A2
+ gf180mcu_fd_sc_mcu7t5v0__nand3_1_100/ZN gf180mcu_fd_sc_mcu7t5v0__nand3_1_99/ZN vdd
+ vss gf180mcu_fd_sc_mcu7t5v0__nand2_1
Xgf180mcu_fd_sc_mcu7t5v0__aoi21_2_20 gf180mcu_fd_sc_mcu7t5v0__aoi21_2_20/B vdd vss
+ gf180mcu_fd_sc_mcu7t5v0__xor3_1_125/A2 gf180mcu_fd_sc_mcu7t5v0__xor3_1_178/A2 gf180mcu_fd_sc_mcu7t5v0__aoi21_2_20/A2
+ vdd vss gf180mcu_fd_sc_mcu7t5v0__aoi21_2
Xgf180mcu_fd_sc_mcu7t5v0__nand2_1_573 vdd vss gf180mcu_fd_sc_mcu7t5v0__nand2_1_573/ZN
+ gf180mcu_fd_sc_mcu7t5v0__inv_1_21/I gf180mcu_fd_sc_mcu7t5v0__or2_4_4/Z vdd vss gf180mcu_fd_sc_mcu7t5v0__nand2_1
Xgf180mcu_fd_sc_mcu7t5v0__nand2_1_584 vdd vss gf180mcu_fd_sc_mcu7t5v0__xor3_1_117/A1
+ gf180mcu_fd_sc_mcu7t5v0__or2_1_7/A1 gf180mcu_fd_sc_mcu7t5v0__inv_1_13/ZN vdd vss
+ gf180mcu_fd_sc_mcu7t5v0__nand2_1
Xgf180mcu_fd_sc_mcu7t5v0__nand2_1_595 vdd vss gf180mcu_fd_sc_mcu7t5v0__xor3_1_124/A2
+ gf180mcu_fd_sc_mcu7t5v0__inv_8_0/I gf180mcu_fd_sc_mcu7t5v0__mux4_4_14/Z vdd vss
+ gf180mcu_fd_sc_mcu7t5v0__nand2_1
Xgf180mcu_fd_sc_mcu7t5v0__clkbuf_16_8 vdd vss gf180mcu_fd_sc_mcu7t5v0__dffq_4_9/CLK
+ gf180mcu_fd_sc_mcu7t5v0__clkbuf_16_8/I vdd vss gf180mcu_fd_sc_mcu7t5v0__clkbuf_16
Xgf180mcu_fd_sc_mcu7t5v0__clkinv_8_2 vdd vss gf180mcu_fd_sc_mcu7t5v0__nor2_1_411/A1
+ gf180mcu_fd_sc_mcu7t5v0__dffq_2_55/Q vdd vss gf180mcu_fd_sc_mcu7t5v0__clkinv_8
Xgf180mcu_fd_sc_mcu7t5v0__nand2_1_6 vdd vss gf180mcu_fd_sc_mcu7t5v0__oai21_1_74/B
+ gf180mcu_fd_sc_mcu7t5v0__and2_1_4/Z gf180mcu_fd_sc_mcu7t5v0__nor2_1_9/A2 vdd vss
+ gf180mcu_fd_sc_mcu7t5v0__nand2_1
Xgf180mcu_fd_sc_mcu7t5v0__mux4_4_12 gf180mcu_fd_sc_mcu7t5v0__mux4_4_16/I0 vss vdd
+ gf180mcu_fd_sc_mcu7t5v0__or2_1_53/A1 gf180mcu_fd_sc_mcu7t5v0__mux4_4_4/I1 gf180mcu_fd_sc_mcu7t5v0__inv_1_20/I
+ gf180mcu_fd_sc_mcu7t5v0__mux4_4_4/I0 gf180mcu_fd_sc_mcu7t5v0__dffq_4_32/Q gf180mcu_fd_sc_mcu7t5v0__mux4_4_12/Z
+ vdd vss gf180mcu_fd_sc_mcu7t5v0__mux4_4
Xgf180mcu_fd_sc_mcu7t5v0__and3_2_0 gf180mcu_fd_sc_mcu7t5v0__nor2_4_1/A2 vdd vss gf180mcu_fd_sc_mcu7t5v0__and3_2_0/Z
+ gf180mcu_fd_sc_mcu7t5v0__nor2_2_6/A2 gf180mcu_fd_sc_mcu7t5v0__mux2_1_2/I0 vdd vss
+ gf180mcu_fd_sc_mcu7t5v0__and3_2
Xgf180mcu_fd_sc_mcu7t5v0__oai21_2_2 gf180mcu_fd_sc_mcu7t5v0__oai21_2_2/A2 gf180mcu_fd_sc_mcu7t5v0__and3_1_1/A3
+ gf180mcu_fd_sc_mcu7t5v0__inv_2_0/I vss gf180mcu_fd_sc_mcu7t5v0__oai21_2_2/B vdd
+ vdd vss gf180mcu_fd_sc_mcu7t5v0__oai21_2
Xgf180mcu_fd_sc_mcu7t5v0__tiel_0 clk_PU vdd vss vdd vss gf180mcu_fd_sc_mcu7t5v0__tiel
Xgf180mcu_fd_sc_mcu7t5v0__nor2_1_100 vdd vss gf180mcu_fd_sc_mcu7t5v0__xor3_2_0/A2
+ gf180mcu_fd_sc_mcu7t5v0__xor2_1_21/A1 gf180mcu_fd_sc_mcu7t5v0__xor3_1_165/Z vdd
+ vss gf180mcu_fd_sc_mcu7t5v0__nor2_1
Xgf180mcu_fd_sc_mcu7t5v0__nor2_1_111 vdd vss gf180mcu_fd_sc_mcu7t5v0__nor2_1_111/ZN
+ gf180mcu_fd_sc_mcu7t5v0__or2_4_4/Z gf180mcu_fd_sc_mcu7t5v0__nor3_1_9/ZN vdd vss
+ gf180mcu_fd_sc_mcu7t5v0__nor2_1
Xgf180mcu_fd_sc_mcu7t5v0__nor2_1_122 vdd vss gf180mcu_fd_sc_mcu7t5v0__xor3_1_67/A2
+ gf180mcu_fd_sc_mcu7t5v0__inv_8_2/ZN gf180mcu_fd_sc_mcu7t5v0__or3_1_9/A2 vdd vss
+ gf180mcu_fd_sc_mcu7t5v0__nor2_1
Xgf180mcu_fd_sc_mcu7t5v0__nor2_1_133 vdd vss gf180mcu_fd_sc_mcu7t5v0__nor2_1_133/ZN
+ gf180mcu_fd_sc_mcu7t5v0__dffq_1_278/Q gf180mcu_fd_sc_mcu7t5v0__nor2_4_17/ZN vdd
+ vss gf180mcu_fd_sc_mcu7t5v0__nor2_1
Xgf180mcu_fd_sc_mcu7t5v0__xor3_1_101 gf180mcu_fd_sc_mcu7t5v0__xor3_1_101/A3 vdd vss
+ gf180mcu_fd_sc_mcu7t5v0__xor3_1_96/A3 gf180mcu_fd_sc_mcu7t5v0__or3_1_19/A1 gf180mcu_fd_sc_mcu7t5v0__oai22_2_1/A1
+ vdd vss gf180mcu_fd_sc_mcu7t5v0__xor3_1
Xgf180mcu_fd_sc_mcu7t5v0__nor2_1_144 vdd vss gf180mcu_fd_sc_mcu7t5v0__nor2_1_144/ZN
+ gf180mcu_fd_sc_mcu7t5v0__nor2_1_144/A1 gf180mcu_fd_sc_mcu7t5v0__inv_2_8/I vdd vss
+ gf180mcu_fd_sc_mcu7t5v0__nor2_1
Xgf180mcu_fd_sc_mcu7t5v0__xor3_1_112 gf180mcu_fd_sc_mcu7t5v0__or2_1_44/A2 vdd vss
+ gf180mcu_fd_sc_mcu7t5v0__xor3_1_112/Z gf180mcu_fd_sc_mcu7t5v0__inv_1_21/I gf180mcu_fd_sc_mcu7t5v0__xor3_1_112/A2
+ vdd vss gf180mcu_fd_sc_mcu7t5v0__xor3_1
Xgf180mcu_fd_sc_mcu7t5v0__xor3_1_123 gf180mcu_fd_sc_mcu7t5v0__xor3_1_123/A3 vdd vss
+ gf180mcu_fd_sc_mcu7t5v0__xor3_1_123/Z gf180mcu_fd_sc_mcu7t5v0__xor3_1_123/A1 gf180mcu_fd_sc_mcu7t5v0__xor3_1_123/A2
+ vdd vss gf180mcu_fd_sc_mcu7t5v0__xor3_1
Xgf180mcu_fd_sc_mcu7t5v0__nor2_1_155 vdd vss gf180mcu_fd_sc_mcu7t5v0__dffq_1_302/D
+ gf180mcu_fd_sc_mcu7t5v0__or2_1_23/A1 gf180mcu_fd_sc_mcu7t5v0__nor2_1_155/A2 vdd
+ vss gf180mcu_fd_sc_mcu7t5v0__nor2_1
Xgf180mcu_fd_sc_mcu7t5v0__clkinv_1_9 vdd vss gf180mcu_fd_sc_mcu7t5v0__xor2_1_34/Z
+ gf180mcu_fd_sc_mcu7t5v0__oai21_1_46/A2 vdd vss gf180mcu_fd_sc_mcu7t5v0__clkinv_1
Xgf180mcu_fd_sc_mcu7t5v0__nor2_1_166 vdd vss gf180mcu_fd_sc_mcu7t5v0__nor2_1_166/ZN
+ gf180mcu_fd_sc_mcu7t5v0__dffq_1_311/Q gf180mcu_fd_sc_mcu7t5v0__nor2_4_28/ZN vdd
+ vss gf180mcu_fd_sc_mcu7t5v0__nor2_1
Xgf180mcu_fd_sc_mcu7t5v0__xor3_1_134 gf180mcu_fd_sc_mcu7t5v0__xor3_1_135/Z vdd vss
+ gf180mcu_fd_sc_mcu7t5v0__xor3_1_134/Z gf180mcu_fd_sc_mcu7t5v0__xor3_1_134/A1 gf180mcu_fd_sc_mcu7t5v0__oai32_1_9/ZN
+ vdd vss gf180mcu_fd_sc_mcu7t5v0__xor3_1
Xgf180mcu_fd_sc_mcu7t5v0__nor2_1_177 vdd vss gf180mcu_fd_sc_mcu7t5v0__oai21_2_8/A2
+ gf180mcu_fd_sc_mcu7t5v0__or2_1_21/A1 gf180mcu_fd_sc_mcu7t5v0__or2_1_21/A2 vdd vss
+ gf180mcu_fd_sc_mcu7t5v0__nor2_1
Xgf180mcu_fd_sc_mcu7t5v0__xor3_1_145 gf180mcu_fd_sc_mcu7t5v0__xor3_1_146/Z vdd vss
+ gf180mcu_fd_sc_mcu7t5v0__xor3_1_145/Z gf180mcu_fd_sc_mcu7t5v0__xor3_1_145/A1 gf180mcu_fd_sc_mcu7t5v0__xor2_1_199/Z
+ vdd vss gf180mcu_fd_sc_mcu7t5v0__xor3_1
Xgf180mcu_fd_sc_mcu7t5v0__nor2_1_188 vdd vss gf180mcu_fd_sc_mcu7t5v0__dffq_1_348/D
+ gf180mcu_fd_sc_mcu7t5v0__oai31_2_0/ZN gf180mcu_fd_sc_mcu7t5v0__xor2_1_93/Z vdd vss
+ gf180mcu_fd_sc_mcu7t5v0__nor2_1
Xgf180mcu_fd_sc_mcu7t5v0__xor3_1_156 gf180mcu_fd_sc_mcu7t5v0__xor3_1_156/A3 vdd vss
+ gf180mcu_fd_sc_mcu7t5v0__xor3_1_156/Z gf180mcu_fd_sc_mcu7t5v0__xor3_1_156/A1 gf180mcu_fd_sc_mcu7t5v0__xor3_1_99/Z
+ vdd vss gf180mcu_fd_sc_mcu7t5v0__xor3_1
Xgf180mcu_fd_sc_mcu7t5v0__nor2_1_199 vdd vss gf180mcu_fd_sc_mcu7t5v0__dffq_1_361/D
+ gf180mcu_fd_sc_mcu7t5v0__and2_1_66/Z gf180mcu_fd_sc_mcu7t5v0__nor2_1_199/A2 vdd
+ vss gf180mcu_fd_sc_mcu7t5v0__nor2_1
Xgf180mcu_fd_sc_mcu7t5v0__xor3_1_167 gf180mcu_fd_sc_mcu7t5v0__oai31_2_1/ZN vdd vss
+ gf180mcu_fd_sc_mcu7t5v0__or2_1_15/A2 gf180mcu_fd_sc_mcu7t5v0__inv_8_1/I gf180mcu_fd_sc_mcu7t5v0__mux4_4_19/Z
+ vdd vss gf180mcu_fd_sc_mcu7t5v0__xor3_1
Xgf180mcu_fd_sc_mcu7t5v0__xor3_1_178 gf180mcu_fd_sc_mcu7t5v0__xor3_1_178/A3 vdd vss
+ gf180mcu_fd_sc_mcu7t5v0__xor3_1_178/Z gf180mcu_fd_sc_mcu7t5v0__or2_1_46/Z gf180mcu_fd_sc_mcu7t5v0__xor3_1_178/A2
+ vdd vss gf180mcu_fd_sc_mcu7t5v0__xor3_1
Xgf180mcu_fd_sc_mcu7t5v0__oai211_1_16 gf180mcu_fd_sc_mcu7t5v0__oai211_1_16/B gf180mcu_fd_sc_mcu7t5v0__oai211_1_16/C
+ vdd vss gf180mcu_fd_sc_mcu7t5v0__aoi211_1_20/B gf180mcu_fd_sc_mcu7t5v0__nor2_1_89/A1
+ gf180mcu_fd_sc_mcu7t5v0__xor3_1_54/A1 vdd vss gf180mcu_fd_sc_mcu7t5v0__oai211_1
Xgf180mcu_fd_sc_mcu7t5v0__oai211_1_27 gf180mcu_fd_sc_mcu7t5v0__oai211_1_27/B gf180mcu_fd_sc_mcu7t5v0__oai211_1_27/C
+ vdd vss gf180mcu_fd_sc_mcu7t5v0__oai211_1_26/B gf180mcu_fd_sc_mcu7t5v0__or2_1_31/A2
+ gf180mcu_fd_sc_mcu7t5v0__oai21_1_213/ZN vdd vss gf180mcu_fd_sc_mcu7t5v0__oai211_1
Xgf180mcu_fd_sc_mcu7t5v0__nand2_1_370 vdd vss gf180mcu_fd_sc_mcu7t5v0__oai31_1_21/B
+ gf180mcu_fd_sc_mcu7t5v0__dffq_2_40/Q gf180mcu_fd_sc_mcu7t5v0__and2_1_79/A2 vdd vss
+ gf180mcu_fd_sc_mcu7t5v0__nand2_1
Xgf180mcu_fd_sc_mcu7t5v0__oai211_1_38 gf180mcu_fd_sc_mcu7t5v0__and2_4_3/Z gf180mcu_fd_sc_mcu7t5v0__oai211_1_38/C
+ vdd vss gf180mcu_fd_sc_mcu7t5v0__oai211_1_38/ZN gf180mcu_fd_sc_mcu7t5v0__mux4_4_6/I0
+ gf180mcu_fd_sc_mcu7t5v0__or2_1_34/A2 vdd vss gf180mcu_fd_sc_mcu7t5v0__oai211_1
Xgf180mcu_fd_sc_mcu7t5v0__nand3_4_14 gf180mcu_fd_sc_mcu7t5v0__and2_2_9/A2 vdd vss
+ gf180mcu_fd_sc_mcu7t5v0__oai32_1_6/B1 gf180mcu_fd_sc_mcu7t5v0__inv_8_1/I gf180mcu_fd_sc_mcu7t5v0__and2_2_9/A1
+ vdd vss gf180mcu_fd_sc_mcu7t5v0__nand3_4
Xgf180mcu_fd_sc_mcu7t5v0__nand2_1_381 vdd vss gf180mcu_fd_sc_mcu7t5v0__nand2_1_387/A2
+ gf180mcu_fd_sc_mcu7t5v0__xor2_1_96/A1 gf180mcu_fd_sc_mcu7t5v0__xor2_1_97/Z vdd vss
+ gf180mcu_fd_sc_mcu7t5v0__nand2_1
Xgf180mcu_fd_sc_mcu7t5v0__oai211_1_49 gf180mcu_fd_sc_mcu7t5v0__oai211_1_49/B gf180mcu_fd_sc_mcu7t5v0__or2_1_34/A2
+ vdd vss gf180mcu_fd_sc_mcu7t5v0__oai211_1_49/ZN gf180mcu_fd_sc_mcu7t5v0__nor2_4_42/ZN
+ gf180mcu_fd_sc_mcu7t5v0__oai31_1_18/ZN vdd vss gf180mcu_fd_sc_mcu7t5v0__oai211_1
Xgf180mcu_fd_sc_mcu7t5v0__nand3_4_25 gf180mcu_fd_sc_mcu7t5v0__and2_4_2/A2 vdd vss
+ gf180mcu_fd_sc_mcu7t5v0__nor3_4_1/A3 gf180mcu_fd_sc_mcu7t5v0__inv_8_0/I gf180mcu_fd_sc_mcu7t5v0__or3_2_2/Z
+ vdd vss gf180mcu_fd_sc_mcu7t5v0__nand3_4
Xgf180mcu_fd_sc_mcu7t5v0__nand2_1_392 vdd vss gf180mcu_fd_sc_mcu7t5v0__nand2_1_392/ZN
+ gf180mcu_fd_sc_mcu7t5v0__oai221_1_8/A1 gf180mcu_fd_sc_mcu7t5v0__nand2_1_392/A2 vdd
+ vss gf180mcu_fd_sc_mcu7t5v0__nand2_1
Xgf180mcu_fd_sc_mcu7t5v0__oai21_1_204 vdd gf180mcu_fd_sc_mcu7t5v0__oai21_1_204/B gf180mcu_fd_sc_mcu7t5v0__nor2_1_253/ZN
+ gf180mcu_fd_sc_mcu7t5v0__xor3_1_80/A2 gf180mcu_fd_sc_mcu7t5v0__xor3_1_79/A2 vss
+ vdd vss gf180mcu_fd_sc_mcu7t5v0__oai21_1
Xgf180mcu_fd_sc_mcu7t5v0__oai21_1_215 vdd gf180mcu_fd_sc_mcu7t5v0__and2_2_12/Z gf180mcu_fd_sc_mcu7t5v0__nor2_4_33/ZN
+ gf180mcu_fd_sc_mcu7t5v0__oai211_1_30/B gf180mcu_fd_sc_mcu7t5v0__mux2_1_8/I0 vss
+ vdd vss gf180mcu_fd_sc_mcu7t5v0__oai21_1
Xgf180mcu_fd_sc_mcu7t5v0__oai21_1_226 vdd gf180mcu_fd_sc_mcu7t5v0__oai21_1_226/B gf180mcu_fd_sc_mcu7t5v0__nor2_1_274/ZN
+ gf180mcu_fd_sc_mcu7t5v0__xor3_1_157/A2 gf180mcu_fd_sc_mcu7t5v0__and2_1_122/Z vss
+ vdd vss gf180mcu_fd_sc_mcu7t5v0__oai21_1
Xgf180mcu_fd_sc_mcu7t5v0__oai21_1_237 vdd gf180mcu_fd_sc_mcu7t5v0__buf_12_0/Z gf180mcu_fd_sc_mcu7t5v0__buf_20_0/Z
+ gf180mcu_fd_sc_mcu7t5v0__aoi21_1_267/B gf180mcu_fd_sc_mcu7t5v0__mux4_2_1/I3 vss
+ vdd vss gf180mcu_fd_sc_mcu7t5v0__oai21_1
Xgf180mcu_fd_sc_mcu7t5v0__oai21_1_248 vdd gf180mcu_fd_sc_mcu7t5v0__buf_8_4/Z gf180mcu_fd_sc_mcu7t5v0__buf_20_0/Z
+ gf180mcu_fd_sc_mcu7t5v0__aoi21_1_276/B gf180mcu_fd_sc_mcu7t5v0__dffq_1_445/Q vss
+ vdd vss gf180mcu_fd_sc_mcu7t5v0__oai21_1
Xgf180mcu_fd_sc_mcu7t5v0__oai21_1_259 vdd gf180mcu_fd_sc_mcu7t5v0__buf_8_4/Z gf180mcu_fd_sc_mcu7t5v0__buf_20_0/I
+ gf180mcu_fd_sc_mcu7t5v0__aoi21_1_293/B gf180mcu_fd_sc_mcu7t5v0__dffq_2_25/Q vss
+ vdd vss gf180mcu_fd_sc_mcu7t5v0__oai21_1
Xgf180mcu_fd_sc_mcu7t5v0__nand3_4_4 gf180mcu_fd_sc_mcu7t5v0__inv_4_1/ZN vdd vss gf180mcu_fd_sc_mcu7t5v0__and2_2_0/A1
+ gf180mcu_fd_sc_mcu7t5v0__inv_2_5/ZN gf180mcu_fd_sc_mcu7t5v0__inv_3_0/I vdd vss gf180mcu_fd_sc_mcu7t5v0__nand3_4
Xgf180mcu_fd_sc_mcu7t5v0__clkinv_1_350 vdd vss gf180mcu_fd_sc_mcu7t5v0__or3_1_24/A2
+ gf180mcu_fd_sc_mcu7t5v0__nand3_1_91/A3 vdd vss gf180mcu_fd_sc_mcu7t5v0__clkinv_1
Xgf180mcu_fd_sc_mcu7t5v0__clkinv_1_361 vdd vss gf180mcu_fd_sc_mcu7t5v0__dffq_1_170/Q
+ gf180mcu_fd_sc_mcu7t5v0__oai22_1_286/B2 vdd vss gf180mcu_fd_sc_mcu7t5v0__clkinv_1
Xgf180mcu_fd_sc_mcu7t5v0__clkinv_3_11 vdd gf180mcu_fd_sc_mcu7t5v0__nor3_4_15/A2 gf180mcu_fd_sc_mcu7t5v0__dffq_1_375/Q
+ vss vdd vss gf180mcu_fd_sc_mcu7t5v0__clkinv_3
Xgf180mcu_fd_sc_mcu7t5v0__clkinv_3_22 vdd gf180mcu_fd_sc_mcu7t5v0__nor2_4_37/A1 gf180mcu_fd_sc_mcu7t5v0__nor3_4_18/A2
+ vss vdd vss gf180mcu_fd_sc_mcu7t5v0__clkinv_3
Xgf180mcu_fd_sc_mcu7t5v0__aoi221_1_5 gf180mcu_fd_sc_mcu7t5v0__oai21_1_28/A2 gf180mcu_fd_sc_mcu7t5v0__nor2_2_44/ZN
+ vdd vss gf180mcu_fd_sc_mcu7t5v0__oai21_1_28/B gf180mcu_fd_sc_mcu7t5v0__inv_4_6/I
+ gf180mcu_fd_sc_mcu7t5v0__nor2_4_37/ZN gf180mcu_fd_sc_mcu7t5v0__nor3_4_17/ZN vdd
+ vss gf180mcu_fd_sc_mcu7t5v0__aoi221_1
Xgf180mcu_fd_sc_mcu7t5v0__nor2_1_7 vdd vss gf180mcu_fd_sc_mcu7t5v0__or3_1_0/A1 gf180mcu_fd_sc_mcu7t5v0__xor3_1_3/A1
+ gf180mcu_fd_sc_mcu7t5v0__xor2_1_6/Z vdd vss gf180mcu_fd_sc_mcu7t5v0__nor2_1
Xgf180mcu_fd_sc_mcu7t5v0__nand3_2_1 gf180mcu_fd_sc_mcu7t5v0__and3_1_1/A3 vdd vss gf180mcu_fd_sc_mcu7t5v0__nor2_2_1/A1
+ gf180mcu_fd_sc_mcu7t5v0__inv_8_1/I gf180mcu_fd_sc_mcu7t5v0__or3_2_1/Z vdd vss gf180mcu_fd_sc_mcu7t5v0__nand3_2
Xgf180mcu_fd_sc_mcu7t5v0__xor2_1_15 vdd vss gf180mcu_fd_sc_mcu7t5v0__xor2_1_15/Z gf180mcu_fd_sc_mcu7t5v0__inv_8_2/I
+ gf180mcu_fd_sc_mcu7t5v0__xor2_1_66/Z vdd vss gf180mcu_fd_sc_mcu7t5v0__xor2_1
Xgf180mcu_fd_sc_mcu7t5v0__xor2_1_26 vdd vss gf180mcu_fd_sc_mcu7t5v0__xor2_1_26/Z gf180mcu_fd_sc_mcu7t5v0__or3_1_9/A1
+ gf180mcu_fd_sc_mcu7t5v0__or2_1_8/A2 vdd vss gf180mcu_fd_sc_mcu7t5v0__xor2_1
Xgf180mcu_fd_sc_mcu7t5v0__xor2_1_37 vdd vss gf180mcu_fd_sc_mcu7t5v0__xor2_1_37/Z gf180mcu_fd_sc_mcu7t5v0__xor2_1_37/A1
+ gf180mcu_fd_sc_mcu7t5v0__xor2_1_37/A2 vdd vss gf180mcu_fd_sc_mcu7t5v0__xor2_1
Xgf180mcu_fd_sc_mcu7t5v0__xor2_1_100 vdd vss gf180mcu_fd_sc_mcu7t5v0__xor2_1_100/Z
+ gf180mcu_fd_sc_mcu7t5v0__inv_1_14/ZN gf180mcu_fd_sc_mcu7t5v0__xor2_1_100/A2 vdd
+ vss gf180mcu_fd_sc_mcu7t5v0__xor2_1
Xgf180mcu_fd_sc_mcu7t5v0__xor2_1_48 vdd vss gf180mcu_fd_sc_mcu7t5v0__xor2_1_48/Z gf180mcu_fd_sc_mcu7t5v0__xor2_1_48/A1
+ gf180mcu_fd_sc_mcu7t5v0__xor2_1_48/A2 vdd vss gf180mcu_fd_sc_mcu7t5v0__xor2_1
Xgf180mcu_fd_sc_mcu7t5v0__xor2_1_111 vdd vss gf180mcu_fd_sc_mcu7t5v0__xor3_1_87/A3
+ gf180mcu_fd_sc_mcu7t5v0__xor2_1_111/A1 gf180mcu_fd_sc_mcu7t5v0__xor2_1_217/Z vdd
+ vss gf180mcu_fd_sc_mcu7t5v0__xor2_1
Xgf180mcu_fd_sc_mcu7t5v0__xor2_1_59 vdd vss gf180mcu_fd_sc_mcu7t5v0__xor2_1_59/Z gf180mcu_fd_sc_mcu7t5v0__xor2_1_59/A1
+ gf180mcu_fd_sc_mcu7t5v0__xor2_1_59/A2 vdd vss gf180mcu_fd_sc_mcu7t5v0__xor2_1
Xgf180mcu_fd_sc_mcu7t5v0__xor2_1_122 vdd vss gf180mcu_fd_sc_mcu7t5v0__xor2_1_122/Z
+ gf180mcu_fd_sc_mcu7t5v0__inv_4_6/I gf180mcu_fd_sc_mcu7t5v0__xor2_1_123/Z vdd vss
+ gf180mcu_fd_sc_mcu7t5v0__xor2_1
Xgf180mcu_fd_sc_mcu7t5v0__xor2_1_133 vdd vss gf180mcu_fd_sc_mcu7t5v0__xor2_1_133/Z
+ gf180mcu_fd_sc_mcu7t5v0__nor4_2_5/A4 gf180mcu_fd_sc_mcu7t5v0__xor2_1_133/A2 vdd
+ vss gf180mcu_fd_sc_mcu7t5v0__xor2_1
Xgf180mcu_fd_sc_mcu7t5v0__xor2_1_144 vdd vss gf180mcu_fd_sc_mcu7t5v0__xor3_1_91/A3
+ gf180mcu_fd_sc_mcu7t5v0__xor2_1_144/A1 gf180mcu_fd_sc_mcu7t5v0__xor3_1_98/Z vdd
+ vss gf180mcu_fd_sc_mcu7t5v0__xor2_1
Xgf180mcu_fd_sc_mcu7t5v0__xor2_1_155 vdd vss gf180mcu_fd_sc_mcu7t5v0__xor2_1_155/Z
+ gf180mcu_fd_sc_mcu7t5v0__inv_4_6/I gf180mcu_fd_sc_mcu7t5v0__xor2_1_224/Z vdd vss
+ gf180mcu_fd_sc_mcu7t5v0__xor2_1
Xgf180mcu_fd_sc_mcu7t5v0__xor2_1_166 vdd vss gf180mcu_fd_sc_mcu7t5v0__xor2_1_166/Z
+ gf180mcu_fd_sc_mcu7t5v0__xor2_1_166/A1 gf180mcu_fd_sc_mcu7t5v0__xor2_1_166/A2 vdd
+ vss gf180mcu_fd_sc_mcu7t5v0__xor2_1
Xgf180mcu_fd_sc_mcu7t5v0__xor2_1_177 vdd vss gf180mcu_fd_sc_mcu7t5v0__or2_1_44/A2
+ gf180mcu_fd_sc_mcu7t5v0__or2_1_50/A1 gf180mcu_fd_sc_mcu7t5v0__or2_1_50/A2 vdd vss
+ gf180mcu_fd_sc_mcu7t5v0__xor2_1
Xgf180mcu_fd_sc_mcu7t5v0__xor2_1_188 vdd vss gf180mcu_fd_sc_mcu7t5v0__xor2_1_188/Z
+ gf180mcu_fd_sc_mcu7t5v0__or3_1_9/A1 gf180mcu_fd_sc_mcu7t5v0__xor2_1_203/Z vdd vss
+ gf180mcu_fd_sc_mcu7t5v0__xor2_1
Xgf180mcu_fd_sc_mcu7t5v0__xor2_1_199 vdd vss gf180mcu_fd_sc_mcu7t5v0__xor2_1_199/Z
+ gf180mcu_fd_sc_mcu7t5v0__xor2_1_199/A1 gf180mcu_fd_sc_mcu7t5v0__xor2_1_199/A2 vdd
+ vss gf180mcu_fd_sc_mcu7t5v0__xor2_1
Xgf180mcu_fd_sc_mcu7t5v0__clkinv_1_180 vdd vss gf180mcu_fd_sc_mcu7t5v0__dffq_1_162/Q
+ gf180mcu_fd_sc_mcu7t5v0__oai22_1_166/B2 vdd vss gf180mcu_fd_sc_mcu7t5v0__clkinv_1
Xgf180mcu_fd_sc_mcu7t5v0__clkinv_1_191 vdd vss gf180mcu_fd_sc_mcu7t5v0__dffq_1_184/Q
+ gf180mcu_fd_sc_mcu7t5v0__oai22_1_176/B2 vdd vss gf180mcu_fd_sc_mcu7t5v0__clkinv_1
Xgf180mcu_fd_sc_mcu7t5v0__nand3_1_15 gf180mcu_fd_sc_mcu7t5v0__inv_2_0/ZN vdd vss gf180mcu_fd_sc_mcu7t5v0__nand3_2_12/A2
+ gf180mcu_fd_sc_mcu7t5v0__dffq_2_23/Q gf180mcu_fd_sc_mcu7t5v0__dffq_4_4/Q vdd vss
+ gf180mcu_fd_sc_mcu7t5v0__nand3_1
Xgf180mcu_fd_sc_mcu7t5v0__nand3_1_26 gf180mcu_fd_sc_mcu7t5v0__xnor2_1_25/A1 vdd vss
+ gf180mcu_fd_sc_mcu7t5v0__xor2_1_44/A1 gf180mcu_fd_sc_mcu7t5v0__inv_12_1/I gf180mcu_fd_sc_mcu7t5v0__xnor3_1_14/ZN
+ vdd vss gf180mcu_fd_sc_mcu7t5v0__nand3_1
Xgf180mcu_fd_sc_mcu7t5v0__nand3_1_37 gf180mcu_fd_sc_mcu7t5v0__nand3_1_37/A3 vdd vss
+ gf180mcu_fd_sc_mcu7t5v0__and2_1_50/A2 gf180mcu_fd_sc_mcu7t5v0__nand3_1_37/A1 gf180mcu_fd_sc_mcu7t5v0__nand3_1_37/A2
+ vdd vss gf180mcu_fd_sc_mcu7t5v0__nand3_1
Xgf180mcu_fd_sc_mcu7t5v0__nand3_1_48 gf180mcu_fd_sc_mcu7t5v0__xnor2_1_85/ZN vdd vss
+ gf180mcu_fd_sc_mcu7t5v0__and3_1_8/A1 gf180mcu_fd_sc_mcu7t5v0__xor2_1_88/Z gf180mcu_fd_sc_mcu7t5v0__xor2_1_83/Z
+ vdd vss gf180mcu_fd_sc_mcu7t5v0__nand3_1
Xgf180mcu_fd_sc_mcu7t5v0__nand3_1_59 gf180mcu_fd_sc_mcu7t5v0__oai211_1_21/B vdd vss
+ gf180mcu_fd_sc_mcu7t5v0__dffq_2_52/D gf180mcu_fd_sc_mcu7t5v0__buf_8_8/Z gf180mcu_fd_sc_mcu7t5v0__nand3_1_59/A2
+ vdd vss gf180mcu_fd_sc_mcu7t5v0__nand3_1
Xgf180mcu_fd_sc_mcu7t5v0__oai32_1_5 gf180mcu_fd_sc_mcu7t5v0__or2_1_45/A1 gf180mcu_fd_sc_mcu7t5v0__oai32_1_5/B1
+ gf180mcu_fd_sc_mcu7t5v0__dffq_2_42/Q vdd vss gf180mcu_fd_sc_mcu7t5v0__oai32_1_5/ZN
+ gf180mcu_fd_sc_mcu7t5v0__dffq_2_40/Q gf180mcu_fd_sc_mcu7t5v0__oai32_1_5/A2 vdd vss
+ gf180mcu_fd_sc_mcu7t5v0__oai32_1
Xgf180mcu_fd_sc_mcu7t5v0__aoi221_1_10 gf180mcu_fd_sc_mcu7t5v0__nor2_2_2/ZN gf180mcu_fd_sc_mcu7t5v0__nor2_4_0/ZN
+ vdd vss gf180mcu_fd_sc_mcu7t5v0__oai21_1_72/B gf180mcu_fd_sc_mcu7t5v0__inv_4_6/I
+ gf180mcu_fd_sc_mcu7t5v0__nor2_4_1/ZN gf180mcu_fd_sc_mcu7t5v0__oai21_1_72/A2 vdd
+ vss gf180mcu_fd_sc_mcu7t5v0__aoi221_1
Xgf180mcu_fd_sc_mcu7t5v0__aoi221_1_21 gf180mcu_fd_sc_mcu7t5v0__nor4_4_1/A1 gf180mcu_fd_sc_mcu7t5v0__or2_4_3/A1
+ vdd vss gf180mcu_fd_sc_mcu7t5v0__nor2_1_160/A2 gf180mcu_fd_sc_mcu7t5v0__dffq_1_305/Q
+ gf180mcu_fd_sc_mcu7t5v0__or3_2_4/Z gf180mcu_fd_sc_mcu7t5v0__nor2_4_26/ZN vdd vss
+ gf180mcu_fd_sc_mcu7t5v0__aoi221_1
Xgf180mcu_fd_sc_mcu7t5v0__aoi221_1_32 gf180mcu_fd_sc_mcu7t5v0__aoi221_1_32/B2 gf180mcu_fd_sc_mcu7t5v0__aoi221_1_32/C
+ vdd vss gf180mcu_fd_sc_mcu7t5v0__aoi211_1_54/B gf180mcu_fd_sc_mcu7t5v0__nor2_2_22/ZN
+ gf180mcu_fd_sc_mcu7t5v0__xor3_1_73/Z gf180mcu_fd_sc_mcu7t5v0__or2_1_25/Z vdd vss
+ gf180mcu_fd_sc_mcu7t5v0__aoi221_1
Xgf180mcu_fd_sc_mcu7t5v0__aoi221_1_43 gf180mcu_fd_sc_mcu7t5v0__nor2_1_273/ZN gf180mcu_fd_sc_mcu7t5v0__aoi221_1_43/C
+ vdd vss gf180mcu_fd_sc_mcu7t5v0__oai21_1_224/A2 gf180mcu_fd_sc_mcu7t5v0__nor2_2_33/ZN
+ gf180mcu_fd_sc_mcu7t5v0__xor3_1_91/A3 gf180mcu_fd_sc_mcu7t5v0__nand3_1_70/ZN vdd
+ vss gf180mcu_fd_sc_mcu7t5v0__aoi221_1
Xgf180mcu_fd_sc_mcu7t5v0__aoi221_1_54 gf180mcu_fd_sc_mcu7t5v0__nor3_4_20/ZN gf180mcu_fd_sc_mcu7t5v0__aoi221_1_54/C
+ vdd vss gf180mcu_fd_sc_mcu7t5v0__aoi221_1_54/ZN gf180mcu_fd_sc_mcu7t5v0__nor3_4_22/ZN
+ gf180mcu_fd_sc_mcu7t5v0__or2_1_42/A2 gf180mcu_fd_sc_mcu7t5v0__xnor2_1_65/ZN vdd
+ vss gf180mcu_fd_sc_mcu7t5v0__aoi221_1
Xgf180mcu_fd_sc_mcu7t5v0__aoi221_1_65 gf180mcu_fd_sc_mcu7t5v0__aoi221_1_65/B2 gf180mcu_fd_sc_mcu7t5v0__aoi21_1_7/B
+ vdd vss gf180mcu_fd_sc_mcu7t5v0__dffq_2_17/D gf180mcu_fd_sc_mcu7t5v0__oai31_4_1/A1
+ gf180mcu_fd_sc_mcu7t5v0__or2_4_4/Z gf180mcu_fd_sc_mcu7t5v0__nand2_1_156/ZN vdd vss
+ gf180mcu_fd_sc_mcu7t5v0__aoi221_1
Xgf180mcu_fd_sc_mcu7t5v0__nor3_4_5 gf180mcu_fd_sc_mcu7t5v0__dffq_4_7/Q vdd vss gf180mcu_fd_sc_mcu7t5v0__or2_1_4/A1
+ gf180mcu_fd_sc_mcu7t5v0__nor3_4_5/A1 gf180mcu_fd_sc_mcu7t5v0__inv_2_6/ZN vdd vss
+ gf180mcu_fd_sc_mcu7t5v0__nor3_4
Xgf180mcu_fd_sc_mcu7t5v0__xnor3_1_3 gf180mcu_fd_sc_mcu7t5v0__nor2_1_6/A1 vdd vss gf180mcu_fd_sc_mcu7t5v0__xor3_1_5/A2
+ gf180mcu_fd_sc_mcu7t5v0__xor2_1_5/A1 gf180mcu_fd_sc_mcu7t5v0__xor2_1_5/A2 vdd vss
+ gf180mcu_fd_sc_mcu7t5v0__xnor3_1
Xgf180mcu_fd_sc_mcu7t5v0__or4_1_1 gf180mcu_fd_sc_mcu7t5v0__or4_1_1/A3 gf180mcu_fd_sc_mcu7t5v0__or4_1_1/A4
+ vdd vss gf180mcu_fd_sc_mcu7t5v0__or4_1_1/Z gf180mcu_fd_sc_mcu7t5v0__or4_1_1/A1 gf180mcu_fd_sc_mcu7t5v0__or4_1_1/A2
+ vdd vss gf180mcu_fd_sc_mcu7t5v0__or4_1
Xgf180mcu_fd_sc_mcu7t5v0__oai31_1_20 vdd gf180mcu_fd_sc_mcu7t5v0__oai31_1_20/ZN gf180mcu_fd_sc_mcu7t5v0__oai31_1_20/B
+ gf180mcu_fd_sc_mcu7t5v0__and2_1_141/Z gf180mcu_fd_sc_mcu7t5v0__nor2_2_57/ZN vss
+ gf180mcu_fd_sc_mcu7t5v0__nor2_2_56/ZN vdd vss gf180mcu_fd_sc_mcu7t5v0__oai31_1
Xgf180mcu_fd_sc_mcu7t5v0__nand2_1_70 vdd vss gf180mcu_fd_sc_mcu7t5v0__nand2_1_70/ZN
+ gf180mcu_fd_sc_mcu7t5v0__oai31_1_1/B gf180mcu_fd_sc_mcu7t5v0__mux4_4_1/Z vdd vss
+ gf180mcu_fd_sc_mcu7t5v0__nand2_1
Xgf180mcu_fd_sc_mcu7t5v0__nand2_1_81 vdd vss gf180mcu_fd_sc_mcu7t5v0__mux2_1_1/I0
+ gf180mcu_fd_sc_mcu7t5v0__inv_8_0/I gf180mcu_fd_sc_mcu7t5v0__mux4_4_4/Z vdd vss gf180mcu_fd_sc_mcu7t5v0__nand2_1
Xgf180mcu_fd_sc_mcu7t5v0__nand2_1_92 vdd vss gf180mcu_fd_sc_mcu7t5v0__xor3_1_28/A1
+ gf180mcu_fd_sc_mcu7t5v0__inv_8_0/I gf180mcu_fd_sc_mcu7t5v0__or4_1_1/A4 vdd vss gf180mcu_fd_sc_mcu7t5v0__nand2_1
Xgf180mcu_fd_sc_mcu7t5v0__and3_1_19 gf180mcu_fd_sc_mcu7t5v0__xor2_1_157/Z vdd vss
+ gf180mcu_fd_sc_mcu7t5v0__or3_1_20/A2 gf180mcu_fd_sc_mcu7t5v0__inv_1_24/I gf180mcu_fd_sc_mcu7t5v0__nor2_2_32/ZN
+ vdd vss gf180mcu_fd_sc_mcu7t5v0__and3_1
Xgf180mcu_fd_sc_mcu7t5v0__and2_1_6 vdd vss gf180mcu_fd_sc_mcu7t5v0__and2_1_6/Z gf180mcu_fd_sc_mcu7t5v0__and2_1_6/A1
+ gf180mcu_fd_sc_mcu7t5v0__and2_1_6/A2 vdd vss gf180mcu_fd_sc_mcu7t5v0__and2_1
Xgf180mcu_fd_sc_mcu7t5v0__aoi222_2_0 gf180mcu_fd_sc_mcu7t5v0__oai21_1_53/ZN gf180mcu_fd_sc_mcu7t5v0__nand3_1_27/ZN
+ gf180mcu_fd_sc_mcu7t5v0__xor2_2_0/Z gf180mcu_fd_sc_mcu7t5v0__nor2_2_6/ZN gf180mcu_fd_sc_mcu7t5v0__nand2_1_8/A2
+ vss vdd gf180mcu_fd_sc_mcu7t5v0__and3_2_0/Z gf180mcu_fd_sc_mcu7t5v0__xor2_1_30/Z
+ vdd vss gf180mcu_fd_sc_mcu7t5v0__aoi222_2
Xgf180mcu_fd_sc_mcu7t5v0__nor2_2_19 vdd vss gf180mcu_fd_sc_mcu7t5v0__oai31_4_2/B gf180mcu_fd_sc_mcu7t5v0__or2_1_23/A1
+ gf180mcu_fd_sc_mcu7t5v0__and4_2_0/Z vdd vss gf180mcu_fd_sc_mcu7t5v0__nor2_2
Xgf180mcu_fd_sc_mcu7t5v0__nor3_2_2 gf180mcu_fd_sc_mcu7t5v0__xor3_1_6/Z vdd vss gf180mcu_fd_sc_mcu7t5v0__or2_1_0/A1
+ gf180mcu_fd_sc_mcu7t5v0__nor3_2_2/A1 gf180mcu_fd_sc_mcu7t5v0__nor3_2_2/A2 vdd vss
+ gf180mcu_fd_sc_mcu7t5v0__nor3_2
Xgf180mcu_fd_sc_mcu7t5v0__dffq_1_307 vdd gf180mcu_fd_sc_mcu7t5v0__dffq_1_307/Q gf180mcu_fd_sc_mcu7t5v0__dffq_4_9/CLK
+ vss gf180mcu_fd_sc_mcu7t5v0__dffq_1_307/D vdd vss gf180mcu_fd_sc_mcu7t5v0__dffq_1
Xgf180mcu_fd_sc_mcu7t5v0__dffq_1_318 vdd gf180mcu_fd_sc_mcu7t5v0__dffq_1_318/Q gf180mcu_fd_sc_mcu7t5v0__dffq_4_9/CLK
+ vss gf180mcu_fd_sc_mcu7t5v0__dffq_1_318/D vdd vss gf180mcu_fd_sc_mcu7t5v0__dffq_1
Xgf180mcu_fd_sc_mcu7t5v0__dffq_1_329 vdd gf180mcu_fd_sc_mcu7t5v0__dffq_1_329/Q gf180mcu_fd_sc_mcu7t5v0__dffq_2_58/CLK
+ vss gf180mcu_fd_sc_mcu7t5v0__dffq_1_329/D vdd vss gf180mcu_fd_sc_mcu7t5v0__dffq_1
Xgf180mcu_fd_sc_mcu7t5v0__aoi21_4_3 gf180mcu_fd_sc_mcu7t5v0__or3_4_0/Z gf180mcu_fd_sc_mcu7t5v0__aoi21_4_3/B
+ vdd vss gf180mcu_fd_sc_mcu7t5v0__aoi21_4_3/ZN gf180mcu_fd_sc_mcu7t5v0__mux4_4_0/I0
+ vdd vss gf180mcu_fd_sc_mcu7t5v0__aoi21_4
Xgf180mcu_fd_sc_mcu7t5v0__oai22_1_19 gf180mcu_fd_sc_mcu7t5v0__nand2_4_4/ZN gf180mcu_fd_sc_mcu7t5v0__oai22_1_33/B1
+ gf180mcu_fd_sc_mcu7t5v0__oai22_1_19/B2 vdd vss gf180mcu_fd_sc_mcu7t5v0__dffq_1_21/D
+ gf180mcu_fd_sc_mcu7t5v0__aoi21_4_5/ZN vdd vss gf180mcu_fd_sc_mcu7t5v0__oai22_1
Xgf180mcu_fd_sc_mcu7t5v0__nand2_1_700 vdd vss gf180mcu_fd_sc_mcu7t5v0__xor3_1_148/A1
+ gf180mcu_fd_sc_mcu7t5v0__nor2_2_58/ZN gf180mcu_fd_sc_mcu7t5v0__xor2_1_204/Z vdd
+ vss gf180mcu_fd_sc_mcu7t5v0__nand2_1
Xgf180mcu_fd_sc_mcu7t5v0__nand2_1_711 vdd vss gf180mcu_fd_sc_mcu7t5v0__or2_1_28/A1
+ gf180mcu_fd_sc_mcu7t5v0__inv_8_0/I gf180mcu_fd_sc_mcu7t5v0__mux4_4_6/Z vdd vss gf180mcu_fd_sc_mcu7t5v0__nand2_1
Xgf180mcu_fd_sc_mcu7t5v0__nand2_1_722 vdd vss gf180mcu_fd_sc_mcu7t5v0__xor2_1_86/A2
+ gf180mcu_fd_sc_mcu7t5v0__or3_1_29/Z gf180mcu_fd_sc_mcu7t5v0__oai21_1_88/ZN vdd vss
+ gf180mcu_fd_sc_mcu7t5v0__nand2_1
Xgf180mcu_fd_sc_mcu7t5v0__and2_1_30 vdd vss gf180mcu_fd_sc_mcu7t5v0__or3_1_7/A1 gf180mcu_fd_sc_mcu7t5v0__inv_8_2/I
+ gf180mcu_fd_sc_mcu7t5v0__xor2_1_54/Z vdd vss gf180mcu_fd_sc_mcu7t5v0__and2_1
Xgf180mcu_fd_sc_mcu7t5v0__and2_1_41 vdd vss gf180mcu_fd_sc_mcu7t5v0__and2_1_41/Z gf180mcu_fd_sc_mcu7t5v0__dffq_1_247/Q
+ gf180mcu_fd_sc_mcu7t5v0__or2_1_34/A2 vdd vss gf180mcu_fd_sc_mcu7t5v0__and2_1
Xgf180mcu_fd_sc_mcu7t5v0__and2_1_52 vdd vss gf180mcu_fd_sc_mcu7t5v0__and2_1_52/Z gf180mcu_fd_sc_mcu7t5v0__nor4_1_0/A2
+ gf180mcu_fd_sc_mcu7t5v0__and2_1_53/Z vdd vss gf180mcu_fd_sc_mcu7t5v0__and2_1
Xgf180mcu_fd_sc_mcu7t5v0__and2_1_63 vdd vss gf180mcu_fd_sc_mcu7t5v0__and2_1_63/Z gf180mcu_fd_sc_mcu7t5v0__dffq_1_352/Q
+ gf180mcu_fd_sc_mcu7t5v0__and2_1_60/Z vdd vss gf180mcu_fd_sc_mcu7t5v0__and2_1
Xgf180mcu_fd_sc_mcu7t5v0__and2_1_74 vdd vss gf180mcu_fd_sc_mcu7t5v0__and2_1_74/Z gf180mcu_fd_sc_mcu7t5v0__buf_8_7/Z
+ gf180mcu_fd_sc_mcu7t5v0__or3_2_4/A1 vdd vss gf180mcu_fd_sc_mcu7t5v0__and2_1
Xgf180mcu_fd_sc_mcu7t5v0__and2_1_85 vdd vss gf180mcu_fd_sc_mcu7t5v0__or3_1_15/A1 gf180mcu_fd_sc_mcu7t5v0__and2_1_85/A1
+ gf180mcu_fd_sc_mcu7t5v0__xor2_1_106/Z vdd vss gf180mcu_fd_sc_mcu7t5v0__and2_1
Xgf180mcu_fd_sc_mcu7t5v0__and2_1_96 vdd vss gf180mcu_fd_sc_mcu7t5v0__or2_1_31/A1 gf180mcu_fd_sc_mcu7t5v0__inv_4_6/I
+ gf180mcu_fd_sc_mcu7t5v0__xor2_1_123/Z vdd vss gf180mcu_fd_sc_mcu7t5v0__and2_1
Xgf180mcu_fd_sc_mcu7t5v0__aoi211_1_20 gf180mcu_fd_sc_mcu7t5v0__aoi211_1_20/B gf180mcu_fd_sc_mcu7t5v0__nor2_1_94/ZN
+ vdd vss gf180mcu_fd_sc_mcu7t5v0__oai21_1_64/A2 gf180mcu_fd_sc_mcu7t5v0__and2_2_8/Z
+ gf180mcu_fd_sc_mcu7t5v0__xor3_1_54/Z vdd vss gf180mcu_fd_sc_mcu7t5v0__aoi211_1
Xgf180mcu_fd_sc_mcu7t5v0__aoi211_1_31 gf180mcu_fd_sc_mcu7t5v0__nor2_1_133/ZN gf180mcu_fd_sc_mcu7t5v0__or2_1_23/A1
+ vdd vss gf180mcu_fd_sc_mcu7t5v0__dffq_1_278/D gf180mcu_fd_sc_mcu7t5v0__inv_4_2/ZN
+ gf180mcu_fd_sc_mcu7t5v0__nor2_4_17/ZN vdd vss gf180mcu_fd_sc_mcu7t5v0__aoi211_1
Xgf180mcu_fd_sc_mcu7t5v0__aoi211_1_42 gf180mcu_fd_sc_mcu7t5v0__nor4_4_2/A2 gf180mcu_fd_sc_mcu7t5v0__nor4_4_2/A1
+ vdd vss gf180mcu_fd_sc_mcu7t5v0__aoi21_1_121/A2 gf180mcu_fd_sc_mcu7t5v0__dffq_1_401/Q
+ gf180mcu_fd_sc_mcu7t5v0__or3_2_4/Z vdd vss gf180mcu_fd_sc_mcu7t5v0__aoi211_1
Xgf180mcu_fd_sc_mcu7t5v0__aoi211_1_53 gf180mcu_fd_sc_mcu7t5v0__dffq_2_50/Q gf180mcu_fd_sc_mcu7t5v0__or2_1_23/A1
+ vdd vss gf180mcu_fd_sc_mcu7t5v0__nand2_1_368/A2 gf180mcu_fd_sc_mcu7t5v0__dffq_1_381/Q
+ gf180mcu_fd_sc_mcu7t5v0__inv_2_8/I vdd vss gf180mcu_fd_sc_mcu7t5v0__aoi211_1
Xgf180mcu_fd_sc_mcu7t5v0__aoi211_1_64 gf180mcu_fd_sc_mcu7t5v0__nor2_1_323/ZN gf180mcu_fd_sc_mcu7t5v0__or2_1_23/A1
+ vdd vss gf180mcu_fd_sc_mcu7t5v0__dffq_1_436/D gf180mcu_fd_sc_mcu7t5v0__nor2_1_411/A1
+ gf180mcu_fd_sc_mcu7t5v0__nor2_4_24/ZN vdd vss gf180mcu_fd_sc_mcu7t5v0__aoi211_1
Xgf180mcu_fd_sc_mcu7t5v0__aoi211_1_75 gf180mcu_fd_sc_mcu7t5v0__nor2_1_328/ZN gf180mcu_fd_sc_mcu7t5v0__or2_1_23/A1
+ vdd vss gf180mcu_fd_sc_mcu7t5v0__dffq_1_429/D gf180mcu_fd_sc_mcu7t5v0__inv_4_2/ZN
+ gf180mcu_fd_sc_mcu7t5v0__nor2_4_27/ZN vdd vss gf180mcu_fd_sc_mcu7t5v0__aoi211_1
Xgf180mcu_fd_sc_mcu7t5v0__aoi211_1_86 gf180mcu_fd_sc_mcu7t5v0__aoi211_1_86/B gf180mcu_fd_sc_mcu7t5v0__or2_4_4/Z
+ vdd vss gf180mcu_fd_sc_mcu7t5v0__aoi211_1_66/C gf180mcu_fd_sc_mcu7t5v0__nor3_1_33/A1
+ gf180mcu_fd_sc_mcu7t5v0__nand2_1_466/ZN vdd vss gf180mcu_fd_sc_mcu7t5v0__aoi211_1
Xgf180mcu_fd_sc_mcu7t5v0__oai211_4_3 gf180mcu_fd_sc_mcu7t5v0__or2_1_39/Z gf180mcu_fd_sc_mcu7t5v0__inv_12_1/I
+ vdd vss gf180mcu_fd_sc_mcu7t5v0__or2_1_38/A1 gf180mcu_fd_sc_mcu7t5v0__and2_1_111/Z
+ gf180mcu_fd_sc_mcu7t5v0__aoi21_4_6/ZN vdd vss gf180mcu_fd_sc_mcu7t5v0__oai211_4
Xgf180mcu_fd_sc_mcu7t5v0__mux2_4_3 gf180mcu_fd_sc_mcu7t5v0__or3_4_0/Z vdd vss gf180mcu_fd_sc_mcu7t5v0__mux2_4_3/Z
+ gf180mcu_fd_sc_mcu7t5v0__or2_4_2/A2 gf180mcu_fd_sc_mcu7t5v0__mux2_4_3/I1 vdd vss
+ gf180mcu_fd_sc_mcu7t5v0__mux2_4
Xgf180mcu_fd_sc_mcu7t5v0__aoi21_1_230 gf180mcu_fd_sc_mcu7t5v0__aoi21_1_230/B vdd vss
+ gf180mcu_fd_sc_mcu7t5v0__dffq_2_61/D gf180mcu_fd_sc_mcu7t5v0__nor2_2_33/A1 gf180mcu_fd_sc_mcu7t5v0__buf_20_0/Z
+ vdd vss gf180mcu_fd_sc_mcu7t5v0__aoi21_1
Xgf180mcu_fd_sc_mcu7t5v0__aoi21_1_241 gf180mcu_fd_sc_mcu7t5v0__xor3_1_90/Z vdd vss
+ gf180mcu_fd_sc_mcu7t5v0__nor2_1_273/A2 gf180mcu_fd_sc_mcu7t5v0__nand3_1_70/A1 gf180mcu_fd_sc_mcu7t5v0__nand3_1_70/A2
+ vdd vss gf180mcu_fd_sc_mcu7t5v0__aoi21_1
Xgf180mcu_fd_sc_mcu7t5v0__aoi21_1_252 gf180mcu_fd_sc_mcu7t5v0__nor2_1_283/ZN vdd vss
+ gf180mcu_fd_sc_mcu7t5v0__xor3_1_94/A1 gf180mcu_fd_sc_mcu7t5v0__xnor2_1_49/ZN gf180mcu_fd_sc_mcu7t5v0__xor2_1_142/Z
+ vdd vss gf180mcu_fd_sc_mcu7t5v0__aoi21_1
Xgf180mcu_fd_sc_mcu7t5v0__aoi21_1_263 gf180mcu_fd_sc_mcu7t5v0__aoi21_1_263/B vdd vss
+ gf180mcu_fd_sc_mcu7t5v0__dffq_4_27/D gf180mcu_fd_sc_mcu7t5v0__nor2_1_300/A1 gf180mcu_fd_sc_mcu7t5v0__buf_20_0/Z
+ vdd vss gf180mcu_fd_sc_mcu7t5v0__aoi21_1
Xgf180mcu_fd_sc_mcu7t5v0__aoi21_1_274 gf180mcu_fd_sc_mcu7t5v0__xor3_1_175/Z vdd vss
+ gf180mcu_fd_sc_mcu7t5v0__nor3_1_32/A2 gf180mcu_fd_sc_mcu7t5v0__nand2_1_529/ZN gf180mcu_fd_sc_mcu7t5v0__nand2_1_528/A2
+ vdd vss gf180mcu_fd_sc_mcu7t5v0__aoi21_1
Xgf180mcu_fd_sc_mcu7t5v0__aoi21_1_285 gf180mcu_fd_sc_mcu7t5v0__or2_1_23/A1 vdd vss
+ gf180mcu_fd_sc_mcu7t5v0__dffq_2_77/D gf180mcu_fd_sc_mcu7t5v0__nand2_1_537/ZN gf180mcu_fd_sc_mcu7t5v0__nand2_1_539/ZN
+ vdd vss gf180mcu_fd_sc_mcu7t5v0__aoi21_1
Xgf180mcu_fd_sc_mcu7t5v0__aoi21_1_296 gf180mcu_fd_sc_mcu7t5v0__aoi21_1_296/B vdd vss
+ gf180mcu_fd_sc_mcu7t5v0__dffq_2_72/D gf180mcu_fd_sc_mcu7t5v0__inv_1_19/ZN gf180mcu_fd_sc_mcu7t5v0__buf_20_0/I
+ vdd vss gf180mcu_fd_sc_mcu7t5v0__aoi21_1
Xgf180mcu_fd_sc_mcu7t5v0__oai33_2_0 gf180mcu_fd_sc_mcu7t5v0__and2_1_1/Z gf180mcu_fd_sc_mcu7t5v0__xor3_1_2/Z
+ gf180mcu_fd_sc_mcu7t5v0__nor3_2_0/A1 gf180mcu_fd_sc_mcu7t5v0__nor3_2_0/A2 vdd vss
+ gf180mcu_fd_sc_mcu7t5v0__xor2_1_7/A1 gf180mcu_fd_sc_mcu7t5v0__xor3_1_2/A2 gf180mcu_fd_sc_mcu7t5v0__nor2_1_4/ZN
+ vdd vss gf180mcu_fd_sc_mcu7t5v0__oai33_2
Xgf180mcu_fd_sc_mcu7t5v0__oai21_1_30 vdd gf180mcu_fd_sc_mcu7t5v0__buf_8_5/Z gf180mcu_fd_sc_mcu7t5v0__buf_20_0/Z
+ gf180mcu_fd_sc_mcu7t5v0__aoi21_1_44/B gf180mcu_fd_sc_mcu7t5v0__dffq_1_2/Q vss vdd
+ vss gf180mcu_fd_sc_mcu7t5v0__oai21_1
Xgf180mcu_fd_sc_mcu7t5v0__oai21_1_41 vdd gf180mcu_fd_sc_mcu7t5v0__or2_1_4/A1 gf180mcu_fd_sc_mcu7t5v0__nor2_2_3/ZN
+ gf180mcu_fd_sc_mcu7t5v0__oai21_1_41/ZN gf180mcu_fd_sc_mcu7t5v0__mux4_4_2/I2 vss
+ vdd vss gf180mcu_fd_sc_mcu7t5v0__oai21_1
Xgf180mcu_fd_sc_mcu7t5v0__oai21_4_6 gf180mcu_fd_sc_mcu7t5v0__oai21_4_6/B vdd vss gf180mcu_fd_sc_mcu7t5v0__xor3_1_92/A1
+ gf180mcu_fd_sc_mcu7t5v0__oai22_1_8/A2 gf180mcu_fd_sc_mcu7t5v0__or2_4_0/Z vdd vss
+ gf180mcu_fd_sc_mcu7t5v0__oai21_4
Xgf180mcu_fd_sc_mcu7t5v0__oai21_1_52 vdd gf180mcu_fd_sc_mcu7t5v0__oai21_1_52/B gf180mcu_fd_sc_mcu7t5v0__oai21_1_52/A2
+ gf180mcu_fd_sc_mcu7t5v0__oai21_1_51/B gf180mcu_fd_sc_mcu7t5v0__mux2_1_2/I0 vss vdd
+ vss gf180mcu_fd_sc_mcu7t5v0__oai21_1
Xgf180mcu_fd_sc_mcu7t5v0__oai22_1_206 gf180mcu_fd_sc_mcu7t5v0__nand2_4_27/ZN gf180mcu_fd_sc_mcu7t5v0__nand2_2_43/ZN
+ gf180mcu_fd_sc_mcu7t5v0__oai22_1_206/B2 vdd vss gf180mcu_fd_sc_mcu7t5v0__dffq_1_197/D
+ gf180mcu_fd_sc_mcu7t5v0__aoi21_4_4/ZN vdd vss gf180mcu_fd_sc_mcu7t5v0__oai22_1
Xgf180mcu_fd_sc_mcu7t5v0__oai21_1_63 vdd gf180mcu_fd_sc_mcu7t5v0__and2_2_8/Z gf180mcu_fd_sc_mcu7t5v0__xor3_1_53/Z
+ gf180mcu_fd_sc_mcu7t5v0__aoi21_1_78/B gf180mcu_fd_sc_mcu7t5v0__oai21_1_63/A1 vss
+ vdd vss gf180mcu_fd_sc_mcu7t5v0__oai21_1
Xgf180mcu_fd_sc_mcu7t5v0__oai21_1_74 vdd gf180mcu_fd_sc_mcu7t5v0__oai21_1_74/B gf180mcu_fd_sc_mcu7t5v0__nor2_1_9/ZN
+ gf180mcu_fd_sc_mcu7t5v0__xor3_1_61/A2 gf180mcu_fd_sc_mcu7t5v0__xnor3_1_5/A2 vss
+ vdd vss gf180mcu_fd_sc_mcu7t5v0__oai21_1
Xgf180mcu_fd_sc_mcu7t5v0__oai21_1_85 vdd gf180mcu_fd_sc_mcu7t5v0__oai21_1_85/B gf180mcu_fd_sc_mcu7t5v0__xor2_2_1/A2
+ gf180mcu_fd_sc_mcu7t5v0__xor3_1_64/A1 gf180mcu_fd_sc_mcu7t5v0__xor2_2_1/A1 vss vdd
+ vss gf180mcu_fd_sc_mcu7t5v0__oai21_1
Xgf180mcu_fd_sc_mcu7t5v0__oai22_1_217 gf180mcu_fd_sc_mcu7t5v0__oai22_1_28/A2 gf180mcu_fd_sc_mcu7t5v0__oai22_1_28/B1
+ gf180mcu_fd_sc_mcu7t5v0__oai22_1_217/B2 vdd vss gf180mcu_fd_sc_mcu7t5v0__dffq_1_207/D
+ gf180mcu_fd_sc_mcu7t5v0__oai21_4_9/ZN vdd vss gf180mcu_fd_sc_mcu7t5v0__oai22_1
Xgf180mcu_fd_sc_mcu7t5v0__oai22_1_228 gf180mcu_fd_sc_mcu7t5v0__oai22_1_28/A2 gf180mcu_fd_sc_mcu7t5v0__oai22_1_28/B1
+ gf180mcu_fd_sc_mcu7t5v0__oai22_1_228/B2 vdd vss gf180mcu_fd_sc_mcu7t5v0__dffq_1_218/D
+ gf180mcu_fd_sc_mcu7t5v0__aoi21_4_4/ZN vdd vss gf180mcu_fd_sc_mcu7t5v0__oai22_1
Xgf180mcu_fd_sc_mcu7t5v0__oai21_1_96 vdd gf180mcu_fd_sc_mcu7t5v0__buf_8_6/Z gf180mcu_fd_sc_mcu7t5v0__aoi22_4_8/ZN
+ gf180mcu_fd_sc_mcu7t5v0__oai21_1_96/ZN gf180mcu_fd_sc_mcu7t5v0__dffq_1_410/Q vss
+ vdd vss gf180mcu_fd_sc_mcu7t5v0__oai21_1
Xgf180mcu_fd_sc_mcu7t5v0__oai22_1_239 gf180mcu_fd_sc_mcu7t5v0__nand2_4_29/ZN gf180mcu_fd_sc_mcu7t5v0__nand2_2_39/ZN
+ gf180mcu_fd_sc_mcu7t5v0__oai22_1_239/B2 vdd vss gf180mcu_fd_sc_mcu7t5v0__dffq_1_235/D
+ gf180mcu_fd_sc_mcu7t5v0__aoi21_4_3/ZN vdd vss gf180mcu_fd_sc_mcu7t5v0__oai22_1
Xgf180mcu_fd_sc_mcu7t5v0__or2_4_2 vdd vss gf180mcu_fd_sc_mcu7t5v0__or2_4_2/Z gf180mcu_fd_sc_mcu7t5v0__or2_4_2/A1
+ gf180mcu_fd_sc_mcu7t5v0__or2_4_2/A2 vdd vss gf180mcu_fd_sc_mcu7t5v0__or2_4
Xgf180mcu_fd_sc_mcu7t5v0__dffq_1_104 vdd gf180mcu_fd_sc_mcu7t5v0__dffq_1_104/Q gf180mcu_fd_sc_mcu7t5v0__dffq_1_96/CLK
+ vss gf180mcu_fd_sc_mcu7t5v0__dffq_1_104/D vdd vss gf180mcu_fd_sc_mcu7t5v0__dffq_1
Xgf180mcu_fd_sc_mcu7t5v0__dffq_1_115 vdd gf180mcu_fd_sc_mcu7t5v0__dffq_1_115/Q gf180mcu_fd_sc_mcu7t5v0__dffq_1_96/CLK
+ vss gf180mcu_fd_sc_mcu7t5v0__dffq_1_115/D vdd vss gf180mcu_fd_sc_mcu7t5v0__dffq_1
Xgf180mcu_fd_sc_mcu7t5v0__dffq_1_126 vdd gf180mcu_fd_sc_mcu7t5v0__dffq_1_126/Q gf180mcu_fd_sc_mcu7t5v0__dffq_1_96/CLK
+ vss gf180mcu_fd_sc_mcu7t5v0__dffq_1_126/D vdd vss gf180mcu_fd_sc_mcu7t5v0__dffq_1
Xgf180mcu_fd_sc_mcu7t5v0__nor2_1_304 vdd vss gf180mcu_fd_sc_mcu7t5v0__nor2_1_304/ZN
+ gf180mcu_fd_sc_mcu7t5v0__dffq_1_423/Q gf180mcu_fd_sc_mcu7t5v0__nor2_4_24/ZN vdd
+ vss gf180mcu_fd_sc_mcu7t5v0__nor2_1
Xgf180mcu_fd_sc_mcu7t5v0__nor2_1_315 vdd vss gf180mcu_fd_sc_mcu7t5v0__nor2_1_315/ZN
+ gf180mcu_fd_sc_mcu7t5v0__nor3_4_17/ZN gf180mcu_fd_sc_mcu7t5v0__nor2_1_315/A2 vdd
+ vss gf180mcu_fd_sc_mcu7t5v0__nor2_1
Xgf180mcu_fd_sc_mcu7t5v0__dffq_1_137 vdd gf180mcu_fd_sc_mcu7t5v0__dffq_1_137/Q gf180mcu_fd_sc_mcu7t5v0__dffq_1_96/CLK
+ vss gf180mcu_fd_sc_mcu7t5v0__dffq_1_137/D vdd vss gf180mcu_fd_sc_mcu7t5v0__dffq_1
Xgf180mcu_fd_sc_mcu7t5v0__nor2_1_326 vdd vss gf180mcu_fd_sc_mcu7t5v0__dffq_2_73/D
+ gf180mcu_fd_sc_mcu7t5v0__aoi21_1_7/B gf180mcu_fd_sc_mcu7t5v0__nor2_1_326/A2 vdd
+ vss gf180mcu_fd_sc_mcu7t5v0__nor2_1
Xgf180mcu_fd_sc_mcu7t5v0__dffq_1_148 vdd gf180mcu_fd_sc_mcu7t5v0__dffq_1_148/Q gf180mcu_fd_sc_mcu7t5v0__dffq_4_15/CLK
+ vss gf180mcu_fd_sc_mcu7t5v0__dffq_1_148/D vdd vss gf180mcu_fd_sc_mcu7t5v0__dffq_1
Xgf180mcu_fd_sc_mcu7t5v0__aoi21_2_0 gf180mcu_fd_sc_mcu7t5v0__nor2_1_3/ZN vdd vss gf180mcu_fd_sc_mcu7t5v0__xor3_1_59/A2
+ gf180mcu_fd_sc_mcu7t5v0__aoi21_2_0/A1 gf180mcu_fd_sc_mcu7t5v0__xor2_1_1/A2 vdd vss
+ gf180mcu_fd_sc_mcu7t5v0__aoi21_2
Xgf180mcu_fd_sc_mcu7t5v0__nor2_1_337 vdd vss gf180mcu_fd_sc_mcu7t5v0__dffq_2_82/D
+ gf180mcu_fd_sc_mcu7t5v0__aoi21_1_7/B gf180mcu_fd_sc_mcu7t5v0__nor2_1_337/A2 vdd
+ vss gf180mcu_fd_sc_mcu7t5v0__nor2_1
Xgf180mcu_fd_sc_mcu7t5v0__dffq_1_159 vdd gf180mcu_fd_sc_mcu7t5v0__dffq_1_159/Q gf180mcu_fd_sc_mcu7t5v0__dffq_2_26/CLK
+ vss gf180mcu_fd_sc_mcu7t5v0__dffq_1_159/D vdd vss gf180mcu_fd_sc_mcu7t5v0__dffq_1
Xgf180mcu_fd_sc_mcu7t5v0__nor2_1_348 vdd vss gf180mcu_fd_sc_mcu7t5v0__xor3_1_116/A1
+ gf180mcu_fd_sc_mcu7t5v0__or3_1_24/A1 gf180mcu_fd_sc_mcu7t5v0__or2_1_24/A2 vdd vss
+ gf180mcu_fd_sc_mcu7t5v0__nor2_1
Xgf180mcu_fd_sc_mcu7t5v0__nor2_1_359 vdd vss gf180mcu_fd_sc_mcu7t5v0__nor2_1_359/ZN
+ gf180mcu_fd_sc_mcu7t5v0__or4_1_0/A1 gf180mcu_fd_sc_mcu7t5v0__mux4_4_15/Z vdd vss
+ gf180mcu_fd_sc_mcu7t5v0__nor2_1
Xgf180mcu_fd_sc_mcu7t5v0__nand2_1_530 vdd vss gf180mcu_fd_sc_mcu7t5v0__nand4_1_17/A3
+ gf180mcu_fd_sc_mcu7t5v0__nor2_1_315/A2 gf180mcu_fd_sc_mcu7t5v0__nor2_1_313/ZN vdd
+ vss gf180mcu_fd_sc_mcu7t5v0__nand2_1
Xgf180mcu_fd_sc_mcu7t5v0__nand2_1_541 vdd vss gf180mcu_fd_sc_mcu7t5v0__nand2_1_541/ZN
+ gf180mcu_fd_sc_mcu7t5v0__mux4_2_1/I3 gf180mcu_fd_sc_mcu7t5v0__clkinv_3_9/ZN vdd
+ vss gf180mcu_fd_sc_mcu7t5v0__nand2_1
Xgf180mcu_fd_sc_mcu7t5v0__nand2_1_552 vdd vss gf180mcu_fd_sc_mcu7t5v0__and2_1_122/A1
+ gf180mcu_fd_sc_mcu7t5v0__inv_2_11/I gf180mcu_fd_sc_mcu7t5v0__xor2_1_128/Z vdd vss
+ gf180mcu_fd_sc_mcu7t5v0__nand2_1
Xgf180mcu_fd_sc_mcu7t5v0__nand2_1_563 vdd vss gf180mcu_fd_sc_mcu7t5v0__nand3_1_85/A1
+ gf180mcu_fd_sc_mcu7t5v0__nor3_4_22/ZN gf180mcu_fd_sc_mcu7t5v0__xor3_1_134/Z vdd
+ vss gf180mcu_fd_sc_mcu7t5v0__nand2_1
Xgf180mcu_fd_sc_mcu7t5v0__aoi21_2_10 gf180mcu_fd_sc_mcu7t5v0__aoi21_2_10/B vdd vss
+ gf180mcu_fd_sc_mcu7t5v0__or2_1_37/A2 gf180mcu_fd_sc_mcu7t5v0__xor3_2_1/A2 gf180mcu_fd_sc_mcu7t5v0__xor2_1_134/Z
+ vdd vss gf180mcu_fd_sc_mcu7t5v0__aoi21_2
Xgf180mcu_fd_sc_mcu7t5v0__nand2_1_574 vdd vss gf180mcu_fd_sc_mcu7t5v0__oai21_1_286/B
+ gf180mcu_fd_sc_mcu7t5v0__mux4_4_7/I0 gf180mcu_fd_sc_mcu7t5v0__xor2_1_173/Z vdd vss
+ gf180mcu_fd_sc_mcu7t5v0__nand2_1
Xgf180mcu_fd_sc_mcu7t5v0__aoi21_2_21 gf180mcu_fd_sc_mcu7t5v0__aoi21_2_21/B vdd vss
+ gf180mcu_fd_sc_mcu7t5v0__xor3_1_118/A2 gf180mcu_fd_sc_mcu7t5v0__and2_1_128/Z gf180mcu_fd_sc_mcu7t5v0__aoi21_2_21/A2
+ vdd vss gf180mcu_fd_sc_mcu7t5v0__aoi21_2
Xgf180mcu_fd_sc_mcu7t5v0__nand2_1_585 vdd vss gf180mcu_fd_sc_mcu7t5v0__and4_1_2/A3
+ gf180mcu_fd_sc_mcu7t5v0__xnor3_1_22/A2 gf180mcu_fd_sc_mcu7t5v0__xnor3_1_22/A3 vdd
+ vss gf180mcu_fd_sc_mcu7t5v0__nand2_1
Xgf180mcu_fd_sc_mcu7t5v0__nand2_1_596 vdd vss gf180mcu_fd_sc_mcu7t5v0__xnor2_1_64/A2
+ gf180mcu_fd_sc_mcu7t5v0__inv_8_0/I gf180mcu_fd_sc_mcu7t5v0__mux4_4_15/Z vdd vss
+ gf180mcu_fd_sc_mcu7t5v0__nand2_1
Xgf180mcu_fd_sc_mcu7t5v0__clkbuf_16_9 vdd vss gf180mcu_fd_sc_mcu7t5v0__dffq_4_15/CLK
+ gf180mcu_fd_sc_mcu7t5v0__clkbuf_16_9/I vdd vss gf180mcu_fd_sc_mcu7t5v0__clkbuf_16
Xgf180mcu_fd_sc_mcu7t5v0__clkinv_8_3 vdd vss gf180mcu_fd_sc_mcu7t5v0__or3_1_9/A1 gf180mcu_fd_sc_mcu7t5v0__dffq_4_37/Q
+ vdd vss gf180mcu_fd_sc_mcu7t5v0__clkinv_8
Xgf180mcu_fd_sc_mcu7t5v0__nand2_1_7 vdd vss gf180mcu_fd_sc_mcu7t5v0__oai21_1_3/B gf180mcu_fd_sc_mcu7t5v0__or3_2_0/A1
+ gf180mcu_fd_sc_mcu7t5v0__xor3_1_7/Z vdd vss gf180mcu_fd_sc_mcu7t5v0__nand2_1
Xgf180mcu_fd_sc_mcu7t5v0__oai211_2_0 gf180mcu_fd_sc_mcu7t5v0__aoi21_4_0/ZN gf180mcu_fd_sc_mcu7t5v0__oai22_1_5/A1
+ gf180mcu_fd_sc_mcu7t5v0__and2_2_5/Z gf180mcu_fd_sc_mcu7t5v0__oai211_4_1/B gf180mcu_fd_sc_mcu7t5v0__inv_8_0/I
+ vdd vss vdd vss gf180mcu_fd_sc_mcu7t5v0__oai211_2
Xgf180mcu_fd_sc_mcu7t5v0__mux2_2_0 gf180mcu_fd_sc_mcu7t5v0__or3_4_0/Z vdd vss gf180mcu_fd_sc_mcu7t5v0__mux2_2_0/Z
+ gf180mcu_fd_sc_mcu7t5v0__nor4_4_1/A2 gf180mcu_fd_sc_mcu7t5v0__mux2_2_0/I1 vdd vss
+ gf180mcu_fd_sc_mcu7t5v0__mux2_2
Xgf180mcu_fd_sc_mcu7t5v0__mux4_4_13 gf180mcu_fd_sc_mcu7t5v0__mux4_4_13/I0 vss vdd
+ gf180mcu_fd_sc_mcu7t5v0__dffq_2_96/Q gf180mcu_fd_sc_mcu7t5v0__mux4_4_5/I1 gf180mcu_fd_sc_mcu7t5v0__inv_1_20/I
+ gf180mcu_fd_sc_mcu7t5v0__mux4_4_5/I0 gf180mcu_fd_sc_mcu7t5v0__dffq_4_32/Q gf180mcu_fd_sc_mcu7t5v0__mux4_4_13/Z
+ vdd vss gf180mcu_fd_sc_mcu7t5v0__mux4_4
Xgf180mcu_fd_sc_mcu7t5v0__and3_2_1 gf180mcu_fd_sc_mcu7t5v0__and3_2_1/A3 vdd vss gf180mcu_fd_sc_mcu7t5v0__and3_2_1/Z
+ gf180mcu_fd_sc_mcu7t5v0__nor4_4_1/A2 gf180mcu_fd_sc_mcu7t5v0__dffq_2_44/Q vdd vss
+ gf180mcu_fd_sc_mcu7t5v0__and3_2
Xgf180mcu_fd_sc_mcu7t5v0__oai21_2_3 gf180mcu_fd_sc_mcu7t5v0__oai21_2_3/A2 gf180mcu_fd_sc_mcu7t5v0__and2_2_3/A2
+ gf180mcu_fd_sc_mcu7t5v0__inv_2_0/I vss gf180mcu_fd_sc_mcu7t5v0__oai21_2_3/B vdd
+ vdd vss gf180mcu_fd_sc_mcu7t5v0__oai21_2
Xgf180mcu_fd_sc_mcu7t5v0__tiel_1 clk_PD vdd vss vdd vss gf180mcu_fd_sc_mcu7t5v0__tiel
Xgf180mcu_fd_sc_mcu7t5v0__nor2_1_101 vdd vss gf180mcu_fd_sc_mcu7t5v0__nor3_1_44/A3
+ gf180mcu_fd_sc_mcu7t5v0__nand4_2_5/A1 gf180mcu_fd_sc_mcu7t5v0__dffq_1_158/Q vdd
+ vss gf180mcu_fd_sc_mcu7t5v0__nor2_1
Xgf180mcu_fd_sc_mcu7t5v0__nor2_1_112 vdd vss gf180mcu_fd_sc_mcu7t5v0__xor3_1_66/A2
+ gf180mcu_fd_sc_mcu7t5v0__nor3_1_8/ZN gf180mcu_fd_sc_mcu7t5v0__nor2_1_116/ZN vdd
+ vss gf180mcu_fd_sc_mcu7t5v0__nor2_1
Xgf180mcu_fd_sc_mcu7t5v0__nor2_1_123 vdd vss gf180mcu_fd_sc_mcu7t5v0__oai21_1_83/A2
+ gf180mcu_fd_sc_mcu7t5v0__xor3_1_65/A1 gf180mcu_fd_sc_mcu7t5v0__xor2_1_80/Z vdd vss
+ gf180mcu_fd_sc_mcu7t5v0__nor2_1
Xgf180mcu_fd_sc_mcu7t5v0__xor3_1_102 gf180mcu_fd_sc_mcu7t5v0__nor3_1_29/A3 vdd vss
+ gf180mcu_fd_sc_mcu7t5v0__xor3_1_102/Z gf180mcu_fd_sc_mcu7t5v0__xor3_1_102/A1 gf180mcu_fd_sc_mcu7t5v0__xor3_1_102/A2
+ vdd vss gf180mcu_fd_sc_mcu7t5v0__xor3_1
Xgf180mcu_fd_sc_mcu7t5v0__nor2_1_134 vdd vss gf180mcu_fd_sc_mcu7t5v0__nor2_1_134/ZN
+ gf180mcu_fd_sc_mcu7t5v0__xor3_1_68/A1 gf180mcu_fd_sc_mcu7t5v0__or2_1_56/Z vdd vss
+ gf180mcu_fd_sc_mcu7t5v0__nor2_1
Xgf180mcu_fd_sc_mcu7t5v0__nor2_1_145 vdd vss gf180mcu_fd_sc_mcu7t5v0__dffq_2_32/D
+ gf180mcu_fd_sc_mcu7t5v0__or2_1_23/A1 gf180mcu_fd_sc_mcu7t5v0__nor2_1_145/A2 vdd
+ vss gf180mcu_fd_sc_mcu7t5v0__nor2_1
Xgf180mcu_fd_sc_mcu7t5v0__xor3_1_113 gf180mcu_fd_sc_mcu7t5v0__xor3_1_113/A3 vdd vss
+ gf180mcu_fd_sc_mcu7t5v0__xor3_1_113/Z gf180mcu_fd_sc_mcu7t5v0__dffq_2_81/Q gf180mcu_fd_sc_mcu7t5v0__xor3_1_113/A2
+ vdd vss gf180mcu_fd_sc_mcu7t5v0__xor3_1
Xgf180mcu_fd_sc_mcu7t5v0__nor2_1_156 vdd vss gf180mcu_fd_sc_mcu7t5v0__nor2_1_156/ZN
+ gf180mcu_fd_sc_mcu7t5v0__or2_4_3/Z gf180mcu_fd_sc_mcu7t5v0__nor2_1_156/A2 vdd vss
+ gf180mcu_fd_sc_mcu7t5v0__nor2_1
Xgf180mcu_fd_sc_mcu7t5v0__xor3_1_124 gf180mcu_fd_sc_mcu7t5v0__xor3_1_124/A3 vdd vss
+ gf180mcu_fd_sc_mcu7t5v0__xor3_1_124/Z gf180mcu_fd_sc_mcu7t5v0__xor3_1_124/A1 gf180mcu_fd_sc_mcu7t5v0__xor3_1_124/A2
+ vdd vss gf180mcu_fd_sc_mcu7t5v0__xor3_1
Xgf180mcu_fd_sc_mcu7t5v0__nor2_1_167 vdd vss gf180mcu_fd_sc_mcu7t5v0__oai21_1_125/B
+ gf180mcu_fd_sc_mcu7t5v0__inv_1_7/ZN gf180mcu_fd_sc_mcu7t5v0__nor2_2_22/A1 vdd vss
+ gf180mcu_fd_sc_mcu7t5v0__nor2_1
Xgf180mcu_fd_sc_mcu7t5v0__xor3_1_135 gf180mcu_fd_sc_mcu7t5v0__xor3_1_127/Z vdd vss
+ gf180mcu_fd_sc_mcu7t5v0__xor3_1_135/Z gf180mcu_fd_sc_mcu7t5v0__xor3_1_135/A1 gf180mcu_fd_sc_mcu7t5v0__xor3_1_135/A2
+ vdd vss gf180mcu_fd_sc_mcu7t5v0__xor3_1
Xgf180mcu_fd_sc_mcu7t5v0__xor3_1_146 gf180mcu_fd_sc_mcu7t5v0__xor3_1_146/A3 vdd vss
+ gf180mcu_fd_sc_mcu7t5v0__xor3_1_146/Z gf180mcu_fd_sc_mcu7t5v0__xor2_1_210/Z gf180mcu_fd_sc_mcu7t5v0__xor3_1_146/A2
+ vdd vss gf180mcu_fd_sc_mcu7t5v0__xor3_1
Xgf180mcu_fd_sc_mcu7t5v0__nor2_1_178 vdd vss gf180mcu_fd_sc_mcu7t5v0__or2_1_21/A2
+ gf180mcu_fd_sc_mcu7t5v0__or2_1_20/A1 gf180mcu_fd_sc_mcu7t5v0__dffq_2_53/Q vdd vss
+ gf180mcu_fd_sc_mcu7t5v0__nor2_1
Xgf180mcu_fd_sc_mcu7t5v0__nor2_1_189 vdd vss gf180mcu_fd_sc_mcu7t5v0__dffq_1_338/D
+ gf180mcu_fd_sc_mcu7t5v0__and2_1_59/Z gf180mcu_fd_sc_mcu7t5v0__nor2_1_189/A2 vdd
+ vss gf180mcu_fd_sc_mcu7t5v0__nor2_1
Xgf180mcu_fd_sc_mcu7t5v0__xor3_1_157 gf180mcu_fd_sc_mcu7t5v0__or2_1_37/Z vdd vss gf180mcu_fd_sc_mcu7t5v0__xor3_1_157/Z
+ gf180mcu_fd_sc_mcu7t5v0__mux4_4_18/I1 gf180mcu_fd_sc_mcu7t5v0__xor3_1_157/A2 vdd
+ vss gf180mcu_fd_sc_mcu7t5v0__xor3_1
Xgf180mcu_fd_sc_mcu7t5v0__xor3_1_168 gf180mcu_fd_sc_mcu7t5v0__nor2_1_33/ZN vdd vss
+ gf180mcu_fd_sc_mcu7t5v0__xor3_1_18/A3 gf180mcu_fd_sc_mcu7t5v0__xor3_1_168/A1 gf180mcu_fd_sc_mcu7t5v0__xor3_1_168/A2
+ vdd vss gf180mcu_fd_sc_mcu7t5v0__xor3_1
Xgf180mcu_fd_sc_mcu7t5v0__oai211_1_17 gf180mcu_fd_sc_mcu7t5v0__oai211_1_17/B gf180mcu_fd_sc_mcu7t5v0__nand3_4_7/ZN
+ vdd vss gf180mcu_fd_sc_mcu7t5v0__oai211_1_11/C gf180mcu_fd_sc_mcu7t5v0__inv_12_1/I
+ gf180mcu_fd_sc_mcu7t5v0__or4_1_1/A1 vdd vss gf180mcu_fd_sc_mcu7t5v0__oai211_1
Xgf180mcu_fd_sc_mcu7t5v0__nand2_1_360 vdd vss gf180mcu_fd_sc_mcu7t5v0__nand2_1_360/ZN
+ gf180mcu_fd_sc_mcu7t5v0__dffq_1_367/Q gf180mcu_fd_sc_mcu7t5v0__inv_2_8/I vdd vss
+ gf180mcu_fd_sc_mcu7t5v0__nand2_1
Xgf180mcu_fd_sc_mcu7t5v0__oai211_1_28 gf180mcu_fd_sc_mcu7t5v0__oai31_1_14/ZN gf180mcu_fd_sc_mcu7t5v0__or2_1_34/A2
+ vdd vss gf180mcu_fd_sc_mcu7t5v0__and3_1_14/A2 gf180mcu_fd_sc_mcu7t5v0__oai31_1_14/B
+ gf180mcu_fd_sc_mcu7t5v0__xor3_1_104/Z vdd vss gf180mcu_fd_sc_mcu7t5v0__oai211_1
Xgf180mcu_fd_sc_mcu7t5v0__nand2_1_371 vdd vss gf180mcu_fd_sc_mcu7t5v0__oai21_1_293/A1
+ gf180mcu_fd_sc_mcu7t5v0__or2_1_24/A2 gf180mcu_fd_sc_mcu7t5v0__xnor2_1_87/A2 vdd
+ vss gf180mcu_fd_sc_mcu7t5v0__nand2_1
Xgf180mcu_fd_sc_mcu7t5v0__oai211_1_39 gf180mcu_fd_sc_mcu7t5v0__oai211_1_39/B gf180mcu_fd_sc_mcu7t5v0__or2_1_34/A2
+ vdd vss gf180mcu_fd_sc_mcu7t5v0__oai211_1_38/C gf180mcu_fd_sc_mcu7t5v0__oai211_1_43/C
+ gf180mcu_fd_sc_mcu7t5v0__oai211_1_39/A2 vdd vss gf180mcu_fd_sc_mcu7t5v0__oai211_1
Xgf180mcu_fd_sc_mcu7t5v0__nand3_4_15 gf180mcu_fd_sc_mcu7t5v0__or2_1_36/A2 vdd vss
+ gf180mcu_fd_sc_mcu7t5v0__and2_2_10/A1 gf180mcu_fd_sc_mcu7t5v0__inv_2_3/ZN gf180mcu_fd_sc_mcu7t5v0__inv_4_4/ZN
+ vdd vss gf180mcu_fd_sc_mcu7t5v0__nand3_4
Xgf180mcu_fd_sc_mcu7t5v0__nand2_1_382 vdd vss gf180mcu_fd_sc_mcu7t5v0__nand2_1_382/ZN
+ gf180mcu_fd_sc_mcu7t5v0__mux4_4_4/I0 gf180mcu_fd_sc_mcu7t5v0__or2_4_4/Z vdd vss
+ gf180mcu_fd_sc_mcu7t5v0__nand2_1
Xgf180mcu_fd_sc_mcu7t5v0__nand2_1_393 vdd vss gf180mcu_fd_sc_mcu7t5v0__nor2_1_229/A2
+ gf180mcu_fd_sc_mcu7t5v0__dffq_1_396/Q gf180mcu_fd_sc_mcu7t5v0__nor4_4_2/A3 vdd vss
+ gf180mcu_fd_sc_mcu7t5v0__nand2_1
Xgf180mcu_fd_sc_mcu7t5v0__oai21_1_205 vdd gf180mcu_fd_sc_mcu7t5v0__oai21_1_205/B gf180mcu_fd_sc_mcu7t5v0__xor2_1_147/Z
+ gf180mcu_fd_sc_mcu7t5v0__xor3_1_77/A2 gf180mcu_fd_sc_mcu7t5v0__xor2_1_146/A1 vss
+ vdd vss gf180mcu_fd_sc_mcu7t5v0__oai21_1
Xgf180mcu_fd_sc_mcu7t5v0__oai21_1_216 vdd gf180mcu_fd_sc_mcu7t5v0__oai21_1_216/B gf180mcu_fd_sc_mcu7t5v0__mux4_4_7/Z
+ gf180mcu_fd_sc_mcu7t5v0__nand4_1_12/A4 gf180mcu_fd_sc_mcu7t5v0__dffq_4_37/Q vss
+ vdd vss gf180mcu_fd_sc_mcu7t5v0__oai21_1
Xgf180mcu_fd_sc_mcu7t5v0__oai21_1_227 vdd gf180mcu_fd_sc_mcu7t5v0__oai21_1_227/B gf180mcu_fd_sc_mcu7t5v0__oai21_1_227/A2
+ gf180mcu_fd_sc_mcu7t5v0__oai21_1_221/B gf180mcu_fd_sc_mcu7t5v0__mux2_1_9/I0 vss
+ vdd vss gf180mcu_fd_sc_mcu7t5v0__oai21_1
Xgf180mcu_fd_sc_mcu7t5v0__oai21_1_238 vdd gf180mcu_fd_sc_mcu7t5v0__buf_12_0/Z gf180mcu_fd_sc_mcu7t5v0__buf_20_0/Z
+ gf180mcu_fd_sc_mcu7t5v0__aoi21_1_235/B gf180mcu_fd_sc_mcu7t5v0__dffq_1_420/Q vss
+ vdd vss gf180mcu_fd_sc_mcu7t5v0__oai21_1
Xgf180mcu_fd_sc_mcu7t5v0__oai21_1_249 vdd gf180mcu_fd_sc_mcu7t5v0__nor2_4_45/ZN gf180mcu_fd_sc_mcu7t5v0__nor3_4_18/ZN
+ gf180mcu_fd_sc_mcu7t5v0__oai211_1_35/B gf180mcu_fd_sc_mcu7t5v0__nor2_2_40/ZN vss
+ vdd vss gf180mcu_fd_sc_mcu7t5v0__oai21_1
Xgf180mcu_fd_sc_mcu7t5v0__nand3_4_5 gf180mcu_fd_sc_mcu7t5v0__inv_4_1/ZN vdd vss gf180mcu_fd_sc_mcu7t5v0__and2_4_0/A1
+ gf180mcu_fd_sc_mcu7t5v0__inv_2_3/ZN gf180mcu_fd_sc_mcu7t5v0__inv_3_0/I vdd vss gf180mcu_fd_sc_mcu7t5v0__nand3_4
Xgf180mcu_fd_sc_mcu7t5v0__clkinv_1_340 vdd vss gf180mcu_fd_sc_mcu7t5v0__dffq_2_14/Q
+ gf180mcu_fd_sc_mcu7t5v0__aoi21_2_15/A1 vdd vss gf180mcu_fd_sc_mcu7t5v0__clkinv_1
Xgf180mcu_fd_sc_mcu7t5v0__clkinv_1_351 vdd vss gf180mcu_fd_sc_mcu7t5v0__xor2_1_160/Z
+ gf180mcu_fd_sc_mcu7t5v0__aoi21_1_327/A1 vdd vss gf180mcu_fd_sc_mcu7t5v0__clkinv_1
Xgf180mcu_fd_sc_mcu7t5v0__clkinv_1_362 vdd vss gf180mcu_fd_sc_mcu7t5v0__dffq_1_456/Q
+ gf180mcu_fd_sc_mcu7t5v0__oai22_1_182/B2 vdd vss gf180mcu_fd_sc_mcu7t5v0__clkinv_1
Xgf180mcu_fd_sc_mcu7t5v0__clkinv_3_12 vdd gf180mcu_fd_sc_mcu7t5v0__oai32_1_6/A2 gf180mcu_fd_sc_mcu7t5v0__dffq_2_97/Q
+ vss vdd vss gf180mcu_fd_sc_mcu7t5v0__clkinv_3
Xgf180mcu_fd_sc_mcu7t5v0__clkinv_3_23 vdd gf180mcu_fd_sc_mcu7t5v0__xor2_1_157/A1 gf180mcu_fd_sc_mcu7t5v0__mux4_4_19/I1
+ vss vdd vss gf180mcu_fd_sc_mcu7t5v0__clkinv_3
Xgf180mcu_fd_sc_mcu7t5v0__nand2_1_190 vdd vss gf180mcu_fd_sc_mcu7t5v0__nand2_1_190/ZN
+ gf180mcu_fd_sc_mcu7t5v0__or2_1_7/A1 gf180mcu_fd_sc_mcu7t5v0__or2_1_16/A2 vdd vss
+ gf180mcu_fd_sc_mcu7t5v0__nand2_1
Xgf180mcu_fd_sc_mcu7t5v0__aoi221_1_6 gf180mcu_fd_sc_mcu7t5v0__aoi221_1_6/B2 gf180mcu_fd_sc_mcu7t5v0__aoi21_1_7/B
+ vdd vss gf180mcu_fd_sc_mcu7t5v0__dffq_2_13/D gf180mcu_fd_sc_mcu7t5v0__xor3_1_22/A1
+ gf180mcu_fd_sc_mcu7t5v0__or2_4_4/Z gf180mcu_fd_sc_mcu7t5v0__nand2_1_85/ZN vdd vss
+ gf180mcu_fd_sc_mcu7t5v0__aoi221_1
Xgf180mcu_fd_sc_mcu7t5v0__nor2_1_8 vdd vss gf180mcu_fd_sc_mcu7t5v0__nor2_1_8/ZN gf180mcu_fd_sc_mcu7t5v0__or3_1_0/A1
+ gf180mcu_fd_sc_mcu7t5v0__or3_1_0/A2 vdd vss gf180mcu_fd_sc_mcu7t5v0__nor2_1
Xgf180mcu_fd_sc_mcu7t5v0__nand3_2_2 gf180mcu_fd_sc_mcu7t5v0__and2_4_1/A2 vdd vss gf180mcu_fd_sc_mcu7t5v0__oai32_1_3/B1
+ gf180mcu_fd_sc_mcu7t5v0__inv_8_1/I gf180mcu_fd_sc_mcu7t5v0__and2_4_1/A1 vdd vss
+ gf180mcu_fd_sc_mcu7t5v0__nand3_2
Xgf180mcu_fd_sc_mcu7t5v0__xor2_1_16 vdd vss gf180mcu_fd_sc_mcu7t5v0__xor2_1_16/Z gf180mcu_fd_sc_mcu7t5v0__nor3_4_0/A2
+ gf180mcu_fd_sc_mcu7t5v0__xor3_1_12/A3 vdd vss gf180mcu_fd_sc_mcu7t5v0__xor2_1
Xgf180mcu_fd_sc_mcu7t5v0__xor2_1_27 vdd vss gf180mcu_fd_sc_mcu7t5v0__xor2_1_27/Z gf180mcu_fd_sc_mcu7t5v0__xor2_1_27/A1
+ gf180mcu_fd_sc_mcu7t5v0__xor2_1_27/A2 vdd vss gf180mcu_fd_sc_mcu7t5v0__xor2_1
Xgf180mcu_fd_sc_mcu7t5v0__xor2_1_38 vdd vss gf180mcu_fd_sc_mcu7t5v0__or3_1_5/A3 gf180mcu_fd_sc_mcu7t5v0__xor2_1_38/A1
+ gf180mcu_fd_sc_mcu7t5v0__xor2_1_38/A2 vdd vss gf180mcu_fd_sc_mcu7t5v0__xor2_1
Xgf180mcu_fd_sc_mcu7t5v0__xor2_1_101 vdd vss gf180mcu_fd_sc_mcu7t5v0__xor2_1_101/Z
+ gf180mcu_fd_sc_mcu7t5v0__xor2_1_101/A1 gf180mcu_fd_sc_mcu7t5v0__xor2_1_101/A2 vdd
+ vss gf180mcu_fd_sc_mcu7t5v0__xor2_1
Xgf180mcu_fd_sc_mcu7t5v0__xor2_1_49 vdd vss gf180mcu_fd_sc_mcu7t5v0__xor2_1_49/Z gf180mcu_fd_sc_mcu7t5v0__or4_1_1/A3
+ gf180mcu_fd_sc_mcu7t5v0__xor2_1_49/A2 vdd vss gf180mcu_fd_sc_mcu7t5v0__xor2_1
Xgf180mcu_fd_sc_mcu7t5v0__xor2_1_112 vdd vss gf180mcu_fd_sc_mcu7t5v0__or2_1_40/A2
+ gf180mcu_fd_sc_mcu7t5v0__xor2_1_112/A1 gf180mcu_fd_sc_mcu7t5v0__xor2_1_116/Z vdd
+ vss gf180mcu_fd_sc_mcu7t5v0__xor2_1
Xgf180mcu_fd_sc_mcu7t5v0__xor2_1_123 vdd vss gf180mcu_fd_sc_mcu7t5v0__xor2_1_123/Z
+ gf180mcu_fd_sc_mcu7t5v0__nor2_2_30/ZN gf180mcu_fd_sc_mcu7t5v0__xor2_1_123/A2 vdd
+ vss gf180mcu_fd_sc_mcu7t5v0__xor2_1
Xgf180mcu_fd_sc_mcu7t5v0__xor2_1_134 vdd vss gf180mcu_fd_sc_mcu7t5v0__xor2_1_134/Z
+ gf180mcu_fd_sc_mcu7t5v0__xor3_2_1/A1 gf180mcu_fd_sc_mcu7t5v0__xor3_2_1/A3 vdd vss
+ gf180mcu_fd_sc_mcu7t5v0__xor2_1
Xgf180mcu_fd_sc_mcu7t5v0__xor2_1_145 vdd vss gf180mcu_fd_sc_mcu7t5v0__xor2_1_145/Z
+ gf180mcu_fd_sc_mcu7t5v0__xor2_1_145/A1 gf180mcu_fd_sc_mcu7t5v0__xor3_1_105/Z vdd
+ vss gf180mcu_fd_sc_mcu7t5v0__xor2_1
Xgf180mcu_fd_sc_mcu7t5v0__xor2_1_156 vdd vss gf180mcu_fd_sc_mcu7t5v0__or3_1_20/A3
+ gf180mcu_fd_sc_mcu7t5v0__inv_2_11/I gf180mcu_fd_sc_mcu7t5v0__xor2_1_128/Z vdd vss
+ gf180mcu_fd_sc_mcu7t5v0__xor2_1
Xgf180mcu_fd_sc_mcu7t5v0__xor2_1_167 vdd vss gf180mcu_fd_sc_mcu7t5v0__xor2_1_167/Z
+ gf180mcu_fd_sc_mcu7t5v0__mux4_4_15/Z gf180mcu_fd_sc_mcu7t5v0__xor3_1_129/A3 vdd
+ vss gf180mcu_fd_sc_mcu7t5v0__xor2_1
Xgf180mcu_fd_sc_mcu7t5v0__xor2_1_178 vdd vss gf180mcu_fd_sc_mcu7t5v0__xor2_1_178/Z
+ gf180mcu_fd_sc_mcu7t5v0__xor3_1_137/A2 gf180mcu_fd_sc_mcu7t5v0__xor3_1_137/A3 vdd
+ vss gf180mcu_fd_sc_mcu7t5v0__xor2_1
Xgf180mcu_fd_sc_mcu7t5v0__xor2_1_189 vdd vss gf180mcu_fd_sc_mcu7t5v0__xor2_1_189/Z
+ gf180mcu_fd_sc_mcu7t5v0__and4_1_3/A4 gf180mcu_fd_sc_mcu7t5v0__nor4_4_4/ZN vdd vss
+ gf180mcu_fd_sc_mcu7t5v0__xor2_1
Xgf180mcu_fd_sc_mcu7t5v0__nor3_1_40 gf180mcu_fd_sc_mcu7t5v0__nor3_1_40/A3 vdd vss
+ gf180mcu_fd_sc_mcu7t5v0__nor3_1_40/ZN gf180mcu_fd_sc_mcu7t5v0__nor3_1_40/A1 gf180mcu_fd_sc_mcu7t5v0__nor3_1_40/A2
+ vdd vss gf180mcu_fd_sc_mcu7t5v0__nor3_1
Xgf180mcu_fd_sc_mcu7t5v0__clkinv_1_170 vdd vss gf180mcu_fd_sc_mcu7t5v0__dffq_1_151/Q
+ gf180mcu_fd_sc_mcu7t5v0__oai22_1_155/B2 vdd vss gf180mcu_fd_sc_mcu7t5v0__clkinv_1
Xgf180mcu_fd_sc_mcu7t5v0__clkinv_1_181 vdd vss gf180mcu_fd_sc_mcu7t5v0__dffq_1_186/Q
+ gf180mcu_fd_sc_mcu7t5v0__oai22_1_168/B2 vdd vss gf180mcu_fd_sc_mcu7t5v0__clkinv_1
Xgf180mcu_fd_sc_mcu7t5v0__clkinv_1_192 vdd vss gf180mcu_fd_sc_mcu7t5v0__dffq_1_189/Q
+ gf180mcu_fd_sc_mcu7t5v0__oai22_1_179/B2 vdd vss gf180mcu_fd_sc_mcu7t5v0__clkinv_1
Xgf180mcu_fd_sc_mcu7t5v0__nand3_1_16 gf180mcu_fd_sc_mcu7t5v0__xor2_1_19/Z vdd vss
+ gf180mcu_fd_sc_mcu7t5v0__oai21_1_40/B gf180mcu_fd_sc_mcu7t5v0__inv_4_6/I gf180mcu_fd_sc_mcu7t5v0__and2_4_2/Z
+ vdd vss gf180mcu_fd_sc_mcu7t5v0__nand3_1
Xgf180mcu_fd_sc_mcu7t5v0__nand3_1_27 gf180mcu_fd_sc_mcu7t5v0__aoi22_2_4/ZN vdd vss
+ gf180mcu_fd_sc_mcu7t5v0__nand3_1_27/ZN gf180mcu_fd_sc_mcu7t5v0__or3_1_9/A1 gf180mcu_fd_sc_mcu7t5v0__nand3_2_17/ZN
+ vdd vss gf180mcu_fd_sc_mcu7t5v0__nand3_1
Xgf180mcu_fd_sc_mcu7t5v0__nand3_1_38 gf180mcu_fd_sc_mcu7t5v0__nand3_1_38/A3 vdd vss
+ gf180mcu_fd_sc_mcu7t5v0__and2_1_51/A2 gf180mcu_fd_sc_mcu7t5v0__nand3_1_38/A1 gf180mcu_fd_sc_mcu7t5v0__nand3_1_38/A2
+ vdd vss gf180mcu_fd_sc_mcu7t5v0__nand3_1
Xgf180mcu_fd_sc_mcu7t5v0__nand3_1_49 gf180mcu_fd_sc_mcu7t5v0__or3_4_0/A3 vdd vss gf180mcu_fd_sc_mcu7t5v0__nand3_1_49/ZN
+ gf180mcu_fd_sc_mcu7t5v0__or3_4_0/A1 gf180mcu_fd_sc_mcu7t5v0__nor3_4_12/A2 vdd vss
+ gf180mcu_fd_sc_mcu7t5v0__nand3_1
Xgf180mcu_fd_sc_mcu7t5v0__oai32_1_6 gf180mcu_fd_sc_mcu7t5v0__oai32_1_6/A3 gf180mcu_fd_sc_mcu7t5v0__oai32_1_6/B1
+ gf180mcu_fd_sc_mcu7t5v0__mux2_1_9/I0 vdd vss gf180mcu_fd_sc_mcu7t5v0__oai32_1_6/ZN
+ gf180mcu_fd_sc_mcu7t5v0__or4_1_0/A2 gf180mcu_fd_sc_mcu7t5v0__oai32_1_6/A2 vdd vss
+ gf180mcu_fd_sc_mcu7t5v0__oai32_1
Xgf180mcu_fd_sc_mcu7t5v0__aoi221_1_11 gf180mcu_fd_sc_mcu7t5v0__and2_2_8/Z gf180mcu_fd_sc_mcu7t5v0__aoi221_1_11/C
+ vdd vss gf180mcu_fd_sc_mcu7t5v0__aoi221_1_7/B2 gf180mcu_fd_sc_mcu7t5v0__nor2_2_10/ZN
+ gf180mcu_fd_sc_mcu7t5v0__nand2_1_172/A2 gf180mcu_fd_sc_mcu7t5v0__xor3_1_51/Z vdd
+ vss gf180mcu_fd_sc_mcu7t5v0__aoi221_1
Xgf180mcu_fd_sc_mcu7t5v0__aoi221_1_22 gf180mcu_fd_sc_mcu7t5v0__aoi221_1_22/B2 gf180mcu_fd_sc_mcu7t5v0__aoi21_1_7/B
+ vdd vss gf180mcu_fd_sc_mcu7t5v0__dffq_2_37/D gf180mcu_fd_sc_mcu7t5v0__nand2_1_334/A1
+ gf180mcu_fd_sc_mcu7t5v0__or2_4_4/Z gf180mcu_fd_sc_mcu7t5v0__nand2_1_321/ZN vdd vss
+ gf180mcu_fd_sc_mcu7t5v0__aoi221_1
Xgf180mcu_fd_sc_mcu7t5v0__aoi221_1_33 gf180mcu_fd_sc_mcu7t5v0__inv_4_2/I gf180mcu_fd_sc_mcu7t5v0__nor2_1_224/ZN
+ vdd vss gf180mcu_fd_sc_mcu7t5v0__nor2_1_223/A2 gf180mcu_fd_sc_mcu7t5v0__dffq_1_393/Q
+ gf180mcu_fd_sc_mcu7t5v0__or2_4_3/Z gf180mcu_fd_sc_mcu7t5v0__nor2_4_32/ZN vdd vss
+ gf180mcu_fd_sc_mcu7t5v0__aoi221_1
Xgf180mcu_fd_sc_mcu7t5v0__aoi221_1_44 gf180mcu_fd_sc_mcu7t5v0__nor2_1_271/ZN gf180mcu_fd_sc_mcu7t5v0__oai32_1_8/A1
+ vdd vss gf180mcu_fd_sc_mcu7t5v0__oai21_1_227/B gf180mcu_fd_sc_mcu7t5v0__dffq_4_37/Q
+ gf180mcu_fd_sc_mcu7t5v0__nor2_2_37/ZN gf180mcu_fd_sc_mcu7t5v0__oai21_1_227/A2 vdd
+ vss gf180mcu_fd_sc_mcu7t5v0__aoi221_1
Xgf180mcu_fd_sc_mcu7t5v0__aoi221_1_55 gf180mcu_fd_sc_mcu7t5v0__oai21_1_294/A2 gf180mcu_fd_sc_mcu7t5v0__nor2_2_46/ZN
+ vdd vss gf180mcu_fd_sc_mcu7t5v0__oai21_1_294/B gf180mcu_fd_sc_mcu7t5v0__inv_4_6/I
+ gf180mcu_fd_sc_mcu7t5v0__or4_1_3/A1 gf180mcu_fd_sc_mcu7t5v0__nor3_4_21/ZN vdd vss
+ gf180mcu_fd_sc_mcu7t5v0__aoi221_1
Xgf180mcu_fd_sc_mcu7t5v0__aoi221_1_66 gf180mcu_fd_sc_mcu7t5v0__oai21_1_337/A2 gf180mcu_fd_sc_mcu7t5v0__nor2_2_44/ZN
+ vdd vss gf180mcu_fd_sc_mcu7t5v0__oai21_1_337/B gf180mcu_fd_sc_mcu7t5v0__dffq_4_37/Q
+ gf180mcu_fd_sc_mcu7t5v0__nor2_4_37/ZN gf180mcu_fd_sc_mcu7t5v0__nor3_4_17/ZN vdd
+ vss gf180mcu_fd_sc_mcu7t5v0__aoi221_1
Xgf180mcu_fd_sc_mcu7t5v0__nor3_4_6 gf180mcu_fd_sc_mcu7t5v0__mux2_4_3/Z vdd vss gf180mcu_fd_sc_mcu7t5v0__nor3_4_6/ZN
+ gf180mcu_fd_sc_mcu7t5v0__mux2_2_0/Z gf180mcu_fd_sc_mcu7t5v0__or2_2_0/A2 vdd vss
+ gf180mcu_fd_sc_mcu7t5v0__nor3_4
Xgf180mcu_fd_sc_mcu7t5v0__xnor3_1_4 gf180mcu_fd_sc_mcu7t5v0__xor3_1_0/Z vdd vss gf180mcu_fd_sc_mcu7t5v0__xnor3_1_4/ZN
+ gf180mcu_fd_sc_mcu7t5v0__xor3_1_6/A1 gf180mcu_fd_sc_mcu7t5v0__xor3_1_6/A2 vdd vss
+ gf180mcu_fd_sc_mcu7t5v0__xnor3_1
Xgf180mcu_fd_sc_mcu7t5v0__or4_1_2 gf180mcu_fd_sc_mcu7t5v0__or4_1_2/A3 gf180mcu_fd_sc_mcu7t5v0__or4_1_2/A4
+ vdd vss gf180mcu_fd_sc_mcu7t5v0__or4_1_2/Z gf180mcu_fd_sc_mcu7t5v0__or4_1_2/A1 gf180mcu_fd_sc_mcu7t5v0__or4_1_2/A2
+ vdd vss gf180mcu_fd_sc_mcu7t5v0__or4_1
Xgf180mcu_fd_sc_mcu7t5v0__oai31_1_10 vdd gf180mcu_fd_sc_mcu7t5v0__dffq_1_388/D gf180mcu_fd_sc_mcu7t5v0__oai31_1_10/B
+ gf180mcu_fd_sc_mcu7t5v0__or2_1_23/A1 gf180mcu_fd_sc_mcu7t5v0__oai31_1_10/A2 vss
+ gf180mcu_fd_sc_mcu7t5v0__nand4_4_2/ZN vdd vss gf180mcu_fd_sc_mcu7t5v0__oai31_1
Xgf180mcu_fd_sc_mcu7t5v0__oai31_1_21 vdd gf180mcu_fd_sc_mcu7t5v0__xnor2_1_88/A2 gf180mcu_fd_sc_mcu7t5v0__oai31_1_21/B
+ gf180mcu_fd_sc_mcu7t5v0__inv_1_13/ZN gf180mcu_fd_sc_mcu7t5v0__or3_1_12/A2 vss gf180mcu_fd_sc_mcu7t5v0__inv_1_14/I
+ vdd vss gf180mcu_fd_sc_mcu7t5v0__oai31_1
Xgf180mcu_fd_sc_mcu7t5v0__nand2_1_60 vdd vss gf180mcu_fd_sc_mcu7t5v0__oai211_1_6/B
+ gf180mcu_fd_sc_mcu7t5v0__or2_1_4/A1 gf180mcu_fd_sc_mcu7t5v0__xor3_1_16/Z vdd vss
+ gf180mcu_fd_sc_mcu7t5v0__nand2_1
Xgf180mcu_fd_sc_mcu7t5v0__nand2_1_71 vdd vss gf180mcu_fd_sc_mcu7t5v0__and2_1_13/A2
+ gf180mcu_fd_sc_mcu7t5v0__or2_1_7/A1 gf180mcu_fd_sc_mcu7t5v0__or2_1_7/A2 vdd vss
+ gf180mcu_fd_sc_mcu7t5v0__nand2_1
Xgf180mcu_fd_sc_mcu7t5v0__nand2_1_82 vdd vss gf180mcu_fd_sc_mcu7t5v0__oai21_2_4/B
+ gf180mcu_fd_sc_mcu7t5v0__dffq_2_41/Q gf180mcu_fd_sc_mcu7t5v0__dffq_4_4/Q vdd vss
+ gf180mcu_fd_sc_mcu7t5v0__nand2_1
Xgf180mcu_fd_sc_mcu7t5v0__nand2_1_93 vdd vss gf180mcu_fd_sc_mcu7t5v0__mux2_1_3/I0
+ gf180mcu_fd_sc_mcu7t5v0__or4_1_0/A1 gf180mcu_fd_sc_mcu7t5v0__or4_1_1/A3 vdd vss
+ gf180mcu_fd_sc_mcu7t5v0__nand2_1
Xgf180mcu_fd_sc_mcu7t5v0__and2_1_7 vdd vss gf180mcu_fd_sc_mcu7t5v0__and2_1_7/Z gf180mcu_fd_sc_mcu7t5v0__or4_1_0/A1
+ gf180mcu_fd_sc_mcu7t5v0__xor2_1_41/Z vdd vss gf180mcu_fd_sc_mcu7t5v0__and2_1
Xgf180mcu_fd_sc_mcu7t5v0__aoi222_2_1 gf180mcu_fd_sc_mcu7t5v0__nor2_4_13/ZN gf180mcu_fd_sc_mcu7t5v0__aoi222_2_1/B1
+ gf180mcu_fd_sc_mcu7t5v0__aoi222_2_1/A2 gf180mcu_fd_sc_mcu7t5v0__nor2_4_7/ZN gf180mcu_fd_sc_mcu7t5v0__nand3_1_43/A2
+ vss vdd gf180mcu_fd_sc_mcu7t5v0__nor3_4_6/ZN gf180mcu_fd_sc_mcu7t5v0__aoi222_2_1/C1
+ vdd vss gf180mcu_fd_sc_mcu7t5v0__aoi222_2
Xgf180mcu_fd_sc_mcu7t5v0__nor3_2_3 gf180mcu_fd_sc_mcu7t5v0__or3_4_0/A3 vdd vss gf180mcu_fd_sc_mcu7t5v0__nor3_2_3/ZN
+ gf180mcu_fd_sc_mcu7t5v0__or3_4_0/A1 gf180mcu_fd_sc_mcu7t5v0__or3_4_0/A2 vdd vss
+ gf180mcu_fd_sc_mcu7t5v0__nor3_2
Xgf180mcu_fd_sc_mcu7t5v0__dffq_1_308 vdd gf180mcu_fd_sc_mcu7t5v0__dffq_1_308/Q gf180mcu_fd_sc_mcu7t5v0__dffq_4_9/CLK
+ vss gf180mcu_fd_sc_mcu7t5v0__dffq_1_308/D vdd vss gf180mcu_fd_sc_mcu7t5v0__dffq_1
Xgf180mcu_fd_sc_mcu7t5v0__dffq_1_319 vdd gf180mcu_fd_sc_mcu7t5v0__inv_4_3/I gf180mcu_fd_sc_mcu7t5v0__dffq_4_9/CLK
+ vss gf180mcu_fd_sc_mcu7t5v0__dffq_1_319/D vdd vss gf180mcu_fd_sc_mcu7t5v0__dffq_1
Xgf180mcu_fd_sc_mcu7t5v0__aoi21_4_4 gf180mcu_fd_sc_mcu7t5v0__or3_4_0/Z gf180mcu_fd_sc_mcu7t5v0__aoi21_4_4/B
+ vdd vss gf180mcu_fd_sc_mcu7t5v0__aoi21_4_4/ZN gf180mcu_fd_sc_mcu7t5v0__mux4_4_3/I0
+ vdd vss gf180mcu_fd_sc_mcu7t5v0__aoi21_4
Xgf180mcu_fd_sc_mcu7t5v0__nand2_1_701 vdd vss gf180mcu_fd_sc_mcu7t5v0__xnor3_1_44/A1
+ gf180mcu_fd_sc_mcu7t5v0__inv_8_0/I gf180mcu_fd_sc_mcu7t5v0__and4_1_3/A4 vdd vss
+ gf180mcu_fd_sc_mcu7t5v0__nand2_1
Xgf180mcu_fd_sc_mcu7t5v0__nand2_1_712 vdd vss gf180mcu_fd_sc_mcu7t5v0__and2_1_88/A1
+ gf180mcu_fd_sc_mcu7t5v0__inv_8_1/I gf180mcu_fd_sc_mcu7t5v0__mux4_4_19/Z vdd vss
+ gf180mcu_fd_sc_mcu7t5v0__nand2_1
Xgf180mcu_fd_sc_mcu7t5v0__nand2_1_723 vdd vss gf180mcu_fd_sc_mcu7t5v0__xor2_1_83/A2
+ gf180mcu_fd_sc_mcu7t5v0__inv_12_1/I gf180mcu_fd_sc_mcu7t5v0__mux4_4_3/Z vdd vss
+ gf180mcu_fd_sc_mcu7t5v0__nand2_1
Xgf180mcu_fd_sc_mcu7t5v0__and2_1_20 vdd vss gf180mcu_fd_sc_mcu7t5v0__and2_1_20/Z gf180mcu_fd_sc_mcu7t5v0__xor3_1_28/A1
+ gf180mcu_fd_sc_mcu7t5v0__mux2_1_3/Z vdd vss gf180mcu_fd_sc_mcu7t5v0__and2_1
Xgf180mcu_fd_sc_mcu7t5v0__and2_1_31 vdd vss gf180mcu_fd_sc_mcu7t5v0__and2_1_31/Z gf180mcu_fd_sc_mcu7t5v0__inv_4_6/I
+ gf180mcu_fd_sc_mcu7t5v0__xor2_1_55/A2 vdd vss gf180mcu_fd_sc_mcu7t5v0__and2_1
Xgf180mcu_fd_sc_mcu7t5v0__and2_1_42 vdd vss gf180mcu_fd_sc_mcu7t5v0__and2_1_42/Z gf180mcu_fd_sc_mcu7t5v0__and2_1_42/A1
+ gf180mcu_fd_sc_mcu7t5v0__and2_1_42/A2 vdd vss gf180mcu_fd_sc_mcu7t5v0__and2_1
Xgf180mcu_fd_sc_mcu7t5v0__and2_1_53 vdd vss gf180mcu_fd_sc_mcu7t5v0__and2_1_53/Z gf180mcu_fd_sc_mcu7t5v0__dffq_1_351/Q
+ gf180mcu_fd_sc_mcu7t5v0__and3_1_10/Z vdd vss gf180mcu_fd_sc_mcu7t5v0__and2_1
Xgf180mcu_fd_sc_mcu7t5v0__and2_1_64 vdd vss gf180mcu_fd_sc_mcu7t5v0__and2_1_64/Z gf180mcu_fd_sc_mcu7t5v0__nor3_1_17/A1
+ gf180mcu_fd_sc_mcu7t5v0__and2_1_67/Z vdd vss gf180mcu_fd_sc_mcu7t5v0__and2_1
Xgf180mcu_fd_sc_mcu7t5v0__and2_1_75 vdd vss gf180mcu_fd_sc_mcu7t5v0__and2_1_75/Z gf180mcu_fd_sc_mcu7t5v0__buf_8_8/Z
+ gf180mcu_fd_sc_mcu7t5v0__nor4_4_2/A3 vdd vss gf180mcu_fd_sc_mcu7t5v0__and2_1
Xgf180mcu_fd_sc_mcu7t5v0__and2_1_86 vdd vss gf180mcu_fd_sc_mcu7t5v0__dffq_4_20/D gf180mcu_fd_sc_mcu7t5v0__buf_8_7/Z
+ gf180mcu_fd_sc_mcu7t5v0__or3_2_4/A3 vdd vss gf180mcu_fd_sc_mcu7t5v0__and2_1
Xgf180mcu_fd_sc_mcu7t5v0__and2_1_97 vdd vss gf180mcu_fd_sc_mcu7t5v0__and2_1_97/Z gf180mcu_fd_sc_mcu7t5v0__nor2_4_33/ZN
+ gf180mcu_fd_sc_mcu7t5v0__xor3_1_80/Z vdd vss gf180mcu_fd_sc_mcu7t5v0__and2_1
Xgf180mcu_fd_sc_mcu7t5v0__aoi211_1_10 gf180mcu_fd_sc_mcu7t5v0__nor2_1_47/ZN gf180mcu_fd_sc_mcu7t5v0__or2_1_23/A1
+ vdd vss gf180mcu_fd_sc_mcu7t5v0__dffq_1_3/D gf180mcu_fd_sc_mcu7t5v0__inv_4_3/ZN
+ gf180mcu_fd_sc_mcu7t5v0__nor2_4_15/ZN vdd vss gf180mcu_fd_sc_mcu7t5v0__aoi211_1
Xgf180mcu_fd_sc_mcu7t5v0__aoi211_1_21 gf180mcu_fd_sc_mcu7t5v0__aoi21_1_88/ZN gf180mcu_fd_sc_mcu7t5v0__xor3_1_38/Z
+ vdd vss gf180mcu_fd_sc_mcu7t5v0__xor3_1_37/A1 gf180mcu_fd_sc_mcu7t5v0__oai31_1_3/A1
+ gf180mcu_fd_sc_mcu7t5v0__inv_1_4/ZN vdd vss gf180mcu_fd_sc_mcu7t5v0__aoi211_1
Xgf180mcu_fd_sc_mcu7t5v0__aoi211_1_32 gf180mcu_fd_sc_mcu7t5v0__nor2_1_136/ZN gf180mcu_fd_sc_mcu7t5v0__or2_1_23/A1
+ vdd vss gf180mcu_fd_sc_mcu7t5v0__dffq_1_280/D gf180mcu_fd_sc_mcu7t5v0__inv_4_2/ZN
+ gf180mcu_fd_sc_mcu7t5v0__nor2_4_20/ZN vdd vss gf180mcu_fd_sc_mcu7t5v0__aoi211_1
Xgf180mcu_fd_sc_mcu7t5v0__aoi211_1_43 gf180mcu_fd_sc_mcu7t5v0__nor2_1_170/ZN gf180mcu_fd_sc_mcu7t5v0__or2_1_23/A1
+ vdd vss gf180mcu_fd_sc_mcu7t5v0__dffq_1_307/D gf180mcu_fd_sc_mcu7t5v0__inv_4_2/ZN
+ gf180mcu_fd_sc_mcu7t5v0__nor2_4_28/ZN vdd vss gf180mcu_fd_sc_mcu7t5v0__aoi211_1
Xgf180mcu_fd_sc_mcu7t5v0__aoi211_1_54 gf180mcu_fd_sc_mcu7t5v0__aoi211_1_54/B gf180mcu_fd_sc_mcu7t5v0__or2_4_4/Z
+ vdd vss gf180mcu_fd_sc_mcu7t5v0__aoi21_1_196/B gf180mcu_fd_sc_mcu7t5v0__nor2_4_30/ZN
+ gf180mcu_fd_sc_mcu7t5v0__xor2_1_101/Z vdd vss gf180mcu_fd_sc_mcu7t5v0__aoi211_1
Xgf180mcu_fd_sc_mcu7t5v0__aoi211_1_65 gf180mcu_fd_sc_mcu7t5v0__nor2_1_304/ZN gf180mcu_fd_sc_mcu7t5v0__or2_1_23/A1
+ vdd vss gf180mcu_fd_sc_mcu7t5v0__dffq_1_423/D gf180mcu_fd_sc_mcu7t5v0__nor2_1_236/A1
+ gf180mcu_fd_sc_mcu7t5v0__nor2_4_24/ZN vdd vss gf180mcu_fd_sc_mcu7t5v0__aoi211_1
Xgf180mcu_fd_sc_mcu7t5v0__aoi211_1_76 gf180mcu_fd_sc_mcu7t5v0__nor2_1_329/ZN gf180mcu_fd_sc_mcu7t5v0__or2_1_23/A1
+ vdd vss gf180mcu_fd_sc_mcu7t5v0__dffq_1_430/D gf180mcu_fd_sc_mcu7t5v0__inv_4_3/ZN
+ gf180mcu_fd_sc_mcu7t5v0__nor2_4_27/ZN vdd vss gf180mcu_fd_sc_mcu7t5v0__aoi211_1
Xgf180mcu_fd_sc_mcu7t5v0__aoi211_1_87 gf180mcu_fd_sc_mcu7t5v0__nor2_1_404/ZN gf180mcu_fd_sc_mcu7t5v0__or2_1_23/A1
+ vdd vss gf180mcu_fd_sc_mcu7t5v0__dffq_1_450/D gf180mcu_fd_sc_mcu7t5v0__inv_4_3/ZN
+ gf180mcu_fd_sc_mcu7t5v0__nor2_4_17/ZN vdd vss gf180mcu_fd_sc_mcu7t5v0__aoi211_1
Xgf180mcu_fd_sc_mcu7t5v0__aoi21_1_220 gf180mcu_fd_sc_mcu7t5v0__nor2_1_238/ZN vdd vss
+ gf180mcu_fd_sc_mcu7t5v0__xor3_1_79/A2 gf180mcu_fd_sc_mcu7t5v0__xor3_1_83/A1 gf180mcu_fd_sc_mcu7t5v0__nand2_1_408/ZN
+ vdd vss gf180mcu_fd_sc_mcu7t5v0__aoi21_1
Xgf180mcu_fd_sc_mcu7t5v0__aoi21_1_231 gf180mcu_fd_sc_mcu7t5v0__nor2_2_31/ZN vdd vss
+ gf180mcu_fd_sc_mcu7t5v0__oai211_1_27/B gf180mcu_fd_sc_mcu7t5v0__nand2_1_464/ZN gf180mcu_fd_sc_mcu7t5v0__oai21_1_214/ZN
+ vdd vss gf180mcu_fd_sc_mcu7t5v0__aoi21_1
Xgf180mcu_fd_sc_mcu7t5v0__aoi21_1_242 gf180mcu_fd_sc_mcu7t5v0__or2_4_4/Z vdd vss gf180mcu_fd_sc_mcu7t5v0__aoi22_1_177/B2
+ gf180mcu_fd_sc_mcu7t5v0__nor2_4_34/ZN gf180mcu_fd_sc_mcu7t5v0__xor3_1_155/Z vdd
+ vss gf180mcu_fd_sc_mcu7t5v0__aoi21_1
Xgf180mcu_fd_sc_mcu7t5v0__aoi21_1_253 gf180mcu_fd_sc_mcu7t5v0__xor3_1_100/A1 vdd vss
+ gf180mcu_fd_sc_mcu7t5v0__oai22_1_272/B1 gf180mcu_fd_sc_mcu7t5v0__inv_8_0/I gf180mcu_fd_sc_mcu7t5v0__oai32_1_8/B1
+ vdd vss gf180mcu_fd_sc_mcu7t5v0__aoi21_1
Xgf180mcu_fd_sc_mcu7t5v0__aoi21_1_264 gf180mcu_fd_sc_mcu7t5v0__aoi21_1_264/B vdd vss
+ gf180mcu_fd_sc_mcu7t5v0__dffq_4_26/D gf180mcu_fd_sc_mcu7t5v0__inv_1_16/ZN gf180mcu_fd_sc_mcu7t5v0__buf_20_0/Z
+ vdd vss gf180mcu_fd_sc_mcu7t5v0__aoi21_1
Xgf180mcu_fd_sc_mcu7t5v0__aoi21_1_275 gf180mcu_fd_sc_mcu7t5v0__aoi21_1_275/B vdd vss
+ gf180mcu_fd_sc_mcu7t5v0__aoi211_1_67/B gf180mcu_fd_sc_mcu7t5v0__or4_1_0/A2 gf180mcu_fd_sc_mcu7t5v0__or3_1_9/A2
+ vdd vss gf180mcu_fd_sc_mcu7t5v0__aoi21_1
Xgf180mcu_fd_sc_mcu7t5v0__aoi21_1_286 gf180mcu_fd_sc_mcu7t5v0__aoi21_1_286/B vdd vss
+ gf180mcu_fd_sc_mcu7t5v0__dffq_4_44/D gf180mcu_fd_sc_mcu7t5v0__nor3_2_5/A1 gf180mcu_fd_sc_mcu7t5v0__buf_20_0/I
+ vdd vss gf180mcu_fd_sc_mcu7t5v0__aoi21_1
Xgf180mcu_fd_sc_mcu7t5v0__aoi21_1_297 gf180mcu_fd_sc_mcu7t5v0__aoi21_1_297/B vdd vss
+ gf180mcu_fd_sc_mcu7t5v0__dffq_2_80/D gf180mcu_fd_sc_mcu7t5v0__or2_1_34/A2 gf180mcu_fd_sc_mcu7t5v0__oai21_1_331/ZN
+ vdd vss gf180mcu_fd_sc_mcu7t5v0__aoi21_1
Xgf180mcu_fd_sc_mcu7t5v0__oai33_2_1 gf180mcu_fd_sc_mcu7t5v0__nor2_2_7/ZN gf180mcu_fd_sc_mcu7t5v0__xor3_1_33/Z
+ gf180mcu_fd_sc_mcu7t5v0__and2_1_20/Z gf180mcu_fd_sc_mcu7t5v0__oai33_2_1/B3 vdd vss
+ gf180mcu_fd_sc_mcu7t5v0__xor2_1_34/A1 gf180mcu_fd_sc_mcu7t5v0__or3_1_3/Z gf180mcu_fd_sc_mcu7t5v0__and2_1_19/Z
+ vdd vss gf180mcu_fd_sc_mcu7t5v0__oai33_2
Xgf180mcu_fd_sc_mcu7t5v0__oai21_1_20 vdd gf180mcu_fd_sc_mcu7t5v0__and2_4_3/Z gf180mcu_fd_sc_mcu7t5v0__or2_1_34/A2
+ gf180mcu_fd_sc_mcu7t5v0__nor2_1_28/A2 gf180mcu_fd_sc_mcu7t5v0__dffq_2_8/Q vss vdd
+ vss gf180mcu_fd_sc_mcu7t5v0__oai21_1
Xgf180mcu_fd_sc_mcu7t5v0__oai21_1_31 vdd gf180mcu_fd_sc_mcu7t5v0__buf_8_5/Z gf180mcu_fd_sc_mcu7t5v0__buf_20_0/Z
+ gf180mcu_fd_sc_mcu7t5v0__aoi21_1_40/B gf180mcu_fd_sc_mcu7t5v0__dffq_1_9/Q vss vdd
+ vss gf180mcu_fd_sc_mcu7t5v0__oai21_1
Xgf180mcu_fd_sc_mcu7t5v0__oai21_1_42 vdd gf180mcu_fd_sc_mcu7t5v0__oai21_1_42/B gf180mcu_fd_sc_mcu7t5v0__aoi22_1_9/ZN
+ gf180mcu_fd_sc_mcu7t5v0__xor3_1_32/A3 gf180mcu_fd_sc_mcu7t5v0__xor3_1_34/A1 vss
+ vdd vss gf180mcu_fd_sc_mcu7t5v0__oai21_1
Xgf180mcu_fd_sc_mcu7t5v0__oai21_4_7 gf180mcu_fd_sc_mcu7t5v0__oai21_4_7/B vdd vss gf180mcu_fd_sc_mcu7t5v0__inv_1_24/ZN
+ gf180mcu_fd_sc_mcu7t5v0__or4_1_1/A1 gf180mcu_fd_sc_mcu7t5v0__or2_4_0/Z vdd vss gf180mcu_fd_sc_mcu7t5v0__oai21_4
Xgf180mcu_fd_sc_mcu7t5v0__oai21_1_53 vdd gf180mcu_fd_sc_mcu7t5v0__oai21_1_53/B gf180mcu_fd_sc_mcu7t5v0__oai21_1_53/A2
+ gf180mcu_fd_sc_mcu7t5v0__oai21_1_53/ZN gf180mcu_fd_sc_mcu7t5v0__mux2_1_2/I0 vss
+ vdd vss gf180mcu_fd_sc_mcu7t5v0__oai21_1
Xgf180mcu_fd_sc_mcu7t5v0__oai21_1_64 vdd gf180mcu_fd_sc_mcu7t5v0__or2_1_34/A2 gf180mcu_fd_sc_mcu7t5v0__oai21_1_64/A2
+ gf180mcu_fd_sc_mcu7t5v0__aoi21_1_87/B gf180mcu_fd_sc_mcu7t5v0__nor2_4_3/ZN vss vdd
+ vss gf180mcu_fd_sc_mcu7t5v0__oai21_1
Xgf180mcu_fd_sc_mcu7t5v0__oai22_1_207 gf180mcu_fd_sc_mcu7t5v0__nand2_4_32/ZN gf180mcu_fd_sc_mcu7t5v0__nand2_2_33/ZN
+ gf180mcu_fd_sc_mcu7t5v0__oai22_1_207/B2 vdd vss gf180mcu_fd_sc_mcu7t5v0__dffq_1_203/D
+ gf180mcu_fd_sc_mcu7t5v0__aoi21_4_4/ZN vdd vss gf180mcu_fd_sc_mcu7t5v0__oai22_1
Xgf180mcu_fd_sc_mcu7t5v0__oai21_1_75 vdd gf180mcu_fd_sc_mcu7t5v0__xor2_1_72/Z gf180mcu_fd_sc_mcu7t5v0__nor3_1_7/A2
+ gf180mcu_fd_sc_mcu7t5v0__oai21_1_75/ZN gf180mcu_fd_sc_mcu7t5v0__nor3_1_7/A1 vss
+ vdd vss gf180mcu_fd_sc_mcu7t5v0__oai21_1
Xgf180mcu_fd_sc_mcu7t5v0__oai22_1_218 gf180mcu_fd_sc_mcu7t5v0__nand2_4_26/ZN gf180mcu_fd_sc_mcu7t5v0__nand2_2_38/ZN
+ gf180mcu_fd_sc_mcu7t5v0__oai22_1_218/B2 vdd vss gf180mcu_fd_sc_mcu7t5v0__dffq_1_222/D
+ gf180mcu_fd_sc_mcu7t5v0__aoi21_4_2/ZN vdd vss gf180mcu_fd_sc_mcu7t5v0__oai22_1
Xgf180mcu_fd_sc_mcu7t5v0__oai22_1_229 gf180mcu_fd_sc_mcu7t5v0__nand2_4_26/ZN gf180mcu_fd_sc_mcu7t5v0__nand2_2_38/ZN
+ gf180mcu_fd_sc_mcu7t5v0__oai22_1_229/B2 vdd vss gf180mcu_fd_sc_mcu7t5v0__dffq_1_220/D
+ gf180mcu_fd_sc_mcu7t5v0__aoi21_4_4/ZN vdd vss gf180mcu_fd_sc_mcu7t5v0__oai22_1
Xgf180mcu_fd_sc_mcu7t5v0__oai21_1_86 vdd gf180mcu_fd_sc_mcu7t5v0__buf_8_5/Z gf180mcu_fd_sc_mcu7t5v0__buf_20_0/Z
+ gf180mcu_fd_sc_mcu7t5v0__aoi21_1_96/B gf180mcu_fd_sc_mcu7t5v0__dffq_1_244/Q vss
+ vdd vss gf180mcu_fd_sc_mcu7t5v0__oai21_1
Xgf180mcu_fd_sc_mcu7t5v0__oai21_1_97 vdd gf180mcu_fd_sc_mcu7t5v0__buf_8_6/Z gf180mcu_fd_sc_mcu7t5v0__nor3_4_14/ZN
+ gf180mcu_fd_sc_mcu7t5v0__oai21_1_97/ZN gf180mcu_fd_sc_mcu7t5v0__dffq_1_289/Q vss
+ vdd vss gf180mcu_fd_sc_mcu7t5v0__oai21_1
Xgf180mcu_fd_sc_mcu7t5v0__or2_4_3 vdd vss gf180mcu_fd_sc_mcu7t5v0__or2_4_3/Z gf180mcu_fd_sc_mcu7t5v0__or2_4_3/A1
+ gf180mcu_fd_sc_mcu7t5v0__or3_2_4/A2 vdd vss gf180mcu_fd_sc_mcu7t5v0__or2_4
Xgf180mcu_fd_sc_mcu7t5v0__dffq_1_105 vdd gf180mcu_fd_sc_mcu7t5v0__dffq_1_105/Q gf180mcu_fd_sc_mcu7t5v0__dffq_1_96/CLK
+ vss gf180mcu_fd_sc_mcu7t5v0__dffq_1_105/D vdd vss gf180mcu_fd_sc_mcu7t5v0__dffq_1
Xgf180mcu_fd_sc_mcu7t5v0__dffq_1_116 vdd gf180mcu_fd_sc_mcu7t5v0__dffq_1_116/Q gf180mcu_fd_sc_mcu7t5v0__dffq_1_96/CLK
+ vss gf180mcu_fd_sc_mcu7t5v0__dffq_1_116/D vdd vss gf180mcu_fd_sc_mcu7t5v0__dffq_1
Xgf180mcu_fd_sc_mcu7t5v0__nor2_1_305 vdd vss gf180mcu_fd_sc_mcu7t5v0__nor2_2_30/A1
+ gf180mcu_fd_sc_mcu7t5v0__oai32_2_2/B1 gf180mcu_fd_sc_mcu7t5v0__oai32_2_2/B2 vdd
+ vss gf180mcu_fd_sc_mcu7t5v0__nor2_1
Xgf180mcu_fd_sc_mcu7t5v0__dffq_1_127 vdd gf180mcu_fd_sc_mcu7t5v0__dffq_1_127/Q gf180mcu_fd_sc_mcu7t5v0__dffq_1_96/CLK
+ vss gf180mcu_fd_sc_mcu7t5v0__dffq_1_127/D vdd vss gf180mcu_fd_sc_mcu7t5v0__dffq_1
Xgf180mcu_fd_sc_mcu7t5v0__nor2_1_316 vdd vss gf180mcu_fd_sc_mcu7t5v0__dffq_2_79/D
+ gf180mcu_fd_sc_mcu7t5v0__nor2_1_316/A1 gf180mcu_fd_sc_mcu7t5v0__nor2_1_316/A2 vdd
+ vss gf180mcu_fd_sc_mcu7t5v0__nor2_1
Xgf180mcu_fd_sc_mcu7t5v0__dffq_1_138 vdd gf180mcu_fd_sc_mcu7t5v0__dffq_1_138/Q gf180mcu_fd_sc_mcu7t5v0__dffq_1_96/CLK
+ vss gf180mcu_fd_sc_mcu7t5v0__dffq_1_138/D vdd vss gf180mcu_fd_sc_mcu7t5v0__dffq_1
Xgf180mcu_fd_sc_mcu7t5v0__aoi21_2_1 gf180mcu_fd_sc_mcu7t5v0__nor2_1_6/ZN vdd vss gf180mcu_fd_sc_mcu7t5v0__xor3_1_3/A2
+ gf180mcu_fd_sc_mcu7t5v0__aoi21_2_1/A1 gf180mcu_fd_sc_mcu7t5v0__xor2_1_5/A2 vdd vss
+ gf180mcu_fd_sc_mcu7t5v0__aoi21_2
Xgf180mcu_fd_sc_mcu7t5v0__dffq_1_149 vdd gf180mcu_fd_sc_mcu7t5v0__dffq_1_149/Q gf180mcu_fd_sc_mcu7t5v0__dffq_2_26/CLK
+ vss gf180mcu_fd_sc_mcu7t5v0__dffq_1_149/D vdd vss gf180mcu_fd_sc_mcu7t5v0__dffq_1
Xgf180mcu_fd_sc_mcu7t5v0__nor2_1_327 vdd vss gf180mcu_fd_sc_mcu7t5v0__nor2_1_327/ZN
+ gf180mcu_fd_sc_mcu7t5v0__dffq_1_420/Q gf180mcu_fd_sc_mcu7t5v0__nor2_4_24/ZN vdd
+ vss gf180mcu_fd_sc_mcu7t5v0__nor2_1
Xgf180mcu_fd_sc_mcu7t5v0__nor2_1_338 vdd vss gf180mcu_fd_sc_mcu7t5v0__nor2_1_338/ZN
+ gf180mcu_fd_sc_mcu7t5v0__oai211_1_43/C gf180mcu_fd_sc_mcu7t5v0__xor3_1_115/Z vdd
+ vss gf180mcu_fd_sc_mcu7t5v0__nor2_1
Xgf180mcu_fd_sc_mcu7t5v0__nor2_1_349 vdd vss gf180mcu_fd_sc_mcu7t5v0__nor2_1_349/ZN
+ gf180mcu_fd_sc_mcu7t5v0__dffq_1_441/Q gf180mcu_fd_sc_mcu7t5v0__and3_2_2/Z vdd vss
+ gf180mcu_fd_sc_mcu7t5v0__nor2_1
Xgf180mcu_fd_sc_mcu7t5v0__nand2_1_520 vdd vss gf180mcu_fd_sc_mcu7t5v0__nand4_1_17/A2
+ gf180mcu_fd_sc_mcu7t5v0__nor3_4_18/ZN gf180mcu_fd_sc_mcu7t5v0__xor2_1_222/Z vdd
+ vss gf180mcu_fd_sc_mcu7t5v0__nand2_1
Xgf180mcu_fd_sc_mcu7t5v0__nand2_1_531 vdd vss gf180mcu_fd_sc_mcu7t5v0__nor2_1_312/A1
+ gf180mcu_fd_sc_mcu7t5v0__nor3_2_5/A1 gf180mcu_fd_sc_mcu7t5v0__mux4_4_2/Z vdd vss
+ gf180mcu_fd_sc_mcu7t5v0__nand2_1
Xgf180mcu_fd_sc_mcu7t5v0__nand2_1_542 vdd vss gf180mcu_fd_sc_mcu7t5v0__nand2_1_542/ZN
+ gf180mcu_fd_sc_mcu7t5v0__dffq_2_57/Q gf180mcu_fd_sc_mcu7t5v0__nor3_4_12/ZN vdd vss
+ gf180mcu_fd_sc_mcu7t5v0__nand2_1
Xgf180mcu_fd_sc_mcu7t5v0__nand2_1_553 vdd vss gf180mcu_fd_sc_mcu7t5v0__oai21_1_226/B
+ gf180mcu_fd_sc_mcu7t5v0__inv_2_13/I gf180mcu_fd_sc_mcu7t5v0__xor3_2_1/Z vdd vss
+ gf180mcu_fd_sc_mcu7t5v0__nand2_1
Xgf180mcu_fd_sc_mcu7t5v0__nand2_1_564 vdd vss gf180mcu_fd_sc_mcu7t5v0__nand4_1_18/A3
+ gf180mcu_fd_sc_mcu7t5v0__nor3_4_20/ZN gf180mcu_fd_sc_mcu7t5v0__nor2_1_357/ZN vdd
+ vss gf180mcu_fd_sc_mcu7t5v0__nand2_1
Xgf180mcu_fd_sc_mcu7t5v0__aoi21_2_11 gf180mcu_fd_sc_mcu7t5v0__aoi21_2_11/B vdd vss
+ gf180mcu_fd_sc_mcu7t5v0__xor3_1_89/A3 gf180mcu_fd_sc_mcu7t5v0__nor2_2_32/A2 gf180mcu_fd_sc_mcu7t5v0__xor3_1_88/A2
+ vdd vss gf180mcu_fd_sc_mcu7t5v0__aoi21_2
Xgf180mcu_fd_sc_mcu7t5v0__aoi21_2_22 gf180mcu_fd_sc_mcu7t5v0__aoi21_2_22/B vdd vss
+ gf180mcu_fd_sc_mcu7t5v0__nor3_1_38/A3 gf180mcu_fd_sc_mcu7t5v0__xor3_1_133/A1 gf180mcu_fd_sc_mcu7t5v0__aoi21_2_22/A2
+ vdd vss gf180mcu_fd_sc_mcu7t5v0__aoi21_2
Xgf180mcu_fd_sc_mcu7t5v0__nand2_1_575 vdd vss gf180mcu_fd_sc_mcu7t5v0__xor2_1_209/A2
+ gf180mcu_fd_sc_mcu7t5v0__nand3_2_28/ZN gf180mcu_fd_sc_mcu7t5v0__nand3_1_89/A3 vdd
+ vss gf180mcu_fd_sc_mcu7t5v0__nand2_1
Xgf180mcu_fd_sc_mcu7t5v0__nand2_1_586 vdd vss gf180mcu_fd_sc_mcu7t5v0__xnor3_1_39/A1
+ gf180mcu_fd_sc_mcu7t5v0__inv_4_6/I gf180mcu_fd_sc_mcu7t5v0__or3_1_12/A2 vdd vss
+ gf180mcu_fd_sc_mcu7t5v0__nand2_1
Xgf180mcu_fd_sc_mcu7t5v0__nand2_1_597 vdd vss gf180mcu_fd_sc_mcu7t5v0__xnor2_1_63/A1
+ gf180mcu_fd_sc_mcu7t5v0__or4_1_0/A1 gf180mcu_fd_sc_mcu7t5v0__mux4_4_13/Z vdd vss
+ gf180mcu_fd_sc_mcu7t5v0__nand2_1
Xgf180mcu_fd_sc_mcu7t5v0__xor2_2_0 vdd vss gf180mcu_fd_sc_mcu7t5v0__xor2_2_0/Z gf180mcu_fd_sc_mcu7t5v0__xor2_2_0/A1
+ gf180mcu_fd_sc_mcu7t5v0__xor3_1_59/Z vdd vss gf180mcu_fd_sc_mcu7t5v0__xor2_2
Xgf180mcu_fd_sc_mcu7t5v0__nand2_1_8 vdd vss gf180mcu_fd_sc_mcu7t5v0__nand2_1_8/ZN
+ gf180mcu_fd_sc_mcu7t5v0__oai31_1_0/B gf180mcu_fd_sc_mcu7t5v0__nand2_1_8/A2 vdd vss
+ gf180mcu_fd_sc_mcu7t5v0__nand2_1
Xgf180mcu_fd_sc_mcu7t5v0__oai211_2_1 gf180mcu_fd_sc_mcu7t5v0__aoi21_2_3/ZN gf180mcu_fd_sc_mcu7t5v0__or2_1_14/A2
+ gf180mcu_fd_sc_mcu7t5v0__and2_1_26/Z gf180mcu_fd_sc_mcu7t5v0__oai21_1_56/B gf180mcu_fd_sc_mcu7t5v0__inv_8_1/I
+ vdd vss vdd vss gf180mcu_fd_sc_mcu7t5v0__oai211_2
Xgf180mcu_fd_sc_mcu7t5v0__mux4_4_14 gf180mcu_fd_sc_mcu7t5v0__inv_1_17/I vss vdd gf180mcu_fd_sc_mcu7t5v0__dffq_2_88/Q
+ gf180mcu_fd_sc_mcu7t5v0__inv_1_3/I gf180mcu_fd_sc_mcu7t5v0__inv_1_20/I gf180mcu_fd_sc_mcu7t5v0__mux4_4_0/I0
+ gf180mcu_fd_sc_mcu7t5v0__dffq_4_32/Q gf180mcu_fd_sc_mcu7t5v0__mux4_4_14/Z vdd vss
+ gf180mcu_fd_sc_mcu7t5v0__mux4_4
Xgf180mcu_fd_sc_mcu7t5v0__and3_2_2 gf180mcu_fd_sc_mcu7t5v0__and3_2_1/Z vdd vss gf180mcu_fd_sc_mcu7t5v0__and3_2_2/Z
+ gf180mcu_fd_sc_mcu7t5v0__and3_2_2/A1 gf180mcu_fd_sc_mcu7t5v0__and3_2_2/A2 vdd vss
+ gf180mcu_fd_sc_mcu7t5v0__and3_2
Xgf180mcu_fd_sc_mcu7t5v0__oai21_2_4 gf180mcu_fd_sc_mcu7t5v0__oai21_2_4/A2 gf180mcu_fd_sc_mcu7t5v0__and2_4_1/A2
+ gf180mcu_fd_sc_mcu7t5v0__inv_2_0/I vss gf180mcu_fd_sc_mcu7t5v0__oai21_2_4/B vdd
+ vdd vss gf180mcu_fd_sc_mcu7t5v0__oai21_2
Xgf180mcu_fd_sc_mcu7t5v0__tiel_2 rst_n_PU vdd vss vdd vss gf180mcu_fd_sc_mcu7t5v0__tiel
Xgf180mcu_fd_sc_mcu7t5v0__or2_2_0 vdd vss gf180mcu_fd_sc_mcu7t5v0__or2_2_0/Z gf180mcu_fd_sc_mcu7t5v0__or2_2_0/A1
+ gf180mcu_fd_sc_mcu7t5v0__or2_2_0/A2 vdd vss gf180mcu_fd_sc_mcu7t5v0__or2_2
Xgf180mcu_fd_sc_mcu7t5v0__nor2_1_102 vdd vss gf180mcu_fd_sc_mcu7t5v0__xor2_1_68/A2
+ gf180mcu_fd_sc_mcu7t5v0__and2_1_38/Z gf180mcu_fd_sc_mcu7t5v0__nor4_2_3/ZN vdd vss
+ gf180mcu_fd_sc_mcu7t5v0__nor2_1
Xgf180mcu_fd_sc_mcu7t5v0__nor2_1_113 vdd vss gf180mcu_fd_sc_mcu7t5v0__nor2_1_113/ZN
+ gf180mcu_fd_sc_mcu7t5v0__dffq_1_243/Q gf180mcu_fd_sc_mcu7t5v0__nor2_4_19/ZN vdd
+ vss gf180mcu_fd_sc_mcu7t5v0__nor2_1
Xgf180mcu_fd_sc_mcu7t5v0__nor2_1_124 vdd vss gf180mcu_fd_sc_mcu7t5v0__nor2_1_124/ZN
+ gf180mcu_fd_sc_mcu7t5v0__or2_1_56/A2 gf180mcu_fd_sc_mcu7t5v0__and2_1_42/A2 vdd vss
+ gf180mcu_fd_sc_mcu7t5v0__nor2_1
Xgf180mcu_fd_sc_mcu7t5v0__nor2_1_135 vdd vss gf180mcu_fd_sc_mcu7t5v0__nor2_1_135/ZN
+ gf180mcu_fd_sc_mcu7t5v0__dffq_1_315/Q gf180mcu_fd_sc_mcu7t5v0__nor2_4_21/ZN vdd
+ vss gf180mcu_fd_sc_mcu7t5v0__nor2_1
Xgf180mcu_fd_sc_mcu7t5v0__xor3_1_103 gf180mcu_fd_sc_mcu7t5v0__nor3_2_7/A3 vdd vss
+ gf180mcu_fd_sc_mcu7t5v0__xor3_1_103/Z gf180mcu_fd_sc_mcu7t5v0__oai32_1_6/B1 gf180mcu_fd_sc_mcu7t5v0__nor3_4_16/A3
+ vdd vss gf180mcu_fd_sc_mcu7t5v0__xor3_1
Xgf180mcu_fd_sc_mcu7t5v0__xor3_1_114 gf180mcu_fd_sc_mcu7t5v0__xor2_1_173/Z vdd vss
+ gf180mcu_fd_sc_mcu7t5v0__xor3_1_114/Z gf180mcu_fd_sc_mcu7t5v0__mux4_4_7/I0 gf180mcu_fd_sc_mcu7t5v0__xor3_1_114/A2
+ vdd vss gf180mcu_fd_sc_mcu7t5v0__xor3_1
Xgf180mcu_fd_sc_mcu7t5v0__nor2_1_146 vdd vss gf180mcu_fd_sc_mcu7t5v0__nor2_1_146/ZN
+ gf180mcu_fd_sc_mcu7t5v0__inv_4_2/ZN gf180mcu_fd_sc_mcu7t5v0__inv_2_8/I vdd vss gf180mcu_fd_sc_mcu7t5v0__nor2_1
Xgf180mcu_fd_sc_mcu7t5v0__nor2_1_157 vdd vss gf180mcu_fd_sc_mcu7t5v0__dffq_2_33/D
+ gf180mcu_fd_sc_mcu7t5v0__or2_1_23/A1 gf180mcu_fd_sc_mcu7t5v0__nor2_1_157/A2 vdd
+ vss gf180mcu_fd_sc_mcu7t5v0__nor2_1
Xgf180mcu_fd_sc_mcu7t5v0__xor3_1_125 gf180mcu_fd_sc_mcu7t5v0__xor3_1_118/Z vdd vss
+ gf180mcu_fd_sc_mcu7t5v0__xor3_1_125/Z gf180mcu_fd_sc_mcu7t5v0__xor3_1_125/A1 gf180mcu_fd_sc_mcu7t5v0__xor3_1_125/A2
+ vdd vss gf180mcu_fd_sc_mcu7t5v0__xor3_1
Xgf180mcu_fd_sc_mcu7t5v0__nor2_1_168 vdd vss gf180mcu_fd_sc_mcu7t5v0__xnor2_1_32/A1
+ gf180mcu_fd_sc_mcu7t5v0__or4_1_0/A2 gf180mcu_fd_sc_mcu7t5v0__inv_1_13/I vdd vss
+ gf180mcu_fd_sc_mcu7t5v0__nor2_1
Xgf180mcu_fd_sc_mcu7t5v0__xor3_1_136 gf180mcu_fd_sc_mcu7t5v0__xor3_1_136/A3 vdd vss
+ gf180mcu_fd_sc_mcu7t5v0__xor3_1_136/Z gf180mcu_fd_sc_mcu7t5v0__oai32_1_9/A1 gf180mcu_fd_sc_mcu7t5v0__xor3_1_137/Z
+ vdd vss gf180mcu_fd_sc_mcu7t5v0__xor3_1
Xgf180mcu_fd_sc_mcu7t5v0__nor2_1_179 vdd vss gf180mcu_fd_sc_mcu7t5v0__nor2_1_179/ZN
+ gf180mcu_fd_sc_mcu7t5v0__nand4_2_5/A2 gf180mcu_fd_sc_mcu7t5v0__nand4_2_5/A3 vdd
+ vss gf180mcu_fd_sc_mcu7t5v0__nor2_1
Xgf180mcu_fd_sc_mcu7t5v0__xor3_1_147 gf180mcu_fd_sc_mcu7t5v0__xor3_1_147/A3 vdd vss
+ gf180mcu_fd_sc_mcu7t5v0__xor3_1_147/Z gf180mcu_fd_sc_mcu7t5v0__xor3_1_147/A1 gf180mcu_fd_sc_mcu7t5v0__xor3_1_147/A2
+ vdd vss gf180mcu_fd_sc_mcu7t5v0__xor3_1
Xgf180mcu_fd_sc_mcu7t5v0__xor3_1_158 gf180mcu_fd_sc_mcu7t5v0__xor3_1_96/Z vdd vss
+ gf180mcu_fd_sc_mcu7t5v0__nor3_2_8/A3 gf180mcu_fd_sc_mcu7t5v0__nor3_4_16/ZN gf180mcu_fd_sc_mcu7t5v0__oai33_2_3/A1
+ vdd vss gf180mcu_fd_sc_mcu7t5v0__xor3_1
Xgf180mcu_fd_sc_mcu7t5v0__xor3_1_169 gf180mcu_fd_sc_mcu7t5v0__mux2_1_1/Z vdd vss gf180mcu_fd_sc_mcu7t5v0__xor3_1_18/A2
+ gf180mcu_fd_sc_mcu7t5v0__xor3_1_170/Z gf180mcu_fd_sc_mcu7t5v0__xor3_1_169/A2 vdd
+ vss gf180mcu_fd_sc_mcu7t5v0__xor3_1
Xgf180mcu_fd_sc_mcu7t5v0__oai211_1_18 gf180mcu_fd_sc_mcu7t5v0__oai211_1_18/B gf180mcu_fd_sc_mcu7t5v0__buf_8_5/I
+ vdd vss gf180mcu_fd_sc_mcu7t5v0__dffq_1_312/D gf180mcu_fd_sc_mcu7t5v0__nor3_1_10/A1
+ gf180mcu_fd_sc_mcu7t5v0__nor2_4_17/ZN vdd vss gf180mcu_fd_sc_mcu7t5v0__oai211_1
Xgf180mcu_fd_sc_mcu7t5v0__nand2_1_350 vdd vss gf180mcu_fd_sc_mcu7t5v0__nor4_4_3/A4
+ gf180mcu_fd_sc_mcu7t5v0__xor2_1_92/A1 gf180mcu_fd_sc_mcu7t5v0__nand4_1_6/A3 vdd
+ vss gf180mcu_fd_sc_mcu7t5v0__nand2_1
Xgf180mcu_fd_sc_mcu7t5v0__nand2_1_361 vdd vss gf180mcu_fd_sc_mcu7t5v0__dffq_4_15/D
+ gf180mcu_fd_sc_mcu7t5v0__nand3_1_57/ZN gf180mcu_fd_sc_mcu7t5v0__nand3_1_58/ZN vdd
+ vss gf180mcu_fd_sc_mcu7t5v0__nand2_1
Xgf180mcu_fd_sc_mcu7t5v0__oai211_1_29 gf180mcu_fd_sc_mcu7t5v0__oai211_1_29/B gf180mcu_fd_sc_mcu7t5v0__oai31_1_14/B
+ vdd vss gf180mcu_fd_sc_mcu7t5v0__oai211_1_29/ZN gf180mcu_fd_sc_mcu7t5v0__inv_12_1/I
+ gf180mcu_fd_sc_mcu7t5v0__mux4_4_6/Z vdd vss gf180mcu_fd_sc_mcu7t5v0__oai211_1
Xgf180mcu_fd_sc_mcu7t5v0__nand2_1_372 vdd vss gf180mcu_fd_sc_mcu7t5v0__oai211_1_24/B
+ gf180mcu_fd_sc_mcu7t5v0__inv_8_0/I gf180mcu_fd_sc_mcu7t5v0__nor2_2_23/ZN vdd vss
+ gf180mcu_fd_sc_mcu7t5v0__nand2_1
Xgf180mcu_fd_sc_mcu7t5v0__nand3_4_16 gf180mcu_fd_sc_mcu7t5v0__oai32_1_6/A3 vdd vss
+ gf180mcu_fd_sc_mcu7t5v0__or3_1_18/A1 gf180mcu_fd_sc_mcu7t5v0__nor2_2_33/A2 gf180mcu_fd_sc_mcu7t5v0__mux2_1_9/I0
+ vdd vss gf180mcu_fd_sc_mcu7t5v0__nand3_4
Xgf180mcu_fd_sc_mcu7t5v0__nand2_1_383 vdd vss gf180mcu_fd_sc_mcu7t5v0__and2_1_82/A1
+ gf180mcu_fd_sc_mcu7t5v0__mux4_4_0/I0 gf180mcu_fd_sc_mcu7t5v0__xnor2_1_33/ZN vdd
+ vss gf180mcu_fd_sc_mcu7t5v0__nand2_1
Xgf180mcu_fd_sc_mcu7t5v0__nand2_1_394 vdd vss gf180mcu_fd_sc_mcu7t5v0__nor2_1_224/A2
+ gf180mcu_fd_sc_mcu7t5v0__dffq_1_395/Q gf180mcu_fd_sc_mcu7t5v0__nor4_4_2/A3 vdd vss
+ gf180mcu_fd_sc_mcu7t5v0__nand2_1
Xgf180mcu_fd_sc_mcu7t5v0__oai21_1_206 vdd gf180mcu_fd_sc_mcu7t5v0__oai21_1_206/B gf180mcu_fd_sc_mcu7t5v0__mux4_4_18/Z
+ gf180mcu_fd_sc_mcu7t5v0__nand4_1_16/A4 gf180mcu_fd_sc_mcu7t5v0__inv_8_2/I vss vdd
+ vss gf180mcu_fd_sc_mcu7t5v0__oai21_1
Xgf180mcu_fd_sc_mcu7t5v0__oai21_1_217 vdd gf180mcu_fd_sc_mcu7t5v0__nor2_2_27/ZN gf180mcu_fd_sc_mcu7t5v0__nor2_2_31/A1
+ gf180mcu_fd_sc_mcu7t5v0__oai211_1_30/C gf180mcu_fd_sc_mcu7t5v0__inv_12_1/I vss vdd
+ vss gf180mcu_fd_sc_mcu7t5v0__oai21_1
Xgf180mcu_fd_sc_mcu7t5v0__oai21_1_228 vdd gf180mcu_fd_sc_mcu7t5v0__xor3_1_97/A1 gf180mcu_fd_sc_mcu7t5v0__oai22_2_1/A1
+ gf180mcu_fd_sc_mcu7t5v0__aoi21_2_13/A2 gf180mcu_fd_sc_mcu7t5v0__nor3_2_7/A3 vss
+ vdd vss gf180mcu_fd_sc_mcu7t5v0__oai21_1
Xgf180mcu_fd_sc_mcu7t5v0__oai21_1_239 vdd gf180mcu_fd_sc_mcu7t5v0__buf_12_0/Z gf180mcu_fd_sc_mcu7t5v0__buf_20_0/Z
+ gf180mcu_fd_sc_mcu7t5v0__aoi21_1_230/B gf180mcu_fd_sc_mcu7t5v0__dffq_1_423/Q vss
+ vdd vss gf180mcu_fd_sc_mcu7t5v0__oai21_1
Xgf180mcu_fd_sc_mcu7t5v0__nand3_4_6 gf180mcu_fd_sc_mcu7t5v0__inv_4_1/ZN vdd vss gf180mcu_fd_sc_mcu7t5v0__and2_2_4/A1
+ gf180mcu_fd_sc_mcu7t5v0__inv_2_2/ZN gf180mcu_fd_sc_mcu7t5v0__inv_3_0/I vdd vss gf180mcu_fd_sc_mcu7t5v0__nand3_4
Xgf180mcu_fd_sc_mcu7t5v0__clkinv_1_330 vdd vss gf180mcu_fd_sc_mcu7t5v0__xnor2_1_41/ZN
+ gf180mcu_fd_sc_mcu7t5v0__nand2_1_438/A2 vdd vss gf180mcu_fd_sc_mcu7t5v0__clkinv_1
Xgf180mcu_fd_sc_mcu7t5v0__clkinv_1_341 vdd vss gf180mcu_fd_sc_mcu7t5v0__dffq_2_70/Q
+ gf180mcu_fd_sc_mcu7t5v0__aoi21_1_289/A1 vdd vss gf180mcu_fd_sc_mcu7t5v0__clkinv_1
Xgf180mcu_fd_sc_mcu7t5v0__clkinv_1_352 vdd vss gf180mcu_fd_sc_mcu7t5v0__mux4_4_13/Z
+ gf180mcu_fd_sc_mcu7t5v0__xor3_1_140/A2 vdd vss gf180mcu_fd_sc_mcu7t5v0__clkinv_1
Xgf180mcu_fd_sc_mcu7t5v0__clkinv_1_363 vdd vss gf180mcu_fd_sc_mcu7t5v0__dffq_1_320/Q
+ gf180mcu_fd_sc_mcu7t5v0__oai22_1_287/B2 vdd vss gf180mcu_fd_sc_mcu7t5v0__clkinv_1
Xgf180mcu_fd_sc_mcu7t5v0__clkinv_3_13 vdd gf180mcu_fd_sc_mcu7t5v0__nor2_2_33/A1 gf180mcu_fd_sc_mcu7t5v0__dffq_2_61/Q
+ vss vdd vss gf180mcu_fd_sc_mcu7t5v0__clkinv_3
Xgf180mcu_fd_sc_mcu7t5v0__nand2_1_180 vdd vss gf180mcu_fd_sc_mcu7t5v0__nor2_1_89/A1
+ gf180mcu_fd_sc_mcu7t5v0__inv_4_0/ZN gf180mcu_fd_sc_mcu7t5v0__nor2_1_91/ZN vdd vss
+ gf180mcu_fd_sc_mcu7t5v0__nand2_1
Xgf180mcu_fd_sc_mcu7t5v0__nand2_1_191 vdd vss gf180mcu_fd_sc_mcu7t5v0__nor2_1_94/A1
+ gf180mcu_fd_sc_mcu7t5v0__inv_4_0/I gf180mcu_fd_sc_mcu7t5v0__nor2_1_91/ZN vdd vss
+ gf180mcu_fd_sc_mcu7t5v0__nand2_1
Xgf180mcu_fd_sc_mcu7t5v0__aoi221_1_7 gf180mcu_fd_sc_mcu7t5v0__aoi221_1_7/B2 gf180mcu_fd_sc_mcu7t5v0__or2_4_4/Z
+ vdd vss gf180mcu_fd_sc_mcu7t5v0__aoi21_1_51/B gf180mcu_fd_sc_mcu7t5v0__nor2_4_3/ZN
+ gf180mcu_fd_sc_mcu7t5v0__xnor2_1_14/ZN gf180mcu_fd_sc_mcu7t5v0__oai22_1_10/ZN vdd
+ vss gf180mcu_fd_sc_mcu7t5v0__aoi221_1
Xgf180mcu_fd_sc_mcu7t5v0__nor2_1_9 vdd vss gf180mcu_fd_sc_mcu7t5v0__nor2_1_9/ZN gf180mcu_fd_sc_mcu7t5v0__and2_1_4/Z
+ gf180mcu_fd_sc_mcu7t5v0__nor2_1_9/A2 vdd vss gf180mcu_fd_sc_mcu7t5v0__nor2_1
Xgf180mcu_fd_sc_mcu7t5v0__nand3_2_3 gf180mcu_fd_sc_mcu7t5v0__and2_2_2/A2 vdd vss gf180mcu_fd_sc_mcu7t5v0__xnor3_1_8/A1
+ gf180mcu_fd_sc_mcu7t5v0__or4_1_0/A1 gf180mcu_fd_sc_mcu7t5v0__or3_2_0/Z vdd vss gf180mcu_fd_sc_mcu7t5v0__nand3_2
Xgf180mcu_fd_sc_mcu7t5v0__xor2_1_17 vdd vss gf180mcu_fd_sc_mcu7t5v0__xor2_1_17/Z gf180mcu_fd_sc_mcu7t5v0__xor2_1_17/A1
+ gf180mcu_fd_sc_mcu7t5v0__xor2_1_18/Z vdd vss gf180mcu_fd_sc_mcu7t5v0__xor2_1
Xgf180mcu_fd_sc_mcu7t5v0__xor2_1_28 vdd vss gf180mcu_fd_sc_mcu7t5v0__xor2_1_28/Z gf180mcu_fd_sc_mcu7t5v0__dffq_4_37/Q
+ gf180mcu_fd_sc_mcu7t5v0__xor2_1_28/A2 vdd vss gf180mcu_fd_sc_mcu7t5v0__xor2_1
Xgf180mcu_fd_sc_mcu7t5v0__xor2_1_39 vdd vss gf180mcu_fd_sc_mcu7t5v0__xor2_1_39/Z gf180mcu_fd_sc_mcu7t5v0__xor2_1_39/A1
+ gf180mcu_fd_sc_mcu7t5v0__xor3_1_42/Z vdd vss gf180mcu_fd_sc_mcu7t5v0__xor2_1
Xgf180mcu_fd_sc_mcu7t5v0__xor2_1_102 vdd vss gf180mcu_fd_sc_mcu7t5v0__xor2_1_102/Z
+ gf180mcu_fd_sc_mcu7t5v0__inv_8_0/I gf180mcu_fd_sc_mcu7t5v0__xor2_1_100/Z vdd vss
+ gf180mcu_fd_sc_mcu7t5v0__xor2_1
Xgf180mcu_fd_sc_mcu7t5v0__xor2_1_113 vdd vss gf180mcu_fd_sc_mcu7t5v0__xor3_1_84/A2
+ gf180mcu_fd_sc_mcu7t5v0__xor2_1_113/A1 gf180mcu_fd_sc_mcu7t5v0__mux2_1_7/Z vdd vss
+ gf180mcu_fd_sc_mcu7t5v0__xor2_1
Xgf180mcu_fd_sc_mcu7t5v0__xor2_1_124 vdd vss gf180mcu_fd_sc_mcu7t5v0__xor2_1_124/Z
+ gf180mcu_fd_sc_mcu7t5v0__mux4_4_7/Z gf180mcu_fd_sc_mcu7t5v0__xor2_1_124/A2 vdd vss
+ gf180mcu_fd_sc_mcu7t5v0__xor2_1
Xgf180mcu_fd_sc_mcu7t5v0__xor2_1_135 vdd vss gf180mcu_fd_sc_mcu7t5v0__xor3_2_1/A3
+ gf180mcu_fd_sc_mcu7t5v0__nor3_2_7/ZN gf180mcu_fd_sc_mcu7t5v0__xor3_1_102/Z vdd vss
+ gf180mcu_fd_sc_mcu7t5v0__xor2_1
Xgf180mcu_fd_sc_mcu7t5v0__xor2_1_146 vdd vss gf180mcu_fd_sc_mcu7t5v0__xor2_1_146/Z
+ gf180mcu_fd_sc_mcu7t5v0__xor2_1_146/A1 gf180mcu_fd_sc_mcu7t5v0__xor2_1_147/Z vdd
+ vss gf180mcu_fd_sc_mcu7t5v0__xor2_1
Xgf180mcu_fd_sc_mcu7t5v0__xor2_1_157 vdd vss gf180mcu_fd_sc_mcu7t5v0__xor2_1_157/Z
+ gf180mcu_fd_sc_mcu7t5v0__xor2_1_157/A1 gf180mcu_fd_sc_mcu7t5v0__xor2_1_157/A2 vdd
+ vss gf180mcu_fd_sc_mcu7t5v0__xor2_1
Xgf180mcu_fd_sc_mcu7t5v0__xor2_1_168 vdd vss gf180mcu_fd_sc_mcu7t5v0__xor2_1_168/Z
+ gf180mcu_fd_sc_mcu7t5v0__xor2_1_168/A1 gf180mcu_fd_sc_mcu7t5v0__xor2_1_169/Z vdd
+ vss gf180mcu_fd_sc_mcu7t5v0__xor2_1
Xgf180mcu_fd_sc_mcu7t5v0__xor2_1_179 vdd vss gf180mcu_fd_sc_mcu7t5v0__xor2_1_179/Z
+ gf180mcu_fd_sc_mcu7t5v0__nor3_1_40/A1 gf180mcu_fd_sc_mcu7t5v0__nor3_1_40/A2 vdd
+ vss gf180mcu_fd_sc_mcu7t5v0__xor2_1
Xgf180mcu_fd_sc_mcu7t5v0__nor3_1_30 gf180mcu_fd_sc_mcu7t5v0__mux4_2_1/I2 vdd vss gf180mcu_fd_sc_mcu7t5v0__nor3_1_30/ZN
+ gf180mcu_fd_sc_mcu7t5v0__mux4_4_9/S0 gf180mcu_fd_sc_mcu7t5v0__inv_1_16/I vdd vss
+ gf180mcu_fd_sc_mcu7t5v0__nor3_1
Xgf180mcu_fd_sc_mcu7t5v0__nor3_1_41 gf180mcu_fd_sc_mcu7t5v0__nor3_1_41/A3 vdd vss
+ gf180mcu_fd_sc_mcu7t5v0__nor3_1_41/ZN gf180mcu_fd_sc_mcu7t5v0__nor3_1_41/A1 gf180mcu_fd_sc_mcu7t5v0__nor3_1_41/A2
+ vdd vss gf180mcu_fd_sc_mcu7t5v0__nor3_1
Xgf180mcu_fd_sc_mcu7t5v0__clkinv_1_160 vdd vss gf180mcu_fd_sc_mcu7t5v0__dffq_1_142/Q
+ gf180mcu_fd_sc_mcu7t5v0__oai22_1_145/B2 vdd vss gf180mcu_fd_sc_mcu7t5v0__clkinv_1
Xgf180mcu_fd_sc_mcu7t5v0__clkinv_1_171 vdd vss gf180mcu_fd_sc_mcu7t5v0__dffq_1_153/Q
+ gf180mcu_fd_sc_mcu7t5v0__oai22_1_158/B2 vdd vss gf180mcu_fd_sc_mcu7t5v0__clkinv_1
Xgf180mcu_fd_sc_mcu7t5v0__clkinv_1_182 vdd vss gf180mcu_fd_sc_mcu7t5v0__dffq_1_275/Q
+ gf180mcu_fd_sc_mcu7t5v0__oai22_1_164/B2 vdd vss gf180mcu_fd_sc_mcu7t5v0__clkinv_1
Xgf180mcu_fd_sc_mcu7t5v0__clkinv_1_193 vdd vss gf180mcu_fd_sc_mcu7t5v0__dffq_1_168/Q
+ gf180mcu_fd_sc_mcu7t5v0__oai22_1_183/B2 vdd vss gf180mcu_fd_sc_mcu7t5v0__clkinv_1
Xgf180mcu_fd_sc_mcu7t5v0__nand3_1_17 gf180mcu_fd_sc_mcu7t5v0__xor3_1_32/A3 vdd vss
+ gf180mcu_fd_sc_mcu7t5v0__oai21_1_43/B gf180mcu_fd_sc_mcu7t5v0__inv_8_2/I gf180mcu_fd_sc_mcu7t5v0__or4_1_1/A3
+ vdd vss gf180mcu_fd_sc_mcu7t5v0__nand3_1
Xgf180mcu_fd_sc_mcu7t5v0__nand3_1_28 gf180mcu_fd_sc_mcu7t5v0__oai31_1_2/B vdd vss
+ gf180mcu_fd_sc_mcu7t5v0__nand3_1_28/ZN gf180mcu_fd_sc_mcu7t5v0__or4_1_1/A1 gf180mcu_fd_sc_mcu7t5v0__or4_1_1/A2
+ vdd vss gf180mcu_fd_sc_mcu7t5v0__nand3_1
Xgf180mcu_fd_sc_mcu7t5v0__nand3_1_39 gf180mcu_fd_sc_mcu7t5v0__nand3_1_39/A3 vdd vss
+ gf180mcu_fd_sc_mcu7t5v0__and2_1_45/A2 gf180mcu_fd_sc_mcu7t5v0__nand3_1_39/A1 gf180mcu_fd_sc_mcu7t5v0__nand3_1_39/A2
+ vdd vss gf180mcu_fd_sc_mcu7t5v0__nand3_1
Xgf180mcu_fd_sc_mcu7t5v0__oai32_1_7 gf180mcu_fd_sc_mcu7t5v0__oai32_1_7/A3 gf180mcu_fd_sc_mcu7t5v0__oai32_1_7/B1
+ gf180mcu_fd_sc_mcu7t5v0__inv_4_6/I vdd vss gf180mcu_fd_sc_mcu7t5v0__oai32_1_7/ZN
+ gf180mcu_fd_sc_mcu7t5v0__oai32_1_8/A1 gf180mcu_fd_sc_mcu7t5v0__oai32_1_7/A2 vdd
+ vss gf180mcu_fd_sc_mcu7t5v0__oai32_1
Xgf180mcu_fd_sc_mcu7t5v0__aoi221_1_12 gf180mcu_fd_sc_mcu7t5v0__nor2_2_9/ZN gf180mcu_fd_sc_mcu7t5v0__nor2_4_3/ZN
+ vdd vss gf180mcu_fd_sc_mcu7t5v0__nand4_1_4/A4 gf180mcu_fd_sc_mcu7t5v0__dffq_4_37/Q
+ gf180mcu_fd_sc_mcu7t5v0__nor3_4_4/ZN gf180mcu_fd_sc_mcu7t5v0__nor2_1_89/A2 vdd vss
+ gf180mcu_fd_sc_mcu7t5v0__aoi221_1
Xgf180mcu_fd_sc_mcu7t5v0__aoi221_1_23 gf180mcu_fd_sc_mcu7t5v0__dffq_2_43/Q gf180mcu_fd_sc_mcu7t5v0__nor2_1_174/ZN
+ vdd vss gf180mcu_fd_sc_mcu7t5v0__nor2_1_164/A2 gf180mcu_fd_sc_mcu7t5v0__dffq_1_317/Q
+ gf180mcu_fd_sc_mcu7t5v0__or2_4_3/Z gf180mcu_fd_sc_mcu7t5v0__nor2_4_32/ZN vdd vss
+ gf180mcu_fd_sc_mcu7t5v0__aoi221_1
Xgf180mcu_fd_sc_mcu7t5v0__aoi221_1_34 gf180mcu_fd_sc_mcu7t5v0__dffq_2_55/Q gf180mcu_fd_sc_mcu7t5v0__nor2_1_229/ZN
+ vdd vss gf180mcu_fd_sc_mcu7t5v0__nor2_1_227/A2 gf180mcu_fd_sc_mcu7t5v0__dffq_1_397/Q
+ gf180mcu_fd_sc_mcu7t5v0__or2_4_3/Z gf180mcu_fd_sc_mcu7t5v0__nor2_4_32/ZN vdd vss
+ gf180mcu_fd_sc_mcu7t5v0__aoi221_1
Xgf180mcu_fd_sc_mcu7t5v0__aoi221_1_45 gf180mcu_fd_sc_mcu7t5v0__aoi221_1_45/B2 gf180mcu_fd_sc_mcu7t5v0__or2_4_4/Z
+ vdd vss gf180mcu_fd_sc_mcu7t5v0__aoi21_1_224/B gf180mcu_fd_sc_mcu7t5v0__nor2_2_31/ZN
+ gf180mcu_fd_sc_mcu7t5v0__xor3_1_87/Z gf180mcu_fd_sc_mcu7t5v0__nand3_1_65/ZN vdd
+ vss gf180mcu_fd_sc_mcu7t5v0__aoi221_1
Xgf180mcu_fd_sc_mcu7t5v0__aoi221_1_56 gf180mcu_fd_sc_mcu7t5v0__aoi221_1_56/B2 gf180mcu_fd_sc_mcu7t5v0__aoi21_1_7/B
+ vdd vss gf180mcu_fd_sc_mcu7t5v0__dffq_2_88/D gf180mcu_fd_sc_mcu7t5v0__aoi22_4_9/A1
+ gf180mcu_fd_sc_mcu7t5v0__or2_4_4/Z gf180mcu_fd_sc_mcu7t5v0__nand2_1_639/ZN vdd vss
+ gf180mcu_fd_sc_mcu7t5v0__aoi221_1
Xgf180mcu_fd_sc_mcu7t5v0__nor3_4_7 gf180mcu_fd_sc_mcu7t5v0__inv_3_2/ZN vdd vss gf180mcu_fd_sc_mcu7t5v0__nor3_4_7/ZN
+ gf180mcu_fd_sc_mcu7t5v0__nor3_4_9/A1 gf180mcu_fd_sc_mcu7t5v0__inv_3_1/ZN vdd vss
+ gf180mcu_fd_sc_mcu7t5v0__nor3_4
Xgf180mcu_fd_sc_mcu7t5v0__xnor3_1_5 gf180mcu_fd_sc_mcu7t5v0__nor2_1_9/A2 vdd vss gf180mcu_fd_sc_mcu7t5v0__xor2_1_8/A2
+ gf180mcu_fd_sc_mcu7t5v0__and2_1_4/Z gf180mcu_fd_sc_mcu7t5v0__xnor3_1_5/A2 vdd vss
+ gf180mcu_fd_sc_mcu7t5v0__xnor3_1
Xgf180mcu_fd_sc_mcu7t5v0__or4_1_3 gf180mcu_fd_sc_mcu7t5v0__or4_1_3/A3 gf180mcu_fd_sc_mcu7t5v0__or4_1_3/A4
+ vdd vss gf180mcu_fd_sc_mcu7t5v0__or4_1_3/Z gf180mcu_fd_sc_mcu7t5v0__or4_1_3/A1 gf180mcu_fd_sc_mcu7t5v0__or4_1_3/A2
+ vdd vss gf180mcu_fd_sc_mcu7t5v0__or4_1
Xgf180mcu_fd_sc_mcu7t5v0__oai31_1_11 vdd gf180mcu_fd_sc_mcu7t5v0__dffq_2_50/D gf180mcu_fd_sc_mcu7t5v0__oai31_1_11/B
+ gf180mcu_fd_sc_mcu7t5v0__or2_1_23/A1 gf180mcu_fd_sc_mcu7t5v0__inv_2_8/ZN vss gf180mcu_fd_sc_mcu7t5v0__aoi21_2_6/B
+ vdd vss gf180mcu_fd_sc_mcu7t5v0__oai31_1
Xgf180mcu_fd_sc_mcu7t5v0__nand2_1_50 vdd vss gf180mcu_fd_sc_mcu7t5v0__oai21_1_19/A2
+ gf180mcu_fd_sc_mcu7t5v0__inv_4_6/I gf180mcu_fd_sc_mcu7t5v0__xor2_1_20/A1 vdd vss
+ gf180mcu_fd_sc_mcu7t5v0__nand2_1
Xgf180mcu_fd_sc_mcu7t5v0__nand2_1_61 vdd vss gf180mcu_fd_sc_mcu7t5v0__xor3_1_15/A3
+ gf180mcu_fd_sc_mcu7t5v0__inv_8_2/I gf180mcu_fd_sc_mcu7t5v0__and2_2_2/Z vdd vss gf180mcu_fd_sc_mcu7t5v0__nand2_1
Xgf180mcu_fd_sc_mcu7t5v0__nand2_1_72 vdd vss gf180mcu_fd_sc_mcu7t5v0__xor2_1_79/A2
+ gf180mcu_fd_sc_mcu7t5v0__inv_12_1/I gf180mcu_fd_sc_mcu7t5v0__mux4_4_4/Z vdd vss
+ gf180mcu_fd_sc_mcu7t5v0__nand2_1
Xgf180mcu_fd_sc_mcu7t5v0__nand2_1_83 vdd vss gf180mcu_fd_sc_mcu7t5v0__oai21_1_29/B
+ gf180mcu_fd_sc_mcu7t5v0__inv_4_6/I gf180mcu_fd_sc_mcu7t5v0__xor2_1_64/Z vdd vss
+ gf180mcu_fd_sc_mcu7t5v0__nand2_1
Xgf180mcu_fd_sc_mcu7t5v0__nand2_1_94 vdd vss gf180mcu_fd_sc_mcu7t5v0__xor3_1_57/A2
+ gf180mcu_fd_sc_mcu7t5v0__inv_12_1/I gf180mcu_fd_sc_mcu7t5v0__or4_1_1/A3 vdd vss
+ gf180mcu_fd_sc_mcu7t5v0__nand2_1
Xgf180mcu_fd_sc_mcu7t5v0__and2_1_8 vdd vss gf180mcu_fd_sc_mcu7t5v0__and2_1_8/Z gf180mcu_fd_sc_mcu7t5v0__inv_12_1/I
+ gf180mcu_fd_sc_mcu7t5v0__and2_4_0/Z vdd vss gf180mcu_fd_sc_mcu7t5v0__and2_1
Xgf180mcu_fd_sc_mcu7t5v0__aoi222_2_2 gf180mcu_fd_sc_mcu7t5v0__nor3_4_6/ZN gf180mcu_fd_sc_mcu7t5v0__aoi222_2_2/B1
+ gf180mcu_fd_sc_mcu7t5v0__aoi222_2_2/A2 gf180mcu_fd_sc_mcu7t5v0__nor2_4_12/ZN gf180mcu_fd_sc_mcu7t5v0__nand3_1_36/A3
+ vss vdd gf180mcu_fd_sc_mcu7t5v0__nor2_4_5/ZN gf180mcu_fd_sc_mcu7t5v0__aoi222_2_2/C1
+ vdd vss gf180mcu_fd_sc_mcu7t5v0__aoi222_2
Xgf180mcu_fd_sc_mcu7t5v0__nor3_2_4 gf180mcu_fd_sc_mcu7t5v0__or3_1_13/A3 vdd vss gf180mcu_fd_sc_mcu7t5v0__nor3_2_4/ZN
+ gf180mcu_fd_sc_mcu7t5v0__inv_8_0/ZN gf180mcu_fd_sc_mcu7t5v0__inv_1_13/I vdd vss
+ gf180mcu_fd_sc_mcu7t5v0__nor3_2
Xgf180mcu_fd_sc_mcu7t5v0__dffq_1_309 vdd gf180mcu_fd_sc_mcu7t5v0__dffq_1_309/Q gf180mcu_fd_sc_mcu7t5v0__dffq_4_9/CLK
+ vss gf180mcu_fd_sc_mcu7t5v0__dffq_1_309/D vdd vss gf180mcu_fd_sc_mcu7t5v0__dffq_1
Xgf180mcu_fd_sc_mcu7t5v0__aoi21_4_5 gf180mcu_fd_sc_mcu7t5v0__or3_4_0/Z gf180mcu_fd_sc_mcu7t5v0__aoi21_4_5/B
+ vdd vss gf180mcu_fd_sc_mcu7t5v0__aoi21_4_5/ZN gf180mcu_fd_sc_mcu7t5v0__mux4_4_4/I0
+ vdd vss gf180mcu_fd_sc_mcu7t5v0__aoi21_4
Xgf180mcu_fd_sc_mcu7t5v0__nand2_1_702 vdd vss gf180mcu_fd_sc_mcu7t5v0__nand2_1_702/ZN
+ gf180mcu_fd_sc_mcu7t5v0__nor2_1_270/ZN gf180mcu_fd_sc_mcu7t5v0__oai32_1_8/B1 vdd
+ vss gf180mcu_fd_sc_mcu7t5v0__nand2_1
Xgf180mcu_fd_sc_mcu7t5v0__nand2_1_713 vdd vss gf180mcu_fd_sc_mcu7t5v0__nand3_1_67/A2
+ gf180mcu_fd_sc_mcu7t5v0__or2_1_15/A1 gf180mcu_fd_sc_mcu7t5v0__or2_1_15/A2 vdd vss
+ gf180mcu_fd_sc_mcu7t5v0__nand2_1
Xgf180mcu_fd_sc_mcu7t5v0__nand2_1_724 vdd vss gf180mcu_fd_sc_mcu7t5v0__xor2_1_83/A1
+ gf180mcu_fd_sc_mcu7t5v0__inv_8_1/I gf180mcu_fd_sc_mcu7t5v0__inv_1_5/I vdd vss gf180mcu_fd_sc_mcu7t5v0__nand2_1
Xgf180mcu_fd_sc_mcu7t5v0__and2_1_10 vdd vss gf180mcu_fd_sc_mcu7t5v0__and2_1_10/Z gf180mcu_fd_sc_mcu7t5v0__nor2_2_15/ZN
+ gf180mcu_fd_sc_mcu7t5v0__xnor3_1_8/A1 vdd vss gf180mcu_fd_sc_mcu7t5v0__and2_1
Xgf180mcu_fd_sc_mcu7t5v0__and2_1_21 vdd vss gf180mcu_fd_sc_mcu7t5v0__and2_1_21/Z gf180mcu_fd_sc_mcu7t5v0__xor3_1_47/Z
+ gf180mcu_fd_sc_mcu7t5v0__xor3_1_1/A3 vdd vss gf180mcu_fd_sc_mcu7t5v0__and2_1
Xgf180mcu_fd_sc_mcu7t5v0__and2_1_32 vdd vss gf180mcu_fd_sc_mcu7t5v0__and2_1_32/Z gf180mcu_fd_sc_mcu7t5v0__inv_3_3/ZN
+ gf180mcu_fd_sc_mcu7t5v0__xor3_1_56/A2 vdd vss gf180mcu_fd_sc_mcu7t5v0__and2_1
Xgf180mcu_fd_sc_mcu7t5v0__and2_1_43 vdd vss gf180mcu_fd_sc_mcu7t5v0__and2_1_43/Z gf180mcu_fd_sc_mcu7t5v0__dffq_1_450/Q
+ gf180mcu_fd_sc_mcu7t5v0__nor2_4_14/A2 vdd vss gf180mcu_fd_sc_mcu7t5v0__and2_1
Xgf180mcu_fd_sc_mcu7t5v0__and2_1_54 vdd vss gf180mcu_fd_sc_mcu7t5v0__and2_1_54/Z gf180mcu_fd_sc_mcu7t5v0__nor4_1_1/A2
+ gf180mcu_fd_sc_mcu7t5v0__and2_1_55/Z vdd vss gf180mcu_fd_sc_mcu7t5v0__and2_1
Xgf180mcu_fd_sc_mcu7t5v0__and2_1_65 vdd vss gf180mcu_fd_sc_mcu7t5v0__and2_1_65/Z gf180mcu_fd_sc_mcu7t5v0__nor3_1_17/A2
+ gf180mcu_fd_sc_mcu7t5v0__and2_1_66/Z vdd vss gf180mcu_fd_sc_mcu7t5v0__and2_1
Xgf180mcu_fd_sc_mcu7t5v0__and2_1_76 vdd vss gf180mcu_fd_sc_mcu7t5v0__and2_1_76/Z gf180mcu_fd_sc_mcu7t5v0__buf_8_8/Z
+ gf180mcu_fd_sc_mcu7t5v0__or2_4_3/A1 vdd vss gf180mcu_fd_sc_mcu7t5v0__and2_1
Xgf180mcu_fd_sc_mcu7t5v0__and2_1_87 vdd vss gf180mcu_fd_sc_mcu7t5v0__nor3_2_6/A1 gf180mcu_fd_sc_mcu7t5v0__and2_1_87/A1
+ gf180mcu_fd_sc_mcu7t5v0__and2_1_87/A2 vdd vss gf180mcu_fd_sc_mcu7t5v0__and2_1
Xgf180mcu_fd_sc_mcu7t5v0__and2_1_98 vdd vss gf180mcu_fd_sc_mcu7t5v0__or3_1_17/A2 gf180mcu_fd_sc_mcu7t5v0__and2_1_98/A1
+ gf180mcu_fd_sc_mcu7t5v0__xor3_1_88/Z vdd vss gf180mcu_fd_sc_mcu7t5v0__and2_1
Xgf180mcu_fd_sc_mcu7t5v0__aoi211_1_11 gf180mcu_fd_sc_mcu7t5v0__nor2_1_48/ZN gf180mcu_fd_sc_mcu7t5v0__or2_1_23/A1
+ vdd vss gf180mcu_fd_sc_mcu7t5v0__dffq_1_4/D gf180mcu_fd_sc_mcu7t5v0__inv_4_2/ZN
+ gf180mcu_fd_sc_mcu7t5v0__nor2_4_16/ZN vdd vss gf180mcu_fd_sc_mcu7t5v0__aoi211_1
Xgf180mcu_fd_sc_mcu7t5v0__aoi211_1_22 gf180mcu_fd_sc_mcu7t5v0__nor2_1_78/ZN gf180mcu_fd_sc_mcu7t5v0__or2_4_4/Z
+ vdd vss gf180mcu_fd_sc_mcu7t5v0__nor2_1_77/A1 gf180mcu_fd_sc_mcu7t5v0__oai31_1_0/B
+ gf180mcu_fd_sc_mcu7t5v0__oai211_1_8/ZN vdd vss gf180mcu_fd_sc_mcu7t5v0__aoi211_1
Xgf180mcu_fd_sc_mcu7t5v0__aoi211_1_33 gf180mcu_fd_sc_mcu7t5v0__nor2_1_137/ZN gf180mcu_fd_sc_mcu7t5v0__or2_1_23/A1
+ vdd vss gf180mcu_fd_sc_mcu7t5v0__dffq_1_283/D gf180mcu_fd_sc_mcu7t5v0__inv_4_3/ZN
+ gf180mcu_fd_sc_mcu7t5v0__nor2_4_20/ZN vdd vss gf180mcu_fd_sc_mcu7t5v0__aoi211_1
Xgf180mcu_fd_sc_mcu7t5v0__aoi211_1_44 gf180mcu_fd_sc_mcu7t5v0__nor2_1_163/ZN gf180mcu_fd_sc_mcu7t5v0__or2_1_23/A1
+ vdd vss gf180mcu_fd_sc_mcu7t5v0__dffq_1_308/D gf180mcu_fd_sc_mcu7t5v0__inv_4_3/ZN
+ gf180mcu_fd_sc_mcu7t5v0__nor2_4_28/ZN vdd vss gf180mcu_fd_sc_mcu7t5v0__aoi211_1
Xgf180mcu_fd_sc_mcu7t5v0__aoi211_1_55 gf180mcu_fd_sc_mcu7t5v0__mux2_1_8/Z gf180mcu_fd_sc_mcu7t5v0__nor2_2_26/ZN
+ vdd vss gf180mcu_fd_sc_mcu7t5v0__nor2_1_263/A2 gf180mcu_fd_sc_mcu7t5v0__or2_1_7/A1
+ gf180mcu_fd_sc_mcu7t5v0__nor2_2_28/ZN vdd vss gf180mcu_fd_sc_mcu7t5v0__aoi211_1
Xgf180mcu_fd_sc_mcu7t5v0__aoi211_1_66 gf180mcu_fd_sc_mcu7t5v0__aoi21_1_7/B gf180mcu_fd_sc_mcu7t5v0__aoi211_1_66/C
+ vdd vss gf180mcu_fd_sc_mcu7t5v0__dffq_4_41/D gf180mcu_fd_sc_mcu7t5v0__inv_1_24/ZN
+ gf180mcu_fd_sc_mcu7t5v0__or2_4_4/Z vdd vss gf180mcu_fd_sc_mcu7t5v0__aoi211_1
Xgf180mcu_fd_sc_mcu7t5v0__aoi211_1_77 gf180mcu_fd_sc_mcu7t5v0__aoi21_1_7/B gf180mcu_fd_sc_mcu7t5v0__aoi211_1_77/C
+ vdd vss gf180mcu_fd_sc_mcu7t5v0__dffq_1_433/D gf180mcu_fd_sc_mcu7t5v0__xor3_1_91/A1
+ gf180mcu_fd_sc_mcu7t5v0__or2_4_4/Z vdd vss gf180mcu_fd_sc_mcu7t5v0__aoi211_1
Xgf180mcu_fd_sc_mcu7t5v0__aoi211_1_88 gf180mcu_fd_sc_mcu7t5v0__nor2_1_118/ZN gf180mcu_fd_sc_mcu7t5v0__or2_1_23/A1
+ vdd vss gf180mcu_fd_sc_mcu7t5v0__dffq_1_241/D gf180mcu_fd_sc_mcu7t5v0__nor2_1_144/A1
+ gf180mcu_fd_sc_mcu7t5v0__nor2_4_17/ZN vdd vss gf180mcu_fd_sc_mcu7t5v0__aoi211_1
Xgf180mcu_fd_sc_mcu7t5v0__aoi21_1_210 gf180mcu_fd_sc_mcu7t5v0__xor2_2_2/A2 vdd vss
+ gf180mcu_fd_sc_mcu7t5v0__aoi21_1_383/B gf180mcu_fd_sc_mcu7t5v0__nand3_1_64/ZN gf180mcu_fd_sc_mcu7t5v0__and2_1_84/A2
+ vdd vss gf180mcu_fd_sc_mcu7t5v0__aoi21_1
Xgf180mcu_fd_sc_mcu7t5v0__clkinv_1_90 vdd vss gf180mcu_fd_sc_mcu7t5v0__dffq_1_95/Q
+ gf180mcu_fd_sc_mcu7t5v0__oai22_1_72/B2 vdd vss gf180mcu_fd_sc_mcu7t5v0__clkinv_1
Xgf180mcu_fd_sc_mcu7t5v0__aoi21_1_221 gf180mcu_fd_sc_mcu7t5v0__xor3_1_105/A3 vdd vss
+ gf180mcu_fd_sc_mcu7t5v0__nor3_1_26/A3 gf180mcu_fd_sc_mcu7t5v0__inv_8_1/I gf180mcu_fd_sc_mcu7t5v0__mux4_4_7/Z
+ vdd vss gf180mcu_fd_sc_mcu7t5v0__aoi21_1
Xgf180mcu_fd_sc_mcu7t5v0__aoi21_1_232 gf180mcu_fd_sc_mcu7t5v0__aoi21_1_232/B vdd vss
+ gf180mcu_fd_sc_mcu7t5v0__dffq_4_23/D gf180mcu_fd_sc_mcu7t5v0__inv_4_4/ZN gf180mcu_fd_sc_mcu7t5v0__buf_20_0/Z
+ vdd vss gf180mcu_fd_sc_mcu7t5v0__aoi21_1
Xgf180mcu_fd_sc_mcu7t5v0__aoi21_1_243 gf180mcu_fd_sc_mcu7t5v0__and2_1_101/Z vdd vss
+ gf180mcu_fd_sc_mcu7t5v0__xor3_1_91/A2 gf180mcu_fd_sc_mcu7t5v0__dffq_1_443/Q gf180mcu_fd_sc_mcu7t5v0__xnor2_1_45/ZN
+ vdd vss gf180mcu_fd_sc_mcu7t5v0__aoi21_1
Xgf180mcu_fd_sc_mcu7t5v0__aoi21_1_254 gf180mcu_fd_sc_mcu7t5v0__aoi21_1_254/B vdd vss
+ gf180mcu_fd_sc_mcu7t5v0__xnor3_1_30/A2 gf180mcu_fd_sc_mcu7t5v0__aoi21_1_254/A1 gf180mcu_fd_sc_mcu7t5v0__nand3_1_78/ZN
+ vdd vss gf180mcu_fd_sc_mcu7t5v0__aoi21_1
Xgf180mcu_fd_sc_mcu7t5v0__aoi21_1_265 gf180mcu_fd_sc_mcu7t5v0__or2_4_4/Z vdd vss gf180mcu_fd_sc_mcu7t5v0__aoi22_1_166/B2
+ gf180mcu_fd_sc_mcu7t5v0__nor2_4_38/ZN gf180mcu_fd_sc_mcu7t5v0__xor3_1_110/Z vdd
+ vss gf180mcu_fd_sc_mcu7t5v0__aoi21_1
Xgf180mcu_fd_sc_mcu7t5v0__aoi21_1_276 gf180mcu_fd_sc_mcu7t5v0__aoi21_1_276/B vdd vss
+ gf180mcu_fd_sc_mcu7t5v0__dffq_4_28/D gf180mcu_fd_sc_mcu7t5v0__nor3_4_18/A1 gf180mcu_fd_sc_mcu7t5v0__buf_20_0/Z
+ vdd vss gf180mcu_fd_sc_mcu7t5v0__aoi21_1
Xgf180mcu_fd_sc_mcu7t5v0__aoi21_1_287 gf180mcu_fd_sc_mcu7t5v0__aoi21_1_287/B vdd vss
+ gf180mcu_fd_sc_mcu7t5v0__dffq_1_452/D gf180mcu_fd_sc_mcu7t5v0__aoi21_1_287/A1 gf180mcu_fd_sc_mcu7t5v0__buf_20_0/I
+ vdd vss gf180mcu_fd_sc_mcu7t5v0__aoi21_1
Xgf180mcu_fd_sc_mcu7t5v0__aoi21_1_298 gf180mcu_fd_sc_mcu7t5v0__nor3_1_33/A1 vdd vss
+ gf180mcu_fd_sc_mcu7t5v0__nor2_1_321/A1 gf180mcu_fd_sc_mcu7t5v0__or3_1_20/Z gf180mcu_fd_sc_mcu7t5v0__and2_1_122/A2
+ vdd vss gf180mcu_fd_sc_mcu7t5v0__aoi21_1
Xgf180mcu_fd_sc_mcu7t5v0__oai33_2_2 gf180mcu_fd_sc_mcu7t5v0__and2_1_0/Z gf180mcu_fd_sc_mcu7t5v0__xor3_1_6/Z
+ gf180mcu_fd_sc_mcu7t5v0__nor3_2_2/A1 gf180mcu_fd_sc_mcu7t5v0__nor3_2_2/A2 vdd vss
+ gf180mcu_fd_sc_mcu7t5v0__xor2_2_0/A1 gf180mcu_fd_sc_mcu7t5v0__xor3_1_6/A2 gf180mcu_fd_sc_mcu7t5v0__nor2_1_0/ZN
+ vdd vss gf180mcu_fd_sc_mcu7t5v0__oai33_2
Xgf180mcu_fd_sc_mcu7t5v0__oai21_1_10 vdd gf180mcu_fd_sc_mcu7t5v0__xor2_1_15/Z gf180mcu_fd_sc_mcu7t5v0__nor3_1_3/A2
+ gf180mcu_fd_sc_mcu7t5v0__oai21_1_10/ZN gf180mcu_fd_sc_mcu7t5v0__and2_1_7/Z vss vdd
+ vss gf180mcu_fd_sc_mcu7t5v0__oai21_1
Xgf180mcu_fd_sc_mcu7t5v0__oai21_1_21 vdd gf180mcu_fd_sc_mcu7t5v0__oai21_1_21/B gf180mcu_fd_sc_mcu7t5v0__nand3_1_1/A3
+ gf180mcu_fd_sc_mcu7t5v0__oai211_1_2/B gf180mcu_fd_sc_mcu7t5v0__dffq_4_37/Q vss vdd
+ vss gf180mcu_fd_sc_mcu7t5v0__oai21_1
Xgf180mcu_fd_sc_mcu7t5v0__oai21_1_32 vdd gf180mcu_fd_sc_mcu7t5v0__buf_8_5/Z gf180mcu_fd_sc_mcu7t5v0__buf_20_0/Z
+ gf180mcu_fd_sc_mcu7t5v0__aoi21_1_41/B gf180mcu_fd_sc_mcu7t5v0__dffq_1_10/Q vss vdd
+ vss gf180mcu_fd_sc_mcu7t5v0__oai21_1
Xgf180mcu_fd_sc_mcu7t5v0__oai21_4_8 gf180mcu_fd_sc_mcu7t5v0__or3_2_3/Z vdd vss gf180mcu_fd_sc_mcu7t5v0__oai21_4_8/A1
+ gf180mcu_fd_sc_mcu7t5v0__or3_1_9/A2 gf180mcu_fd_sc_mcu7t5v0__oai31_4_1/ZN vdd vss
+ gf180mcu_fd_sc_mcu7t5v0__oai21_4
Xgf180mcu_fd_sc_mcu7t5v0__oai21_1_43 vdd gf180mcu_fd_sc_mcu7t5v0__oai21_1_43/B gf180mcu_fd_sc_mcu7t5v0__oai21_1_43/A2
+ gf180mcu_fd_sc_mcu7t5v0__xor3_1_36/A2 gf180mcu_fd_sc_mcu7t5v0__xor3_1_32/A1 vss
+ vdd vss gf180mcu_fd_sc_mcu7t5v0__oai21_1
Xgf180mcu_fd_sc_mcu7t5v0__oai21_1_54 vdd gf180mcu_fd_sc_mcu7t5v0__and2_4_3/Z gf180mcu_fd_sc_mcu7t5v0__oai21_1_54/A2
+ gf180mcu_fd_sc_mcu7t5v0__aoi21_1_63/B gf180mcu_fd_sc_mcu7t5v0__or2_4_4/Z vss vdd
+ vss gf180mcu_fd_sc_mcu7t5v0__oai21_1
Xgf180mcu_fd_sc_mcu7t5v0__oai21_1_65 vdd gf180mcu_fd_sc_mcu7t5v0__oai21_1_65/B gf180mcu_fd_sc_mcu7t5v0__xor2_1_55/Z
+ gf180mcu_fd_sc_mcu7t5v0__nand4_1_5/A2 gf180mcu_fd_sc_mcu7t5v0__oai21_1_65/A1 vss
+ vdd vss gf180mcu_fd_sc_mcu7t5v0__oai21_1
Xgf180mcu_fd_sc_mcu7t5v0__oai22_1_208 gf180mcu_fd_sc_mcu7t5v0__nand2_4_28/ZN gf180mcu_fd_sc_mcu7t5v0__nand2_2_44/ZN
+ gf180mcu_fd_sc_mcu7t5v0__oai22_1_208/B2 vdd vss gf180mcu_fd_sc_mcu7t5v0__dffq_1_198/D
+ gf180mcu_fd_sc_mcu7t5v0__aoi21_4_4/ZN vdd vss gf180mcu_fd_sc_mcu7t5v0__oai22_1
Xgf180mcu_fd_sc_mcu7t5v0__oai21_1_76 vdd gf180mcu_fd_sc_mcu7t5v0__nor3_1_9/A1 gf180mcu_fd_sc_mcu7t5v0__oai221_1_5/ZN
+ gf180mcu_fd_sc_mcu7t5v0__oai21_1_76/ZN gf180mcu_fd_sc_mcu7t5v0__oai32_1_3/ZN vss
+ vdd vss gf180mcu_fd_sc_mcu7t5v0__oai21_1
Xgf180mcu_fd_sc_mcu7t5v0__oai22_1_219 gf180mcu_fd_sc_mcu7t5v0__nand2_4_31/ZN gf180mcu_fd_sc_mcu7t5v0__nand2_2_42/ZN
+ gf180mcu_fd_sc_mcu7t5v0__oai22_1_219/B2 vdd vss gf180mcu_fd_sc_mcu7t5v0__dffq_1_209/D
+ gf180mcu_fd_sc_mcu7t5v0__aoi21_4_4/ZN vdd vss gf180mcu_fd_sc_mcu7t5v0__oai22_1
Xgf180mcu_fd_sc_mcu7t5v0__oai21_1_87 vdd gf180mcu_fd_sc_mcu7t5v0__buf_8_5/Z gf180mcu_fd_sc_mcu7t5v0__buf_20_0/Z
+ gf180mcu_fd_sc_mcu7t5v0__aoi21_1_95/B gf180mcu_fd_sc_mcu7t5v0__dffq_1_243/Q vss
+ vdd vss gf180mcu_fd_sc_mcu7t5v0__oai21_1
Xgf180mcu_fd_sc_mcu7t5v0__oai21_1_98 vdd gf180mcu_fd_sc_mcu7t5v0__buf_8_6/Z gf180mcu_fd_sc_mcu7t5v0__nor3_4_14/ZN
+ gf180mcu_fd_sc_mcu7t5v0__oai21_1_98/ZN gf180mcu_fd_sc_mcu7t5v0__dffq_1_285/Q vss
+ vdd vss gf180mcu_fd_sc_mcu7t5v0__oai21_1
Xgf180mcu_fd_sc_mcu7t5v0__or2_4_4 vdd vss gf180mcu_fd_sc_mcu7t5v0__or2_4_4/Z gf180mcu_fd_sc_mcu7t5v0__or3_4_0/A3
+ gf180mcu_fd_sc_mcu7t5v0__or2_4_4/A2 vdd vss gf180mcu_fd_sc_mcu7t5v0__or2_4
Xgf180mcu_fd_sc_mcu7t5v0__dffq_1_106 vdd gf180mcu_fd_sc_mcu7t5v0__dffq_1_106/Q gf180mcu_fd_sc_mcu7t5v0__dffq_2_26/CLK
+ vss gf180mcu_fd_sc_mcu7t5v0__dffq_1_106/D vdd vss gf180mcu_fd_sc_mcu7t5v0__dffq_1
Xgf180mcu_fd_sc_mcu7t5v0__dffq_1_117 vdd gf180mcu_fd_sc_mcu7t5v0__dffq_1_117/Q gf180mcu_fd_sc_mcu7t5v0__dffq_1_96/CLK
+ vss gf180mcu_fd_sc_mcu7t5v0__dffq_1_117/D vdd vss gf180mcu_fd_sc_mcu7t5v0__dffq_1
Xgf180mcu_fd_sc_mcu7t5v0__nor2_1_306 vdd vss gf180mcu_fd_sc_mcu7t5v0__nor2_1_306/ZN
+ gf180mcu_fd_sc_mcu7t5v0__dffq_1_417/Q gf180mcu_fd_sc_mcu7t5v0__nor2_4_18/ZN vdd
+ vss gf180mcu_fd_sc_mcu7t5v0__nor2_1
Xgf180mcu_fd_sc_mcu7t5v0__dffq_1_128 vdd gf180mcu_fd_sc_mcu7t5v0__dffq_1_128/Q gf180mcu_fd_sc_mcu7t5v0__dffq_1_96/CLK
+ vss gf180mcu_fd_sc_mcu7t5v0__dffq_1_128/D vdd vss gf180mcu_fd_sc_mcu7t5v0__dffq_1
Xgf180mcu_fd_sc_mcu7t5v0__nor2_1_317 vdd vss gf180mcu_fd_sc_mcu7t5v0__nor2_1_317/ZN
+ gf180mcu_fd_sc_mcu7t5v0__dffq_1_426/Q gf180mcu_fd_sc_mcu7t5v0__and3_2_2/Z vdd vss
+ gf180mcu_fd_sc_mcu7t5v0__nor2_1
Xgf180mcu_fd_sc_mcu7t5v0__dffq_1_139 vdd gf180mcu_fd_sc_mcu7t5v0__dffq_1_139/Q gf180mcu_fd_sc_mcu7t5v0__dffq_1_96/CLK
+ vss gf180mcu_fd_sc_mcu7t5v0__dffq_1_139/D vdd vss gf180mcu_fd_sc_mcu7t5v0__dffq_1
Xgf180mcu_fd_sc_mcu7t5v0__nor2_1_328 vdd vss gf180mcu_fd_sc_mcu7t5v0__nor2_1_328/ZN
+ gf180mcu_fd_sc_mcu7t5v0__dffq_1_429/Q gf180mcu_fd_sc_mcu7t5v0__nor2_4_27/ZN vdd
+ vss gf180mcu_fd_sc_mcu7t5v0__nor2_1
Xgf180mcu_fd_sc_mcu7t5v0__aoi21_2_2 gf180mcu_fd_sc_mcu7t5v0__aoi21_2_2/B vdd vss gf180mcu_fd_sc_mcu7t5v0__xor3_1_30/A2
+ gf180mcu_fd_sc_mcu7t5v0__xor2_1_35/A1 gf180mcu_fd_sc_mcu7t5v0__aoi21_2_2/A2 vdd
+ vss gf180mcu_fd_sc_mcu7t5v0__aoi21_2
Xgf180mcu_fd_sc_mcu7t5v0__nor2_1_339 vdd vss gf180mcu_fd_sc_mcu7t5v0__xor2_1_158/A1
+ gf180mcu_fd_sc_mcu7t5v0__oai21_1_288/B gf180mcu_fd_sc_mcu7t5v0__or2_1_43/Z vdd vss
+ gf180mcu_fd_sc_mcu7t5v0__nor2_1
Xgf180mcu_fd_sc_mcu7t5v0__nand2_1_510 vdd vss gf180mcu_fd_sc_mcu7t5v0__xor3_1_93/A2
+ gf180mcu_fd_sc_mcu7t5v0__dffq_4_37/Q gf180mcu_fd_sc_mcu7t5v0__nor4_2_5/A3 vdd vss
+ gf180mcu_fd_sc_mcu7t5v0__nand2_1
Xgf180mcu_fd_sc_mcu7t5v0__nand2_1_521 vdd vss gf180mcu_fd_sc_mcu7t5v0__oai21_1_244/B
+ gf180mcu_fd_sc_mcu7t5v0__dffq_2_65/Q gf180mcu_fd_sc_mcu7t5v0__xor2_1_222/Z vdd vss
+ gf180mcu_fd_sc_mcu7t5v0__nand2_1
Xgf180mcu_fd_sc_mcu7t5v0__nand2_1_532 vdd vss gf180mcu_fd_sc_mcu7t5v0__oai31_1_7/B
+ gf180mcu_fd_sc_mcu7t5v0__oai31_1_8/ZN gf180mcu_fd_sc_mcu7t5v0__xor2_1_87/Z vdd vss
+ gf180mcu_fd_sc_mcu7t5v0__nand2_1
Xgf180mcu_fd_sc_mcu7t5v0__nand2_1_543 vdd vss gf180mcu_fd_sc_mcu7t5v0__nand2_1_543/ZN
+ gf180mcu_fd_sc_mcu7t5v0__mux4_4_1/I3 gf180mcu_fd_sc_mcu7t5v0__clkinv_3_9/ZN vdd
+ vss gf180mcu_fd_sc_mcu7t5v0__nand2_1
Xgf180mcu_fd_sc_mcu7t5v0__nand2_1_554 vdd vss gf180mcu_fd_sc_mcu7t5v0__aoi22_4_10/B2
+ gf180mcu_fd_sc_mcu7t5v0__dffq_4_35/Q gf180mcu_fd_sc_mcu7t5v0__or2_1_42/A1 vdd vss
+ gf180mcu_fd_sc_mcu7t5v0__nand2_1
Xgf180mcu_fd_sc_mcu7t5v0__nand2_1_565 vdd vss gf180mcu_fd_sc_mcu7t5v0__oai21_1_281/A2
+ gf180mcu_fd_sc_mcu7t5v0__dffq_4_37/Q gf180mcu_fd_sc_mcu7t5v0__mux4_4_12/Z vdd vss
+ gf180mcu_fd_sc_mcu7t5v0__nand2_1
Xgf180mcu_fd_sc_mcu7t5v0__aoi21_2_12 gf180mcu_fd_sc_mcu7t5v0__inv_4_4/I vdd vss gf180mcu_fd_sc_mcu7t5v0__oai211_2_6/A2
+ gf180mcu_fd_sc_mcu7t5v0__or2_1_17/A1 gf180mcu_fd_sc_mcu7t5v0__or2_1_36/A2 vdd vss
+ gf180mcu_fd_sc_mcu7t5v0__aoi21_2
Xgf180mcu_fd_sc_mcu7t5v0__aoi21_2_23 gf180mcu_fd_sc_mcu7t5v0__aoi21_2_23/B vdd vss
+ gf180mcu_fd_sc_mcu7t5v0__nor2_2_58/A1 gf180mcu_fd_sc_mcu7t5v0__aoi21_2_23/A1 gf180mcu_fd_sc_mcu7t5v0__xor2_1_206/Z
+ vdd vss gf180mcu_fd_sc_mcu7t5v0__aoi21_2
Xgf180mcu_fd_sc_mcu7t5v0__nand2_1_576 vdd vss gf180mcu_fd_sc_mcu7t5v0__nand4_1_20/A2
+ gf180mcu_fd_sc_mcu7t5v0__nor3_4_22/ZN gf180mcu_fd_sc_mcu7t5v0__xor3_1_113/A3 vdd
+ vss gf180mcu_fd_sc_mcu7t5v0__nand2_1
Xgf180mcu_fd_sc_mcu7t5v0__nand2_1_587 vdd vss gf180mcu_fd_sc_mcu7t5v0__nor3_1_36/A2
+ gf180mcu_fd_sc_mcu7t5v0__inv_8_2/I gf180mcu_fd_sc_mcu7t5v0__inv_1_14/I vdd vss gf180mcu_fd_sc_mcu7t5v0__nand2_1
Xgf180mcu_fd_sc_mcu7t5v0__nand2_1_598 vdd vss gf180mcu_fd_sc_mcu7t5v0__xor3_1_124/A1
+ gf180mcu_fd_sc_mcu7t5v0__or4_1_0/A1 gf180mcu_fd_sc_mcu7t5v0__mux4_4_15/Z vdd vss
+ gf180mcu_fd_sc_mcu7t5v0__nand2_1
Xgf180mcu_fd_sc_mcu7t5v0__xor2_2_1 vdd vss gf180mcu_fd_sc_mcu7t5v0__xor2_2_1/Z gf180mcu_fd_sc_mcu7t5v0__xor2_2_1/A1
+ gf180mcu_fd_sc_mcu7t5v0__xor2_2_1/A2 vdd vss gf180mcu_fd_sc_mcu7t5v0__xor2_2
Xgf180mcu_fd_sc_mcu7t5v0__nand2_1_9 vdd vss gf180mcu_fd_sc_mcu7t5v0__nand3_1_0/A3
+ gf180mcu_fd_sc_mcu7t5v0__nand2_1_9/A1 gf180mcu_fd_sc_mcu7t5v0__nand2_1_9/A2 vdd
+ vss gf180mcu_fd_sc_mcu7t5v0__nand2_1
Xgf180mcu_fd_sc_mcu7t5v0__oai211_2_2 gf180mcu_fd_sc_mcu7t5v0__aoi21_2_3/ZN gf180mcu_fd_sc_mcu7t5v0__oai22_1_6/A2
+ gf180mcu_fd_sc_mcu7t5v0__and2_1_26/Z gf180mcu_fd_sc_mcu7t5v0__oai21_1_56/B gf180mcu_fd_sc_mcu7t5v0__inv_8_0/I
+ vdd vss vdd vss gf180mcu_fd_sc_mcu7t5v0__oai211_2
Xgf180mcu_fd_sc_mcu7t5v0__mux4_4_15 gf180mcu_fd_sc_mcu7t5v0__inv_1_18/I vss vdd gf180mcu_fd_sc_mcu7t5v0__or2_1_39/A1
+ gf180mcu_fd_sc_mcu7t5v0__inv_1_2/I gf180mcu_fd_sc_mcu7t5v0__inv_1_20/I gf180mcu_fd_sc_mcu7t5v0__mux4_4_3/I0
+ gf180mcu_fd_sc_mcu7t5v0__dffq_4_32/Q gf180mcu_fd_sc_mcu7t5v0__mux4_4_15/Z vdd vss
+ gf180mcu_fd_sc_mcu7t5v0__mux4_4
Xgf180mcu_fd_sc_mcu7t5v0__and3_2_3 gf180mcu_fd_sc_mcu7t5v0__and3_2_3/A3 vdd vss gf180mcu_fd_sc_mcu7t5v0__and3_2_3/Z
+ gf180mcu_fd_sc_mcu7t5v0__and3_2_3/A1 gf180mcu_fd_sc_mcu7t5v0__and3_2_3/A2 vdd vss
+ gf180mcu_fd_sc_mcu7t5v0__and3_2
Xgf180mcu_fd_sc_mcu7t5v0__oai21_2_5 gf180mcu_fd_sc_mcu7t5v0__inv_3_0/ZN gf180mcu_fd_sc_mcu7t5v0__oai21_2_5/ZN
+ gf180mcu_fd_sc_mcu7t5v0__inv_3_3/I vss gf180mcu_fd_sc_mcu7t5v0__inv_4_1/ZN vdd vdd
+ vss gf180mcu_fd_sc_mcu7t5v0__oai21_2
Xgf180mcu_fd_sc_mcu7t5v0__tiel_3 rst_n_PD vdd vss vdd vss gf180mcu_fd_sc_mcu7t5v0__tiel
Xgf180mcu_fd_sc_mcu7t5v0__or2_2_1 vdd vss gf180mcu_fd_sc_mcu7t5v0__or2_2_1/Z gf180mcu_fd_sc_mcu7t5v0__or2_2_1/A1
+ gf180mcu_fd_sc_mcu7t5v0__inv_4_5/I vdd vss gf180mcu_fd_sc_mcu7t5v0__or2_2
Xgf180mcu_fd_sc_mcu7t5v0__nor2_1_103 vdd vss gf180mcu_fd_sc_mcu7t5v0__and2_1_38/A2
+ gf180mcu_fd_sc_mcu7t5v0__dffq_4_8/Q gf180mcu_fd_sc_mcu7t5v0__inv_2_6/I vdd vss gf180mcu_fd_sc_mcu7t5v0__nor2_1
Xgf180mcu_fd_sc_mcu7t5v0__nor2_1_114 vdd vss gf180mcu_fd_sc_mcu7t5v0__nor2_1_114/ZN
+ gf180mcu_fd_sc_mcu7t5v0__dffq_1_244/Q gf180mcu_fd_sc_mcu7t5v0__nor2_4_19/ZN vdd
+ vss gf180mcu_fd_sc_mcu7t5v0__nor2_1
Xgf180mcu_fd_sc_mcu7t5v0__nor2_1_125 vdd vss gf180mcu_fd_sc_mcu7t5v0__xnor3_1_18/A2
+ gf180mcu_fd_sc_mcu7t5v0__or3_1_24/A1 gf180mcu_fd_sc_mcu7t5v0__inv_1_5/ZN vdd vss
+ gf180mcu_fd_sc_mcu7t5v0__nor2_1
Xgf180mcu_fd_sc_mcu7t5v0__nor2_1_136 vdd vss gf180mcu_fd_sc_mcu7t5v0__nor2_1_136/ZN
+ gf180mcu_fd_sc_mcu7t5v0__dffq_1_280/Q gf180mcu_fd_sc_mcu7t5v0__nor2_4_20/ZN vdd
+ vss gf180mcu_fd_sc_mcu7t5v0__nor2_1
Xgf180mcu_fd_sc_mcu7t5v0__xor3_1_104 gf180mcu_fd_sc_mcu7t5v0__xor3_1_80/Z vdd vss
+ gf180mcu_fd_sc_mcu7t5v0__xor3_1_104/Z gf180mcu_fd_sc_mcu7t5v0__or2_1_34/A1 gf180mcu_fd_sc_mcu7t5v0__xor3_1_104/A2
+ vdd vss gf180mcu_fd_sc_mcu7t5v0__xor3_1
Xgf180mcu_fd_sc_mcu7t5v0__nor2_1_147 vdd vss gf180mcu_fd_sc_mcu7t5v0__dffq_2_31/D
+ gf180mcu_fd_sc_mcu7t5v0__or2_1_23/A1 gf180mcu_fd_sc_mcu7t5v0__nor2_1_147/A2 vdd
+ vss gf180mcu_fd_sc_mcu7t5v0__nor2_1
Xgf180mcu_fd_sc_mcu7t5v0__xor3_1_115 gf180mcu_fd_sc_mcu7t5v0__xor3_1_134/Z vdd vss
+ gf180mcu_fd_sc_mcu7t5v0__xor3_1_115/Z gf180mcu_fd_sc_mcu7t5v0__mux4_2_1/I2 gf180mcu_fd_sc_mcu7t5v0__xor3_1_115/A2
+ vdd vss gf180mcu_fd_sc_mcu7t5v0__xor3_1
Xgf180mcu_fd_sc_mcu7t5v0__nor2_1_158 vdd vss gf180mcu_fd_sc_mcu7t5v0__dffq_1_318/D
+ gf180mcu_fd_sc_mcu7t5v0__or2_1_23/A1 gf180mcu_fd_sc_mcu7t5v0__nor2_1_158/A2 vdd
+ vss gf180mcu_fd_sc_mcu7t5v0__nor2_1
Xgf180mcu_fd_sc_mcu7t5v0__xor3_1_126 gf180mcu_fd_sc_mcu7t5v0__xor3_1_178/Z vdd vss
+ gf180mcu_fd_sc_mcu7t5v0__xor3_1_126/Z gf180mcu_fd_sc_mcu7t5v0__and4_1_2/Z gf180mcu_fd_sc_mcu7t5v0__xor2_1_170/Z
+ vdd vss gf180mcu_fd_sc_mcu7t5v0__xor3_1
Xgf180mcu_fd_sc_mcu7t5v0__xor3_1_137 gf180mcu_fd_sc_mcu7t5v0__xor3_1_137/A3 vdd vss
+ gf180mcu_fd_sc_mcu7t5v0__xor3_1_137/Z gf180mcu_fd_sc_mcu7t5v0__xor3_1_137/A1 gf180mcu_fd_sc_mcu7t5v0__xor3_1_137/A2
+ vdd vss gf180mcu_fd_sc_mcu7t5v0__xor3_1
Xgf180mcu_fd_sc_mcu7t5v0__nor2_1_169 vdd vss gf180mcu_fd_sc_mcu7t5v0__dffq_2_110/D
+ gf180mcu_fd_sc_mcu7t5v0__nor2_1_169/A1 gf180mcu_fd_sc_mcu7t5v0__nor2_1_169/A2 vdd
+ vss gf180mcu_fd_sc_mcu7t5v0__nor2_1
Xgf180mcu_fd_sc_mcu7t5v0__xor3_1_148 gf180mcu_fd_sc_mcu7t5v0__xor2_1_201/Z vdd vss
+ gf180mcu_fd_sc_mcu7t5v0__xor3_1_148/Z gf180mcu_fd_sc_mcu7t5v0__xor3_1_148/A1 gf180mcu_fd_sc_mcu7t5v0__xor3_1_148/A2
+ vdd vss gf180mcu_fd_sc_mcu7t5v0__xor3_1
Xgf180mcu_fd_sc_mcu7t5v0__xor3_1_159 gf180mcu_fd_sc_mcu7t5v0__xor3_1_159/A3 vdd vss
+ gf180mcu_fd_sc_mcu7t5v0__xor3_1_159/Z gf180mcu_fd_sc_mcu7t5v0__xor3_1_159/A1 gf180mcu_fd_sc_mcu7t5v0__nor2_2_39/ZN
+ vdd vss gf180mcu_fd_sc_mcu7t5v0__xor3_1
Xgf180mcu_fd_sc_mcu7t5v0__nand2_1_340 vdd vss gf180mcu_fd_sc_mcu7t5v0__nor2_1_176/A1
+ gf180mcu_fd_sc_mcu7t5v0__buf_8_8/I gf180mcu_fd_sc_mcu7t5v0__or2_1_20/Z vdd vss gf180mcu_fd_sc_mcu7t5v0__nand2_1
Xgf180mcu_fd_sc_mcu7t5v0__oai211_1_19 gf180mcu_fd_sc_mcu7t5v0__oai211_1_19/B gf180mcu_fd_sc_mcu7t5v0__or2_1_34/A2
+ vdd vss gf180mcu_fd_sc_mcu7t5v0__oai211_1_19/ZN gf180mcu_fd_sc_mcu7t5v0__nor2_4_30/ZN
+ gf180mcu_fd_sc_mcu7t5v0__oai221_1_7/ZN vdd vss gf180mcu_fd_sc_mcu7t5v0__oai211_1
Xgf180mcu_fd_sc_mcu7t5v0__nand2_1_351 vdd vss gf180mcu_fd_sc_mcu7t5v0__xor2_1_93/A2
+ gf180mcu_fd_sc_mcu7t5v0__nor4_1_1/A4 gf180mcu_fd_sc_mcu7t5v0__and2_1_58/Z vdd vss
+ gf180mcu_fd_sc_mcu7t5v0__nand2_1
Xgf180mcu_fd_sc_mcu7t5v0__nand2_1_362 vdd vss gf180mcu_fd_sc_mcu7t5v0__oai31_1_11/B
+ gf180mcu_fd_sc_mcu7t5v0__dffq_2_50/Q gf180mcu_fd_sc_mcu7t5v0__oai31_4_2/B vdd vss
+ gf180mcu_fd_sc_mcu7t5v0__nand2_1
Xgf180mcu_fd_sc_mcu7t5v0__nand2_1_373 vdd vss gf180mcu_fd_sc_mcu7t5v0__xnor2_1_87/A2
+ gf180mcu_fd_sc_mcu7t5v0__oai31_1_21/B gf180mcu_fd_sc_mcu7t5v0__nand4_1_10/ZN vdd
+ vss gf180mcu_fd_sc_mcu7t5v0__nand2_1
Xgf180mcu_fd_sc_mcu7t5v0__nand3_4_17 gf180mcu_fd_sc_mcu7t5v0__nor2_2_33/A1 vdd vss
+ gf180mcu_fd_sc_mcu7t5v0__mux2_1_9/I0 gf180mcu_fd_sc_mcu7t5v0__oai32_1_6/A2 gf180mcu_fd_sc_mcu7t5v0__dffq_4_40/Q
+ vdd vss gf180mcu_fd_sc_mcu7t5v0__nand3_4
Xgf180mcu_fd_sc_mcu7t5v0__nand2_1_384 vdd vss gf180mcu_fd_sc_mcu7t5v0__xnor3_1_22/A1
+ gf180mcu_fd_sc_mcu7t5v0__inv_8_0/I gf180mcu_fd_sc_mcu7t5v0__inv_1_14/I vdd vss gf180mcu_fd_sc_mcu7t5v0__nand2_1
Xgf180mcu_fd_sc_mcu7t5v0__nand2_1_395 vdd vss gf180mcu_fd_sc_mcu7t5v0__nor2_1_225/A2
+ gf180mcu_fd_sc_mcu7t5v0__dffq_1_392/Q gf180mcu_fd_sc_mcu7t5v0__nor4_4_2/A3 vdd vss
+ gf180mcu_fd_sc_mcu7t5v0__nand2_1
Xgf180mcu_fd_sc_mcu7t5v0__oai21_1_207 vdd gf180mcu_fd_sc_mcu7t5v0__oai21_1_207/B gf180mcu_fd_sc_mcu7t5v0__oai21_1_207/A2
+ gf180mcu_fd_sc_mcu7t5v0__oai21_1_206/B gf180mcu_fd_sc_mcu7t5v0__and3_2_3/A2 vss
+ vdd vss gf180mcu_fd_sc_mcu7t5v0__oai21_1
Xgf180mcu_fd_sc_mcu7t5v0__oai21_1_218 vdd gf180mcu_fd_sc_mcu7t5v0__or2_1_34/A2 gf180mcu_fd_sc_mcu7t5v0__oai21_1_219/ZN
+ gf180mcu_fd_sc_mcu7t5v0__nor2_1_321/A2 gf180mcu_fd_sc_mcu7t5v0__nor2_4_34/ZN vss
+ vdd vss gf180mcu_fd_sc_mcu7t5v0__oai21_1
Xgf180mcu_fd_sc_mcu7t5v0__oai21_1_229 vdd gf180mcu_fd_sc_mcu7t5v0__oai21_1_229/B gf180mcu_fd_sc_mcu7t5v0__nor2_1_290/ZN
+ gf180mcu_fd_sc_mcu7t5v0__xor3_1_98/A1 gf180mcu_fd_sc_mcu7t5v0__xnor3_1_30/A2 vss
+ vdd vss gf180mcu_fd_sc_mcu7t5v0__oai21_1
Xgf180mcu_fd_sc_mcu7t5v0__nand3_4_7 gf180mcu_fd_sc_mcu7t5v0__inv_4_0/ZN vdd vss gf180mcu_fd_sc_mcu7t5v0__nand3_4_7/ZN
+ gf180mcu_fd_sc_mcu7t5v0__nor3_4_3/A1 gf180mcu_fd_sc_mcu7t5v0__inv_2_4/I vdd vss
+ gf180mcu_fd_sc_mcu7t5v0__nand3_4
Xgf180mcu_fd_sc_mcu7t5v0__clkinv_1_320 vdd vss gf180mcu_fd_sc_mcu7t5v0__nor3_1_24/A1
+ gf180mcu_fd_sc_mcu7t5v0__nor3_1_23/A1 vdd vss gf180mcu_fd_sc_mcu7t5v0__clkinv_1
Xgf180mcu_fd_sc_mcu7t5v0__clkinv_1_331 vdd vss gf180mcu_fd_sc_mcu7t5v0__xor2_1_124/A2
+ gf180mcu_fd_sc_mcu7t5v0__aoi21_1_229/B vdd vss gf180mcu_fd_sc_mcu7t5v0__clkinv_1
Xgf180mcu_fd_sc_mcu7t5v0__clkinv_1_342 vdd vss gf180mcu_fd_sc_mcu7t5v0__dffq_2_65/Q
+ gf180mcu_fd_sc_mcu7t5v0__oai31_4_3/A1 vdd vss gf180mcu_fd_sc_mcu7t5v0__clkinv_1
Xgf180mcu_fd_sc_mcu7t5v0__clkinv_1_353 vdd vss gf180mcu_fd_sc_mcu7t5v0__xor2_1_170/Z
+ gf180mcu_fd_sc_mcu7t5v0__oai21_1_299/A1 vdd vss gf180mcu_fd_sc_mcu7t5v0__clkinv_1
Xgf180mcu_fd_sc_mcu7t5v0__clkinv_1_364 vdd vss gf180mcu_fd_sc_mcu7t5v0__dffq_1_457/Q
+ gf180mcu_fd_sc_mcu7t5v0__oai22_1_180/B2 vdd vss gf180mcu_fd_sc_mcu7t5v0__clkinv_1
Xgf180mcu_fd_sc_mcu7t5v0__clkinv_3_14 vdd gf180mcu_fd_sc_mcu7t5v0__oai21_4_5/A1 gf180mcu_fd_sc_mcu7t5v0__mux4_4_18/I1
+ vss vdd vss gf180mcu_fd_sc_mcu7t5v0__clkinv_3
Xgf180mcu_fd_sc_mcu7t5v0__dffq_4_0 gf180mcu_fd_sc_mcu7t5v0__dffq_4_0/D gf180mcu_fd_sc_mcu7t5v0__dffq_4_0/Q
+ vdd vss gf180mcu_fd_sc_mcu7t5v0__dffq_4_6/CLK vdd vss gf180mcu_fd_sc_mcu7t5v0__dffq_4
Xgf180mcu_fd_sc_mcu7t5v0__nand2_1_170 vdd vss gf180mcu_fd_sc_mcu7t5v0__oai211_1_12/B
+ gf180mcu_fd_sc_mcu7t5v0__inv_8_0/I gf180mcu_fd_sc_mcu7t5v0__nor3_4_4/ZN vdd vss
+ gf180mcu_fd_sc_mcu7t5v0__nand2_1
Xgf180mcu_fd_sc_mcu7t5v0__nand2_1_181 vdd vss gf180mcu_fd_sc_mcu7t5v0__xor2_1_59/A2
+ gf180mcu_fd_sc_mcu7t5v0__inv_12_1/I gf180mcu_fd_sc_mcu7t5v0__or2_1_16/A2 vdd vss
+ gf180mcu_fd_sc_mcu7t5v0__nand2_1
Xgf180mcu_fd_sc_mcu7t5v0__nand2_1_192 vdd vss gf180mcu_fd_sc_mcu7t5v0__inv_1_4/I gf180mcu_fd_sc_mcu7t5v0__inv_4_6/I
+ gf180mcu_fd_sc_mcu7t5v0__oai22_1_8/A2 vdd vss gf180mcu_fd_sc_mcu7t5v0__nand2_1
Xgf180mcu_fd_sc_mcu7t5v0__aoi221_1_8 gf180mcu_fd_sc_mcu7t5v0__nor2_2_2/ZN gf180mcu_fd_sc_mcu7t5v0__nor2_4_0/ZN
+ vdd vss gf180mcu_fd_sc_mcu7t5v0__oai21_1_53/B gf180mcu_fd_sc_mcu7t5v0__dffq_4_37/Q
+ gf180mcu_fd_sc_mcu7t5v0__nor2_4_1/ZN gf180mcu_fd_sc_mcu7t5v0__oai21_1_53/A2 vdd
+ vss gf180mcu_fd_sc_mcu7t5v0__aoi221_1
Xgf180mcu_fd_sc_mcu7t5v0__nand3_2_4 gf180mcu_fd_sc_mcu7t5v0__and2_2_3/A2 vdd vss gf180mcu_fd_sc_mcu7t5v0__or2_1_2/A2
+ gf180mcu_fd_sc_mcu7t5v0__inv_8_1/I gf180mcu_fd_sc_mcu7t5v0__and2_2_3/A1 vdd vss
+ gf180mcu_fd_sc_mcu7t5v0__nand3_2
Xgf180mcu_fd_sc_mcu7t5v0__xor2_1_18 vdd vss gf180mcu_fd_sc_mcu7t5v0__xor2_1_18/Z gf180mcu_fd_sc_mcu7t5v0__inv_8_0/I
+ gf180mcu_fd_sc_mcu7t5v0__xor2_1_67/Z vdd vss gf180mcu_fd_sc_mcu7t5v0__xor2_1
Xgf180mcu_fd_sc_mcu7t5v0__xor2_1_29 vdd vss gf180mcu_fd_sc_mcu7t5v0__xor2_1_29/Z gf180mcu_fd_sc_mcu7t5v0__xor2_1_29/A1
+ gf180mcu_fd_sc_mcu7t5v0__xor3_1_20/Z vdd vss gf180mcu_fd_sc_mcu7t5v0__xor2_1
Xgf180mcu_fd_sc_mcu7t5v0__xor2_1_103 vdd vss gf180mcu_fd_sc_mcu7t5v0__xor2_1_97/A2
+ gf180mcu_fd_sc_mcu7t5v0__nor3_2_5/ZN gf180mcu_fd_sc_mcu7t5v0__xor3_1_72/Z vdd vss
+ gf180mcu_fd_sc_mcu7t5v0__xor2_1
Xgf180mcu_fd_sc_mcu7t5v0__xor2_1_114 vdd vss gf180mcu_fd_sc_mcu7t5v0__xor2_1_114/Z
+ gf180mcu_fd_sc_mcu7t5v0__xor2_1_114/A1 gf180mcu_fd_sc_mcu7t5v0__xor2_1_114/A2 vdd
+ vss gf180mcu_fd_sc_mcu7t5v0__xor2_1
Xgf180mcu_fd_sc_mcu7t5v0__xor2_1_125 vdd vss gf180mcu_fd_sc_mcu7t5v0__xor2_1_125/Z
+ gf180mcu_fd_sc_mcu7t5v0__inv_1_15/I gf180mcu_fd_sc_mcu7t5v0__and2_2_12/Z vdd vss
+ gf180mcu_fd_sc_mcu7t5v0__xor2_1
Xgf180mcu_fd_sc_mcu7t5v0__xor2_1_136 vdd vss gf180mcu_fd_sc_mcu7t5v0__xor2_1_136/Z
+ gf180mcu_fd_sc_mcu7t5v0__inv_8_2/I gf180mcu_fd_sc_mcu7t5v0__xor2_1_137/Z vdd vss
+ gf180mcu_fd_sc_mcu7t5v0__xor2_1
Xgf180mcu_fd_sc_mcu7t5v0__xor2_1_147 vdd vss gf180mcu_fd_sc_mcu7t5v0__xor2_1_147/Z
+ gf180mcu_fd_sc_mcu7t5v0__xor2_1_147/A1 gf180mcu_fd_sc_mcu7t5v0__xor2_1_108/Z vdd
+ vss gf180mcu_fd_sc_mcu7t5v0__xor2_1
Xgf180mcu_fd_sc_mcu7t5v0__xor2_1_158 vdd vss gf180mcu_fd_sc_mcu7t5v0__or2_1_42/A2
+ gf180mcu_fd_sc_mcu7t5v0__xor2_1_158/A1 gf180mcu_fd_sc_mcu7t5v0__xor2_1_158/A2 vdd
+ vss gf180mcu_fd_sc_mcu7t5v0__xor2_1
Xgf180mcu_fd_sc_mcu7t5v0__xor2_1_169 vdd vss gf180mcu_fd_sc_mcu7t5v0__xor2_1_169/Z
+ gf180mcu_fd_sc_mcu7t5v0__xor2_1_169/A1 gf180mcu_fd_sc_mcu7t5v0__xor3_1_125/Z vdd
+ vss gf180mcu_fd_sc_mcu7t5v0__xor2_1
Xgf180mcu_fd_sc_mcu7t5v0__nor3_1_20 gf180mcu_fd_sc_mcu7t5v0__and2_1_77/Z vdd vss gf180mcu_fd_sc_mcu7t5v0__nor3_1_20/ZN
+ gf180mcu_fd_sc_mcu7t5v0__oai31_4_2/ZN gf180mcu_fd_sc_mcu7t5v0__nor3_1_20/A2 vdd
+ vss gf180mcu_fd_sc_mcu7t5v0__nor3_1
Xgf180mcu_fd_sc_mcu7t5v0__nor3_1_31 gf180mcu_fd_sc_mcu7t5v0__inv_1_21/I vdd vss gf180mcu_fd_sc_mcu7t5v0__nor3_1_31/ZN
+ gf180mcu_fd_sc_mcu7t5v0__mux4_4_9/S0 gf180mcu_fd_sc_mcu7t5v0__inv_1_16/I vdd vss
+ gf180mcu_fd_sc_mcu7t5v0__nor3_1
Xgf180mcu_fd_sc_mcu7t5v0__nor3_1_42 gf180mcu_fd_sc_mcu7t5v0__xor2_1_129/Z vdd vss
+ gf180mcu_fd_sc_mcu7t5v0__nor3_1_42/ZN gf180mcu_fd_sc_mcu7t5v0__nor3_1_42/A1 gf180mcu_fd_sc_mcu7t5v0__or3_1_18/A2
+ vdd vss gf180mcu_fd_sc_mcu7t5v0__nor3_1
Xgf180mcu_fd_sc_mcu7t5v0__clkinv_1_150 vdd vss gf180mcu_fd_sc_mcu7t5v0__dffq_1_127/Q
+ gf180mcu_fd_sc_mcu7t5v0__oai22_1_139/B2 vdd vss gf180mcu_fd_sc_mcu7t5v0__clkinv_1
Xgf180mcu_fd_sc_mcu7t5v0__clkinv_1_161 vdd vss gf180mcu_fd_sc_mcu7t5v0__dffq_1_143/Q
+ gf180mcu_fd_sc_mcu7t5v0__oai22_1_147/B2 vdd vss gf180mcu_fd_sc_mcu7t5v0__clkinv_1
Xgf180mcu_fd_sc_mcu7t5v0__clkinv_1_172 vdd vss gf180mcu_fd_sc_mcu7t5v0__dffq_1_159/Q
+ gf180mcu_fd_sc_mcu7t5v0__oai22_1_159/B2 vdd vss gf180mcu_fd_sc_mcu7t5v0__clkinv_1
Xgf180mcu_fd_sc_mcu7t5v0__clkinv_1_183 vdd vss gf180mcu_fd_sc_mcu7t5v0__dffq_1_161/Q
+ gf180mcu_fd_sc_mcu7t5v0__oai22_1_167/B2 vdd vss gf180mcu_fd_sc_mcu7t5v0__clkinv_1
Xgf180mcu_fd_sc_mcu7t5v0__clkinv_1_194 vdd vss gf180mcu_fd_sc_mcu7t5v0__dffq_1_273/Q
+ gf180mcu_fd_sc_mcu7t5v0__oai22_1_184/B2 vdd vss gf180mcu_fd_sc_mcu7t5v0__clkinv_1
Xgf180mcu_fd_sc_mcu7t5v0__nand3_1_18 gf180mcu_fd_sc_mcu7t5v0__xor3_1_47/A2 vdd vss
+ gf180mcu_fd_sc_mcu7t5v0__nand3_1_18/ZN gf180mcu_fd_sc_mcu7t5v0__or2_1_14/Z gf180mcu_fd_sc_mcu7t5v0__or3_1_4/Z
+ vdd vss gf180mcu_fd_sc_mcu7t5v0__nand3_1
Xgf180mcu_fd_sc_mcu7t5v0__nand3_1_29 gf180mcu_fd_sc_mcu7t5v0__inv_4_1/ZN vdd vss gf180mcu_fd_sc_mcu7t5v0__nand2_2_7/A1
+ gf180mcu_fd_sc_mcu7t5v0__dffq_1_14/Q gf180mcu_fd_sc_mcu7t5v0__inv_3_0/I vdd vss
+ gf180mcu_fd_sc_mcu7t5v0__nand3_1
Xgf180mcu_fd_sc_mcu7t5v0__inv_3_0 vss gf180mcu_fd_sc_mcu7t5v0__inv_3_0/ZN gf180mcu_fd_sc_mcu7t5v0__inv_3_0/I
+ vdd vdd vss gf180mcu_fd_sc_mcu7t5v0__inv_3
Xgf180mcu_fd_sc_mcu7t5v0__oai32_1_8 gf180mcu_fd_sc_mcu7t5v0__oai32_1_8/A3 gf180mcu_fd_sc_mcu7t5v0__oai32_1_8/B1
+ gf180mcu_fd_sc_mcu7t5v0__inv_8_2/I vdd vss gf180mcu_fd_sc_mcu7t5v0__oai32_1_8/ZN
+ gf180mcu_fd_sc_mcu7t5v0__oai32_1_8/A1 gf180mcu_fd_sc_mcu7t5v0__oai32_1_8/A2 vdd
+ vss gf180mcu_fd_sc_mcu7t5v0__oai32_1
Xgf180mcu_fd_sc_mcu7t5v0__aoi221_1_13 gf180mcu_fd_sc_mcu7t5v0__nor2_2_9/ZN gf180mcu_fd_sc_mcu7t5v0__nor2_4_3/ZN
+ vdd vss gf180mcu_fd_sc_mcu7t5v0__oai221_1_4/C gf180mcu_fd_sc_mcu7t5v0__or4_1_0/A1
+ gf180mcu_fd_sc_mcu7t5v0__nor3_4_4/ZN gf180mcu_fd_sc_mcu7t5v0__clkinv_1_18/ZN vdd
+ vss gf180mcu_fd_sc_mcu7t5v0__aoi221_1
Xgf180mcu_fd_sc_mcu7t5v0__aoi221_1_24 gf180mcu_fd_sc_mcu7t5v0__oai21_1_125/ZN gf180mcu_fd_sc_mcu7t5v0__nor2_4_30/ZN
+ vdd vss gf180mcu_fd_sc_mcu7t5v0__aoi211_1_47/C gf180mcu_fd_sc_mcu7t5v0__nor3_2_5/A1
+ gf180mcu_fd_sc_mcu7t5v0__inv_1_13/I gf180mcu_fd_sc_mcu7t5v0__oai31_1_9/ZN vdd vss
+ gf180mcu_fd_sc_mcu7t5v0__aoi221_1
Xgf180mcu_fd_sc_mcu7t5v0__aoi221_1_35 gf180mcu_fd_sc_mcu7t5v0__dffq_2_56/Q gf180mcu_fd_sc_mcu7t5v0__nor2_1_226/ZN
+ vdd vss gf180mcu_fd_sc_mcu7t5v0__nor2_1_212/A2 gf180mcu_fd_sc_mcu7t5v0__dffq_1_400/Q
+ gf180mcu_fd_sc_mcu7t5v0__or2_4_3/Z gf180mcu_fd_sc_mcu7t5v0__nor2_4_32/ZN vdd vss
+ gf180mcu_fd_sc_mcu7t5v0__aoi221_1
Xgf180mcu_fd_sc_mcu7t5v0__aoi221_1_46 gf180mcu_fd_sc_mcu7t5v0__oai21_1_242/A2 gf180mcu_fd_sc_mcu7t5v0__nor2_2_44/ZN
+ vdd vss gf180mcu_fd_sc_mcu7t5v0__oai21_1_242/B gf180mcu_fd_sc_mcu7t5v0__inv_8_2/I
+ gf180mcu_fd_sc_mcu7t5v0__nor2_4_37/ZN gf180mcu_fd_sc_mcu7t5v0__nor3_4_17/ZN vdd
+ vss gf180mcu_fd_sc_mcu7t5v0__aoi221_1
Xgf180mcu_fd_sc_mcu7t5v0__aoi221_1_57 gf180mcu_fd_sc_mcu7t5v0__nor2_2_57/ZN gf180mcu_fd_sc_mcu7t5v0__nor2_2_54/ZN
+ vdd vss gf180mcu_fd_sc_mcu7t5v0__oai211_1_54/A2 gf180mcu_fd_sc_mcu7t5v0__inv_8_2/I
+ gf180mcu_fd_sc_mcu7t5v0__nand2_1_671/ZN gf180mcu_fd_sc_mcu7t5v0__nand2_1_649/ZN
+ vdd vss gf180mcu_fd_sc_mcu7t5v0__aoi221_1
Xgf180mcu_fd_sc_mcu7t5v0__nor3_4_8 gf180mcu_fd_sc_mcu7t5v0__inv_3_2/ZN vdd vss gf180mcu_fd_sc_mcu7t5v0__nor3_4_8/ZN
+ gf180mcu_fd_sc_mcu7t5v0__nor3_4_9/A1 gf180mcu_fd_sc_mcu7t5v0__inv_3_1/I vdd vss
+ gf180mcu_fd_sc_mcu7t5v0__nor3_4
Xgf180mcu_fd_sc_mcu7t5v0__oai21_4_10 gf180mcu_fd_sc_mcu7t5v0__oai21_4_10/B vdd vss
+ gf180mcu_fd_sc_mcu7t5v0__dffq_1_318/Q gf180mcu_fd_sc_mcu7t5v0__oai22_1_98/A1 gf180mcu_fd_sc_mcu7t5v0__or3_4_0/Z
+ vdd vss gf180mcu_fd_sc_mcu7t5v0__oai21_4
Xgf180mcu_fd_sc_mcu7t5v0__xnor3_1_6 gf180mcu_fd_sc_mcu7t5v0__xor3_1_8/A3 vdd vss gf180mcu_fd_sc_mcu7t5v0__xnor3_1_6/ZN
+ gf180mcu_fd_sc_mcu7t5v0__xor3_1_8/A1 gf180mcu_fd_sc_mcu7t5v0__xor3_1_4/Z vdd vss
+ gf180mcu_fd_sc_mcu7t5v0__xnor3_1
Xgf180mcu_fd_sc_mcu7t5v0__oai31_1_12 vdd gf180mcu_fd_sc_mcu7t5v0__oai31_1_12/ZN gf180mcu_fd_sc_mcu7t5v0__oai31_1_12/B
+ gf180mcu_fd_sc_mcu7t5v0__and2_1_80/Z gf180mcu_fd_sc_mcu7t5v0__oai31_1_12/A2 vss
+ gf180mcu_fd_sc_mcu7t5v0__oai31_1_12/A3 vdd vss gf180mcu_fd_sc_mcu7t5v0__oai31_1
Xgf180mcu_fd_sc_mcu7t5v0__nand2_1_40 vdd vss gf180mcu_fd_sc_mcu7t5v0__oai211_1_2/C
+ gf180mcu_fd_sc_mcu7t5v0__nor2_2_14/ZN gf180mcu_fd_sc_mcu7t5v0__xor2_1_7/Z vdd vss
+ gf180mcu_fd_sc_mcu7t5v0__nand2_1
Xgf180mcu_fd_sc_mcu7t5v0__nand2_1_51 vdd vss gf180mcu_fd_sc_mcu7t5v0__oai21_1_18/A2
+ gf180mcu_fd_sc_mcu7t5v0__dffq_4_37/Q gf180mcu_fd_sc_mcu7t5v0__nand3_1_1/A3 vdd vss
+ gf180mcu_fd_sc_mcu7t5v0__nand2_1
Xgf180mcu_fd_sc_mcu7t5v0__nand2_1_62 vdd vss gf180mcu_fd_sc_mcu7t5v0__xor3_1_15/A2
+ gf180mcu_fd_sc_mcu7t5v0__dffq_4_37/Q gf180mcu_fd_sc_mcu7t5v0__and2_2_1/Z vdd vss
+ gf180mcu_fd_sc_mcu7t5v0__nand2_1
Xgf180mcu_fd_sc_mcu7t5v0__nand2_1_73 vdd vss gf180mcu_fd_sc_mcu7t5v0__xor2_1_27/A2
+ gf180mcu_fd_sc_mcu7t5v0__inv_12_1/I gf180mcu_fd_sc_mcu7t5v0__or2_1_7/A2 vdd vss
+ gf180mcu_fd_sc_mcu7t5v0__nand2_1
Xgf180mcu_fd_sc_mcu7t5v0__nand2_1_84 vdd vss gf180mcu_fd_sc_mcu7t5v0__mux2_1_2/S gf180mcu_fd_sc_mcu7t5v0__or2_1_7/A1
+ gf180mcu_fd_sc_mcu7t5v0__xor3_1_20/A2 vdd vss gf180mcu_fd_sc_mcu7t5v0__nand2_1
Xgf180mcu_fd_sc_mcu7t5v0__nand2_1_95 vdd vss gf180mcu_fd_sc_mcu7t5v0__nand2_1_95/ZN
+ gf180mcu_fd_sc_mcu7t5v0__or2_1_11/Z gf180mcu_fd_sc_mcu7t5v0__xor3_1_31/Z vdd vss
+ gf180mcu_fd_sc_mcu7t5v0__nand2_1
Xgf180mcu_fd_sc_mcu7t5v0__and2_1_9 vdd vss gf180mcu_fd_sc_mcu7t5v0__or3_1_2/A1 gf180mcu_fd_sc_mcu7t5v0__dffq_4_37/Q
+ gf180mcu_fd_sc_mcu7t5v0__and2_1_9/A2 vdd vss gf180mcu_fd_sc_mcu7t5v0__and2_1
Xgf180mcu_fd_sc_mcu7t5v0__aoi222_2_3 gf180mcu_fd_sc_mcu7t5v0__nor2_4_12/ZN gf180mcu_fd_sc_mcu7t5v0__aoi222_2_3/B1
+ gf180mcu_fd_sc_mcu7t5v0__aoi222_2_3/A2 gf180mcu_fd_sc_mcu7t5v0__nor2_4_5/ZN gf180mcu_fd_sc_mcu7t5v0__nand3_1_45/A2
+ vss vdd gf180mcu_fd_sc_mcu7t5v0__nor3_4_6/ZN gf180mcu_fd_sc_mcu7t5v0__aoi222_2_3/C1
+ vdd vss gf180mcu_fd_sc_mcu7t5v0__aoi222_2
Xgf180mcu_fd_sc_mcu7t5v0__nor3_2_5 gf180mcu_fd_sc_mcu7t5v0__or3_1_13/A3 vdd vss gf180mcu_fd_sc_mcu7t5v0__nor3_2_5/ZN
+ gf180mcu_fd_sc_mcu7t5v0__nor3_2_5/A1 gf180mcu_fd_sc_mcu7t5v0__inv_1_13/I vdd vss
+ gf180mcu_fd_sc_mcu7t5v0__nor3_2
Xgf180mcu_fd_sc_mcu7t5v0__aoi21_4_6 gf180mcu_fd_sc_mcu7t5v0__or2_1_36/A2 gf180mcu_fd_sc_mcu7t5v0__inv_4_4/I
+ vdd vss gf180mcu_fd_sc_mcu7t5v0__aoi21_4_6/ZN gf180mcu_fd_sc_mcu7t5v0__inv_3_3/ZN
+ vdd vss gf180mcu_fd_sc_mcu7t5v0__aoi21_4
Xgf180mcu_fd_sc_mcu7t5v0__nand2_1_703 vdd vss gf180mcu_fd_sc_mcu7t5v0__xor3_1_146/A2
+ gf180mcu_fd_sc_mcu7t5v0__inv_8_0/I gf180mcu_fd_sc_mcu7t5v0__and3_1_23/A2 vdd vss
+ gf180mcu_fd_sc_mcu7t5v0__nand2_1
Xgf180mcu_fd_sc_mcu7t5v0__nand2_1_714 vdd vss gf180mcu_fd_sc_mcu7t5v0__xor3_1_168/A2
+ gf180mcu_fd_sc_mcu7t5v0__or2_1_7/A1 gf180mcu_fd_sc_mcu7t5v0__mux4_4_2/Z vdd vss
+ gf180mcu_fd_sc_mcu7t5v0__nand2_1
Xgf180mcu_fd_sc_mcu7t5v0__nand2_1_725 vdd vss gf180mcu_fd_sc_mcu7t5v0__xor3_1_173/A1
+ gf180mcu_fd_sc_mcu7t5v0__inv_8_0/I gf180mcu_fd_sc_mcu7t5v0__inv_1_5/I vdd vss gf180mcu_fd_sc_mcu7t5v0__nand2_1
Xgf180mcu_fd_sc_mcu7t5v0__and2_1_11 vdd vss gf180mcu_fd_sc_mcu7t5v0__and2_1_11/Z gf180mcu_fd_sc_mcu7t5v0__xnor3_1_8/A1
+ gf180mcu_fd_sc_mcu7t5v0__xnor3_1_8/A2 vdd vss gf180mcu_fd_sc_mcu7t5v0__and2_1
Xgf180mcu_fd_sc_mcu7t5v0__and2_1_22 vdd vss gf180mcu_fd_sc_mcu7t5v0__and2_1_22/Z gf180mcu_fd_sc_mcu7t5v0__and2_1_22/A1
+ gf180mcu_fd_sc_mcu7t5v0__oai22_1_6/A2 vdd vss gf180mcu_fd_sc_mcu7t5v0__and2_1
Xgf180mcu_fd_sc_mcu7t5v0__and2_1_33 vdd vss gf180mcu_fd_sc_mcu7t5v0__or3_1_5/A2 gf180mcu_fd_sc_mcu7t5v0__xor2_2_0/A1
+ gf180mcu_fd_sc_mcu7t5v0__xor3_1_59/Z vdd vss gf180mcu_fd_sc_mcu7t5v0__and2_1
Xgf180mcu_fd_sc_mcu7t5v0__and2_1_44 vdd vss gf180mcu_fd_sc_mcu7t5v0__and2_1_44/Z gf180mcu_fd_sc_mcu7t5v0__dffq_1_278/Q
+ gf180mcu_fd_sc_mcu7t5v0__nor2_4_14/A2 vdd vss gf180mcu_fd_sc_mcu7t5v0__and2_1
Xgf180mcu_fd_sc_mcu7t5v0__and2_1_55 vdd vss gf180mcu_fd_sc_mcu7t5v0__and2_1_55/Z gf180mcu_fd_sc_mcu7t5v0__nor4_1_0/A3
+ gf180mcu_fd_sc_mcu7t5v0__and2_1_56/Z vdd vss gf180mcu_fd_sc_mcu7t5v0__and2_1
Xgf180mcu_fd_sc_mcu7t5v0__and2_1_66 vdd vss gf180mcu_fd_sc_mcu7t5v0__and2_1_66/Z gf180mcu_fd_sc_mcu7t5v0__or4_1_2/A2
+ gf180mcu_fd_sc_mcu7t5v0__and2_1_64/Z vdd vss gf180mcu_fd_sc_mcu7t5v0__and2_1
Xgf180mcu_fd_sc_mcu7t5v0__and2_1_77 vdd vss gf180mcu_fd_sc_mcu7t5v0__and2_1_77/Z gf180mcu_fd_sc_mcu7t5v0__nor3_1_13/A1
+ gf180mcu_fd_sc_mcu7t5v0__and3_1_12/Z vdd vss gf180mcu_fd_sc_mcu7t5v0__and2_1
Xgf180mcu_fd_sc_mcu7t5v0__and2_1_88 vdd vss gf180mcu_fd_sc_mcu7t5v0__or3_1_27/A2 gf180mcu_fd_sc_mcu7t5v0__and2_1_88/A1
+ gf180mcu_fd_sc_mcu7t5v0__or2_1_28/A1 vdd vss gf180mcu_fd_sc_mcu7t5v0__and2_1
Xgf180mcu_fd_sc_mcu7t5v0__and2_1_99 vdd vss gf180mcu_fd_sc_mcu7t5v0__or3_1_17/A1 gf180mcu_fd_sc_mcu7t5v0__inv_8_1/I
+ gf180mcu_fd_sc_mcu7t5v0__xor2_1_127/Z vdd vss gf180mcu_fd_sc_mcu7t5v0__and2_1
Xgf180mcu_fd_sc_mcu7t5v0__aoi211_1_12 gf180mcu_fd_sc_mcu7t5v0__nor2_1_52/ZN gf180mcu_fd_sc_mcu7t5v0__or2_1_23/A1
+ vdd vss gf180mcu_fd_sc_mcu7t5v0__dffq_1_5/D gf180mcu_fd_sc_mcu7t5v0__nor2_1_144/A1
+ gf180mcu_fd_sc_mcu7t5v0__nor2_4_16/ZN vdd vss gf180mcu_fd_sc_mcu7t5v0__aoi211_1
Xgf180mcu_fd_sc_mcu7t5v0__aoi211_1_23 gf180mcu_fd_sc_mcu7t5v0__nor2_1_106/ZN gf180mcu_fd_sc_mcu7t5v0__or2_1_23/A1
+ vdd vss gf180mcu_fd_sc_mcu7t5v0__dffq_1_229/D gf180mcu_fd_sc_mcu7t5v0__inv_4_3/ZN
+ gf180mcu_fd_sc_mcu7t5v0__nor2_4_22/ZN vdd vss gf180mcu_fd_sc_mcu7t5v0__aoi211_1
Xgf180mcu_fd_sc_mcu7t5v0__aoi211_1_34 gf180mcu_fd_sc_mcu7t5v0__nor2_1_162/ZN gf180mcu_fd_sc_mcu7t5v0__or2_1_23/A1
+ vdd vss gf180mcu_fd_sc_mcu7t5v0__dffq_1_445/D gf180mcu_fd_sc_mcu7t5v0__nor2_1_144/A1
+ gf180mcu_fd_sc_mcu7t5v0__nor2_4_20/ZN vdd vss gf180mcu_fd_sc_mcu7t5v0__aoi211_1
Xgf180mcu_fd_sc_mcu7t5v0__aoi211_1_45 gf180mcu_fd_sc_mcu7t5v0__nor2_1_165/ZN gf180mcu_fd_sc_mcu7t5v0__or2_1_23/A1
+ vdd vss gf180mcu_fd_sc_mcu7t5v0__dffq_1_310/D gf180mcu_fd_sc_mcu7t5v0__nor2_1_411/A1
+ gf180mcu_fd_sc_mcu7t5v0__nor2_4_28/ZN vdd vss gf180mcu_fd_sc_mcu7t5v0__aoi211_1
Xgf180mcu_fd_sc_mcu7t5v0__aoi211_1_56 gf180mcu_fd_sc_mcu7t5v0__oai221_1_9/ZN gf180mcu_fd_sc_mcu7t5v0__nor2_2_31/ZN
+ vdd vss gf180mcu_fd_sc_mcu7t5v0__aoi221_1_45/B2 gf180mcu_fd_sc_mcu7t5v0__nor2_4_33/ZN
+ gf180mcu_fd_sc_mcu7t5v0__xor3_1_87/A3 vdd vss gf180mcu_fd_sc_mcu7t5v0__aoi211_1
Xgf180mcu_fd_sc_mcu7t5v0__aoi211_1_67 gf180mcu_fd_sc_mcu7t5v0__aoi211_1_67/B gf180mcu_fd_sc_mcu7t5v0__nor2_4_38/ZN
+ vdd vss gf180mcu_fd_sc_mcu7t5v0__oai21_1_246/B gf180mcu_fd_sc_mcu7t5v0__nor3_4_18/ZN
+ gf180mcu_fd_sc_mcu7t5v0__xor2_1_148/A2 vdd vss gf180mcu_fd_sc_mcu7t5v0__aoi211_1
Xgf180mcu_fd_sc_mcu7t5v0__aoi211_1_78 gf180mcu_fd_sc_mcu7t5v0__nor2_1_333/ZN gf180mcu_fd_sc_mcu7t5v0__or2_1_23/A1
+ vdd vss gf180mcu_fd_sc_mcu7t5v0__dffq_1_440/D gf180mcu_fd_sc_mcu7t5v0__nor2_1_236/A1
+ gf180mcu_fd_sc_mcu7t5v0__nor2_4_27/ZN vdd vss gf180mcu_fd_sc_mcu7t5v0__aoi211_1
Xgf180mcu_fd_sc_mcu7t5v0__aoi21_1_200 gf180mcu_fd_sc_mcu7t5v0__aoi21_1_200/B vdd vss
+ gf180mcu_fd_sc_mcu7t5v0__dffq_1_397/D gf180mcu_fd_sc_mcu7t5v0__nor2_1_203/A1 gf180mcu_fd_sc_mcu7t5v0__nor2_4_31/ZN
+ vdd vss gf180mcu_fd_sc_mcu7t5v0__aoi21_1
Xgf180mcu_fd_sc_mcu7t5v0__clkinv_1_80 vdd vss gf180mcu_fd_sc_mcu7t5v0__dffq_1_271/Q
+ gf180mcu_fd_sc_mcu7t5v0__oai22_1_67/B2 vdd vss gf180mcu_fd_sc_mcu7t5v0__clkinv_1
Xgf180mcu_fd_sc_mcu7t5v0__aoi21_1_211 gf180mcu_fd_sc_mcu7t5v0__xor3_1_75/Z vdd vss
+ gf180mcu_fd_sc_mcu7t5v0__and2_1_85/A1 gf180mcu_fd_sc_mcu7t5v0__or3_1_13/Z gf180mcu_fd_sc_mcu7t5v0__nand4_2_2/ZN
+ vdd vss gf180mcu_fd_sc_mcu7t5v0__aoi21_1
Xgf180mcu_fd_sc_mcu7t5v0__clkinv_1_91 vdd vss gf180mcu_fd_sc_mcu7t5v0__dffq_1_87/Q
+ gf180mcu_fd_sc_mcu7t5v0__oai22_1_89/B2 vdd vss gf180mcu_fd_sc_mcu7t5v0__clkinv_1
Xgf180mcu_fd_sc_mcu7t5v0__aoi21_1_222 gf180mcu_fd_sc_mcu7t5v0__nor2_1_251/ZN vdd vss
+ gf180mcu_fd_sc_mcu7t5v0__xor3_1_81/A1 gf180mcu_fd_sc_mcu7t5v0__xor3_1_78/A1 gf180mcu_fd_sc_mcu7t5v0__nand2_1_434/ZN
+ vdd vss gf180mcu_fd_sc_mcu7t5v0__aoi21_1
Xgf180mcu_fd_sc_mcu7t5v0__aoi21_1_233 gf180mcu_fd_sc_mcu7t5v0__nor2_2_26/ZN vdd vss
+ gf180mcu_fd_sc_mcu7t5v0__oai211_1_56/A2 gf180mcu_fd_sc_mcu7t5v0__mux2_1_8/I1 gf180mcu_fd_sc_mcu7t5v0__and2_1_88/A1
+ vdd vss gf180mcu_fd_sc_mcu7t5v0__aoi21_1
Xgf180mcu_fd_sc_mcu7t5v0__aoi21_1_244 gf180mcu_fd_sc_mcu7t5v0__aoi21_1_7/B vdd vss
+ gf180mcu_fd_sc_mcu7t5v0__dffq_1_443/D gf180mcu_fd_sc_mcu7t5v0__nand2_1_482/ZN gf180mcu_fd_sc_mcu7t5v0__oai211_1_31/ZN
+ vdd vss gf180mcu_fd_sc_mcu7t5v0__aoi21_1
Xgf180mcu_fd_sc_mcu7t5v0__aoi21_1_255 gf180mcu_fd_sc_mcu7t5v0__xor3_1_99/A2 vdd vss
+ gf180mcu_fd_sc_mcu7t5v0__aoi21_1_254/B gf180mcu_fd_sc_mcu7t5v0__or2_1_38/Z gf180mcu_fd_sc_mcu7t5v0__or3_1_19/Z
+ vdd vss gf180mcu_fd_sc_mcu7t5v0__aoi21_1
Xgf180mcu_fd_sc_mcu7t5v0__aoi21_1_266 gf180mcu_fd_sc_mcu7t5v0__aoi21_1_7/B vdd vss
+ gf180mcu_fd_sc_mcu7t5v0__dffq_2_66/D gf180mcu_fd_sc_mcu7t5v0__nand2_1_518/ZN gf180mcu_fd_sc_mcu7t5v0__oai211_1_40/ZN
+ vdd vss gf180mcu_fd_sc_mcu7t5v0__aoi21_1
Xgf180mcu_fd_sc_mcu7t5v0__aoi21_1_277 gf180mcu_fd_sc_mcu7t5v0__aoi21_1_277/B vdd vss
+ gf180mcu_fd_sc_mcu7t5v0__dffq_4_29/D gf180mcu_fd_sc_mcu7t5v0__inv_8_2/ZN gf180mcu_fd_sc_mcu7t5v0__buf_20_0/Z
+ vdd vss gf180mcu_fd_sc_mcu7t5v0__aoi21_1
Xgf180mcu_fd_sc_mcu7t5v0__aoi21_1_288 gf180mcu_fd_sc_mcu7t5v0__aoi21_1_288/B vdd vss
+ gf180mcu_fd_sc_mcu7t5v0__dffq_4_30/D gf180mcu_fd_sc_mcu7t5v0__inv_4_5/ZN gf180mcu_fd_sc_mcu7t5v0__buf_20_0/I
+ vdd vss gf180mcu_fd_sc_mcu7t5v0__aoi21_1
Xgf180mcu_fd_sc_mcu7t5v0__aoi21_1_299 gf180mcu_fd_sc_mcu7t5v0__xor2_1_157/Z vdd vss
+ gf180mcu_fd_sc_mcu7t5v0__nor3_1_33/A2 gf180mcu_fd_sc_mcu7t5v0__inv_1_24/I gf180mcu_fd_sc_mcu7t5v0__nor2_2_32/ZN
+ vdd vss gf180mcu_fd_sc_mcu7t5v0__aoi21_1
Xgf180mcu_fd_sc_mcu7t5v0__oai33_2_3 gf180mcu_fd_sc_mcu7t5v0__oai33_2_3/A3 gf180mcu_fd_sc_mcu7t5v0__nor3_2_8/A3
+ gf180mcu_fd_sc_mcu7t5v0__nor3_2_8/A1 gf180mcu_fd_sc_mcu7t5v0__nor3_2_8/A2 vdd vss
+ gf180mcu_fd_sc_mcu7t5v0__xor2_2_4/A1 gf180mcu_fd_sc_mcu7t5v0__oai33_2_3/A1 gf180mcu_fd_sc_mcu7t5v0__oai33_2_3/A2
+ vdd vss gf180mcu_fd_sc_mcu7t5v0__oai33_2
Xgf180mcu_fd_sc_mcu7t5v0__oai21_1_11 vdd gf180mcu_fd_sc_mcu7t5v0__oai21_1_11/B gf180mcu_fd_sc_mcu7t5v0__nor2_1_25/ZN
+ gf180mcu_fd_sc_mcu7t5v0__xor2_1_23/A1 gf180mcu_fd_sc_mcu7t5v0__xor3_1_16/A2 vss
+ vdd vss gf180mcu_fd_sc_mcu7t5v0__oai21_1
Xgf180mcu_fd_sc_mcu7t5v0__oai21_1_22 vdd gf180mcu_fd_sc_mcu7t5v0__buf_8_5/Z gf180mcu_fd_sc_mcu7t5v0__buf_20_0/Z
+ gf180mcu_fd_sc_mcu7t5v0__aoi21_1_32/B gf180mcu_fd_sc_mcu7t5v0__dffq_1_1/Q vss vdd
+ vss gf180mcu_fd_sc_mcu7t5v0__oai21_1
Xgf180mcu_fd_sc_mcu7t5v0__oai21_1_33 vdd gf180mcu_fd_sc_mcu7t5v0__buf_12_0/Z gf180mcu_fd_sc_mcu7t5v0__buf_20_0/Z
+ gf180mcu_fd_sc_mcu7t5v0__aoi21_1_42/B gf180mcu_fd_sc_mcu7t5v0__dffq_1_4/Q vss vdd
+ vss gf180mcu_fd_sc_mcu7t5v0__oai21_1
Xgf180mcu_fd_sc_mcu7t5v0__oai21_1_44 vdd gf180mcu_fd_sc_mcu7t5v0__oai21_1_44/B gf180mcu_fd_sc_mcu7t5v0__nor2_1_62/ZN
+ gf180mcu_fd_sc_mcu7t5v0__xor3_1_36/A1 gf180mcu_fd_sc_mcu7t5v0__oai21_1_44/A1 vss
+ vdd vss gf180mcu_fd_sc_mcu7t5v0__oai21_1
Xgf180mcu_fd_sc_mcu7t5v0__oai21_4_9 gf180mcu_fd_sc_mcu7t5v0__oai21_4_9/B vdd vss gf180mcu_fd_sc_mcu7t5v0__dffq_2_33/Q
+ gf180mcu_fd_sc_mcu7t5v0__oai21_4_9/ZN gf180mcu_fd_sc_mcu7t5v0__or3_4_0/Z vdd vss
+ gf180mcu_fd_sc_mcu7t5v0__oai21_4
Xgf180mcu_fd_sc_mcu7t5v0__oai21_1_55 vdd gf180mcu_fd_sc_mcu7t5v0__and2_4_3/Z gf180mcu_fd_sc_mcu7t5v0__or2_1_34/A2
+ gf180mcu_fd_sc_mcu7t5v0__aoi21_1_62/B gf180mcu_fd_sc_mcu7t5v0__inv_2_5/I vss vdd
+ vss gf180mcu_fd_sc_mcu7t5v0__oai21_1
Xgf180mcu_fd_sc_mcu7t5v0__oai21_1_66 vdd gf180mcu_fd_sc_mcu7t5v0__oai31_1_2/B gf180mcu_fd_sc_mcu7t5v0__xnor2_1_21/A2
+ gf180mcu_fd_sc_mcu7t5v0__xor3_1_54/A3 gf180mcu_fd_sc_mcu7t5v0__oai22_1_8/A2 vss
+ vdd vss gf180mcu_fd_sc_mcu7t5v0__oai21_1
Xgf180mcu_fd_sc_mcu7t5v0__oai22_1_209 gf180mcu_fd_sc_mcu7t5v0__and2_4_1/Z gf180mcu_fd_sc_mcu7t5v0__and2_1_35/Z
+ gf180mcu_fd_sc_mcu7t5v0__oai22_1_1/B2 vdd vss gf180mcu_fd_sc_mcu7t5v0__oai221_1_5/C
+ gf180mcu_fd_sc_mcu7t5v0__inv_8_1/I vdd vss gf180mcu_fd_sc_mcu7t5v0__oai22_1
Xgf180mcu_fd_sc_mcu7t5v0__oai21_1_77 vdd gf180mcu_fd_sc_mcu7t5v0__and3_1_24/Z gf180mcu_fd_sc_mcu7t5v0__xor2_1_73/Z
+ gf180mcu_fd_sc_mcu7t5v0__oai221_1_5/A2 gf180mcu_fd_sc_mcu7t5v0__and2_1_36/A1 vss
+ vdd vss gf180mcu_fd_sc_mcu7t5v0__oai21_1
Xgf180mcu_fd_sc_mcu7t5v0__oai21_1_88 vdd gf180mcu_fd_sc_mcu7t5v0__or3_1_29/A3 gf180mcu_fd_sc_mcu7t5v0__or3_1_29/A2
+ gf180mcu_fd_sc_mcu7t5v0__oai21_1_88/ZN gf180mcu_fd_sc_mcu7t5v0__or3_1_29/A1 vss
+ vdd vss gf180mcu_fd_sc_mcu7t5v0__oai21_1
Xgf180mcu_fd_sc_mcu7t5v0__oai21_1_99 vdd gf180mcu_fd_sc_mcu7t5v0__buf_8_6/Z gf180mcu_fd_sc_mcu7t5v0__aoi22_4_8/ZN
+ gf180mcu_fd_sc_mcu7t5v0__oai21_1_99/ZN gf180mcu_fd_sc_mcu7t5v0__dffq_1_409/Q vss
+ vdd vss gf180mcu_fd_sc_mcu7t5v0__oai21_1
Xgf180mcu_fd_sc_mcu7t5v0__dffq_1_107 vdd gf180mcu_fd_sc_mcu7t5v0__dffq_1_107/Q gf180mcu_fd_sc_mcu7t5v0__dffq_2_26/CLK
+ vss gf180mcu_fd_sc_mcu7t5v0__dffq_1_107/D vdd vss gf180mcu_fd_sc_mcu7t5v0__dffq_1
Xgf180mcu_fd_sc_mcu7t5v0__dffq_1_118 vdd gf180mcu_fd_sc_mcu7t5v0__dffq_1_118/Q gf180mcu_fd_sc_mcu7t5v0__dffq_1_96/CLK
+ vss gf180mcu_fd_sc_mcu7t5v0__dffq_1_118/D vdd vss gf180mcu_fd_sc_mcu7t5v0__dffq_1
Xgf180mcu_fd_sc_mcu7t5v0__nor2_1_307 vdd vss gf180mcu_fd_sc_mcu7t5v0__dffq_2_78/D
+ gf180mcu_fd_sc_mcu7t5v0__aoi21_1_7/B gf180mcu_fd_sc_mcu7t5v0__nor2_1_307/A2 vdd
+ vss gf180mcu_fd_sc_mcu7t5v0__nor2_1
Xgf180mcu_fd_sc_mcu7t5v0__dffq_1_129 vdd gf180mcu_fd_sc_mcu7t5v0__dffq_1_129/Q gf180mcu_fd_sc_mcu7t5v0__dffq_1_96/CLK
+ vss gf180mcu_fd_sc_mcu7t5v0__dffq_1_129/D vdd vss gf180mcu_fd_sc_mcu7t5v0__dffq_1
Xgf180mcu_fd_sc_mcu7t5v0__nor2_1_318 vdd vss gf180mcu_fd_sc_mcu7t5v0__xnor3_1_49/A3
+ gf180mcu_fd_sc_mcu7t5v0__nor3_2_5/A1 gf180mcu_fd_sc_mcu7t5v0__or3_1_24/A2 vdd vss
+ gf180mcu_fd_sc_mcu7t5v0__nor2_1
Xgf180mcu_fd_sc_mcu7t5v0__aoi21_2_3 gf180mcu_fd_sc_mcu7t5v0__inv_4_1/I vdd vss gf180mcu_fd_sc_mcu7t5v0__aoi21_2_3/ZN
+ gf180mcu_fd_sc_mcu7t5v0__or2_1_17/A1 gf180mcu_fd_sc_mcu7t5v0__inv_3_0/I vdd vss
+ gf180mcu_fd_sc_mcu7t5v0__aoi21_2
Xgf180mcu_fd_sc_mcu7t5v0__nor2_1_329 vdd vss gf180mcu_fd_sc_mcu7t5v0__nor2_1_329/ZN
+ gf180mcu_fd_sc_mcu7t5v0__dffq_1_430/Q gf180mcu_fd_sc_mcu7t5v0__nor2_4_27/ZN vdd
+ vss gf180mcu_fd_sc_mcu7t5v0__nor2_1
Xgf180mcu_fd_sc_mcu7t5v0__nand2_1_500 vdd vss gf180mcu_fd_sc_mcu7t5v0__oai211_2_6/B
+ gf180mcu_fd_sc_mcu7t5v0__aoi22_4_9/A1 gf180mcu_fd_sc_mcu7t5v0__nor2_2_36/ZN vdd
+ vss gf180mcu_fd_sc_mcu7t5v0__nand2_1
Xgf180mcu_fd_sc_mcu7t5v0__nand2_1_511 vdd vss gf180mcu_fd_sc_mcu7t5v0__xor2_1_139/A1
+ gf180mcu_fd_sc_mcu7t5v0__inv_8_1/I gf180mcu_fd_sc_mcu7t5v0__oai32_1_7/B1 vdd vss
+ gf180mcu_fd_sc_mcu7t5v0__nand2_1
Xgf180mcu_fd_sc_mcu7t5v0__nand2_1_522 vdd vss gf180mcu_fd_sc_mcu7t5v0__and2_1_114/A1
+ gf180mcu_fd_sc_mcu7t5v0__dffq_2_79/Q gf180mcu_fd_sc_mcu7t5v0__xor2_1_148/A2 vdd
+ vss gf180mcu_fd_sc_mcu7t5v0__nand2_1
Xgf180mcu_fd_sc_mcu7t5v0__nand2_1_533 vdd vss gf180mcu_fd_sc_mcu7t5v0__oai221_1_12/C
+ gf180mcu_fd_sc_mcu7t5v0__or4_1_0/A1 gf180mcu_fd_sc_mcu7t5v0__nor2_2_42/ZN vdd vss
+ gf180mcu_fd_sc_mcu7t5v0__nand2_1
Xgf180mcu_fd_sc_mcu7t5v0__nand2_1_544 vdd vss gf180mcu_fd_sc_mcu7t5v0__nand2_1_544/ZN
+ gf180mcu_fd_sc_mcu7t5v0__mux4_4_4/I3 gf180mcu_fd_sc_mcu7t5v0__clkinv_3_9/ZN vdd
+ vss gf180mcu_fd_sc_mcu7t5v0__nand2_1
Xgf180mcu_fd_sc_mcu7t5v0__nand2_1_555 vdd vss gf180mcu_fd_sc_mcu7t5v0__aoi22_4_11/B1
+ gf180mcu_fd_sc_mcu7t5v0__dffq_2_74/Q gf180mcu_fd_sc_mcu7t5v0__inv_4_7/ZN vdd vss
+ gf180mcu_fd_sc_mcu7t5v0__nand2_1
Xgf180mcu_fd_sc_mcu7t5v0__nand2_1_566 vdd vss gf180mcu_fd_sc_mcu7t5v0__oai21_1_285/A2
+ gf180mcu_fd_sc_mcu7t5v0__inv_8_2/I gf180mcu_fd_sc_mcu7t5v0__mux4_4_14/Z vdd vss
+ gf180mcu_fd_sc_mcu7t5v0__nand2_1
Xgf180mcu_fd_sc_mcu7t5v0__aoi21_2_13 gf180mcu_fd_sc_mcu7t5v0__nor3_1_28/ZN vdd vss
+ gf180mcu_fd_sc_mcu7t5v0__xor3_1_142/A2 gf180mcu_fd_sc_mcu7t5v0__xor3_1_97/A3 gf180mcu_fd_sc_mcu7t5v0__aoi21_2_13/A2
+ vdd vss gf180mcu_fd_sc_mcu7t5v0__aoi21_2
Xgf180mcu_fd_sc_mcu7t5v0__nand2_1_577 vdd vss gf180mcu_fd_sc_mcu7t5v0__and2_1_123/A2
+ gf180mcu_fd_sc_mcu7t5v0__inv_8_0/I gf180mcu_fd_sc_mcu7t5v0__mux4_4_13/Z vdd vss
+ gf180mcu_fd_sc_mcu7t5v0__nand2_1
Xgf180mcu_fd_sc_mcu7t5v0__aoi21_2_24 gf180mcu_fd_sc_mcu7t5v0__aoi21_2_24/B vdd vss
+ gf180mcu_fd_sc_mcu7t5v0__xor2_1_47/A2 gf180mcu_fd_sc_mcu7t5v0__and2_2_12/Z gf180mcu_fd_sc_mcu7t5v0__and2_1_91/Z
+ vdd vss gf180mcu_fd_sc_mcu7t5v0__aoi21_2
Xgf180mcu_fd_sc_mcu7t5v0__nand2_1_588 vdd vss gf180mcu_fd_sc_mcu7t5v0__nand2_1_588/ZN
+ gf180mcu_fd_sc_mcu7t5v0__xor3_1_118/A2 gf180mcu_fd_sc_mcu7t5v0__xor3_1_118/A3 vdd
+ vss gf180mcu_fd_sc_mcu7t5v0__nand2_1
Xgf180mcu_fd_sc_mcu7t5v0__nand2_1_599 vdd vss gf180mcu_fd_sc_mcu7t5v0__xor3_1_122/A1
+ gf180mcu_fd_sc_mcu7t5v0__inv_8_1/I gf180mcu_fd_sc_mcu7t5v0__xor2_1_162/A1 vdd vss
+ gf180mcu_fd_sc_mcu7t5v0__nand2_1
Xgf180mcu_fd_sc_mcu7t5v0__xor2_2_2 vdd vss gf180mcu_fd_sc_mcu7t5v0__xor2_2_2/Z gf180mcu_fd_sc_mcu7t5v0__xor2_2_2/A1
+ gf180mcu_fd_sc_mcu7t5v0__xor2_2_2/A2 vdd vss gf180mcu_fd_sc_mcu7t5v0__xor2_2
Xgf180mcu_fd_sc_mcu7t5v0__oai211_2_3 gf180mcu_fd_sc_mcu7t5v0__oai31_4_1/ZN gf180mcu_fd_sc_mcu7t5v0__xor2_1_88/A1
+ gf180mcu_fd_sc_mcu7t5v0__oai21_4_8/A1 gf180mcu_fd_sc_mcu7t5v0__inv_8_0/I gf180mcu_fd_sc_mcu7t5v0__or3_2_3/Z
+ vdd vss vdd vss gf180mcu_fd_sc_mcu7t5v0__oai211_2
Xgf180mcu_fd_sc_mcu7t5v0__mux4_4_16 gf180mcu_fd_sc_mcu7t5v0__mux4_4_16/I0 vss vdd
+ gf180mcu_fd_sc_mcu7t5v0__mux4_4_7/I0 gf180mcu_fd_sc_mcu7t5v0__or2_1_55/A1 gf180mcu_fd_sc_mcu7t5v0__inv_4_5/I
+ gf180mcu_fd_sc_mcu7t5v0__mux4_4_4/I3 gf180mcu_fd_sc_mcu7t5v0__or2_2_1/A1 gf180mcu_fd_sc_mcu7t5v0__mux4_4_16/Z
+ vdd vss gf180mcu_fd_sc_mcu7t5v0__mux4_4
Xgf180mcu_fd_sc_mcu7t5v0__oai21_2_6 gf180mcu_fd_sc_mcu7t5v0__or2_4_0/Z gf180mcu_fd_sc_mcu7t5v0__or2_1_16/A2
+ gf180mcu_fd_sc_mcu7t5v0__xor3_1_91/A1 vss gf180mcu_fd_sc_mcu7t5v0__oai21_2_6/B vdd
+ vdd vss gf180mcu_fd_sc_mcu7t5v0__oai21_2
Xgf180mcu_fd_sc_mcu7t5v0__or3_1_20 gf180mcu_fd_sc_mcu7t5v0__or3_1_20/A3 vdd vss gf180mcu_fd_sc_mcu7t5v0__or3_1_20/Z
+ gf180mcu_fd_sc_mcu7t5v0__or3_1_20/A1 gf180mcu_fd_sc_mcu7t5v0__or3_1_20/A2 vdd vss
+ gf180mcu_fd_sc_mcu7t5v0__or3_1
Xgf180mcu_fd_sc_mcu7t5v0__nor3_4_20 gf180mcu_fd_sc_mcu7t5v0__or4_1_3/A3 vdd vss gf180mcu_fd_sc_mcu7t5v0__nor3_4_20/ZN
+ gf180mcu_fd_sc_mcu7t5v0__or4_1_3/A1 gf180mcu_fd_sc_mcu7t5v0__or4_1_3/A2 vdd vss
+ gf180mcu_fd_sc_mcu7t5v0__nor3_4
Xgf180mcu_fd_sc_mcu7t5v0__tiel_4 uart_rx_PU vdd vss vdd vss gf180mcu_fd_sc_mcu7t5v0__tiel
Xgf180mcu_fd_sc_mcu7t5v0__nor2_1_104 vdd vss gf180mcu_fd_sc_mcu7t5v0__nor2_1_104/ZN
+ gf180mcu_fd_sc_mcu7t5v0__oai21_1_16/A1 gf180mcu_fd_sc_mcu7t5v0__nor3_1_7/A2 vdd
+ vss gf180mcu_fd_sc_mcu7t5v0__nor2_1
Xgf180mcu_fd_sc_mcu7t5v0__nor2_1_115 vdd vss gf180mcu_fd_sc_mcu7t5v0__aoi21_4_3/B
+ gf180mcu_fd_sc_mcu7t5v0__inv_4_2/ZN gf180mcu_fd_sc_mcu7t5v0__or3_4_0/Z vdd vss gf180mcu_fd_sc_mcu7t5v0__nor2_1
Xgf180mcu_fd_sc_mcu7t5v0__nor2_1_126 vdd vss gf180mcu_fd_sc_mcu7t5v0__xor3_1_65/A1
+ gf180mcu_fd_sc_mcu7t5v0__nor2_1_126/A1 gf180mcu_fd_sc_mcu7t5v0__xor3_1_173/Z vdd
+ vss gf180mcu_fd_sc_mcu7t5v0__nor2_1
Xgf180mcu_fd_sc_mcu7t5v0__xor3_1_105 gf180mcu_fd_sc_mcu7t5v0__xor3_1_105/A3 vdd vss
+ gf180mcu_fd_sc_mcu7t5v0__xor3_1_105/Z gf180mcu_fd_sc_mcu7t5v0__xor3_1_86/Z gf180mcu_fd_sc_mcu7t5v0__xor3_1_105/A2
+ vdd vss gf180mcu_fd_sc_mcu7t5v0__xor3_1
Xgf180mcu_fd_sc_mcu7t5v0__nor2_1_137 vdd vss gf180mcu_fd_sc_mcu7t5v0__nor2_1_137/ZN
+ gf180mcu_fd_sc_mcu7t5v0__dffq_1_283/Q gf180mcu_fd_sc_mcu7t5v0__nor2_4_20/ZN vdd
+ vss gf180mcu_fd_sc_mcu7t5v0__nor2_1
Xgf180mcu_fd_sc_mcu7t5v0__nor2_1_148 vdd vss gf180mcu_fd_sc_mcu7t5v0__and3_2_2/A1
+ gf180mcu_fd_sc_mcu7t5v0__or2_4_2/A1 gf180mcu_fd_sc_mcu7t5v0__or2_4_2/A2 vdd vss
+ gf180mcu_fd_sc_mcu7t5v0__nor2_1
Xgf180mcu_fd_sc_mcu7t5v0__xor3_1_116 gf180mcu_fd_sc_mcu7t5v0__xor3_1_108/Z vdd vss
+ gf180mcu_fd_sc_mcu7t5v0__xor3_1_116/Z gf180mcu_fd_sc_mcu7t5v0__xor3_1_116/A1 gf180mcu_fd_sc_mcu7t5v0__xor3_1_116/A2
+ vdd vss gf180mcu_fd_sc_mcu7t5v0__xor3_1
Xgf180mcu_fd_sc_mcu7t5v0__nor2_1_159 vdd vss gf180mcu_fd_sc_mcu7t5v0__nor2_1_159/ZN
+ gf180mcu_fd_sc_mcu7t5v0__or2_4_3/Z gf180mcu_fd_sc_mcu7t5v0__nor2_1_159/A2 vdd vss
+ gf180mcu_fd_sc_mcu7t5v0__nor2_1
Xgf180mcu_fd_sc_mcu7t5v0__xor3_1_127 gf180mcu_fd_sc_mcu7t5v0__xor3_1_122/Z vdd vss
+ gf180mcu_fd_sc_mcu7t5v0__xor3_1_127/Z gf180mcu_fd_sc_mcu7t5v0__nor3_1_37/ZN gf180mcu_fd_sc_mcu7t5v0__xor3_1_128/Z
+ vdd vss gf180mcu_fd_sc_mcu7t5v0__xor3_1
Xgf180mcu_fd_sc_mcu7t5v0__xor3_1_138 gf180mcu_fd_sc_mcu7t5v0__xor3_1_138/A3 vdd vss
+ gf180mcu_fd_sc_mcu7t5v0__xor3_1_138/Z gf180mcu_fd_sc_mcu7t5v0__xor3_1_138/A1 gf180mcu_fd_sc_mcu7t5v0__or2_1_49/Z
+ vdd vss gf180mcu_fd_sc_mcu7t5v0__xor3_1
Xgf180mcu_fd_sc_mcu7t5v0__xor3_1_149 gf180mcu_fd_sc_mcu7t5v0__xor3_1_149/A3 vdd vss
+ gf180mcu_fd_sc_mcu7t5v0__xor3_1_149/Z gf180mcu_fd_sc_mcu7t5v0__xor3_1_149/A1 gf180mcu_fd_sc_mcu7t5v0__xor3_1_149/A2
+ vdd vss gf180mcu_fd_sc_mcu7t5v0__xor3_1
Xgf180mcu_fd_sc_mcu7t5v0__nand2_1_330 vdd vss gf180mcu_fd_sc_mcu7t5v0__oai32_1_4/A3
+ gf180mcu_fd_sc_mcu7t5v0__or2_1_19/Z gf180mcu_fd_sc_mcu7t5v0__oai32_1_4/B1 vdd vss
+ gf180mcu_fd_sc_mcu7t5v0__nand2_1
Xgf180mcu_fd_sc_mcu7t5v0__nand2_1_341 vdd vss gf180mcu_fd_sc_mcu7t5v0__nand2_1_343/A1
+ gf180mcu_fd_sc_mcu7t5v0__dffq_1_329/Q gf180mcu_fd_sc_mcu7t5v0__and3_2_2/A2 vdd vss
+ gf180mcu_fd_sc_mcu7t5v0__nand2_1
Xgf180mcu_fd_sc_mcu7t5v0__nand2_1_352 vdd vss gf180mcu_fd_sc_mcu7t5v0__oai22_1_265/A2
+ gf180mcu_fd_sc_mcu7t5v0__buf_8_8/I gf180mcu_fd_sc_mcu7t5v0__or2_1_20/A1 vdd vss
+ gf180mcu_fd_sc_mcu7t5v0__nand2_1
Xgf180mcu_fd_sc_mcu7t5v0__nand2_1_363 vdd vss gf180mcu_fd_sc_mcu7t5v0__oai31_1_10/B
+ gf180mcu_fd_sc_mcu7t5v0__oai31_4_2/A3 gf180mcu_fd_sc_mcu7t5v0__oai31_4_2/B vdd vss
+ gf180mcu_fd_sc_mcu7t5v0__nand2_1
Xgf180mcu_fd_sc_mcu7t5v0__nand2_1_374 vdd vss gf180mcu_fd_sc_mcu7t5v0__aoi222_1_9/B1
+ gf180mcu_fd_sc_mcu7t5v0__or3_1_24/A1 gf180mcu_fd_sc_mcu7t5v0__nor2_2_49/A2 vdd vss
+ gf180mcu_fd_sc_mcu7t5v0__nand2_1
Xgf180mcu_fd_sc_mcu7t5v0__nand3_4_18 gf180mcu_fd_sc_mcu7t5v0__nor2_2_33/A1 vdd vss
+ gf180mcu_fd_sc_mcu7t5v0__nor3_1_33/A1 gf180mcu_fd_sc_mcu7t5v0__dffq_2_97/Q gf180mcu_fd_sc_mcu7t5v0__dffq_4_40/Q
+ vdd vss gf180mcu_fd_sc_mcu7t5v0__nand3_4
Xgf180mcu_fd_sc_mcu7t5v0__nand2_1_385 vdd vss gf180mcu_fd_sc_mcu7t5v0__nand2_1_388/A2
+ gf180mcu_fd_sc_mcu7t5v0__nor2_1_221/A1 gf180mcu_fd_sc_mcu7t5v0__xor2_1_102/Z vdd
+ vss gf180mcu_fd_sc_mcu7t5v0__nand2_1
Xgf180mcu_fd_sc_mcu7t5v0__nand2_1_396 vdd vss gf180mcu_fd_sc_mcu7t5v0__nand2_1_398/A1
+ gf180mcu_fd_sc_mcu7t5v0__xor2_1_105/A1 gf180mcu_fd_sc_mcu7t5v0__xor3_1_126/Z vdd
+ vss gf180mcu_fd_sc_mcu7t5v0__nand2_1
Xgf180mcu_fd_sc_mcu7t5v0__oai21_1_208 vdd gf180mcu_fd_sc_mcu7t5v0__oai21_1_208/B gf180mcu_fd_sc_mcu7t5v0__oai21_1_208/A2
+ gf180mcu_fd_sc_mcu7t5v0__oai21_1_216/B gf180mcu_fd_sc_mcu7t5v0__and3_2_3/A2 vss
+ vdd vss gf180mcu_fd_sc_mcu7t5v0__oai21_1
Xgf180mcu_fd_sc_mcu7t5v0__oai21_1_219 vdd gf180mcu_fd_sc_mcu7t5v0__oai21_1_219/B gf180mcu_fd_sc_mcu7t5v0__oai21_1_219/A2
+ gf180mcu_fd_sc_mcu7t5v0__oai21_1_219/ZN gf180mcu_fd_sc_mcu7t5v0__or3_1_18/A1 vss
+ vdd vss gf180mcu_fd_sc_mcu7t5v0__oai21_1
Xgf180mcu_fd_sc_mcu7t5v0__nand3_4_8 gf180mcu_fd_sc_mcu7t5v0__nor2_2_14/A1 vdd vss
+ gf180mcu_fd_sc_mcu7t5v0__nor3_1_9/A1 gf180mcu_fd_sc_mcu7t5v0__dffq_4_8/Q gf180mcu_fd_sc_mcu7t5v0__inv_2_6/I
+ vdd vss gf180mcu_fd_sc_mcu7t5v0__nand3_4
.ends
