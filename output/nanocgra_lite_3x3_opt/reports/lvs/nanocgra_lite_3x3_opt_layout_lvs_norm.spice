* NGSPICE file created from NanoCGRA_Lite.ext - technology: gf180mcuD

* Black-box entry subcircuit for gf180mcu_fd_sc_mcu7t5v0__xnor3_1 abstract view
.subckt gf180mcu_fd_sc_mcu7t5v0__xnor3_1 A1 A2 A3 ZN VDD VNW VPW VSS
.ends

* Black-box entry subcircuit for gf180mcu_fd_sc_mcu7t5v0__dffq_2 abstract view
.subckt gf180mcu_fd_sc_mcu7t5v0__dffq_2 D CLK Q VDD VNW VPW VSS
.ends

* Black-box entry subcircuit for gf180mcu_fd_sc_mcu7t5v0__or3_1 abstract view
.subckt gf180mcu_fd_sc_mcu7t5v0__or3_1 A1 A2 A3 Z VDD VNW VPW VSS
.ends

* Black-box entry subcircuit for gf180mcu_fd_sc_mcu7t5v0__clkinv_1 abstract view
.subckt gf180mcu_fd_sc_mcu7t5v0__clkinv_1 I ZN VDD VNW VPW VSS
.ends

* Black-box entry subcircuit for gf180mcu_fd_sc_mcu7t5v0__nand3_1 abstract view
.subckt gf180mcu_fd_sc_mcu7t5v0__nand3_1 A1 A2 A3 ZN VDD VNW VPW VSS
.ends

* Black-box entry subcircuit for gf180mcu_fd_sc_mcu7t5v0__xnor2_1 abstract view
.subckt gf180mcu_fd_sc_mcu7t5v0__xnor2_1 A1 A2 ZN VDD VNW VPW VSS
.ends

* Black-box entry subcircuit for gf180mcu_fd_sc_mcu7t5v0__nand2_1 abstract view
.subckt gf180mcu_fd_sc_mcu7t5v0__nand2_1 A1 A2 ZN VDD VNW VPW VSS
.ends

* Black-box entry subcircuit for gf180mcu_fd_sc_mcu7t5v0__oai31_1 abstract view
.subckt gf180mcu_fd_sc_mcu7t5v0__oai31_1 A1 A2 A3 B ZN VDD VNW VPW VSS
.ends

* Black-box entry subcircuit for gf180mcu_fd_sc_mcu7t5v0__xor2_1 abstract view
.subckt gf180mcu_fd_sc_mcu7t5v0__xor2_1 A1 A2 Z VDD VNW VPW VSS
.ends

* Black-box entry subcircuit for gf180mcu_fd_sc_mcu7t5v0__inv_1 abstract view
.subckt gf180mcu_fd_sc_mcu7t5v0__inv_1 I ZN VDD VNW VPW VSS
.ends

* Black-box entry subcircuit for gf180mcu_fd_sc_mcu7t5v0__oai21_1 abstract view
.subckt gf180mcu_fd_sc_mcu7t5v0__oai21_1 A1 A2 B ZN VDD VNW VPW VSS
.ends

* Black-box entry subcircuit for gf180mcu_fd_sc_mcu7t5v0__xor3_1 abstract view
.subckt gf180mcu_fd_sc_mcu7t5v0__xor3_1 A1 A2 A3 Z VDD VNW VPW VSS
.ends

* Black-box entry subcircuit for gf180mcu_fd_sc_mcu7t5v0__oai22_1 abstract view
.subckt gf180mcu_fd_sc_mcu7t5v0__oai22_1 A1 A2 B1 B2 ZN VDD VNW VPW VSS
.ends

* Black-box entry subcircuit for gf180mcu_fd_sc_mcu7t5v0__nand2_4 abstract view
.subckt gf180mcu_fd_sc_mcu7t5v0__nand2_4 A1 A2 ZN VDD VNW VPW VSS
.ends

* Black-box entry subcircuit for gf180mcu_fd_sc_mcu7t5v0__or2_1 abstract view
.subckt gf180mcu_fd_sc_mcu7t5v0__or2_1 A1 A2 Z VDD VNW VPW VSS
.ends

* Black-box entry subcircuit for gf180mcu_fd_sc_mcu7t5v0__aoi21_1 abstract view
.subckt gf180mcu_fd_sc_mcu7t5v0__aoi21_1 A1 A2 B ZN VDD VNW VPW VSS
.ends

* Black-box entry subcircuit for gf180mcu_fd_sc_mcu7t5v0__dffq_1 abstract view
.subckt gf180mcu_fd_sc_mcu7t5v0__dffq_1 D CLK Q VDD VNW VPW VSS
.ends

* Black-box entry subcircuit for gf180mcu_fd_sc_mcu7t5v0__filltie abstract view
.subckt gf180mcu_fd_sc_mcu7t5v0__filltie VDD VSS
.ends

* Black-box entry subcircuit for gf180mcu_fd_sc_mcu7t5v0__oai21_4 abstract view
.subckt gf180mcu_fd_sc_mcu7t5v0__oai21_4 A1 A2 B ZN VDD VNW VPW VSS
.ends

* Black-box entry subcircuit for gf180mcu_fd_sc_mcu7t5v0__nor2_1 abstract view
.subckt gf180mcu_fd_sc_mcu7t5v0__nor2_1 A1 A2 ZN VDD VNW VPW VSS
.ends

* Black-box entry subcircuit for gf180mcu_fd_sc_mcu7t5v0__nor2_2 abstract view
.subckt gf180mcu_fd_sc_mcu7t5v0__nor2_2 A1 A2 ZN VDD VNW VPW VSS
.ends

* Black-box entry subcircuit for gf180mcu_fd_sc_mcu7t5v0__aoi22_1 abstract view
.subckt gf180mcu_fd_sc_mcu7t5v0__aoi22_1 A1 A2 B1 B2 ZN VDD VNW VPW VSS
.ends

* Black-box entry subcircuit for gf180mcu_fd_sc_mcu7t5v0__and2_2 abstract view
.subckt gf180mcu_fd_sc_mcu7t5v0__and2_2 A1 A2 Z VDD VNW VPW VSS
.ends

* Black-box entry subcircuit for gf180mcu_fd_sc_mcu7t5v0__aoi222_1 abstract view
.subckt gf180mcu_fd_sc_mcu7t5v0__aoi222_1 A1 A2 B1 B2 C1 C2 ZN VDD VNW VPW VSS
.ends

* Black-box entry subcircuit for gf180mcu_fd_sc_mcu7t5v0__xor2_2 abstract view
.subckt gf180mcu_fd_sc_mcu7t5v0__xor2_2 A1 A2 Z VDD VNW VPW VSS
.ends

* Black-box entry subcircuit for gf180mcu_fd_sc_mcu7t5v0__mux4_4 abstract view
.subckt gf180mcu_fd_sc_mcu7t5v0__mux4_4 I0 I1 I2 I3 S0 S1 Z VDD VNW VPW VSS
.ends

* Black-box entry subcircuit for gf180mcu_fd_sc_mcu7t5v0__aoi221_1 abstract view
.subckt gf180mcu_fd_sc_mcu7t5v0__aoi221_1 A1 A2 B1 B2 C ZN VDD VNW VPW VSS
.ends

* Black-box entry subcircuit for gf180mcu_fd_sc_mcu7t5v0__dffq_4 abstract view
.subckt gf180mcu_fd_sc_mcu7t5v0__dffq_4 D CLK Q VDD VNW VPW VSS
.ends

* Black-box entry subcircuit for gf180mcu_fd_sc_mcu7t5v0__nand4_1 abstract view
.subckt gf180mcu_fd_sc_mcu7t5v0__nand4_1 A1 A2 A3 A4 ZN VDD VNW VPW VSS
.ends

* Black-box entry subcircuit for gf180mcu_fd_sc_mcu7t5v0__nor3_2 abstract view
.subckt gf180mcu_fd_sc_mcu7t5v0__nor3_2 A1 A2 A3 ZN VDD VNW VPW VSS
.ends

* Black-box entry subcircuit for gf180mcu_fd_sc_mcu7t5v0__aoi211_1 abstract view
.subckt gf180mcu_fd_sc_mcu7t5v0__aoi211_1 A1 A2 B C ZN VDD VNW VPW VSS
.ends

* Black-box entry subcircuit for gf180mcu_fd_sc_mcu7t5v0__oai211_2 abstract view
.subckt gf180mcu_fd_sc_mcu7t5v0__oai211_2 A1 A2 B C ZN VDD VNW VPW VSS
.ends

* Black-box entry subcircuit for gf180mcu_fd_sc_mcu7t5v0__oai221_2 abstract view
.subckt gf180mcu_fd_sc_mcu7t5v0__oai221_2 A1 A2 B1 B2 C ZN VDD VNW VPW VSS
.ends

* Black-box entry subcircuit for gf180mcu_fd_sc_mcu7t5v0__nand3_2 abstract view
.subckt gf180mcu_fd_sc_mcu7t5v0__nand3_2 A1 A2 A3 ZN VDD VNW VPW VSS
.ends

* Black-box entry subcircuit for gf180mcu_fd_sc_mcu7t5v0__oai211_1 abstract view
.subckt gf180mcu_fd_sc_mcu7t5v0__oai211_1 A1 A2 B C ZN VDD VNW VPW VSS
.ends

* Black-box entry subcircuit for gf180mcu_fd_sc_mcu7t5v0__aoi22_2 abstract view
.subckt gf180mcu_fd_sc_mcu7t5v0__aoi22_2 A1 A2 B1 B2 ZN VDD VNW VPW VSS
.ends

* Black-box entry subcircuit for gf180mcu_fd_sc_mcu7t5v0__and3_1 abstract view
.subckt gf180mcu_fd_sc_mcu7t5v0__and3_1 A1 A2 A3 Z VDD VNW VPW VSS
.ends

* Black-box entry subcircuit for gf180mcu_fd_sc_mcu7t5v0__oai31_4 abstract view
.subckt gf180mcu_fd_sc_mcu7t5v0__oai31_4 A1 A2 A3 B ZN VDD VNW VPW VSS
.ends

* Black-box entry subcircuit for gf180mcu_fd_sc_mcu7t5v0__clkinv_2 abstract view
.subckt gf180mcu_fd_sc_mcu7t5v0__clkinv_2 I ZN VDD VNW VPW VSS
.ends

* Black-box entry subcircuit for gf180mcu_fd_sc_mcu7t5v0__mux2_4 abstract view
.subckt gf180mcu_fd_sc_mcu7t5v0__mux2_4 I0 I1 S Z VDD VNW VPW VSS
.ends

* Black-box entry subcircuit for gf180mcu_fd_sc_mcu7t5v0__nor4_1 abstract view
.subckt gf180mcu_fd_sc_mcu7t5v0__nor4_1 A1 A2 A3 A4 ZN VDD VNW VPW VSS
.ends

* Black-box entry subcircuit for gf180mcu_fd_sc_mcu7t5v0__nand2_2 abstract view
.subckt gf180mcu_fd_sc_mcu7t5v0__nand2_2 A1 A2 ZN VDD VNW VPW VSS
.ends

* Black-box entry subcircuit for gf180mcu_fd_sc_mcu7t5v0__and2_1 abstract view
.subckt gf180mcu_fd_sc_mcu7t5v0__and2_1 A1 A2 Z VDD VNW VPW VSS
.ends

* Black-box entry subcircuit for gf180mcu_fd_sc_mcu7t5v0__endcap abstract view
.subckt gf180mcu_fd_sc_mcu7t5v0__endcap VDD VSS
.ends

* Black-box entry subcircuit for gf180mcu_fd_sc_mcu7t5v0__or4_1 abstract view
.subckt gf180mcu_fd_sc_mcu7t5v0__or4_1 A1 A2 A3 A4 Z VDD VNW VPW VSS
.ends

* Black-box entry subcircuit for gf180mcu_fd_sc_mcu7t5v0__clkinv_3 abstract view
.subckt gf180mcu_fd_sc_mcu7t5v0__clkinv_3 I ZN VDD VNW VPW VSS
.ends

* Black-box entry subcircuit for gf180mcu_fd_sc_mcu7t5v0__nor3_1 abstract view
.subckt gf180mcu_fd_sc_mcu7t5v0__nor3_1 A1 A2 A3 ZN VDD VNW VPW VSS
.ends

* Black-box entry subcircuit for gf180mcu_fd_sc_mcu7t5v0__nand3_4 abstract view
.subckt gf180mcu_fd_sc_mcu7t5v0__nand3_4 A1 A2 A3 ZN VDD VNW VPW VSS
.ends

* Black-box entry subcircuit for gf180mcu_fd_sc_mcu7t5v0__nor3_4 abstract view
.subckt gf180mcu_fd_sc_mcu7t5v0__nor3_4 A1 A2 A3 ZN VDD VNW VPW VSS
.ends

* Black-box entry subcircuit for gf180mcu_fd_sc_mcu7t5v0__oai22_4 abstract view
.subckt gf180mcu_fd_sc_mcu7t5v0__oai22_4 A1 A2 B1 B2 ZN VDD VNW VPW VSS
.ends

* Black-box entry subcircuit for gf180mcu_fd_sc_mcu7t5v0__aoi22_4 abstract view
.subckt gf180mcu_fd_sc_mcu7t5v0__aoi22_4 A1 A2 B1 B2 ZN VDD VNW VPW VSS
.ends

* Black-box entry subcircuit for gf180mcu_fd_sc_mcu7t5v0__oai32_4 abstract view
.subckt gf180mcu_fd_sc_mcu7t5v0__oai32_4 A1 A2 A3 B1 B2 ZN VDD VNW VPW VSS
.ends

* Black-box entry subcircuit for gf180mcu_fd_sc_mcu7t5v0__oai21_2 abstract view
.subckt gf180mcu_fd_sc_mcu7t5v0__oai21_2 A1 A2 B ZN VDD VNW VPW VSS
.ends

* Black-box entry subcircuit for gf180mcu_fd_sc_mcu7t5v0__oai221_1 abstract view
.subckt gf180mcu_fd_sc_mcu7t5v0__oai221_1 A1 A2 B1 B2 C ZN VDD VNW VPW VSS
.ends

* Black-box entry subcircuit for gf180mcu_fd_sc_mcu7t5v0__aoi222_2 abstract view
.subckt gf180mcu_fd_sc_mcu7t5v0__aoi222_2 A1 A2 B1 B2 C1 C2 ZN VDD VNW VPW VSS
.ends

* Black-box entry subcircuit for gf180mcu_fd_sc_mcu7t5v0__aoi21_2 abstract view
.subckt gf180mcu_fd_sc_mcu7t5v0__aoi21_2 A1 A2 B ZN VDD VNW VPW VSS
.ends

* Black-box entry subcircuit for gf180mcu_fd_sc_mcu7t5v0__and2_4 abstract view
.subckt gf180mcu_fd_sc_mcu7t5v0__and2_4 A1 A2 Z VDD VNW VPW VSS
.ends

* Black-box entry subcircuit for gf180mcu_fd_sc_mcu7t5v0__aoi21_4 abstract view
.subckt gf180mcu_fd_sc_mcu7t5v0__aoi21_4 A1 A2 B ZN VDD VNW VPW VSS
.ends

* Black-box entry subcircuit for gf180mcu_fd_sc_mcu7t5v0__nor2_4 abstract view
.subckt gf180mcu_fd_sc_mcu7t5v0__nor2_4 A1 A2 ZN VDD VNW VPW VSS
.ends

* Black-box entry subcircuit for gf180mcu_fd_sc_mcu7t5v0__tiel abstract view
.subckt gf180mcu_fd_sc_mcu7t5v0__tiel ZN VDD VNW VPW VSS
.ends

* Black-box entry subcircuit for gf180mcu_fd_sc_mcu7t5v0__oai211_4 abstract view
.subckt gf180mcu_fd_sc_mcu7t5v0__oai211_4 A1 A2 B C ZN VDD VNW VPW VSS
.ends

* Black-box entry subcircuit for gf180mcu_fd_sc_mcu7t5v0__aoi221_4 abstract view
.subckt gf180mcu_fd_sc_mcu7t5v0__aoi221_4 A1 A2 B1 B2 C ZN VDD VNW VPW VSS
.ends

* Black-box entry subcircuit for gf180mcu_fd_sc_mcu7t5v0__mux4_2 abstract view
.subckt gf180mcu_fd_sc_mcu7t5v0__mux4_2 I0 I1 I2 I3 S0 S1 Z VDD VNW VPW VSS
.ends

* Black-box entry subcircuit for gf180mcu_fd_sc_mcu7t5v0__nand4_2 abstract view
.subckt gf180mcu_fd_sc_mcu7t5v0__nand4_2 A1 A2 A3 A4 ZN VDD VNW VPW VSS
.ends

* Black-box entry subcircuit for gf180mcu_fd_sc_mcu7t5v0__buf_8 abstract view
.subckt gf180mcu_fd_sc_mcu7t5v0__buf_8 I Z VDD VNW VPW VSS
.ends

* Black-box entry subcircuit for gf180mcu_fd_sc_mcu7t5v0__and4_1 abstract view
.subckt gf180mcu_fd_sc_mcu7t5v0__and4_1 A1 A2 A3 A4 Z VDD VNW VPW VSS
.ends

* Black-box entry subcircuit for gf180mcu_fd_sc_mcu7t5v0__or2_4 abstract view
.subckt gf180mcu_fd_sc_mcu7t5v0__or2_4 A1 A2 Z VDD VNW VPW VSS
.ends

* Black-box entry subcircuit for gf180mcu_fd_sc_mcu7t5v0__and3_2 abstract view
.subckt gf180mcu_fd_sc_mcu7t5v0__and3_2 A1 A2 A3 Z VDD VNW VPW VSS
.ends

* Black-box entry subcircuit for gf180mcu_fd_sc_mcu7t5v0__clkinv_4 abstract view
.subckt gf180mcu_fd_sc_mcu7t5v0__clkinv_4 I ZN VDD VNW VPW VSS
.ends

* Black-box entry subcircuit for gf180mcu_fd_sc_mcu7t5v0__or2_2 abstract view
.subckt gf180mcu_fd_sc_mcu7t5v0__or2_2 A1 A2 Z VDD VNW VPW VSS
.ends

* Black-box entry subcircuit for gf180mcu_fd_sc_mcu7t5v0__mux2_1 abstract view
.subckt gf180mcu_fd_sc_mcu7t5v0__mux2_1 I0 I1 S Z VDD VNW VPW VSS
.ends

* Black-box entry subcircuit for gf180mcu_fd_sc_mcu7t5v0__aoi222_4 abstract view
.subckt gf180mcu_fd_sc_mcu7t5v0__aoi222_4 A1 A2 B1 B2 C1 C2 ZN VDD VNW VPW VSS
.ends

* Black-box entry subcircuit for gf180mcu_fd_sc_mcu7t5v0__inv_4 abstract view
.subckt gf180mcu_fd_sc_mcu7t5v0__inv_4 I ZN VDD VNW VPW VSS
.ends

* Black-box entry subcircuit for gf180mcu_fd_sc_mcu7t5v0__inv_2 abstract view
.subckt gf180mcu_fd_sc_mcu7t5v0__inv_2 I ZN VDD VNW VPW VSS
.ends

* Black-box entry subcircuit for gf180mcu_fd_sc_mcu7t5v0__oai32_1 abstract view
.subckt gf180mcu_fd_sc_mcu7t5v0__oai32_1 A1 A2 A3 B1 B2 ZN VDD VNW VPW VSS
.ends

* Black-box entry subcircuit for gf180mcu_fd_sc_mcu7t5v0__aoi221_2 abstract view
.subckt gf180mcu_fd_sc_mcu7t5v0__aoi221_2 A1 A2 B1 B2 C ZN VDD VNW VPW VSS
.ends

* Black-box entry subcircuit for gf180mcu_fd_sc_mcu7t5v0__and4_2 abstract view
.subckt gf180mcu_fd_sc_mcu7t5v0__and4_2 A1 A2 A3 A4 Z VDD VNW VPW VSS
.ends

* Black-box entry subcircuit for gf180mcu_fd_sc_mcu7t5v0__oai22_2 abstract view
.subckt gf180mcu_fd_sc_mcu7t5v0__oai22_2 A1 A2 B1 B2 ZN VDD VNW VPW VSS
.ends

* Black-box entry subcircuit for gf180mcu_fd_sc_mcu7t5v0__or3_2 abstract view
.subckt gf180mcu_fd_sc_mcu7t5v0__or3_2 A1 A2 A3 Z VDD VNW VPW VSS
.ends

* Black-box entry subcircuit for gf180mcu_fd_sc_mcu7t5v0__oai31_2 abstract view
.subckt gf180mcu_fd_sc_mcu7t5v0__oai31_2 A1 A2 A3 B ZN VDD VNW VPW VSS
.ends

* Black-box entry subcircuit for gf180mcu_fd_sc_mcu7t5v0__nand4_4 abstract view
.subckt gf180mcu_fd_sc_mcu7t5v0__nand4_4 A1 A2 A3 A4 ZN VDD VNW VPW VSS
.ends

* Black-box entry subcircuit for gf180mcu_fd_sc_mcu7t5v0__oai33_2 abstract view
.subckt gf180mcu_fd_sc_mcu7t5v0__oai33_2 A1 A2 A3 B1 B2 B3 ZN VDD VNW VPW VSS
.ends

* Black-box entry subcircuit for gf180mcu_fd_sc_mcu7t5v0__inv_12 abstract view
.subckt gf180mcu_fd_sc_mcu7t5v0__inv_12 I ZN VDD VNW VPW VSS
.ends

* Black-box entry subcircuit for gf180mcu_fd_sc_mcu7t5v0__nor4_2 abstract view
.subckt gf180mcu_fd_sc_mcu7t5v0__nor4_2 A1 A2 A3 A4 ZN VDD VNW VPW VSS
.ends

* Black-box entry subcircuit for gf180mcu_fd_sc_mcu7t5v0__or3_4 abstract view
.subckt gf180mcu_fd_sc_mcu7t5v0__or3_4 A1 A2 A3 Z VDD VNW VPW VSS
.ends

* Black-box entry subcircuit for gf180mcu_fd_sc_mcu7t5v0__oai32_2 abstract view
.subckt gf180mcu_fd_sc_mcu7t5v0__oai32_2 A1 A2 A3 B1 B2 ZN VDD VNW VPW VSS
.ends

* Black-box entry subcircuit for gf180mcu_fd_sc_mcu7t5v0__inv_8 abstract view
.subckt gf180mcu_fd_sc_mcu7t5v0__inv_8 I ZN VDD VNW VPW VSS
.ends

* Black-box entry subcircuit for gf180mcu_fd_sc_mcu7t5v0__aoi211_2 abstract view
.subckt gf180mcu_fd_sc_mcu7t5v0__aoi211_2 A1 A2 B C ZN VDD VNW VPW VSS
.ends

* Black-box entry subcircuit for gf180mcu_fd_sc_mcu7t5v0__nor4_4 abstract view
.subckt gf180mcu_fd_sc_mcu7t5v0__nor4_4 A1 A2 A3 A4 ZN VDD VNW VPW VSS
.ends

* Black-box entry subcircuit for gf180mcu_fd_sc_mcu7t5v0__xor3_2 abstract view
.subckt gf180mcu_fd_sc_mcu7t5v0__xor3_2 A1 A2 A3 Z VDD VNW VPW VSS
.ends

* Black-box entry subcircuit for gf180mcu_fd_sc_mcu7t5v0__clkinv_8 abstract view
.subckt gf180mcu_fd_sc_mcu7t5v0__clkinv_8 I ZN VDD VNW VPW VSS
.ends

* Black-box entry subcircuit for gf180mcu_fd_sc_mcu7t5v0__buf_20 abstract view
.subckt gf180mcu_fd_sc_mcu7t5v0__buf_20 I Z VDD VNW VPW VSS
.ends

* Black-box entry subcircuit for gf180mcu_fd_sc_mcu7t5v0__mux2_2 abstract view
.subckt gf180mcu_fd_sc_mcu7t5v0__mux2_2 I0 I1 S Z VDD VNW VPW VSS
.ends

* Black-box entry subcircuit for gf180mcu_fd_sc_mcu7t5v0__inv_3 abstract view
.subckt gf180mcu_fd_sc_mcu7t5v0__inv_3 I ZN VDD VNW VPW VSS
.ends

* Black-box entry subcircuit for gf180mcu_fd_sc_mcu7t5v0__inv_20 abstract view
.subckt gf180mcu_fd_sc_mcu7t5v0__inv_20 I ZN VDD VNW VPW VSS
.ends

* Black-box entry subcircuit for gf180mcu_fd_sc_mcu7t5v0__aoi211_4 abstract view
.subckt gf180mcu_fd_sc_mcu7t5v0__aoi211_4 A1 A2 B C ZN VDD VNW VPW VSS
.ends

* Black-box entry subcircuit for gf180mcu_fd_sc_mcu7t5v0__tieh abstract view
.subckt gf180mcu_fd_sc_mcu7t5v0__tieh Z VDD VNW VPW VSS
.ends

.subckt NanoCGRA_Lite vss clk_PU clk_PD clk rst_n_PU rst_n_PD rst_n uart_rx_PU uart_rx_PD
+ uart_rx uart_tx_CS uart_tx_SL uart_tx_IE uart_tx_OE uart_tx_PU uart_tx_PD uart_tx_OUT
+ uart_tx_IN vdd vss vss vss vss vss vdd vdd vdd vdd
+ vdd
X_05903_ _05903_/A1 _05903_/A2 _05900_/Z _05906_/A3 vdd vdd vss vss
+ gf180mcu_fd_sc_mcu7t5v0__xnor3_1
X_09671_ _09671_/D clk _09671_/Q vdd vdd vss vss gf180mcu_fd_sc_mcu7t5v0__dffq_2
X_06883_ _08721_/A1 _06941_/A2 _06884_/A2 _06929_/B vdd vdd vss vss
+ gf180mcu_fd_sc_mcu7t5v0__or3_1
X_05834_ _05834_/I _05883_/A1 vdd vdd vss vss gf180mcu_fd_sc_mcu7t5v0__clkinv_1
X_08622_ _09714_/Q _08678_/A2 _08623_/B _08675_/B vdd vdd vss vss
+ gf180mcu_fd_sc_mcu7t5v0__nand3_1
X_05765_ _05943_/A2 _05765_/A2 _05767_/A2 vdd vdd vss vss gf180mcu_fd_sc_mcu7t5v0__xnor2_1
X_08553_ _08703_/B _08552_/Z _08554_/A2 vdd vdd vss vss gf180mcu_fd_sc_mcu7t5v0__nand2_1
X_08484_ _08685_/A2 _08688_/A2 _08678_/A2 _08703_/B _08485_/A2 vdd vdd
+ vss vss gf180mcu_fd_sc_mcu7t5v0__oai31_1
X_07504_ _07504_/A1 _07503_/B _07504_/Z vdd vdd vss vss gf180mcu_fd_sc_mcu7t5v0__xor2_1
X_04716_ _09925_/Q _09175_/A3 vdd vdd vss vss gf180mcu_fd_sc_mcu7t5v0__inv_1
X_05696_ _05964_/B2 _05709_/B _05696_/B _05697_/B vdd vdd vss vss
+ gf180mcu_fd_sc_mcu7t5v0__oai21_1
X_07435_ _07435_/A1 _07435_/A2 _07435_/A3 _07464_/B vdd vdd vss vss
+ gf180mcu_fd_sc_mcu7t5v0__xor3_1
X_07366_ _07366_/A1 _07366_/A2 _07371_/A2 vdd vdd vss vss gf180mcu_fd_sc_mcu7t5v0__xnor2_1
X_06317_ _09403_/A1 _06323_/A2 _06323_/B1 _06317_/B2 _09585_/D vdd vdd
+ vss vss gf180mcu_fd_sc_mcu7t5v0__oai22_1
X_09105_ _09400_/A1 _09105_/A2 _09114_/A2 vdd vdd vss vss gf180mcu_fd_sc_mcu7t5v0__nand2_4
X_07297_ _09996_/Q _09073_/A2 _08734_/B _07298_/B vdd vdd vss vss
+ gf180mcu_fd_sc_mcu7t5v0__oai21_1
X_06248_ _09577_/Q _06246_/Z _06248_/Z vdd vdd vss vss gf180mcu_fd_sc_mcu7t5v0__or2_1
X_09036_ _09036_/A1 _09036_/A2 _09399_/C _09875_/D vdd vdd vss vss
+ gf180mcu_fd_sc_mcu7t5v0__aoi21_1
X_06179_ _09710_/Q _06178_/Z _06238_/A2 vdd vdd vss vss gf180mcu_fd_sc_mcu7t5v0__nand2_1
X_09938_ _09938_/D clk _09938_/Q vdd vdd vss vss gf180mcu_fd_sc_mcu7t5v0__dffq_1
X_09869_ _09869_/D clk _09869_/Q vdd vdd vss vss gf180mcu_fd_sc_mcu7t5v0__dffq_1
XTAP_1800 vdd vss gf180mcu_fd_sc_mcu7t5v0__filltie
XTAP_1833 vdd vss gf180mcu_fd_sc_mcu7t5v0__filltie
XTAP_1822 vdd vss gf180mcu_fd_sc_mcu7t5v0__filltie
XTAP_1811 vdd vss gf180mcu_fd_sc_mcu7t5v0__filltie
XTAP_1866 vdd vss gf180mcu_fd_sc_mcu7t5v0__filltie
XTAP_1855 vdd vss gf180mcu_fd_sc_mcu7t5v0__filltie
XTAP_1844 vdd vss gf180mcu_fd_sc_mcu7t5v0__filltie
XTAP_1899 vdd vss gf180mcu_fd_sc_mcu7t5v0__filltie
XTAP_1888 vdd vss gf180mcu_fd_sc_mcu7t5v0__filltie
XTAP_1877 vdd vss gf180mcu_fd_sc_mcu7t5v0__filltie
X_10009_ _10009_/D clk _10009_/Q vdd vdd vss vss gf180mcu_fd_sc_mcu7t5v0__dffq_1
X_05550_ _05550_/A1 _05550_/A2 _05572_/A2 vdd vdd vss vss gf180mcu_fd_sc_mcu7t5v0__nand2_1
X_05481_ _05481_/A1 _05481_/A2 _05486_/C1 vdd vdd vss vss gf180mcu_fd_sc_mcu7t5v0__nand2_1
X_07220_ _09711_/Q _07160_/Z _07220_/B _07221_/A3 vdd vdd vss vss
+ gf180mcu_fd_sc_mcu7t5v0__aoi21_1
X_07151_ _07152_/A2 _07152_/A3 _07197_/A2 vdd vdd vss vss gf180mcu_fd_sc_mcu7t5v0__nand2_1
X_06102_ _06146_/B _06146_/A2 _06105_/A3 vdd vdd vss vss gf180mcu_fd_sc_mcu7t5v0__nand2_1
X_07082_ _07065_/Z _07126_/B _07084_/A2 vdd vdd vss vss gf180mcu_fd_sc_mcu7t5v0__xnor2_1
X_06033_ _08291_/B _06016_/I _06033_/B _06036_/A3 vdd vdd vss vss
+ gf180mcu_fd_sc_mcu7t5v0__oai21_1
X_07984_ _09710_/Q _08003_/A2 _07985_/A2 vdd vdd vss vss gf180mcu_fd_sc_mcu7t5v0__nand2_1
X_09723_ _09723_/D clk _09723_/Q vdd vdd vss vss gf180mcu_fd_sc_mcu7t5v0__dffq_1
X_06935_ _09715_/Q _06719_/I _06938_/A2 vdd vdd vss vss gf180mcu_fd_sc_mcu7t5v0__nand2_1
X_06866_ _06814_/Z _06867_/A2 _06867_/B _06866_/Z vdd vdd vss vss
+ gf180mcu_fd_sc_mcu7t5v0__or3_1
X_09654_ _09654_/D clk _09654_/Q vdd vdd vss vss gf180mcu_fd_sc_mcu7t5v0__dffq_1
X_05817_ _05863_/A1 _05816_/Z _05817_/Z vdd vdd vss vss gf180mcu_fd_sc_mcu7t5v0__xor2_1
X_08605_ _08555_/Z _08605_/A2 _08604_/B _08605_/Z vdd vdd vss vss
+ gf180mcu_fd_sc_mcu7t5v0__or3_1
X_09585_ _09585_/D clk _09585_/Q vdd vdd vss vss gf180mcu_fd_sc_mcu7t5v0__dffq_1
XTAP_1107 vdd vss gf180mcu_fd_sc_mcu7t5v0__filltie
XTAP_1118 vdd vss gf180mcu_fd_sc_mcu7t5v0__filltie
XTAP_1129 vdd vss gf180mcu_fd_sc_mcu7t5v0__filltie
X_06797_ _06735_/I _06842_/A1 _06797_/A3 _06797_/Z vdd vdd vss vss
+ gf180mcu_fd_sc_mcu7t5v0__xor3_1
X_05748_ _05839_/A1 _05839_/A2 _05839_/B _05943_/A2 vdd vdd vss vss
+ gf180mcu_fd_sc_mcu7t5v0__oai21_4
X_08536_ _08498_/Z _08535_/Z _08570_/B vdd vdd vss vss gf180mcu_fd_sc_mcu7t5v0__nor2_1
X_08467_ _08685_/A2 _08688_/A2 _08703_/B _08468_/A2 vdd vdd vss vss
+ gf180mcu_fd_sc_mcu7t5v0__oai21_1
X_05679_ _05679_/A1 _05679_/A2 _05698_/B1 vdd vdd vss vss gf180mcu_fd_sc_mcu7t5v0__xnor2_1
X_08398_ _09720_/Q _08412_/A2 _08699_/A2 vdd vdd vss vss gf180mcu_fd_sc_mcu7t5v0__nor2_2
X_07418_ _09713_/Q _07317_/Z _07349_/Z _09712_/Q _07434_/A2 vdd vdd vss
+ vss gf180mcu_fd_sc_mcu7t5v0__aoi22_1
X_07349_ _07364_/A2 _07364_/A3 _07349_/Z vdd vdd vss vss gf180mcu_fd_sc_mcu7t5v0__and2_2
X_09019_ _09407_/A1 _09021_/A2 _09021_/B1 _09019_/B2 _09864_/D vdd vdd
+ vss vss gf180mcu_fd_sc_mcu7t5v0__oai22_1
XTAP_1630 vdd vss gf180mcu_fd_sc_mcu7t5v0__filltie
XTAP_1641 vdd vss gf180mcu_fd_sc_mcu7t5v0__filltie
XTAP_1685 vdd vss gf180mcu_fd_sc_mcu7t5v0__filltie
XTAP_1674 vdd vss gf180mcu_fd_sc_mcu7t5v0__filltie
XTAP_1652 vdd vss gf180mcu_fd_sc_mcu7t5v0__filltie
XTAP_1663 vdd vss gf180mcu_fd_sc_mcu7t5v0__filltie
XTAP_1696 vdd vss gf180mcu_fd_sc_mcu7t5v0__filltie
X_04981_ _09831_/Q _08978_/B2 vdd vdd vss vss gf180mcu_fd_sc_mcu7t5v0__clkinv_1
X_06720_ _09710_/Q _06719_/I _06760_/A2 vdd vdd vss vss gf180mcu_fd_sc_mcu7t5v0__nand2_1
X_06651_ _09408_/A1 _06652_/A2 _06652_/B1 _06651_/B2 _09611_/D vdd vdd
+ vss vss gf180mcu_fd_sc_mcu7t5v0__oai22_1
X_05602_ _08736_/A2 _05602_/A2 _05602_/B1 _05631_/B2 _09002_/A2 _05602_/C2 _05604_/A2
+ vdd vdd vss vss gf180mcu_fd_sc_mcu7t5v0__aoi222_1
X_06582_ _06439_/B _06613_/A2 _06583_/A2 vdd vdd vss vss gf180mcu_fd_sc_mcu7t5v0__nand2_1
X_09370_ _10005_/Q _09377_/A2 _09371_/B vdd vdd vss vss gf180mcu_fd_sc_mcu7t5v0__nor2_1
X_05533_ _05533_/A1 _05533_/A2 _05537_/A2 vdd vdd vss vss gf180mcu_fd_sc_mcu7t5v0__nand2_1
X_08321_ _09716_/Q _08354_/A2 _08321_/B _08322_/A4 vdd vdd vss vss
+ gf180mcu_fd_sc_mcu7t5v0__oai21_1
X_08252_ _08252_/A1 _08250_/Z _08252_/Z vdd vdd vss vss gf180mcu_fd_sc_mcu7t5v0__xor2_2
X_05464_ _09853_/Q _05627_/A2 _05627_/B1 _09586_/Q _05466_/A1 vdd vdd
+ vss vss gf180mcu_fd_sc_mcu7t5v0__aoi22_1
X_07203_ _07204_/A2 _07204_/A3 _07255_/A2 vdd vdd vss vss gf180mcu_fd_sc_mcu7t5v0__nand2_1
X_05395_ _09405_/A1 _05399_/A2 _05399_/B1 _05395_/B2 _09545_/D vdd vdd
+ vss vss gf180mcu_fd_sc_mcu7t5v0__oai22_1
X_08183_ _08177_/Z _08235_/A2 _08235_/B _08257_/A1 vdd vdd vss vss
+ gf180mcu_fd_sc_mcu7t5v0__oai21_1
X_07134_ _09714_/Q _07106_/Z _07136_/A2 vdd vdd vss vss gf180mcu_fd_sc_mcu7t5v0__nand2_1
X_07065_ _09574_/Q _09650_/Q _09684_/Q _09616_/Q _09638_/Q _09637_/Q _07065_/Z vdd
+ vdd vss vss gf180mcu_fd_sc_mcu7t5v0__mux4_4
X_06016_ _06016_/I _06032_/A3 vdd vdd vss vss gf180mcu_fd_sc_mcu7t5v0__clkinv_1
X_07967_ _07911_/Z _07967_/A2 _07967_/B _08009_/A2 vdd vdd vss vss
+ gf180mcu_fd_sc_mcu7t5v0__oai21_1
X_09706_ _09706_/D clk _09706_/Q vdd vdd vss vss gf180mcu_fd_sc_mcu7t5v0__dffq_2
X_06918_ _09716_/Q _06672_/B _06955_/A1 _06919_/A2 _06918_/C _06919_/B vdd vdd
+ vss vss gf180mcu_fd_sc_mcu7t5v0__aoi221_1
X_07898_ _07926_/B2 _07896_/Z _07898_/Z vdd vdd vss vss gf180mcu_fd_sc_mcu7t5v0__xor2_1
X_06849_ _06838_/Z _06848_/Z _06902_/A1 vdd vdd vss vss gf180mcu_fd_sc_mcu7t5v0__nand2_1
X_09637_ _09637_/D clk _09637_/Q vdd vdd vss vss gf180mcu_fd_sc_mcu7t5v0__dffq_4
X_09568_ _09568_/D clk _09568_/Q vdd vdd vss vss gf180mcu_fd_sc_mcu7t5v0__dffq_4
X_08519_ _08667_/C _08515_/Z _08519_/B _08520_/A2 vdd vdd vss vss
+ gf180mcu_fd_sc_mcu7t5v0__aoi21_1
X_09499_ _09499_/D clk _09499_/Q vdd vdd vss vss gf180mcu_fd_sc_mcu7t5v0__dffq_1
XTAP_1460 vdd vss gf180mcu_fd_sc_mcu7t5v0__filltie
XTAP_1471 vdd vss gf180mcu_fd_sc_mcu7t5v0__filltie
XTAP_1482 vdd vss gf180mcu_fd_sc_mcu7t5v0__filltie
XTAP_1493 vdd vss gf180mcu_fd_sc_mcu7t5v0__filltie
X_05180_ _09928_/Q _05180_/A2 _05180_/A3 _05180_/A4 _05193_/A1 vdd vdd
+ vss vss gf180mcu_fd_sc_mcu7t5v0__nand4_1
X_08870_ _08899_/A2 _08870_/A2 _08870_/B _09785_/D vdd vdd vss vss
+ gf180mcu_fd_sc_mcu7t5v0__aoi21_1
X_07821_ _09714_/Q _07681_/Z _07824_/A3 vdd vdd vss vss gf180mcu_fd_sc_mcu7t5v0__nand2_1
X_07752_ _07820_/A1 _07744_/Z _07753_/A3 _07820_/A2 vdd vdd vss vss
+ gf180mcu_fd_sc_mcu7t5v0__nor3_2
X_04964_ _09509_/Q _05355_/B2 vdd vdd vss vss gf180mcu_fd_sc_mcu7t5v0__clkinv_1
X_04895_ _09475_/Q _05311_/B2 vdd vdd vss vss gf180mcu_fd_sc_mcu7t5v0__clkinv_1
X_07683_ _08291_/B _07761_/A1 _07698_/B vdd vdd vss vss gf180mcu_fd_sc_mcu7t5v0__nor2_2
X_06703_ _06669_/I _06706_/A2 _06703_/B _06781_/C _06704_/B vdd vdd vss
+ vss gf180mcu_fd_sc_mcu7t5v0__aoi211_1
X_06634_ _06634_/A1 _09073_/A2 _06634_/B _09600_/D vdd vdd vss vss
+ gf180mcu_fd_sc_mcu7t5v0__aoi21_1
X_09422_ _09422_/D clk _09422_/Q vdd vdd vss vss gf180mcu_fd_sc_mcu7t5v0__dffq_1
X_09353_ _09397_/A1 _09355_/A2 _09353_/B _09399_/C _09997_/D vdd vdd vss
+ vss gf180mcu_fd_sc_mcu7t5v0__aoi211_1
X_06565_ _06566_/A1 _06566_/A2 _06599_/A1 vdd vdd vss vss gf180mcu_fd_sc_mcu7t5v0__nand2_1
X_08304_ _08304_/A1 _08304_/A2 _08306_/B vdd vdd vss vss gf180mcu_fd_sc_mcu7t5v0__xor2_1
X_06496_ _07474_/A1 _08565_/C _06496_/B1 _06496_/B2 _08670_/B _09596_/D vdd
+ vdd vss vss gf180mcu_fd_sc_mcu7t5v0__aoi221_1
X_05516_ _05632_/C2 _05516_/A2 _05516_/B1 _09105_/A2 _05516_/C1 _09012_/A1 _05517_/A3
+ vdd vdd vss vss gf180mcu_fd_sc_mcu7t5v0__aoi222_1
X_09284_ _09397_/A1 _09286_/A2 _09284_/B _09399_/C _09967_/D vdd vdd vss
+ vss gf180mcu_fd_sc_mcu7t5v0__aoi211_1
X_08235_ _08177_/Z _08235_/A2 _08235_/B _09712_/Q _08286_/A2 vdd vdd vss
+ vss gf180mcu_fd_sc_mcu7t5v0__oai211_2
X_05447_ _09640_/Q _05627_/A2 _05627_/B1 _09695_/Q _05449_/A1 vdd vdd
+ vss vss gf180mcu_fd_sc_mcu7t5v0__aoi22_1
X_05378_ _09408_/A1 _05379_/A2 _05379_/B1 _05378_/B2 _09532_/D vdd vdd
+ vss vss gf180mcu_fd_sc_mcu7t5v0__oai22_1
X_08166_ _08358_/I0 _08286_/A1 _08166_/B1 _08166_/B2 _08166_/C _08167_/B vdd
+ vdd vss vss gf180mcu_fd_sc_mcu7t5v0__oai221_2
X_07117_ _07062_/Z _07116_/Z _07117_/Z vdd vdd vss vss gf180mcu_fd_sc_mcu7t5v0__xor2_1
X_08097_ _09710_/Q _08283_/A2 _08283_/A3 _08099_/A3 vdd vdd vss vss
+ gf180mcu_fd_sc_mcu7t5v0__nand3_2
X_07048_ _09712_/Q _07046_/Z _07079_/A2 vdd vdd vss vss gf180mcu_fd_sc_mcu7t5v0__nor2_1
X_08999_ _09407_/A1 _09001_/A2 _09001_/B1 _08999_/B2 _09848_/D vdd vdd
+ vss vss gf180mcu_fd_sc_mcu7t5v0__oai22_1
XTAP_507 vdd vss gf180mcu_fd_sc_mcu7t5v0__filltie
XTAP_518 vdd vss gf180mcu_fd_sc_mcu7t5v0__filltie
XTAP_529 vdd vss gf180mcu_fd_sc_mcu7t5v0__filltie
X_06350_ _09710_/Q _06608_/A2 _06350_/B _06350_/C _06353_/C vdd vdd vss
+ vss gf180mcu_fd_sc_mcu7t5v0__oai211_1
XTAP_1290 vdd vss gf180mcu_fd_sc_mcu7t5v0__filltie
X_05301_ _09404_/A1 _05306_/A2 _05306_/B1 _05301_/B2 _09452_/D vdd vdd
+ vss vss gf180mcu_fd_sc_mcu7t5v0__oai22_1
X_06281_ _09633_/Q _06313_/A1 _09565_/Q _05985_/Z _06282_/B2 vdd vdd vss
+ vss gf180mcu_fd_sc_mcu7t5v0__aoi22_2
X_08020_ _08020_/A1 _09104_/A2 _08020_/B _09677_/D vdd vdd vss vss
+ gf180mcu_fd_sc_mcu7t5v0__aoi21_1
X_05232_ _09397_/A1 _05217_/S _05233_/B vdd vdd vss vss gf180mcu_fd_sc_mcu7t5v0__nor2_1
X_05163_ _05161_/Z _05163_/A2 _05163_/B _09732_/D vdd vdd vss vss
+ gf180mcu_fd_sc_mcu7t5v0__oai21_1
X_05094_ _09497_/Q _05339_/B2 vdd vdd vss vss gf180mcu_fd_sc_mcu7t5v0__clkinv_1
X_09971_ _09971_/D clk _09971_/Q vdd vdd vss vss gf180mcu_fd_sc_mcu7t5v0__dffq_1
X_08922_ _09406_/A1 _08925_/A2 _08925_/B1 _08922_/B2 _09807_/D vdd vdd
+ vss vss gf180mcu_fd_sc_mcu7t5v0__oai22_1
X_08853_ _09399_/C _09779_/Q _09780_/D vdd vdd vss vss gf180mcu_fd_sc_mcu7t5v0__or2_1
X_07804_ _07788_/Z _07804_/A2 _07804_/Z vdd vdd vss vss gf180mcu_fd_sc_mcu7t5v0__xor2_1
X_08784_ _08784_/A1 _08851_/A1 _08784_/B _09754_/D vdd vdd vss vss
+ gf180mcu_fd_sc_mcu7t5v0__aoi21_1
X_05996_ _09710_/Q _06309_/A1 _05996_/B _06006_/A1 vdd vdd vss vss
+ gf180mcu_fd_sc_mcu7t5v0__oai21_1
X_04947_ _10022_/Q _09405_/B2 vdd vdd vss vss gf180mcu_fd_sc_mcu7t5v0__clkinv_1
X_07735_ _09668_/Q _07698_/B _07734_/B _07735_/Z vdd vdd vss vss gf180mcu_fd_sc_mcu7t5v0__and3_1
X_09405_ _09405_/A1 _09409_/A2 _09409_/B1 _09405_/B2 _10022_/D vdd vdd
+ vss vss gf180mcu_fd_sc_mcu7t5v0__oai22_1
X_04878_ _09851_/Q _09004_/B2 vdd vdd vss vss gf180mcu_fd_sc_mcu7t5v0__clkinv_1
X_07666_ _07472_/B _09073_/A2 _07666_/B _09659_/D vdd vdd vss vss
+ gf180mcu_fd_sc_mcu7t5v0__aoi21_1
X_06617_ _06617_/A1 _06617_/A2 _06617_/B _06618_/I0 vdd vdd vss vss
+ gf180mcu_fd_sc_mcu7t5v0__oai21_1
X_07597_ _07598_/A2 _07596_/B _07617_/A2 vdd vdd vss vss gf180mcu_fd_sc_mcu7t5v0__xnor2_1
X_09336_ _09391_/A1 _09344_/A2 _09336_/B _09399_/C _09989_/D vdd vdd vss
+ vss gf180mcu_fd_sc_mcu7t5v0__aoi211_1
X_06548_ _06387_/B _06640_/A1 _06548_/A3 _06548_/B _06626_/A2 vdd vdd
+ vss vss gf180mcu_fd_sc_mcu7t5v0__oai31_4
X_09267_ _09960_/Q _09274_/A2 _09268_/B vdd vdd vss vss gf180mcu_fd_sc_mcu7t5v0__nor2_1
X_06479_ _06450_/C _06478_/Z _06496_/B1 vdd vdd vss vss gf180mcu_fd_sc_mcu7t5v0__nand2_1
X_08218_ _08167_/C _08218_/A2 _08706_/B _08219_/B vdd vdd vss vss
+ gf180mcu_fd_sc_mcu7t5v0__oai21_1
X_09198_ _09198_/I _09199_/B1 vdd vdd vss vss gf180mcu_fd_sc_mcu7t5v0__clkinv_1
X_08149_ _08172_/A1 _08101_/I _08146_/Z _08149_/Z vdd vdd vss vss
+ gf180mcu_fd_sc_mcu7t5v0__xor3_1
XTAP_315 vdd vss gf180mcu_fd_sc_mcu7t5v0__filltie
XTAP_304 vdd vss gf180mcu_fd_sc_mcu7t5v0__filltie
XTAP_348 vdd vss gf180mcu_fd_sc_mcu7t5v0__filltie
XTAP_337 vdd vss gf180mcu_fd_sc_mcu7t5v0__filltie
XTAP_326 vdd vss gf180mcu_fd_sc_mcu7t5v0__filltie
XTAP_359 vdd vss gf180mcu_fd_sc_mcu7t5v0__filltie
X_05850_ _05851_/A1 _05849_/Z _05882_/A1 vdd vdd vss vss gf180mcu_fd_sc_mcu7t5v0__nand2_1
X_04801_ _09636_/Q _07298_/A1 vdd vdd vss vss gf180mcu_fd_sc_mcu7t5v0__clkinv_2
X_05781_ _07506_/B _05645_/I _05781_/Z vdd vdd vss vss gf180mcu_fd_sc_mcu7t5v0__or2_1
X_07520_ _09714_/Q _07349_/Z _07522_/B vdd vdd vss vss gf180mcu_fd_sc_mcu7t5v0__nand2_1
X_04732_ _09793_/Q _05114_/A1 vdd vdd vss vss gf180mcu_fd_sc_mcu7t5v0__clkinv_1
X_07451_ _07653_/A1 _07439_/Z _07459_/A1 vdd vdd vss vss gf180mcu_fd_sc_mcu7t5v0__nand2_1
X_06402_ _06608_/A2 _06562_/A2 _06439_/B _06405_/A3 vdd vdd vss vss
+ gf180mcu_fd_sc_mcu7t5v0__oai21_1
X_07382_ _09658_/Q _09594_/Q _07384_/A2 vdd vdd vss vss gf180mcu_fd_sc_mcu7t5v0__nor2_1
X_09121_ _09121_/A1 _09136_/A2 _09121_/B1 _09121_/B2 _09399_/C _09908_/D vdd
+ vdd vss vss gf180mcu_fd_sc_mcu7t5v0__aoi221_1
X_06333_ _09601_/Q _06634_/A1 _06348_/A2 vdd vdd vss vss gf180mcu_fd_sc_mcu7t5v0__nand2_1
X_06264_ _06264_/A1 _06264_/A2 _08670_/B _09577_/D vdd vdd vss vss
+ gf180mcu_fd_sc_mcu7t5v0__aoi21_1
X_09052_ _09556_/Q _09033_/I _09054_/A1 vdd vdd vss vss gf180mcu_fd_sc_mcu7t5v0__nand2_1
X_06195_ _06195_/A1 _06195_/A2 _06251_/B vdd vdd vss vss gf180mcu_fd_sc_mcu7t5v0__nand2_1
X_08003_ _09717_/Q _08003_/A2 _08011_/A2 vdd vdd vss vss gf180mcu_fd_sc_mcu7t5v0__nand2_1
X_05215_ _09909_/Q _09892_/Q _05217_/S _05216_/I vdd vdd vss vss gf180mcu_fd_sc_mcu7t5v0__mux2_4
X_05146_ _09775_/Q _09774_/Q _09777_/Q _09776_/Q _05148_/A1 vdd vdd vss
+ vss gf180mcu_fd_sc_mcu7t5v0__nor4_1
X_09954_ _09954_/D clk _09954_/Q vdd vdd vss vss gf180mcu_fd_sc_mcu7t5v0__dffq_1
X_05077_ _09834_/Q _08981_/B2 vdd vdd vss vss gf180mcu_fd_sc_mcu7t5v0__clkinv_1
XTAP_871 vdd vss gf180mcu_fd_sc_mcu7t5v0__filltie
XTAP_860 vdd vss gf180mcu_fd_sc_mcu7t5v0__filltie
X_08905_ _09401_/A1 _08913_/A2 _08913_/B1 vdd vdd vss vss gf180mcu_fd_sc_mcu7t5v0__nand2_2
X_09885_ _09885_/D clk _09885_/Q vdd vdd vss vss gf180mcu_fd_sc_mcu7t5v0__dffq_1
XTAP_882 vdd vss gf180mcu_fd_sc_mcu7t5v0__filltie
XTAP_893 vdd vss gf180mcu_fd_sc_mcu7t5v0__filltie
X_08836_ _09773_/Q _08832_/Z _08845_/B _08837_/A2 vdd vdd vss vss
+ gf180mcu_fd_sc_mcu7t5v0__oai21_1
X_05979_ _06307_/A1 _09579_/Q _05998_/A2 vdd vdd vss vss gf180mcu_fd_sc_mcu7t5v0__nor2_2
X_08767_ _09747_/Q _08782_/A2 _09226_/B _08768_/B vdd vdd vss vss
+ gf180mcu_fd_sc_mcu7t5v0__oai21_1
X_07718_ _09711_/Q _07717_/Z _07718_/Z vdd vdd vss vss gf180mcu_fd_sc_mcu7t5v0__and2_1
X_08698_ _08696_/Z _08698_/A2 _08704_/A1 vdd vdd vss vss gf180mcu_fd_sc_mcu7t5v0__nand2_1
X_07649_ _07649_/A1 _07649_/A2 _07653_/B2 vdd vdd vss vss gf180mcu_fd_sc_mcu7t5v0__nor2_1
X_09319_ _09982_/Q _09322_/A2 _09320_/B vdd vdd vss vss gf180mcu_fd_sc_mcu7t5v0__nor2_1
X_10025_ _10025_/D clk _10025_/Q vdd vdd vss vss gf180mcu_fd_sc_mcu7t5v0__dffq_1
XPHY_170 vdd vss gf180mcu_fd_sc_mcu7t5v0__endcap
XPHY_181 vdd vss gf180mcu_fd_sc_mcu7t5v0__endcap
XPHY_192 vdd vss gf180mcu_fd_sc_mcu7t5v0__endcap
X_05000_ _09698_/Q _08382_/B2 vdd vdd vss vss gf180mcu_fd_sc_mcu7t5v0__clkinv_1
X_06951_ _06949_/Z _06957_/A2 _06951_/Z vdd vdd vss vss gf180mcu_fd_sc_mcu7t5v0__and2_1
X_09670_ _09670_/D clk _09670_/Q vdd vdd vss vss gf180mcu_fd_sc_mcu7t5v0__dffq_1
X_05902_ _05903_/A1 _05903_/A2 _05902_/Z vdd vdd vss vss gf180mcu_fd_sc_mcu7t5v0__or2_1
X_08621_ _08621_/A1 _08621_/A2 _08621_/B _08623_/B vdd vdd vss vss
+ gf180mcu_fd_sc_mcu7t5v0__oai21_1
X_06882_ _06882_/A1 _06882_/A2 _06882_/B _06884_/A2 vdd vdd vss vss
+ gf180mcu_fd_sc_mcu7t5v0__aoi21_1
X_05833_ _05833_/A1 _05831_/Z _05834_/I vdd vdd vss vss gf180mcu_fd_sc_mcu7t5v0__xor2_1
X_05764_ _05940_/A2 _05689_/B _05711_/I _05922_/B _05765_/A2 vdd vdd vss
+ vss gf180mcu_fd_sc_mcu7t5v0__oai31_1
X_08552_ _08685_/A2 _08688_/A2 _08678_/A2 _08677_/A2 _08552_/Z vdd vdd
+ vss vss gf180mcu_fd_sc_mcu7t5v0__or4_1
X_08483_ _08483_/A1 _08389_/Z _08483_/B _08677_/A2 vdd vdd vss vss
+ gf180mcu_fd_sc_mcu7t5v0__oai21_4
X_07503_ _07503_/A1 _07503_/A2 _07503_/B _07553_/A2 vdd vdd vss vss
+ gf180mcu_fd_sc_mcu7t5v0__oai21_1
X_04715_ _09470_/Q _09228_/A2 vdd vdd vss vss gf180mcu_fd_sc_mcu7t5v0__clkinv_3
X_07434_ _07516_/A1 _07434_/A2 _07435_/A3 _07516_/A2 vdd vdd vss vss
+ gf180mcu_fd_sc_mcu7t5v0__nor3_1
X_05695_ _05930_/B2 _05709_/B _05930_/C _05696_/B vdd vdd vss vss
+ gf180mcu_fd_sc_mcu7t5v0__aoi21_1
X_07365_ _07366_/A1 _07366_/A2 _07365_/Z vdd vdd vss vss gf180mcu_fd_sc_mcu7t5v0__or2_1
X_06316_ _09402_/A1 _06323_/A2 _06323_/B1 _06316_/B2 _09584_/D vdd vdd
+ vss vss gf180mcu_fd_sc_mcu7t5v0__oai22_1
X_07296_ _07296_/A1 _09073_/A2 _07296_/B _09635_/D vdd vdd vss vss
+ gf180mcu_fd_sc_mcu7t5v0__aoi21_1
X_09104_ _09104_/A1 _09104_/A2 _09399_/C _09899_/D vdd vdd vss vss
+ gf180mcu_fd_sc_mcu7t5v0__aoi21_1
X_06247_ _09577_/Q _06246_/Z _06265_/B vdd vdd vss vss gf180mcu_fd_sc_mcu7t5v0__and2_1
X_09035_ _09875_/Q _09103_/A2 _09036_/A2 vdd vdd vss vss gf180mcu_fd_sc_mcu7t5v0__nand2_1
X_06178_ _09888_/Q _09631_/Q _09597_/Q _09563_/Q _09582_/Q _09583_/Q _06178_/Z vdd
+ vdd vss vss gf180mcu_fd_sc_mcu7t5v0__mux4_4
X_05129_ _09524_/Q _08926_/B _05130_/B vdd vdd vss vss gf180mcu_fd_sc_mcu7t5v0__nand2_1
X_09937_ _09937_/D clk _09937_/Q vdd vdd vss vss gf180mcu_fd_sc_mcu7t5v0__dffq_1
XTAP_690 vdd vss gf180mcu_fd_sc_mcu7t5v0__filltie
X_09868_ _09868_/D clk _09868_/Q vdd vdd vss vss gf180mcu_fd_sc_mcu7t5v0__dffq_1
X_09799_ _09799_/D clk _09799_/Q vdd vdd vss vss gf180mcu_fd_sc_mcu7t5v0__dffq_1
X_08819_ _09767_/Q _08819_/A2 _09768_/Q _08820_/A3 vdd vdd vss vss
+ gf180mcu_fd_sc_mcu7t5v0__aoi21_1
XTAP_1834 vdd vss gf180mcu_fd_sc_mcu7t5v0__filltie
XTAP_1823 vdd vss gf180mcu_fd_sc_mcu7t5v0__filltie
XTAP_1801 vdd vss gf180mcu_fd_sc_mcu7t5v0__filltie
XTAP_1812 vdd vss gf180mcu_fd_sc_mcu7t5v0__filltie
XTAP_1856 vdd vss gf180mcu_fd_sc_mcu7t5v0__filltie
XTAP_1867 vdd vss gf180mcu_fd_sc_mcu7t5v0__filltie
XTAP_1845 vdd vss gf180mcu_fd_sc_mcu7t5v0__filltie
XTAP_1889 vdd vss gf180mcu_fd_sc_mcu7t5v0__filltie
XTAP_1878 vdd vss gf180mcu_fd_sc_mcu7t5v0__filltie
X_10008_ _10008_/D clk _10008_/Q vdd vdd vss vss gf180mcu_fd_sc_mcu7t5v0__dffq_1
X_05480_ _09484_/Q _05628_/A2 _05628_/B1 _09500_/Q _05481_/A2 vdd vdd
+ vss vss gf180mcu_fd_sc_mcu7t5v0__aoi22_1
X_07150_ _07152_/A2 _07152_/A3 _07197_/B vdd vdd vss vss gf180mcu_fd_sc_mcu7t5v0__nor2_1
X_06101_ _06101_/A1 _06016_/I _06101_/A3 _06146_/A2 vdd vdd vss vss
+ gf180mcu_fd_sc_mcu7t5v0__nand3_1
X_07081_ _07001_/Z _07081_/A2 _07126_/B vdd vdd vss vss gf180mcu_fd_sc_mcu7t5v0__nor2_1
X_06032_ _09711_/Q _06005_/B _06032_/A3 _06036_/A2 vdd vdd vss vss
+ gf180mcu_fd_sc_mcu7t5v0__nand3_1
X_07983_ _08002_/A2 _08002_/A3 _08003_/A2 vdd vdd vss vss gf180mcu_fd_sc_mcu7t5v0__nand2_1
X_09722_ _09722_/D clk _09722_/Q vdd vdd vss vss gf180mcu_fd_sc_mcu7t5v0__dffq_4
X_06934_ _06939_/A2 _06934_/A2 _06933_/Z _06934_/Z vdd vdd vss vss
+ gf180mcu_fd_sc_mcu7t5v0__xor3_1
X_06865_ _08721_/A1 _06865_/A2 _06867_/B vdd vdd vss vss gf180mcu_fd_sc_mcu7t5v0__xor2_1
X_09653_ _09653_/D clk _09653_/Q vdd vdd vss vss gf180mcu_fd_sc_mcu7t5v0__dffq_1
X_09584_ _09584_/D clk _09584_/Q vdd vdd vss vss gf180mcu_fd_sc_mcu7t5v0__dffq_1
X_08604_ _08555_/Z _08605_/A2 _08604_/B _08657_/A2 vdd vdd vss vss
+ gf180mcu_fd_sc_mcu7t5v0__oai21_1
X_05816_ _09714_/Q _05816_/A2 _05816_/Z vdd vdd vss vss gf180mcu_fd_sc_mcu7t5v0__xor2_1
X_08535_ _08535_/A1 _08535_/A2 _08535_/A3 _08535_/Z vdd vdd vss vss
+ gf180mcu_fd_sc_mcu7t5v0__xor3_1
XTAP_1108 vdd vss gf180mcu_fd_sc_mcu7t5v0__filltie
XTAP_1119 vdd vss gf180mcu_fd_sc_mcu7t5v0__filltie
X_06796_ _06796_/A1 _06844_/A1 _06834_/B vdd vdd vss vss gf180mcu_fd_sc_mcu7t5v0__nor2_1
X_05747_ _09065_/A1 _05978_/A1 _05976_/A1 _05839_/B vdd vdd vss vss
+ gf180mcu_fd_sc_mcu7t5v0__nand3_4
X_05678_ _08291_/B _05645_/I _05709_/B _05716_/A1 vdd vdd vss vss
+ gf180mcu_fd_sc_mcu7t5v0__nor3_2
X_08466_ _08466_/A1 _08431_/Z _08466_/B _08481_/A1 vdd vdd vss vss
+ gf180mcu_fd_sc_mcu7t5v0__aoi21_1
X_08397_ _09719_/Q _08727_/A1 _08412_/A2 vdd vdd vss vss gf180mcu_fd_sc_mcu7t5v0__nand2_2
X_07417_ _07452_/C _07417_/A2 _07417_/A3 _07516_/A1 vdd vdd vss vss
+ gf180mcu_fd_sc_mcu7t5v0__nor3_4
X_07348_ _07664_/A1 _07348_/A2 _07348_/B1 _09659_/Q _07364_/A3 vdd vdd
+ vss vss gf180mcu_fd_sc_mcu7t5v0__oai22_4
X_07279_ _07240_/Z _07242_/Z _07279_/Z vdd vdd vss vss gf180mcu_fd_sc_mcu7t5v0__or2_1
X_09018_ _09406_/A1 _09021_/A2 _09021_/B1 _09018_/B2 _09863_/D vdd vdd
+ vss vss gf180mcu_fd_sc_mcu7t5v0__oai22_1
XTAP_1620 vdd vss gf180mcu_fd_sc_mcu7t5v0__filltie
XTAP_1631 vdd vss gf180mcu_fd_sc_mcu7t5v0__filltie
XTAP_1642 vdd vss gf180mcu_fd_sc_mcu7t5v0__filltie
XTAP_1675 vdd vss gf180mcu_fd_sc_mcu7t5v0__filltie
XTAP_1653 vdd vss gf180mcu_fd_sc_mcu7t5v0__filltie
XTAP_1664 vdd vss gf180mcu_fd_sc_mcu7t5v0__filltie
XTAP_1697 vdd vss gf180mcu_fd_sc_mcu7t5v0__filltie
XTAP_1686 vdd vss gf180mcu_fd_sc_mcu7t5v0__filltie
X_04980_ _09807_/Q _08922_/B2 vdd vdd vss vss gf180mcu_fd_sc_mcu7t5v0__clkinv_1
X_06650_ _09407_/A1 _06652_/A2 _06652_/B1 _06650_/B2 _09610_/D vdd vdd
+ vss vss gf180mcu_fd_sc_mcu7t5v0__oai22_1
X_05601_ _09400_/A2 _05601_/A2 _05601_/B1 _05631_/C1 _05604_/A1 vdd vdd
+ vss vss gf180mcu_fd_sc_mcu7t5v0__aoi22_1
X_06581_ _09715_/Q _06531_/Z _06581_/B _06624_/A1 vdd vdd vss vss
+ gf180mcu_fd_sc_mcu7t5v0__aoi21_1
X_05532_ _09546_/Q _05628_/A2 _05628_/B1 _09863_/Q _05533_/A2 vdd vdd
+ vss vss gf180mcu_fd_sc_mcu7t5v0__aoi22_1
X_08320_ _08358_/I0 _08320_/A2 _08320_/B _08321_/B vdd vdd vss vss
+ gf180mcu_fd_sc_mcu7t5v0__oai21_1
X_08251_ _08252_/A1 _08250_/Z _08251_/Z vdd vdd vss vss gf180mcu_fd_sc_mcu7t5v0__and2_1
X_05463_ _05463_/A1 _05463_/A2 _05485_/A2 vdd vdd vss vss gf180mcu_fd_sc_mcu7t5v0__nand2_1
X_07202_ _07204_/A2 _07204_/A3 _07255_/B vdd vdd vss vss gf180mcu_fd_sc_mcu7t5v0__nor2_1
X_05394_ _09404_/A1 _05399_/A2 _05399_/B1 _05394_/B2 _09544_/D vdd vdd
+ vss vss gf180mcu_fd_sc_mcu7t5v0__oai22_1
X_08182_ _08182_/A1 _08331_/B1 _08182_/B1 _08182_/B2 _08284_/A2 vdd vdd
+ vss vss gf180mcu_fd_sc_mcu7t5v0__aoi22_4
X_07133_ _07184_/A2 _07133_/A2 _07133_/Z vdd vdd vss vss gf180mcu_fd_sc_mcu7t5v0__or2_1
X_07064_ _09711_/Q _07033_/Z _07069_/A1 vdd vdd vss vss gf180mcu_fd_sc_mcu7t5v0__nand2_1
X_06015_ _06012_/Z _06013_/Z _06015_/A3 _06231_/B1 _09884_/Q _06016_/I vdd vdd
+ vss vss gf180mcu_fd_sc_mcu7t5v0__oai32_4
X_07966_ _07911_/Z _07967_/A2 _07967_/B _07966_/Z vdd vdd vss vss
+ gf180mcu_fd_sc_mcu7t5v0__or3_1
X_09705_ _09705_/D clk _09705_/Q vdd vdd vss vss gf180mcu_fd_sc_mcu7t5v0__dffq_2
X_06917_ _09716_/Q _06890_/Z _06919_/A2 vdd vdd vss vss gf180mcu_fd_sc_mcu7t5v0__nand2_1
X_07897_ _07837_/I _07878_/Z _07897_/A3 _07926_/B1 vdd vdd vss vss
+ gf180mcu_fd_sc_mcu7t5v0__xnor3_1
X_09636_ _09636_/D clk _09636_/Q vdd vdd vss vss gf180mcu_fd_sc_mcu7t5v0__dffq_2
X_06848_ _06928_/A1 _06928_/A2 _06848_/Z vdd vdd vss vss gf180mcu_fd_sc_mcu7t5v0__xor2_1
X_06779_ _09713_/Q _06956_/A2 _06780_/C vdd vdd vss vss gf180mcu_fd_sc_mcu7t5v0__nand2_1
X_09567_ _09567_/D clk _09567_/Q vdd vdd vss vss gf180mcu_fd_sc_mcu7t5v0__dffq_2
X_09498_ _09498_/D clk _09498_/Q vdd vdd vss vss gf180mcu_fd_sc_mcu7t5v0__dffq_1
X_08518_ _08432_/B _08489_/Z _08518_/B _08519_/B vdd vdd vss vss gf180mcu_fd_sc_mcu7t5v0__aoi21_1
X_08449_ _08706_/B _08449_/A2 _08449_/B _09703_/D vdd vdd vss vss
+ gf180mcu_fd_sc_mcu7t5v0__aoi21_1
XTAP_1450 vdd vss gf180mcu_fd_sc_mcu7t5v0__filltie
XTAP_1461 vdd vss gf180mcu_fd_sc_mcu7t5v0__filltie
XTAP_1472 vdd vss gf180mcu_fd_sc_mcu7t5v0__filltie
XTAP_1483 vdd vss gf180mcu_fd_sc_mcu7t5v0__filltie
XTAP_1494 vdd vss gf180mcu_fd_sc_mcu7t5v0__filltie
X_07820_ _07820_/A1 _07820_/A2 _07820_/B _07869_/A1 vdd vdd vss vss
+ gf180mcu_fd_sc_mcu7t5v0__oai21_2
X_07751_ _09710_/Q _07749_/Z _07753_/A3 vdd vdd vss vss gf180mcu_fd_sc_mcu7t5v0__nand2_1
X_04963_ _09501_/Q _05345_/B2 vdd vdd vss vss gf180mcu_fd_sc_mcu7t5v0__clkinv_1
X_06702_ _06702_/A1 _06702_/A2 _06706_/A2 vdd vdd vss vss gf180mcu_fd_sc_mcu7t5v0__xnor2_1
X_07682_ _07677_/Z _07741_/A3 _07761_/A1 vdd vdd vss vss gf180mcu_fd_sc_mcu7t5v0__nand2_1
X_04894_ _09451_/Q _05300_/B2 vdd vdd vss vss gf180mcu_fd_sc_mcu7t5v0__clkinv_1
X_09421_ _09421_/D clk _09421_/Q vdd vdd vss vss gf180mcu_fd_sc_mcu7t5v0__dffq_1
X_06633_ _10004_/Q _09073_/A2 _08734_/B _06634_/B vdd vdd vss vss
+ gf180mcu_fd_sc_mcu7t5v0__oai21_1
X_06564_ _06564_/A1 _06614_/B2 _06564_/A3 _06566_/A2 vdd vdd vss vss
+ gf180mcu_fd_sc_mcu7t5v0__xnor3_1
X_09352_ _09997_/Q _09355_/A2 _09353_/B vdd vdd vss vss gf180mcu_fd_sc_mcu7t5v0__nor2_1
X_08303_ _08304_/A1 _08304_/A2 _08326_/A1 vdd vdd vss vss gf180mcu_fd_sc_mcu7t5v0__nand2_1
X_05515_ _09002_/A2 _05515_/A2 _05515_/B1 _05631_/B2 _05631_/C1 _05515_/C2 _05517_/A2
+ vdd vdd vss vss gf180mcu_fd_sc_mcu7t5v0__aoi222_1
X_06495_ _06350_/C _06495_/A2 _08565_/C _06496_/B2 vdd vdd vss vss
+ gf180mcu_fd_sc_mcu7t5v0__aoi21_1
X_09283_ _09967_/Q _09286_/A2 _09284_/B vdd vdd vss vss gf180mcu_fd_sc_mcu7t5v0__nor2_1
X_05446_ _05446_/A1 _05446_/A2 _05457_/C1 vdd vdd vss vss gf180mcu_fd_sc_mcu7t5v0__nand2_1
X_08234_ _08133_/Z _08234_/A2 _08234_/B _09712_/Q _08341_/A1 vdd vdd vss
+ vss gf180mcu_fd_sc_mcu7t5v0__oai211_2
X_05377_ _09407_/A1 _05379_/A2 _05379_/B1 _05377_/B2 _09531_/D vdd vdd
+ vss vss gf180mcu_fd_sc_mcu7t5v0__oai22_1
X_08165_ _09713_/Q _08359_/A2 _08166_/C vdd vdd vss vss gf180mcu_fd_sc_mcu7t5v0__nand2_1
X_07116_ _07116_/A1 _07114_/I _07116_/Z vdd vdd vss vss gf180mcu_fd_sc_mcu7t5v0__xor2_1
X_08096_ _08283_/A2 _08283_/A3 _08096_/Z vdd vdd vss vss gf180mcu_fd_sc_mcu7t5v0__and2_2
X_07047_ _09712_/Q _07046_/Z _07079_/B vdd vdd vss vss gf180mcu_fd_sc_mcu7t5v0__nand2_1
X_08998_ _09406_/A1 _09001_/A2 _09001_/B1 _08998_/B2 _09847_/D vdd vdd
+ vss vss gf180mcu_fd_sc_mcu7t5v0__oai22_1
X_07949_ _07949_/A1 _07947_/Z _07949_/Z vdd vdd vss vss gf180mcu_fd_sc_mcu7t5v0__xor2_1
X_09619_ _09619_/D clk _09619_/Q vdd vdd vss vss gf180mcu_fd_sc_mcu7t5v0__dffq_2
XTAP_508 vdd vss gf180mcu_fd_sc_mcu7t5v0__filltie
XTAP_519 vdd vss gf180mcu_fd_sc_mcu7t5v0__filltie
XTAP_1280 vdd vss gf180mcu_fd_sc_mcu7t5v0__filltie
XTAP_1291 vdd vss gf180mcu_fd_sc_mcu7t5v0__filltie
X_05300_ _09403_/A1 _05306_/A2 _05306_/B1 _05300_/B2 _09451_/D vdd vdd
+ vss vss gf180mcu_fd_sc_mcu7t5v0__oai22_1
X_06280_ _09599_/Q _06313_/A1 _06280_/B _06282_/B1 vdd vdd vss vss
+ gf180mcu_fd_sc_mcu7t5v0__oai21_2
X_05231_ _05231_/A1 _05246_/A2 _09404_/A1 _05246_/B2 _09412_/D vdd vdd
+ vss vss gf180mcu_fd_sc_mcu7t5v0__oai22_1
X_05162_ _08806_/B _09733_/Q _05163_/A2 vdd vdd vss vss gf180mcu_fd_sc_mcu7t5v0__nand2_1
X_05093_ _09489_/Q _05329_/B2 vdd vdd vss vss gf180mcu_fd_sc_mcu7t5v0__clkinv_1
X_09970_ _09970_/D clk _09970_/Q vdd vdd vss vss gf180mcu_fd_sc_mcu7t5v0__dffq_1
X_08921_ _09405_/A1 _08925_/A2 _08925_/B1 _08921_/B2 _09806_/D vdd vdd
+ vss vss gf180mcu_fd_sc_mcu7t5v0__oai22_1
X_08852_ _09399_/C uart_rx _09779_/D vdd vdd vss vss gf180mcu_fd_sc_mcu7t5v0__or2_1
X_07803_ _07681_/Z _07712_/Z _07749_/Z _07803_/B _07804_/A2 vdd vdd vss
+ vss gf180mcu_fd_sc_mcu7t5v0__oai31_1
X_05995_ _09581_/Q _06298_/B _06259_/C vdd vdd vss vss gf180mcu_fd_sc_mcu7t5v0__nor2_2
X_08783_ _09746_/Q _08851_/A1 _09226_/B _08784_/B vdd vdd vss vss
+ gf180mcu_fd_sc_mcu7t5v0__oai21_1
X_07734_ _09668_/Q _07698_/B _07734_/B _07736_/A2 vdd vdd vss vss
+ gf180mcu_fd_sc_mcu7t5v0__aoi21_1
X_04946_ _09737_/Q _08750_/B2 vdd vdd vss vss gf180mcu_fd_sc_mcu7t5v0__clkinv_1
X_07665_ _09993_/Q _09073_/A2 _08734_/B _07666_/B vdd vdd vss vss
+ gf180mcu_fd_sc_mcu7t5v0__oai21_1
X_06616_ _06616_/A1 _06600_/Z _06615_/Z _06616_/Z vdd vdd vss vss
+ gf180mcu_fd_sc_mcu7t5v0__xor3_1
X_09404_ _09404_/A1 _09409_/A2 _09409_/B1 _09404_/B2 _10021_/D vdd vdd
+ vss vss gf180mcu_fd_sc_mcu7t5v0__oai22_1
X_04877_ _09418_/Q _05253_/B2 vdd vdd vss vss gf180mcu_fd_sc_mcu7t5v0__clkinv_1
X_07596_ _07596_/A1 _07542_/Z _07596_/B _07618_/A2 vdd vdd vss vss
+ gf180mcu_fd_sc_mcu7t5v0__oai21_1
X_09335_ _09989_/Q _09344_/A2 _09336_/B vdd vdd vss vss gf180mcu_fd_sc_mcu7t5v0__nor2_1
X_06547_ _09653_/Q _06605_/A2 _06605_/B1 _09889_/Q _06548_/B vdd vdd vss
+ vss gf180mcu_fd_sc_mcu7t5v0__aoi22_2
X_06478_ _07474_/A1 _06498_/A1 _06480_/A2 _06478_/Z vdd vdd vss vss
+ gf180mcu_fd_sc_mcu7t5v0__xor3_1
X_09266_ _09391_/A1 _09274_/A2 _09266_/B _09399_/C _09959_/D vdd vdd vss
+ vss gf180mcu_fd_sc_mcu7t5v0__aoi211_1
X_08217_ _08217_/A1 _08201_/Z _08217_/B1 _08217_/B2 _08217_/C _08218_/A2 vdd
+ vdd vss vss gf180mcu_fd_sc_mcu7t5v0__oai221_1
X_05429_ _05632_/C2 _05429_/A2 _09105_/A2 _05429_/B2 _05429_/C1 _09012_/A1 _05430_/A3
+ vdd vdd vss vss gf180mcu_fd_sc_mcu7t5v0__aoi222_2
X_09197_ _09790_/Q _09299_/A3 _09378_/A2 _09759_/Q _09198_/I vdd vdd vss
+ vss gf180mcu_fd_sc_mcu7t5v0__aoi22_1
X_08148_ _08172_/A1 _08146_/Z _08223_/B3 vdd vdd vss vss gf180mcu_fd_sc_mcu7t5v0__xnor2_1
X_08079_ _09682_/Q _08083_/B1 _08079_/Z vdd vdd vss vss gf180mcu_fd_sc_mcu7t5v0__xor2_1
XTAP_305 vdd vss gf180mcu_fd_sc_mcu7t5v0__filltie
XTAP_338 vdd vss gf180mcu_fd_sc_mcu7t5v0__filltie
XTAP_327 vdd vss gf180mcu_fd_sc_mcu7t5v0__filltie
XTAP_316 vdd vss gf180mcu_fd_sc_mcu7t5v0__filltie
XTAP_349 vdd vss gf180mcu_fd_sc_mcu7t5v0__filltie
X_05780_ _05708_/Z _05780_/A2 _05780_/B _05803_/A2 vdd vdd vss vss
+ gf180mcu_fd_sc_mcu7t5v0__aoi21_1
X_04800_ _09637_/Q _07300_/A1 vdd vdd vss vss gf180mcu_fd_sc_mcu7t5v0__inv_1
X_04731_ _09883_/Q _09059_/A1 vdd vdd vss vss gf180mcu_fd_sc_mcu7t5v0__clkinv_1
X_07450_ _07649_/A1 _07503_/A2 _07458_/A2 vdd vdd vss vss gf180mcu_fd_sc_mcu7t5v0__nor2_1
X_06401_ _06406_/A1 _06366_/Z _06407_/A1 vdd vdd vss vss gf180mcu_fd_sc_mcu7t5v0__nor2_1
X_07381_ _08463_/A1 _07472_/B _09658_/Q _07575_/A2 vdd vdd vss vss
+ gf180mcu_fd_sc_mcu7t5v0__nand3_2
X_06332_ _09600_/Q _06448_/A2 _06628_/B2 vdd vdd vss vss gf180mcu_fd_sc_mcu7t5v0__nor2_2
X_09120_ _09935_/Q _09116_/I _09121_/B1 vdd vdd vss vss gf180mcu_fd_sc_mcu7t5v0__nand2_1
X_09051_ _09051_/A1 _09051_/A2 _09399_/C _09880_/D vdd vdd vss vss
+ gf180mcu_fd_sc_mcu7t5v0__aoi21_1
X_06263_ _06072_/C _06249_/Z _06263_/B _08706_/B _06264_/A2 vdd vdd vss
+ vss gf180mcu_fd_sc_mcu7t5v0__oai211_1
X_08002_ _06623_/B _08002_/A2 _08002_/A3 _08012_/B2 vdd vdd vss vss
+ gf180mcu_fd_sc_mcu7t5v0__nand3_2
X_06194_ _06146_/B _06125_/Z _06195_/A2 vdd vdd vss vss gf180mcu_fd_sc_mcu7t5v0__nand2_1
X_05214_ _09089_/B _05214_/A2 _05276_/A1 vdd vdd vss vss gf180mcu_fd_sc_mcu7t5v0__nand2_4
X_05145_ _09399_/C _08897_/A2 _08858_/B _05145_/B _09525_/D vdd vdd vss
+ vss gf180mcu_fd_sc_mcu7t5v0__oai31_1
X_09953_ _09953_/D clk _09953_/Q vdd vdd vss vss gf180mcu_fd_sc_mcu7t5v0__dffq_1
X_05076_ _09810_/Q _08925_/B2 vdd vdd vss vss gf180mcu_fd_sc_mcu7t5v0__clkinv_1
XTAP_850 vdd vss gf180mcu_fd_sc_mcu7t5v0__filltie
XTAP_861 vdd vss gf180mcu_fd_sc_mcu7t5v0__filltie
X_08904_ _08972_/A1 _09105_/A2 _08913_/A2 vdd vdd vss vss gf180mcu_fd_sc_mcu7t5v0__nand2_4
X_09884_ _09884_/D clk _09884_/Q vdd vdd vss vss gf180mcu_fd_sc_mcu7t5v0__dffq_2
XTAP_872 vdd vss gf180mcu_fd_sc_mcu7t5v0__filltie
XTAP_883 vdd vss gf180mcu_fd_sc_mcu7t5v0__filltie
XTAP_894 vdd vss gf180mcu_fd_sc_mcu7t5v0__filltie
X_08835_ _09773_/Q _08832_/Z _08835_/Z vdd vdd vss vss gf180mcu_fd_sc_mcu7t5v0__and2_1
X_08766_ _08766_/A1 _08766_/A2 _09745_/D vdd vdd vss vss gf180mcu_fd_sc_mcu7t5v0__nor2_1
X_07717_ _07712_/Z _07717_/A2 _07717_/Z vdd vdd vss vss gf180mcu_fd_sc_mcu7t5v0__xor2_1
X_05978_ _05978_/A1 _09104_/A2 _05978_/B _09570_/D vdd vdd vss vss
+ gf180mcu_fd_sc_mcu7t5v0__aoi21_1
X_04929_ _09516_/Q _05364_/B2 vdd vdd vss vss gf180mcu_fd_sc_mcu7t5v0__clkinv_1
X_08697_ _09717_/Q _08699_/A3 _08698_/A2 vdd vdd vss vss gf180mcu_fd_sc_mcu7t5v0__nand2_1
X_07648_ _07648_/A1 _07648_/A2 _07648_/B _07649_/A2 vdd vdd vss vss
+ gf180mcu_fd_sc_mcu7t5v0__aoi21_1
X_07579_ _09711_/Q _07633_/B _07587_/A2 vdd vdd vss vss gf180mcu_fd_sc_mcu7t5v0__nand2_1
X_09318_ _09395_/A1 _09322_/A2 _09318_/B _09399_/C _09981_/D vdd vdd vss
+ vss gf180mcu_fd_sc_mcu7t5v0__aoi211_1
X_09249_ _09467_/Q _09953_/Q _09257_/B _09250_/B vdd vdd vss vss gf180mcu_fd_sc_mcu7t5v0__oai21_1
X_10024_ _10024_/D clk _10024_/Q vdd vdd vss vss gf180mcu_fd_sc_mcu7t5v0__dffq_1
XPHY_160 vdd vss gf180mcu_fd_sc_mcu7t5v0__endcap
XPHY_171 vdd vss gf180mcu_fd_sc_mcu7t5v0__endcap
XPHY_182 vdd vss gf180mcu_fd_sc_mcu7t5v0__endcap
XPHY_193 vdd vss gf180mcu_fd_sc_mcu7t5v0__endcap
X_06950_ _09717_/Q _06931_/Z _06957_/A2 vdd vdd vss vss gf180mcu_fd_sc_mcu7t5v0__nand2_1
X_06881_ _08721_/A1 _06941_/A2 _06884_/A1 vdd vdd vss vss gf180mcu_fd_sc_mcu7t5v0__nor2_1
X_05901_ _07452_/C _05901_/A2 _05950_/A2 vdd vdd vss vss gf180mcu_fd_sc_mcu7t5v0__nor2_1
X_05832_ _05833_/A1 _05831_/Z _05913_/A1 vdd vdd vss vss gf180mcu_fd_sc_mcu7t5v0__nor2_1
X_08620_ _09714_/Q _08678_/A2 _08624_/A2 vdd vdd vss vss gf180mcu_fd_sc_mcu7t5v0__nand2_1
X_05763_ _05763_/A1 _05725_/Z _05763_/B _05810_/A1 vdd vdd vss vss
+ gf180mcu_fd_sc_mcu7t5v0__aoi21_2
X_08551_ _08551_/A1 _08488_/Z _08551_/B _08558_/A1 vdd vdd vss vss
+ gf180mcu_fd_sc_mcu7t5v0__aoi21_1
X_05694_ _05694_/A1 _05692_/Z _05694_/B _05699_/A2 vdd vdd vss vss
+ gf180mcu_fd_sc_mcu7t5v0__oai21_1
X_08482_ _09722_/Q _09721_/Q _09684_/Q _08483_/B vdd vdd vss vss gf180mcu_fd_sc_mcu7t5v0__nand3_2
X_07502_ _09714_/Q _07500_/Z _07503_/B vdd vdd vss vss gf180mcu_fd_sc_mcu7t5v0__xor2_1
X_04714_ _09926_/Q _09228_/A1 vdd vdd vss vss gf180mcu_fd_sc_mcu7t5v0__inv_1
X_07433_ _07433_/A1 _07480_/A1 _07435_/A3 vdd vdd vss vss gf180mcu_fd_sc_mcu7t5v0__xnor2_1
X_09103_ _09103_/A1 _09103_/A2 _09399_/C _09898_/D vdd vdd vss vss
+ gf180mcu_fd_sc_mcu7t5v0__aoi21_1
X_07364_ _09710_/Q _07364_/A2 _07364_/A3 _07366_/A2 vdd vdd vss vss
+ gf180mcu_fd_sc_mcu7t5v0__nand3_1
X_06315_ _09013_/A1 _06323_/A2 _06323_/B1 vdd vdd vss vss gf180mcu_fd_sc_mcu7t5v0__nand2_2
X_07295_ _09995_/Q _09073_/A2 _08734_/B _07296_/B vdd vdd vss vss
+ gf180mcu_fd_sc_mcu7t5v0__oai21_1
X_06246_ _06246_/A1 _06246_/A2 _06246_/Z vdd vdd vss vss gf180mcu_fd_sc_mcu7t5v0__xor2_1
X_09034_ _09550_/Q _09033_/I _09036_/A1 vdd vdd vss vss gf180mcu_fd_sc_mcu7t5v0__nand2_1
X_06177_ _06177_/A1 _06177_/A2 _06238_/A1 vdd vdd vss vss gf180mcu_fd_sc_mcu7t5v0__xnor2_1
X_05128_ _05128_/A1 _05128_/A2 _09523_/D vdd vdd vss vss gf180mcu_fd_sc_mcu7t5v0__nand2_1
X_05059_ _09504_/Q _05348_/B2 vdd vdd vss vss gf180mcu_fd_sc_mcu7t5v0__clkinv_1
X_09936_ _09936_/D clk _09936_/Q vdd vdd vss vss gf180mcu_fd_sc_mcu7t5v0__dffq_1
XTAP_691 vdd vss gf180mcu_fd_sc_mcu7t5v0__filltie
XTAP_680 vdd vss gf180mcu_fd_sc_mcu7t5v0__filltie
X_09867_ _09867_/D clk _09867_/Q vdd vdd vss vss gf180mcu_fd_sc_mcu7t5v0__dffq_1
X_09798_ _09798_/D clk _09798_/Q vdd vdd vss vss gf180mcu_fd_sc_mcu7t5v0__dffq_1
X_08818_ _09767_/Q _09768_/Q _08819_/A2 _08818_/Z vdd vdd vss vss
+ gf180mcu_fd_sc_mcu7t5v0__and3_1
X_08749_ _09403_/A1 _08755_/A2 _08755_/B1 _08749_/B2 _09736_/D vdd vdd
+ vss vss gf180mcu_fd_sc_mcu7t5v0__oai22_1
XTAP_1824 vdd vss gf180mcu_fd_sc_mcu7t5v0__filltie
XTAP_1813 vdd vss gf180mcu_fd_sc_mcu7t5v0__filltie
XTAP_1802 vdd vss gf180mcu_fd_sc_mcu7t5v0__filltie
XTAP_1857 vdd vss gf180mcu_fd_sc_mcu7t5v0__filltie
XTAP_1846 vdd vss gf180mcu_fd_sc_mcu7t5v0__filltie
XTAP_1835 vdd vss gf180mcu_fd_sc_mcu7t5v0__filltie
XTAP_1879 vdd vss gf180mcu_fd_sc_mcu7t5v0__filltie
XTAP_1868 vdd vss gf180mcu_fd_sc_mcu7t5v0__filltie
X_10007_ _10007_/D clk _10007_/Q vdd vdd vss vss gf180mcu_fd_sc_mcu7t5v0__dffq_1
X_07080_ _07003_/B _07000_/Z _07033_/Z _07081_/A2 vdd vdd vss vss
+ gf180mcu_fd_sc_mcu7t5v0__nor3_1
X_06100_ _06419_/A2 _06119_/A1 _06097_/Z _06100_/Z vdd vdd vss vss
+ gf180mcu_fd_sc_mcu7t5v0__xor3_1
X_06031_ _06004_/B _06026_/S _06056_/A1 vdd vdd vss vss gf180mcu_fd_sc_mcu7t5v0__nor2_1
X_07982_ _09882_/Q _07886_/Z _07982_/B1 _09620_/Q _08002_/A3 vdd vdd vss
+ vss gf180mcu_fd_sc_mcu7t5v0__aoi22_2
X_06933_ _06933_/A1 _06933_/A2 _06933_/Z vdd vdd vss vss gf180mcu_fd_sc_mcu7t5v0__xor2_1
X_09721_ _09721_/D clk _09721_/Q vdd vdd vss vss gf180mcu_fd_sc_mcu7t5v0__dffq_4
X_06864_ _08721_/A1 _06865_/A2 _06864_/Z vdd vdd vss vss gf180mcu_fd_sc_mcu7t5v0__or2_1
X_09652_ _09652_/D clk _09652_/Q vdd vdd vss vss gf180mcu_fd_sc_mcu7t5v0__dffq_2
X_08603_ _09715_/Q _08601_/Z _08604_/B vdd vdd vss vss gf180mcu_fd_sc_mcu7t5v0__xor2_1
X_06795_ _09711_/Q _06792_/Z _06844_/A1 vdd vdd vss vss gf180mcu_fd_sc_mcu7t5v0__nand2_1
X_09583_ _09583_/D clk _09583_/Q vdd vdd vss vss gf180mcu_fd_sc_mcu7t5v0__dffq_4
X_05815_ _09714_/Q _05816_/A2 _05863_/B vdd vdd vss vss gf180mcu_fd_sc_mcu7t5v0__and2_1
X_08534_ _08572_/S _08534_/A2 _08535_/A3 _08534_/Z vdd vdd vss vss
+ gf180mcu_fd_sc_mcu7t5v0__or3_1
XTAP_1109 vdd vss gf180mcu_fd_sc_mcu7t5v0__filltie
X_05746_ _05746_/A1 _09570_/Q _05976_/A1 _05746_/B _05839_/A2 vdd vdd
+ vss vss gf180mcu_fd_sc_mcu7t5v0__oai31_4
X_05677_ _09711_/Q _05689_/B _05709_/B vdd vdd vss vss gf180mcu_fd_sc_mcu7t5v0__nand2_2
X_08465_ _08465_/A1 _08463_/Z _08478_/A2 vdd vdd vss vss gf180mcu_fd_sc_mcu7t5v0__xnor2_1
X_08396_ _08727_/A1 _08405_/A2 _08561_/B vdd vdd vss vss gf180mcu_fd_sc_mcu7t5v0__nand2_1
X_07416_ _09713_/Q _07349_/Z _07467_/B vdd vdd vss vss gf180mcu_fd_sc_mcu7t5v0__nand2_1
X_07347_ _09658_/Q _09593_/Q _07348_/B1 vdd vdd vss vss gf180mcu_fd_sc_mcu7t5v0__nor2_1
X_09017_ _09405_/A1 _09021_/A2 _09021_/B1 _09017_/B2 _09862_/D vdd vdd
+ vss vss gf180mcu_fd_sc_mcu7t5v0__oai22_1
X_07278_ _07278_/A1 _07276_/Z _07278_/Z vdd vdd vss vss gf180mcu_fd_sc_mcu7t5v0__and2_1
X_06229_ _06226_/Z _06227_/Z _06231_/A3 _06230_/B vdd vdd vss vss
+ gf180mcu_fd_sc_mcu7t5v0__nor3_2
X_09919_ _09919_/D clk _09919_/Q vdd vdd vss vss gf180mcu_fd_sc_mcu7t5v0__dffq_2
XTAP_1610 vdd vss gf180mcu_fd_sc_mcu7t5v0__filltie
XTAP_1621 vdd vss gf180mcu_fd_sc_mcu7t5v0__filltie
XTAP_1632 vdd vss gf180mcu_fd_sc_mcu7t5v0__filltie
XTAP_1676 vdd vss gf180mcu_fd_sc_mcu7t5v0__filltie
XTAP_1654 vdd vss gf180mcu_fd_sc_mcu7t5v0__filltie
XTAP_1665 vdd vss gf180mcu_fd_sc_mcu7t5v0__filltie
XTAP_1643 vdd vss gf180mcu_fd_sc_mcu7t5v0__filltie
XTAP_1698 vdd vss gf180mcu_fd_sc_mcu7t5v0__filltie
XTAP_1687 vdd vss gf180mcu_fd_sc_mcu7t5v0__filltie
X_05600_ _05600_/A1 _05600_/A2 _05601_/B1 vdd vdd vss vss gf180mcu_fd_sc_mcu7t5v0__nand2_1
X_06580_ _06580_/A1 _06576_/Z _06593_/A2 vdd vdd vss vss gf180mcu_fd_sc_mcu7t5v0__nand2_1
X_05531_ _09414_/Q _05627_/A2 _05627_/B1 _09847_/Q _05533_/A1 vdd vdd
+ vss vss gf180mcu_fd_sc_mcu7t5v0__aoi22_1
X_08250_ _08250_/A1 _08274_/B2 _08246_/Z _08250_/Z vdd vdd vss vss
+ gf180mcu_fd_sc_mcu7t5v0__xor3_1
X_05462_ _09544_/Q _05628_/A2 _05628_/B1 _09861_/Q _05463_/A2 vdd vdd
+ vss vss gf180mcu_fd_sc_mcu7t5v0__aoi22_1
X_08181_ _08182_/A1 _08331_/B1 _08235_/B vdd vdd vss vss gf180mcu_fd_sc_mcu7t5v0__nand2_2
X_07201_ _07201_/A1 _07201_/A2 _07204_/A3 vdd vdd vss vss gf180mcu_fd_sc_mcu7t5v0__nor2_1
X_05393_ _09403_/A1 _05399_/A2 _05399_/B1 _05393_/B2 _09543_/D vdd vdd
+ vss vss gf180mcu_fd_sc_mcu7t5v0__oai22_1
X_07132_ _07284_/B _07132_/A2 _07133_/A2 vdd vdd vss vss gf180mcu_fd_sc_mcu7t5v0__nand2_1
X_07063_ _07063_/A1 _07063_/A2 _07071_/A1 vdd vdd vss vss gf180mcu_fd_sc_mcu7t5v0__xnor2_1
X_06014_ _07348_/A2 _09582_/Q _09583_/Q _06015_/A3 vdd vdd vss vss
+ gf180mcu_fd_sc_mcu7t5v0__aoi21_2
X_07965_ _09716_/Q _07963_/Z _07967_/B vdd vdd vss vss gf180mcu_fd_sc_mcu7t5v0__xor2_1
X_09704_ _09704_/D clk _09704_/Q vdd vdd vss vss gf180mcu_fd_sc_mcu7t5v0__dffq_1
X_06916_ _06958_/A1 _06916_/A2 _06921_/A3 vdd vdd vss vss gf180mcu_fd_sc_mcu7t5v0__nand2_1
X_07896_ _07837_/I _07878_/Z _07897_/A3 _07896_/Z vdd vdd vss vss
+ gf180mcu_fd_sc_mcu7t5v0__xor3_1
X_09635_ _09635_/D clk _09635_/Q vdd vdd vss vss gf180mcu_fd_sc_mcu7t5v0__dffq_1
X_06847_ _06928_/A1 _06928_/A2 _06897_/A1 vdd vdd vss vss gf180mcu_fd_sc_mcu7t5v0__nor2_1
X_06778_ _06955_/A1 _06889_/A1 _06918_/C _06780_/B1 vdd vdd vss vss
+ gf180mcu_fd_sc_mcu7t5v0__aoi21_1
X_09566_ _09566_/D clk _09566_/Q vdd vdd vss vss gf180mcu_fd_sc_mcu7t5v0__dffq_2
X_05729_ _09712_/Q _05711_/I _05795_/A1 vdd vdd vss vss gf180mcu_fd_sc_mcu7t5v0__nand2_1
X_09497_ _09497_/D clk _09497_/Q vdd vdd vss vss gf180mcu_fd_sc_mcu7t5v0__dffq_1
X_08517_ _08695_/A1 _08517_/A2 _08517_/B1 _08517_/B2 _08517_/C _08518_/B vdd
+ vdd vss vss gf180mcu_fd_sc_mcu7t5v0__oai221_1
X_08448_ _09703_/Q _08706_/B _08708_/B _08449_/B vdd vdd vss vss gf180mcu_fd_sc_mcu7t5v0__oai21_1
X_08379_ _09403_/A1 _08385_/A2 _08385_/B1 _08379_/B2 _09695_/D vdd vdd
+ vss vss gf180mcu_fd_sc_mcu7t5v0__oai22_1
XTAP_1440 vdd vss gf180mcu_fd_sc_mcu7t5v0__filltie
XTAP_1451 vdd vss gf180mcu_fd_sc_mcu7t5v0__filltie
XTAP_1462 vdd vss gf180mcu_fd_sc_mcu7t5v0__filltie
XTAP_1473 vdd vss gf180mcu_fd_sc_mcu7t5v0__filltie
XTAP_1484 vdd vss gf180mcu_fd_sc_mcu7t5v0__filltie
XTAP_1495 vdd vss gf180mcu_fd_sc_mcu7t5v0__filltie
X_04962_ _09529_/Q _05375_/B2 vdd vdd vss vss gf180mcu_fd_sc_mcu7t5v0__clkinv_1
X_07750_ _07745_/Z _07934_/A3 _07879_/A2 vdd vdd vss vss gf180mcu_fd_sc_mcu7t5v0__nand2_2
X_06701_ _06674_/B _06722_/A2 _06723_/A1 vdd vdd vss vss gf180mcu_fd_sc_mcu7t5v0__nand2_1
X_07681_ _07677_/Z _07741_/A3 _07681_/Z vdd vdd vss vss gf180mcu_fd_sc_mcu7t5v0__and2_4
X_04893_ _09443_/Q _05290_/B2 vdd vdd vss vss gf180mcu_fd_sc_mcu7t5v0__clkinv_1
X_06632_ _06632_/A1 _08565_/C _06632_/B1 _06632_/B2 _08670_/B _09599_/D vdd
+ vdd vss vss gf180mcu_fd_sc_mcu7t5v0__aoi221_1
X_09420_ _09420_/D clk _09420_/Q vdd vdd vss vss gf180mcu_fd_sc_mcu7t5v0__dffq_1
X_06563_ _06564_/A1 _06564_/A3 _06563_/Z vdd vdd vss vss gf180mcu_fd_sc_mcu7t5v0__and2_1
X_09351_ _09395_/A1 _09355_/A2 _09351_/B _09399_/C _09996_/D vdd vdd vss
+ vss gf180mcu_fd_sc_mcu7t5v0__aoi211_1
X_08302_ _08245_/Z _08327_/A1 _08302_/A3 _08304_/A2 vdd vdd vss vss
+ gf180mcu_fd_sc_mcu7t5v0__xnor3_1
X_05514_ _08736_/A2 _05514_/A2 _05514_/B1 _09400_/A2 _05517_/A1 vdd vdd
+ vss vss gf180mcu_fd_sc_mcu7t5v0__aoi22_1
X_09282_ _09395_/A1 _09286_/A2 _09282_/B _09399_/C _09966_/D vdd vdd vss
+ vss gf180mcu_fd_sc_mcu7t5v0__aoi211_1
X_06494_ _06494_/A1 _06494_/A2 _06494_/B _06494_/C _06495_/A2 vdd vdd
+ vss vss gf180mcu_fd_sc_mcu7t5v0__oai211_1
X_08233_ _09713_/Q _08283_/A2 _08283_/A3 _08278_/B2 vdd vdd vss vss
+ gf180mcu_fd_sc_mcu7t5v0__nand3_1
X_05445_ _09828_/Q _05628_/A2 _05628_/B1 _10020_/Q _05446_/A2 vdd vdd
+ vss vss gf180mcu_fd_sc_mcu7t5v0__aoi22_1
X_05376_ _09406_/A1 _05379_/A2 _05379_/B1 _05376_/B2 _09530_/D vdd vdd
+ vss vss gf180mcu_fd_sc_mcu7t5v0__oai22_1
X_08164_ _08319_/B2 _08286_/A1 _08359_/B _08166_/B1 vdd vdd vss vss
+ gf180mcu_fd_sc_mcu7t5v0__aoi21_1
X_08095_ _09692_/Q _08095_/A2 _08095_/B _08283_/A3 vdd vdd vss vss
+ gf180mcu_fd_sc_mcu7t5v0__oai21_4
X_07115_ _07116_/A1 _07114_/I _07144_/B vdd vdd vss vss gf180mcu_fd_sc_mcu7t5v0__nand2_1
X_07046_ _07033_/Z _07046_/A2 _07046_/Z vdd vdd vss vss gf180mcu_fd_sc_mcu7t5v0__xor2_1
X_08997_ _09405_/A1 _09001_/A2 _09001_/B1 _08997_/B2 _09846_/D vdd vdd
+ vss vss gf180mcu_fd_sc_mcu7t5v0__oai22_1
X_07948_ _07949_/A1 _07947_/Z _07980_/B vdd vdd vss vss gf180mcu_fd_sc_mcu7t5v0__nor2_1
X_07879_ _07452_/C _07879_/A2 _07930_/A1 vdd vdd vss vss gf180mcu_fd_sc_mcu7t5v0__nor2_1
X_09618_ _09618_/D clk _09618_/Q vdd vdd vss vss gf180mcu_fd_sc_mcu7t5v0__dffq_2
X_09549_ _09549_/D clk _09549_/Q vdd vdd vss vss gf180mcu_fd_sc_mcu7t5v0__dffq_1
XTAP_509 vdd vss gf180mcu_fd_sc_mcu7t5v0__filltie
XTAP_1270 vdd vss gf180mcu_fd_sc_mcu7t5v0__filltie
XTAP_1281 vdd vss gf180mcu_fd_sc_mcu7t5v0__filltie
XTAP_1292 vdd vss gf180mcu_fd_sc_mcu7t5v0__filltie
X_05230_ _09560_/Q _05217_/S _05230_/B _09404_/A1 vdd vdd vss vss
+ gf180mcu_fd_sc_mcu7t5v0__aoi21_4
X_05161_ _05161_/A1 _05161_/A2 _05161_/A3 _05161_/Z vdd vdd vss vss
+ gf180mcu_fd_sc_mcu7t5v0__or3_1
X_05092_ _09513_/Q _05359_/B2 vdd vdd vss vss gf180mcu_fd_sc_mcu7t5v0__clkinv_1
X_08920_ _09404_/A1 _08925_/A2 _08925_/B1 _08920_/B2 _09805_/D vdd vdd
+ vss vss gf180mcu_fd_sc_mcu7t5v0__oai22_1
X_08851_ _08851_/A1 _08851_/A2 _09399_/C _09778_/D vdd vdd vss vss
+ gf180mcu_fd_sc_mcu7t5v0__aoi21_1
X_07802_ _07813_/B _07801_/Z _07817_/A1 vdd vdd vss vss gf180mcu_fd_sc_mcu7t5v0__nand2_1
X_05994_ _09580_/Q _09579_/Q _06298_/B vdd vdd vss vss gf180mcu_fd_sc_mcu7t5v0__nand2_1
X_08782_ _08782_/A1 _08782_/A2 _08782_/B _09753_/D vdd vdd vss vss
+ gf180mcu_fd_sc_mcu7t5v0__aoi21_1
X_04945_ _09796_/Q _08908_/B2 vdd vdd vss vss gf180mcu_fd_sc_mcu7t5v0__clkinv_1
X_07733_ _08060_/A2 _07733_/A2 _07734_/B vdd vdd vss vss gf180mcu_fd_sc_mcu7t5v0__xor2_1
X_04876_ _09584_/Q _06316_/B2 vdd vdd vss vss gf180mcu_fd_sc_mcu7t5v0__clkinv_1
X_07664_ _07664_/A1 _09073_/A2 _07664_/B _09658_/D vdd vdd vss vss
+ gf180mcu_fd_sc_mcu7t5v0__aoi21_1
X_06615_ _06612_/Z _06615_/A2 _06615_/A3 _06615_/Z vdd vdd vss vss
+ gf180mcu_fd_sc_mcu7t5v0__xor3_1
X_09403_ _09403_/A1 _09409_/A2 _09409_/B1 _09403_/B2 _10020_/D vdd vdd
+ vss vss gf180mcu_fd_sc_mcu7t5v0__oai22_1
X_07595_ _07595_/A1 _07595_/A2 _07596_/B vdd vdd vss vss gf180mcu_fd_sc_mcu7t5v0__xor2_2
X_06546_ _06546_/A1 _06546_/A2 _06546_/B _06573_/A1 vdd vdd vss vss
+ gf180mcu_fd_sc_mcu7t5v0__oai21_1
X_09334_ _09334_/A1 _09311_/Z _09344_/A2 vdd vdd vss vss gf180mcu_fd_sc_mcu7t5v0__nor2_4
X_06477_ _09596_/Q _06480_/A2 _06498_/B vdd vdd vss vss gf180mcu_fd_sc_mcu7t5v0__nand2_1
X_09265_ _09959_/Q _09274_/A2 _09266_/B vdd vdd vss vss gf180mcu_fd_sc_mcu7t5v0__nor2_1
X_09196_ _09173_/B _09254_/A2 _09196_/B _09931_/D vdd vdd vss vss
+ gf180mcu_fd_sc_mcu7t5v0__aoi21_1
X_08216_ _09714_/Q _08284_/A2 _08216_/B _08217_/C vdd vdd vss vss
+ gf180mcu_fd_sc_mcu7t5v0__oai21_1
X_05428_ _08736_/A2 _05428_/A2 _05428_/B1 _05631_/B2 _09002_/A2 _05428_/C2 _05430_/A2
+ vdd vdd vss vss gf180mcu_fd_sc_mcu7t5v0__aoi222_1
X_08147_ _08172_/A1 _08146_/Z _08147_/Z vdd vdd vss vss gf180mcu_fd_sc_mcu7t5v0__xor2_1
X_05359_ _09409_/A1 _05359_/A2 _05359_/B1 _05359_/B2 _09513_/D vdd vdd
+ vss vss gf180mcu_fd_sc_mcu7t5v0__oai22_1
X_08078_ _08087_/A1 _08083_/B1 _08106_/A1 vdd vdd vss vss gf180mcu_fd_sc_mcu7t5v0__nor2_1
X_07029_ _09712_/Q _07000_/Z _07063_/A1 vdd vdd vss vss gf180mcu_fd_sc_mcu7t5v0__nand2_1
X_10040_ _10040_/ZN vdd vdd vss vss gf180mcu_fd_sc_mcu7t5v0__tiel
XTAP_306 vdd vss gf180mcu_fd_sc_mcu7t5v0__filltie
XTAP_339 vdd vss gf180mcu_fd_sc_mcu7t5v0__filltie
XTAP_328 vdd vss gf180mcu_fd_sc_mcu7t5v0__filltie
XTAP_317 vdd vss gf180mcu_fd_sc_mcu7t5v0__filltie
X_04730_ _09884_/Q _09061_/A1 vdd vdd vss vss gf180mcu_fd_sc_mcu7t5v0__clkinv_1
X_06400_ _06450_/C _06399_/Z _06414_/B vdd vdd vss vss gf180mcu_fd_sc_mcu7t5v0__nand2_1
X_07380_ _07388_/A1 _07417_/A3 _07380_/Z vdd vdd vss vss gf180mcu_fd_sc_mcu7t5v0__and2_1
X_06331_ _09602_/Q _06636_/A1 _06448_/A2 vdd vdd vss vss gf180mcu_fd_sc_mcu7t5v0__nand2_1
X_06262_ _06072_/C _06262_/A2 _06262_/A3 _06262_/A4 _06263_/B vdd vdd
+ vss vss gf180mcu_fd_sc_mcu7t5v0__nand4_1
X_09050_ _09880_/Q _09103_/A2 _09051_/A2 vdd vdd vss vss gf180mcu_fd_sc_mcu7t5v0__nand2_1
X_08001_ _08001_/A1 _07998_/Z _08013_/C vdd vdd vss vss gf180mcu_fd_sc_mcu7t5v0__nand2_1
X_05213_ _09100_/A1 _05213_/A2 _05214_/A2 vdd vdd vss vss gf180mcu_fd_sc_mcu7t5v0__nand2_2
X_06193_ _06290_/A1 _06189_/Z _06206_/A2 vdd vdd vss vss gf180mcu_fd_sc_mcu7t5v0__nand2_1
X_05144_ _09525_/Q _08926_/B _05145_/B vdd vdd vss vss gf180mcu_fd_sc_mcu7t5v0__nand2_1
X_09952_ _09952_/D clk _09952_/Q vdd vdd vss vss gf180mcu_fd_sc_mcu7t5v0__dffq_1
X_05075_ _10026_/Q _09409_/B2 vdd vdd vss vss gf180mcu_fd_sc_mcu7t5v0__clkinv_1
X_08903_ _08903_/A1 _08903_/A2 _08903_/B _09793_/D vdd vdd vss vss
+ gf180mcu_fd_sc_mcu7t5v0__aoi21_1
XTAP_840 vdd vss gf180mcu_fd_sc_mcu7t5v0__filltie
XTAP_851 vdd vss gf180mcu_fd_sc_mcu7t5v0__filltie
XTAP_862 vdd vss gf180mcu_fd_sc_mcu7t5v0__filltie
X_09883_ _09883_/D clk _09883_/Q vdd vdd vss vss gf180mcu_fd_sc_mcu7t5v0__dffq_2
XTAP_873 vdd vss gf180mcu_fd_sc_mcu7t5v0__filltie
XTAP_884 vdd vss gf180mcu_fd_sc_mcu7t5v0__filltie
XTAP_895 vdd vss gf180mcu_fd_sc_mcu7t5v0__filltie
X_08834_ _08832_/Z _08834_/A2 _09772_/D vdd vdd vss vss gf180mcu_fd_sc_mcu7t5v0__nor2_1
X_08765_ _09744_/Q _08761_/B _09745_/Q _08766_/A2 vdd vdd vss vss
+ gf180mcu_fd_sc_mcu7t5v0__aoi21_1
X_07716_ _07677_/Z _07741_/A3 _07803_/B _07717_/A2 vdd vdd vss vss
+ gf180mcu_fd_sc_mcu7t5v0__nand3_1
X_05977_ _10018_/Q _09104_/A2 _09259_/B _05978_/B vdd vdd vss vss
+ gf180mcu_fd_sc_mcu7t5v0__oai21_1
X_04928_ _09536_/Q _05384_/B2 vdd vdd vss vss gf180mcu_fd_sc_mcu7t5v0__clkinv_1
X_08696_ _09717_/Q _08699_/A3 _08696_/Z vdd vdd vss vss gf180mcu_fd_sc_mcu7t5v0__or2_1
X_04859_ _09426_/Q _05267_/B2 vdd vdd vss vss gf180mcu_fd_sc_mcu7t5v0__clkinv_1
X_07647_ _07648_/A1 _07648_/A2 _07648_/B _07653_/B1 vdd vdd vss vss
+ gf180mcu_fd_sc_mcu7t5v0__nand3_1
X_07578_ _07577_/B _07578_/A2 _07635_/B2 _07586_/C vdd vdd vss vss
+ gf180mcu_fd_sc_mcu7t5v0__xor3_1
X_06529_ _06580_/A1 _06525_/Z _06541_/A2 vdd vdd vss vss gf180mcu_fd_sc_mcu7t5v0__nand2_1
X_09317_ _09981_/Q _09322_/A2 _09318_/B vdd vdd vss vss gf180mcu_fd_sc_mcu7t5v0__nor2_1
X_09248_ _09467_/Q _09248_/A2 _09248_/B _09952_/D vdd vdd vss vss
+ gf180mcu_fd_sc_mcu7t5v0__aoi21_1
X_09179_ _09246_/A2 _09173_/B _09179_/B _09927_/D vdd vdd vss vss
+ gf180mcu_fd_sc_mcu7t5v0__aoi21_1
X_10023_ _10023_/D clk _10023_/Q vdd vdd vss vss gf180mcu_fd_sc_mcu7t5v0__dffq_1
XPHY_150 vdd vss gf180mcu_fd_sc_mcu7t5v0__endcap
XPHY_161 vdd vss gf180mcu_fd_sc_mcu7t5v0__endcap
XPHY_172 vdd vss gf180mcu_fd_sc_mcu7t5v0__endcap
XPHY_183 vdd vss gf180mcu_fd_sc_mcu7t5v0__endcap
XPHY_194 vdd vss gf180mcu_fd_sc_mcu7t5v0__endcap
X_06880_ _09716_/Q _06658_/I _06929_/A1 vdd vdd vss vss gf180mcu_fd_sc_mcu7t5v0__nand2_1
X_05900_ _09711_/Q _05836_/Z _05900_/Z vdd vdd vss vss gf180mcu_fd_sc_mcu7t5v0__and2_1
X_05831_ _08721_/A1 _05645_/I _05831_/Z vdd vdd vss vss gf180mcu_fd_sc_mcu7t5v0__or2_1
X_05762_ _05762_/A1 _05761_/B _05762_/Z vdd vdd vss vss gf180mcu_fd_sc_mcu7t5v0__xor2_1
X_08550_ _08695_/A1 _08550_/A2 _08564_/C vdd vdd vss vss gf180mcu_fd_sc_mcu7t5v0__nor2_1
X_05693_ _05694_/A1 _05692_/Z _05693_/Z vdd vdd vss vss gf180mcu_fd_sc_mcu7t5v0__and2_1
X_08481_ _08481_/A1 _08481_/A2 _08481_/B _08551_/A1 vdd vdd vss vss
+ gf180mcu_fd_sc_mcu7t5v0__oai21_1
X_07501_ _09714_/Q _07500_/Z _07553_/A1 vdd vdd vss vss gf180mcu_fd_sc_mcu7t5v0__nand2_1
X_04713_ _09927_/Q _05180_/A2 vdd vdd vss vss gf180mcu_fd_sc_mcu7t5v0__clkinv_1
X_07432_ _07433_/A1 _07480_/A1 _07468_/A2 vdd vdd vss vss gf180mcu_fd_sc_mcu7t5v0__nor2_1
X_09102_ _09899_/Q _09898_/Q _09897_/Q _09102_/C _09897_/D vdd vdd vss
+ vss gf180mcu_fd_sc_mcu7t5v0__aoi211_1
X_07363_ _09711_/Q _07377_/A2 _07377_/A3 _07366_/A1 vdd vdd vss vss
+ gf180mcu_fd_sc_mcu7t5v0__nand3_1
X_06314_ _09002_/A2 _09022_/A1 _06323_/A2 vdd vdd vss vss gf180mcu_fd_sc_mcu7t5v0__nand2_4
X_07294_ _07294_/A1 _09073_/A2 _07294_/B _09634_/D vdd vdd vss vss
+ gf180mcu_fd_sc_mcu7t5v0__aoi21_1
X_06245_ _06246_/A1 _06246_/A2 _06266_/B vdd vdd vss vss gf180mcu_fd_sc_mcu7t5v0__or2_1
X_09033_ _09033_/I _09103_/A2 vdd vdd vss vss gf180mcu_fd_sc_mcu7t5v0__clkinv_3
X_06176_ _06177_/A1 _06177_/A2 _06218_/A2 vdd vdd vss vss gf180mcu_fd_sc_mcu7t5v0__nor2_1
X_05127_ _09257_/B _09524_/Q _05121_/Z _05128_/A2 vdd vdd vss vss
+ gf180mcu_fd_sc_mcu7t5v0__nand3_1
X_05058_ _09532_/Q _05378_/B2 vdd vdd vss vss gf180mcu_fd_sc_mcu7t5v0__clkinv_1
X_09935_ _09935_/D clk _09935_/Q vdd vdd vss vss gf180mcu_fd_sc_mcu7t5v0__dffq_1
XTAP_670 vdd vss gf180mcu_fd_sc_mcu7t5v0__filltie
X_09866_ _09866_/D clk _09866_/Q vdd vdd vss vss gf180mcu_fd_sc_mcu7t5v0__dffq_1
XTAP_692 vdd vss gf180mcu_fd_sc_mcu7t5v0__filltie
XTAP_681 vdd vss gf180mcu_fd_sc_mcu7t5v0__filltie
X_08817_ _08806_/B _08817_/A2 _08816_/Z _09767_/D vdd vdd vss vss
+ gf180mcu_fd_sc_mcu7t5v0__and3_1
X_09797_ _09797_/D clk _09797_/Q vdd vdd vss vss gf180mcu_fd_sc_mcu7t5v0__dffq_1
X_08748_ _09402_/A1 _08755_/A2 _08755_/B1 _08748_/B2 _09735_/D vdd vdd
+ vss vss gf180mcu_fd_sc_mcu7t5v0__oai22_1
XTAP_1825 vdd vss gf180mcu_fd_sc_mcu7t5v0__filltie
XTAP_1814 vdd vss gf180mcu_fd_sc_mcu7t5v0__filltie
XTAP_1803 vdd vss gf180mcu_fd_sc_mcu7t5v0__filltie
X_08679_ _08679_/A1 _08679_/A2 _08679_/A3 _08679_/Z vdd vdd vss vss
+ gf180mcu_fd_sc_mcu7t5v0__xor3_1
XTAP_1858 vdd vss gf180mcu_fd_sc_mcu7t5v0__filltie
XTAP_1847 vdd vss gf180mcu_fd_sc_mcu7t5v0__filltie
XTAP_1836 vdd vss gf180mcu_fd_sc_mcu7t5v0__filltie
XTAP_1869 vdd vss gf180mcu_fd_sc_mcu7t5v0__filltie
X_10006_ _10006_/D clk _10006_/Q vdd vdd vss vss gf180mcu_fd_sc_mcu7t5v0__dffq_1
X_06030_ _08291_/B _06016_/I _06037_/A3 vdd vdd vss vss gf180mcu_fd_sc_mcu7t5v0__nor2_1
X_07981_ _09688_/Q _09680_/Q _08024_/A1 _08002_/A2 vdd vdd vss vss
+ gf180mcu_fd_sc_mcu7t5v0__nand3_1
X_06932_ _09710_/Q _06931_/Z _06933_/A2 vdd vdd vss vss gf180mcu_fd_sc_mcu7t5v0__nand2_1
X_09720_ _09720_/D clk _09720_/Q vdd vdd vss vss gf180mcu_fd_sc_mcu7t5v0__dffq_4
X_06863_ _06845_/Z _06863_/A2 _06865_/A2 vdd vdd vss vss gf180mcu_fd_sc_mcu7t5v0__xnor2_1
X_09651_ _09651_/D clk _09651_/Q vdd vdd vss vss gf180mcu_fd_sc_mcu7t5v0__dffq_1
X_08602_ _09715_/Q _08601_/Z _08657_/A1 vdd vdd vss vss gf180mcu_fd_sc_mcu7t5v0__nand2_1
X_06794_ _06842_/A1 _06797_/A3 _06834_/A2 vdd vdd vss vss gf180mcu_fd_sc_mcu7t5v0__nand2_1
X_09582_ _09582_/D clk _09582_/Q vdd vdd vss vss gf180mcu_fd_sc_mcu7t5v0__dffq_4
X_05814_ _05901_/A2 _05814_/A2 _05816_/A2 vdd vdd vss vss gf180mcu_fd_sc_mcu7t5v0__xnor2_1
X_08533_ _09714_/Q _08685_/A2 _08535_/A3 vdd vdd vss vss gf180mcu_fd_sc_mcu7t5v0__nand2_1
X_05745_ _06419_/A2 _09570_/Q _09569_/Q _05839_/A1 vdd vdd vss vss
+ gf180mcu_fd_sc_mcu7t5v0__aoi21_4
X_08464_ _08465_/A1 _08463_/Z _08514_/A2 vdd vdd vss vss gf180mcu_fd_sc_mcu7t5v0__nand2_1
X_05676_ _09710_/Q _05689_/B _05679_/A2 vdd vdd vss vss gf180mcu_fd_sc_mcu7t5v0__nand2_1
X_08395_ _09718_/Q _08404_/A2 _08510_/A1 vdd vdd vss vss gf180mcu_fd_sc_mcu7t5v0__nor2_2
X_07415_ _07452_/C _07465_/A2 _07435_/A2 vdd vdd vss vss gf180mcu_fd_sc_mcu7t5v0__nor2_1
X_07346_ _08058_/A1 _07472_/B _09658_/Q _07364_/A2 vdd vdd vss vss
+ gf180mcu_fd_sc_mcu7t5v0__nand3_4
X_09016_ _09404_/A1 _09021_/A2 _09021_/B1 _09016_/B2 _09861_/D vdd vdd
+ vss vss gf180mcu_fd_sc_mcu7t5v0__oai22_1
X_07277_ _09633_/Q _07277_/A2 _07276_/Z _07277_/Z vdd vdd vss vss
+ gf180mcu_fd_sc_mcu7t5v0__xor3_1
X_06228_ _06579_/A1 _09583_/Q _09582_/Q _06231_/A3 vdd vdd vss vss
+ gf180mcu_fd_sc_mcu7t5v0__aoi21_2
X_06159_ _06159_/A1 _06159_/A2 _08670_/B _09575_/D vdd vdd vss vss
+ gf180mcu_fd_sc_mcu7t5v0__aoi21_1
X_09918_ _09918_/D clk _09918_/Q vdd vdd vss vss gf180mcu_fd_sc_mcu7t5v0__dffq_2
X_09849_ _09849_/D clk _09849_/Q vdd vdd vss vss gf180mcu_fd_sc_mcu7t5v0__dffq_1
XTAP_1600 vdd vss gf180mcu_fd_sc_mcu7t5v0__filltie
XTAP_1611 vdd vss gf180mcu_fd_sc_mcu7t5v0__filltie
XTAP_1622 vdd vss gf180mcu_fd_sc_mcu7t5v0__filltie
XTAP_1633 vdd vss gf180mcu_fd_sc_mcu7t5v0__filltie
XTAP_1655 vdd vss gf180mcu_fd_sc_mcu7t5v0__filltie
XTAP_1666 vdd vss gf180mcu_fd_sc_mcu7t5v0__filltie
XTAP_1644 vdd vss gf180mcu_fd_sc_mcu7t5v0__filltie
XTAP_1699 vdd vss gf180mcu_fd_sc_mcu7t5v0__filltie
XTAP_1688 vdd vss gf180mcu_fd_sc_mcu7t5v0__filltie
XTAP_1677 vdd vss gf180mcu_fd_sc_mcu7t5v0__filltie
X_05530_ _05530_/A1 _05530_/A2 _05545_/C1 vdd vdd vss vss gf180mcu_fd_sc_mcu7t5v0__nand2_1
X_05461_ _09412_/Q _05627_/A2 _05627_/B1 _09845_/Q _05463_/A1 vdd vdd
+ vss vss gf180mcu_fd_sc_mcu7t5v0__aoi22_1
X_05392_ _09402_/A1 _05399_/A2 _05399_/B1 _05392_/B2 _09542_/D vdd vdd
+ vss vss gf180mcu_fd_sc_mcu7t5v0__oai22_1
X_08180_ _09706_/Q _08375_/A1 _08180_/B _08182_/B2 vdd vdd vss vss
+ gf180mcu_fd_sc_mcu7t5v0__oai21_2
X_07200_ _09715_/Q _07000_/Z _07204_/A2 vdd vdd vss vss gf180mcu_fd_sc_mcu7t5v0__nand2_1
X_07131_ _07131_/A1 _07131_/A2 _07130_/B _07132_/A2 vdd vdd vss vss
+ gf180mcu_fd_sc_mcu7t5v0__nand3_1
X_07062_ _07062_/A1 _07103_/A1 _07062_/Z vdd vdd vss vss gf180mcu_fd_sc_mcu7t5v0__or2_1
X_06013_ _09593_/Q _06280_/B _06013_/Z vdd vdd vss vss gf180mcu_fd_sc_mcu7t5v0__and2_1
X_07964_ _09716_/Q _07963_/Z _08009_/A1 vdd vdd vss vss gf180mcu_fd_sc_mcu7t5v0__nand2_1
X_07895_ _07878_/Z _07897_/A3 _07895_/Z vdd vdd vss vss gf180mcu_fd_sc_mcu7t5v0__and2_1
X_09703_ _09703_/D clk _09703_/Q vdd vdd vss vss gf180mcu_fd_sc_mcu7t5v0__dffq_1
X_06915_ _06913_/Z _06948_/B _06916_/A2 vdd vdd vss vss gf180mcu_fd_sc_mcu7t5v0__nor2_1
X_06846_ _09710_/Q _06845_/Z _06928_/A2 vdd vdd vss vss gf180mcu_fd_sc_mcu7t5v0__nand2_1
X_09634_ _09634_/D clk _09634_/Q vdd vdd vss vss gf180mcu_fd_sc_mcu7t5v0__dffq_2
X_06777_ _09713_/Q _06752_/I _06889_/A1 vdd vdd vss vss gf180mcu_fd_sc_mcu7t5v0__nand2_1
X_09565_ _09565_/D clk _09565_/Q vdd vdd vss vss gf180mcu_fd_sc_mcu7t5v0__dffq_2
X_05728_ _05694_/B _05728_/A2 _05735_/A2 vdd vdd vss vss gf180mcu_fd_sc_mcu7t5v0__nand2_1
X_09496_ _09496_/D clk _09496_/Q vdd vdd vss vss gf180mcu_fd_sc_mcu7t5v0__dffq_1
X_08516_ _09713_/Q _08700_/A2 _08516_/B1 _08699_/A2 _08667_/C _08517_/C vdd
+ vdd vss vss gf180mcu_fd_sc_mcu7t5v0__aoi221_1
X_08447_ _08447_/A1 _08447_/A2 _08447_/B1 _08476_/C _08449_/A2 vdd vdd
+ vss vss gf180mcu_fd_sc_mcu7t5v0__oai22_1
X_05659_ _05974_/A1 _05928_/B _05965_/A2 vdd vdd vss vss gf180mcu_fd_sc_mcu7t5v0__nor2_2
X_08378_ _09402_/A1 _08385_/A2 _08385_/B1 _08378_/B2 _09694_/D vdd vdd
+ vss vss gf180mcu_fd_sc_mcu7t5v0__oai22_1
X_07329_ _07330_/A2 _07650_/I0 _07611_/A1 _07649_/A1 vdd vdd vss vss
+ gf180mcu_fd_sc_mcu7t5v0__nand3_4
XTAP_1441 vdd vss gf180mcu_fd_sc_mcu7t5v0__filltie
XTAP_1430 vdd vss gf180mcu_fd_sc_mcu7t5v0__filltie
XTAP_1452 vdd vss gf180mcu_fd_sc_mcu7t5v0__filltie
XTAP_1463 vdd vss gf180mcu_fd_sc_mcu7t5v0__filltie
XTAP_1474 vdd vss gf180mcu_fd_sc_mcu7t5v0__filltie
XTAP_1485 vdd vss gf180mcu_fd_sc_mcu7t5v0__filltie
XTAP_1496 vdd vss gf180mcu_fd_sc_mcu7t5v0__filltie
X_04961_ _09517_/Q _05365_/B2 vdd vdd vss vss gf180mcu_fd_sc_mcu7t5v0__clkinv_1
X_06700_ _08291_/B _06941_/A2 _06702_/A2 vdd vdd vss vss gf180mcu_fd_sc_mcu7t5v0__nor2_1
X_07680_ _09679_/Q _07680_/A2 _07680_/B _07741_/A3 vdd vdd vss vss
+ gf180mcu_fd_sc_mcu7t5v0__oai21_4
X_04892_ _09435_/Q _05280_/B2 vdd vdd vss vss gf180mcu_fd_sc_mcu7t5v0__clkinv_1
X_06631_ _06350_/C _06631_/A2 _08565_/C _06632_/B2 vdd vdd vss vss
+ gf180mcu_fd_sc_mcu7t5v0__aoi21_1
X_06562_ _09716_/Q _06562_/A2 _06614_/A2 vdd vdd vss vss gf180mcu_fd_sc_mcu7t5v0__nand2_1
X_09350_ _09996_/Q _09355_/A2 _09351_/B vdd vdd vss vss gf180mcu_fd_sc_mcu7t5v0__nor2_1
X_08301_ _08245_/Z _08302_/A3 _08327_/A2 vdd vdd vss vss gf180mcu_fd_sc_mcu7t5v0__nor2_1
X_05513_ _05513_/A1 _05513_/A2 _05515_/B1 vdd vdd vss vss gf180mcu_fd_sc_mcu7t5v0__nand2_1
X_09281_ _09966_/Q _09286_/A2 _09282_/B vdd vdd vss vss gf180mcu_fd_sc_mcu7t5v0__nor2_1
X_06493_ _09714_/Q _06493_/A2 _06493_/B1 _06628_/B2 _06590_/C _06494_/A2 vdd
+ vdd vss vss gf180mcu_fd_sc_mcu7t5v0__aoi221_1
X_08232_ _08227_/I _08230_/B _08232_/A3 _08232_/Z vdd vdd vss vss
+ gf180mcu_fd_sc_mcu7t5v0__xor3_1
X_05444_ _09836_/Q _05627_/A2 _05627_/B1 _09804_/Q _05446_/A1 vdd vdd
+ vss vss gf180mcu_fd_sc_mcu7t5v0__aoi22_1
X_05375_ _09405_/A1 _05379_/A2 _05379_/B1 _05375_/B2 _09529_/D vdd vdd
+ vss vss gf180mcu_fd_sc_mcu7t5v0__oai22_1
X_08163_ _08133_/Z _08234_/A2 _08234_/B _09713_/Q _08286_/A1 vdd vdd vss
+ vss gf180mcu_fd_sc_mcu7t5v0__oai211_4
X_08094_ _09693_/Q _09670_/Q _08095_/B vdd vdd vss vss gf180mcu_fd_sc_mcu7t5v0__nand2_1
X_07114_ _07114_/I _07144_/A2 vdd vdd vss vss gf180mcu_fd_sc_mcu7t5v0__clkinv_1
X_07045_ _07003_/B _07000_/Z _07178_/B _07046_/A2 vdd vdd vss vss
+ gf180mcu_fd_sc_mcu7t5v0__oai21_1
X_08996_ _09404_/A1 _09001_/A2 _09001_/B1 _08996_/B2 _09845_/D vdd vdd
+ vss vss gf180mcu_fd_sc_mcu7t5v0__oai22_1
X_07947_ _07947_/A1 _07947_/A2 _07947_/A3 _07947_/Z vdd vdd vss vss
+ gf180mcu_fd_sc_mcu7t5v0__xor3_1
X_07878_ _07873_/I _07877_/C _07878_/A3 _07878_/Z vdd vdd vss vss
+ gf180mcu_fd_sc_mcu7t5v0__xor3_1
X_06829_ _06829_/A1 _06829_/A2 _06829_/B _06876_/A1 vdd vdd vss vss
+ gf180mcu_fd_sc_mcu7t5v0__oai21_1
X_09617_ _09617_/D clk _09617_/Q vdd vdd vss vss gf180mcu_fd_sc_mcu7t5v0__dffq_2
X_09548_ _09548_/D clk _09548_/Q vdd vdd vss vss gf180mcu_fd_sc_mcu7t5v0__dffq_1
X_09479_ _09479_/D clk _09479_/Q vdd vdd vss vss gf180mcu_fd_sc_mcu7t5v0__dffq_1
XTAP_1260 vdd vss gf180mcu_fd_sc_mcu7t5v0__filltie
XTAP_1271 vdd vss gf180mcu_fd_sc_mcu7t5v0__filltie
XTAP_1282 vdd vss gf180mcu_fd_sc_mcu7t5v0__filltie
XTAP_1293 vdd vss gf180mcu_fd_sc_mcu7t5v0__filltie
X_05160_ _09765_/Q _05160_/A2 _05161_/A3 vdd vdd vss vss gf180mcu_fd_sc_mcu7t5v0__nand2_1
X_05091_ _09505_/Q _05349_/B2 vdd vdd vss vss gf180mcu_fd_sc_mcu7t5v0__clkinv_1
X_08850_ _09778_/Q _08850_/A2 _08851_/A2 vdd vdd vss vss gf180mcu_fd_sc_mcu7t5v0__nand2_1
X_07801_ _09671_/Q _07819_/A1 _07798_/Z _07801_/Z vdd vdd vss vss
+ gf180mcu_fd_sc_mcu7t5v0__xor3_1
X_05993_ _06307_/A1 _06305_/A1 _05996_/B vdd vdd vss vss gf180mcu_fd_sc_mcu7t5v0__nor2_4
X_08781_ _09780_/Q _08782_/A2 _09226_/B _08782_/B vdd vdd vss vss
+ gf180mcu_fd_sc_mcu7t5v0__oai21_1
X_07732_ _08060_/A2 _07733_/A2 _07740_/A1 vdd vdd vss vss gf180mcu_fd_sc_mcu7t5v0__nor2_1
X_04944_ _09869_/Q _09026_/B2 vdd vdd vss vss gf180mcu_fd_sc_mcu7t5v0__clkinv_1
X_04875_ _09605_/Q _06645_/B2 vdd vdd vss vss gf180mcu_fd_sc_mcu7t5v0__clkinv_1
X_07663_ _09992_/Q _09073_/A2 _08734_/B _07664_/B vdd vdd vss vss
+ gf180mcu_fd_sc_mcu7t5v0__oai21_1
X_06614_ _06614_/A1 _06614_/A2 _06563_/Z _06614_/B2 _06615_/A3 vdd vdd
+ vss vss gf180mcu_fd_sc_mcu7t5v0__oai22_1
X_09402_ _09402_/A1 _09409_/A2 _09409_/B1 _09402_/B2 _10019_/D vdd vdd
+ vss vss gf180mcu_fd_sc_mcu7t5v0__oai22_1
X_09333_ _09399_/A1 _09333_/A2 _09333_/B _09399_/C _09988_/D vdd vdd vss
+ vss gf180mcu_fd_sc_mcu7t5v0__aoi211_1
X_07594_ _07595_/A1 _07595_/A2 _07618_/A1 vdd vdd vss vss gf180mcu_fd_sc_mcu7t5v0__nand2_1
X_06545_ _06545_/A1 _06526_/Z _06545_/B _06596_/A1 vdd vdd vss vss
+ gf180mcu_fd_sc_mcu7t5v0__aoi21_1
X_06476_ _09596_/Q _06480_/A2 _06498_/A2 vdd vdd vss vss gf180mcu_fd_sc_mcu7t5v0__nor2_1
X_09264_ _09300_/A1 _09356_/A2 _09274_/A2 vdd vdd vss vss gf180mcu_fd_sc_mcu7t5v0__nor2_4
X_09195_ _09931_/Q _09173_/B _09257_/B _09196_/B vdd vdd vss vss gf180mcu_fd_sc_mcu7t5v0__oai21_1
X_05427_ _05631_/C1 _05427_/A2 _09400_/A2 _05427_/B2 _05430_/A1 vdd vdd
+ vss vss gf180mcu_fd_sc_mcu7t5v0__aoi22_1
X_08215_ _08358_/I0 _08215_/A2 _08215_/B _08216_/B vdd vdd vss vss
+ gf180mcu_fd_sc_mcu7t5v0__oai21_1
X_08146_ _08172_/A2 _08172_/B _08146_/Z vdd vdd vss vss gf180mcu_fd_sc_mcu7t5v0__xor2_1
X_05358_ _09408_/A1 _05359_/A2 _05359_/B1 _05358_/B2 _09512_/D vdd vdd
+ vss vss gf180mcu_fd_sc_mcu7t5v0__oai22_1
X_08077_ _09711_/Q _08359_/A2 _08083_/C vdd vdd vss vss gf180mcu_fd_sc_mcu7t5v0__nand2_1
X_05289_ _09402_/A1 _05296_/A2 _05296_/B1 _05289_/B2 _09442_/D vdd vdd
+ vss vss gf180mcu_fd_sc_mcu7t5v0__oai22_1
X_07028_ _09712_/Q _07003_/B _07062_/A1 vdd vdd vss vss gf180mcu_fd_sc_mcu7t5v0__nand2_1
X_08979_ _09407_/A1 _08981_/A2 _08981_/B1 _08979_/B2 _09832_/D vdd vdd
+ vss vss gf180mcu_fd_sc_mcu7t5v0__oai22_1
XTAP_329 vdd vss gf180mcu_fd_sc_mcu7t5v0__filltie
XTAP_318 vdd vss gf180mcu_fd_sc_mcu7t5v0__filltie
XTAP_307 vdd vss gf180mcu_fd_sc_mcu7t5v0__filltie
X_06330_ _06638_/A1 _09601_/Q _06413_/A1 vdd vdd vss vss gf180mcu_fd_sc_mcu7t5v0__nor2_2
XTAP_1090 vdd vss gf180mcu_fd_sc_mcu7t5v0__filltie
X_06261_ _09716_/Q _06261_/A2 _06261_/B _06262_/A4 vdd vdd vss vss
+ gf180mcu_fd_sc_mcu7t5v0__oai21_1
X_08000_ _07771_/C _07999_/Z _08014_/B vdd vdd vss vss gf180mcu_fd_sc_mcu7t5v0__nor2_1
X_05212_ _09916_/Q _09074_/B _09209_/A2 _05213_/A2 vdd vdd vss vss
+ gf180mcu_fd_sc_mcu7t5v0__nand3_1
X_06192_ _09576_/Q _06211_/A1 _06189_/Z _06192_/Z vdd vdd vss vss
+ gf180mcu_fd_sc_mcu7t5v0__xor3_1
X_05143_ _09246_/A2 _05143_/A2 _05143_/B _09463_/D vdd vdd vss vss
+ gf180mcu_fd_sc_mcu7t5v0__oai21_1
X_05074_ _09741_/Q _08754_/B2 vdd vdd vss vss gf180mcu_fd_sc_mcu7t5v0__clkinv_1
X_09951_ _09951_/D clk _09951_/Q vdd vdd vss vss gf180mcu_fd_sc_mcu7t5v0__dffq_1
X_08902_ _09793_/Q _08903_/A2 _08902_/B _09226_/B _08903_/B vdd vdd vss
+ vss gf180mcu_fd_sc_mcu7t5v0__oai211_1
XTAP_830 vdd vss gf180mcu_fd_sc_mcu7t5v0__filltie
XTAP_841 vdd vss gf180mcu_fd_sc_mcu7t5v0__filltie
XTAP_852 vdd vss gf180mcu_fd_sc_mcu7t5v0__filltie
X_09882_ _09882_/D clk _09882_/Q vdd vdd vss vss gf180mcu_fd_sc_mcu7t5v0__dffq_2
XTAP_874 vdd vss gf180mcu_fd_sc_mcu7t5v0__filltie
XTAP_863 vdd vss gf180mcu_fd_sc_mcu7t5v0__filltie
XTAP_885 vdd vss gf180mcu_fd_sc_mcu7t5v0__filltie
X_08833_ _09772_/Q _08829_/Z _08845_/B _08834_/A2 vdd vdd vss vss
+ gf180mcu_fd_sc_mcu7t5v0__oai21_1
XTAP_896 vdd vss gf180mcu_fd_sc_mcu7t5v0__filltie
X_08764_ _08766_/A1 _08763_/Z _09744_/D vdd vdd vss vss gf180mcu_fd_sc_mcu7t5v0__nor2_1
X_05976_ _05976_/A1 _09104_/A2 _05976_/B _09569_/D vdd vdd vss vss
+ gf180mcu_fd_sc_mcu7t5v0__aoi21_1
X_04927_ _09476_/Q _05312_/B2 vdd vdd vss vss gf180mcu_fd_sc_mcu7t5v0__clkinv_1
X_07715_ _09676_/Q _07715_/A2 _07803_/B vdd vdd vss vss gf180mcu_fd_sc_mcu7t5v0__nand2_1
X_08695_ _08695_/A1 _08693_/Z _08705_/C vdd vdd vss vss gf180mcu_fd_sc_mcu7t5v0__nor2_1
X_04858_ _09410_/Q _05225_/A1 vdd vdd vss vss gf180mcu_fd_sc_mcu7t5v0__clkinv_1
X_07646_ _09717_/Q _07646_/A2 _07646_/A3 _07648_/B vdd vdd vss vss
+ gf180mcu_fd_sc_mcu7t5v0__xor3_1
X_04789_ _09656_/Q _07660_/A1 vdd vdd vss vss gf180mcu_fd_sc_mcu7t5v0__clkinv_1
X_07577_ _09712_/Q _07475_/I _07577_/B _07635_/B1 vdd vdd vss vss
+ gf180mcu_fd_sc_mcu7t5v0__aoi21_1
X_06528_ _09597_/Q _06545_/A1 _06525_/Z _06528_/Z vdd vdd vss vss
+ gf180mcu_fd_sc_mcu7t5v0__xor3_1
X_09316_ _09393_/A1 _09322_/A2 _09316_/B _09399_/C _09980_/D vdd vdd vss
+ vss gf180mcu_fd_sc_mcu7t5v0__aoi211_1
X_09247_ _09467_/Q _09952_/Q _09257_/B _09248_/B vdd vdd vss vss gf180mcu_fd_sc_mcu7t5v0__oai21_1
X_06459_ _09604_/Q _06141_/B _06605_/A2 _07494_/B _06459_/C _06555_/A2 vdd vdd
+ vss vss gf180mcu_fd_sc_mcu7t5v0__aoi221_4
X_09178_ _09927_/Q _09173_/B _09257_/B _09179_/B vdd vdd vss vss gf180mcu_fd_sc_mcu7t5v0__oai21_1
X_08129_ _07452_/C _08129_/A2 _08129_/A3 _08224_/A1 vdd vdd vss vss
+ gf180mcu_fd_sc_mcu7t5v0__nor3_4
X_10022_ _10022_/D clk _10022_/Q vdd vdd vss vss gf180mcu_fd_sc_mcu7t5v0__dffq_1
XPHY_140 vdd vss gf180mcu_fd_sc_mcu7t5v0__endcap
XPHY_151 vdd vss gf180mcu_fd_sc_mcu7t5v0__endcap
XPHY_162 vdd vss gf180mcu_fd_sc_mcu7t5v0__endcap
XPHY_173 vdd vss gf180mcu_fd_sc_mcu7t5v0__endcap
XPHY_184 vdd vss gf180mcu_fd_sc_mcu7t5v0__endcap
XPHY_195 vdd vss gf180mcu_fd_sc_mcu7t5v0__endcap
X_05830_ _05830_/A1 _05830_/A2 _05830_/B _05851_/A1 vdd vdd vss vss
+ gf180mcu_fd_sc_mcu7t5v0__oai21_1
X_05761_ _05761_/A1 _05761_/A2 _05761_/B _05808_/A2 vdd vdd vss vss
+ gf180mcu_fd_sc_mcu7t5v0__aoi21_1
X_07500_ _07548_/A1 _07500_/A2 _07500_/Z vdd vdd vss vss gf180mcu_fd_sc_mcu7t5v0__xor2_1
X_05692_ _09711_/Q _05811_/A2 _05692_/A3 _05692_/Z vdd vdd vss vss
+ gf180mcu_fd_sc_mcu7t5v0__xor3_1
X_04712_ _09928_/Q _05200_/A1 vdd vdd vss vss gf180mcu_fd_sc_mcu7t5v0__clkinv_1
X_08480_ _08670_/B _08480_/A2 _09704_/D vdd vdd vss vss gf180mcu_fd_sc_mcu7t5v0__nor2_1
X_07431_ _09711_/Q _07623_/A2 _07570_/A1 vdd vdd vss vss gf180mcu_fd_sc_mcu7t5v0__nand2_2
X_07362_ _09711_/Q _07349_/Z _07361_/Z _07651_/B _07368_/C vdd vdd vss
+ vss gf180mcu_fd_sc_mcu7t5v0__oai22_1
X_06313_ _06313_/A1 _09073_/A2 _06313_/B _09583_/D vdd vdd vss vss
+ gf180mcu_fd_sc_mcu7t5v0__aoi21_1
X_09101_ _09278_/C _09101_/A2 _09102_/C vdd vdd vss vss gf180mcu_fd_sc_mcu7t5v0__nand2_1
X_07293_ _09994_/Q _09073_/A2 _08734_/B _07294_/B vdd vdd vss vss
+ gf180mcu_fd_sc_mcu7t5v0__oai21_1
X_06244_ _06266_/A1 _06266_/A2 _06246_/A2 vdd vdd vss vss gf180mcu_fd_sc_mcu7t5v0__xnor2_1
X_09032_ _09899_/Q _09032_/A2 _09897_/Q _09033_/I vdd vdd vss vss
+ gf180mcu_fd_sc_mcu7t5v0__nor3_4
X_06175_ _06175_/A1 _06275_/A1 _06177_/A2 vdd vdd vss vss gf180mcu_fd_sc_mcu7t5v0__xnor2_1
X_05126_ _09257_/B _09523_/Q _08858_/B _05128_/A1 vdd vdd vss vss
+ gf180mcu_fd_sc_mcu7t5v0__nand3_1
X_09934_ _09934_/D clk _09934_/Q vdd vdd vss vss gf180mcu_fd_sc_mcu7t5v0__dffq_1
X_05057_ _09520_/Q _05368_/B2 vdd vdd vss vss gf180mcu_fd_sc_mcu7t5v0__clkinv_1
XTAP_660 vdd vss gf180mcu_fd_sc_mcu7t5v0__filltie
X_09865_ _09865_/D clk _09865_/Q vdd vdd vss vss gf180mcu_fd_sc_mcu7t5v0__dffq_1
XTAP_693 vdd vss gf180mcu_fd_sc_mcu7t5v0__filltie
XTAP_682 vdd vss gf180mcu_fd_sc_mcu7t5v0__filltie
XTAP_671 vdd vss gf180mcu_fd_sc_mcu7t5v0__filltie
X_08816_ _09767_/Q _08819_/A2 _08816_/Z vdd vdd vss vss gf180mcu_fd_sc_mcu7t5v0__xor2_1
X_09796_ _09796_/D clk _09796_/Q vdd vdd vss vss gf180mcu_fd_sc_mcu7t5v0__dffq_1
X_08747_ _09023_/A1 _08755_/A2 _08755_/B1 vdd vdd vss vss gf180mcu_fd_sc_mcu7t5v0__nand2_2
X_05959_ _09717_/Q _05945_/Z _05959_/Z vdd vdd vss vss gf180mcu_fd_sc_mcu7t5v0__or2_1
XTAP_1815 vdd vss gf180mcu_fd_sc_mcu7t5v0__filltie
XTAP_1804 vdd vss gf180mcu_fd_sc_mcu7t5v0__filltie
X_08678_ _09715_/Q _08678_/A2 _08679_/A3 vdd vdd vss vss gf180mcu_fd_sc_mcu7t5v0__nand2_1
XTAP_1848 vdd vss gf180mcu_fd_sc_mcu7t5v0__filltie
XTAP_1837 vdd vss gf180mcu_fd_sc_mcu7t5v0__filltie
XTAP_1826 vdd vss gf180mcu_fd_sc_mcu7t5v0__filltie
X_07629_ _09710_/Q _07646_/A2 _07630_/A2 vdd vdd vss vss gf180mcu_fd_sc_mcu7t5v0__nand2_1
XTAP_1859 vdd vss gf180mcu_fd_sc_mcu7t5v0__filltie
X_10005_ _10005_/D clk _10005_/Q vdd vdd vss vss gf180mcu_fd_sc_mcu7t5v0__dffq_1
X_07980_ _07980_/A1 _07949_/Z _07980_/B _07997_/A2 vdd vdd vss vss
+ gf180mcu_fd_sc_mcu7t5v0__aoi21_1
X_06931_ _09565_/Q _09633_/Q _09675_/Q _09882_/Q _09625_/Q _09624_/Q _06931_/Z vdd
+ vdd vss vss gf180mcu_fd_sc_mcu7t5v0__mux4_2
X_09650_ _09650_/D clk _09650_/Q vdd vdd vss vss gf180mcu_fd_sc_mcu7t5v0__dffq_2
X_06862_ _06792_/Z _06910_/A2 _06910_/B _06863_/A2 vdd vdd vss vss
+ gf180mcu_fd_sc_mcu7t5v0__oai21_1
X_08601_ _08689_/A2 _08659_/A1 _08601_/Z vdd vdd vss vss gf180mcu_fd_sc_mcu7t5v0__xor2_1
X_06793_ _09710_/Q _06792_/Z _06797_/A3 vdd vdd vss vss gf180mcu_fd_sc_mcu7t5v0__nand2_1
X_05813_ _05901_/A2 _05814_/A2 _05922_/A1 vdd vdd vss vss gf180mcu_fd_sc_mcu7t5v0__nand2_1
X_09581_ _09581_/D clk _09581_/Q vdd vdd vss vss gf180mcu_fd_sc_mcu7t5v0__dffq_4
X_08532_ _09713_/Q _08688_/A2 _08626_/A2 _09710_/Q _08534_/A2 vdd vdd
+ vss vss gf180mcu_fd_sc_mcu7t5v0__aoi22_1
X_05744_ _09878_/Q _09570_/Q _09569_/Q _05746_/B vdd vdd vss vss gf180mcu_fd_sc_mcu7t5v0__nand3_2
X_08463_ _08463_/A1 _08461_/I _08463_/Z vdd vdd vss vss gf180mcu_fd_sc_mcu7t5v0__xor2_1
X_05675_ _05689_/B _05811_/A2 vdd vdd vss vss gf180mcu_fd_sc_mcu7t5v0__clkinv_1
X_07414_ _07414_/A1 _07414_/A2 _07414_/Z vdd vdd vss vss gf180mcu_fd_sc_mcu7t5v0__and2_1
X_08394_ _09720_/Q _08729_/A1 _08404_/A2 vdd vdd vss vss gf180mcu_fd_sc_mcu7t5v0__nand2_2
X_07345_ _08291_/B _07317_/Z _07358_/A1 vdd vdd vss vss gf180mcu_fd_sc_mcu7t5v0__nand2_1
X_07276_ _07276_/A1 _07276_/A2 _07275_/Z _07276_/Z vdd vdd vss vss
+ gf180mcu_fd_sc_mcu7t5v0__xor3_1
X_09015_ _09403_/A1 _09021_/A2 _09021_/B1 _09015_/B2 _09860_/D vdd vdd
+ vss vss gf180mcu_fd_sc_mcu7t5v0__oai22_1
X_06227_ _09564_/Q _05985_/Z _06227_/Z vdd vdd vss vss gf180mcu_fd_sc_mcu7t5v0__and2_1
X_06158_ _06072_/C _06143_/Z _06158_/B _08706_/B _06159_/A2 vdd vdd vss
+ vss gf180mcu_fd_sc_mcu7t5v0__oai211_1
X_06089_ _06089_/A1 _06174_/A1 _06089_/Z vdd vdd vss vss gf180mcu_fd_sc_mcu7t5v0__or2_1
X_05109_ _09909_/Q _09908_/Q _09299_/A3 vdd vdd vss vss gf180mcu_fd_sc_mcu7t5v0__nor2_4
X_09917_ _09917_/D clk _09917_/Q vdd vdd vss vss gf180mcu_fd_sc_mcu7t5v0__dffq_2
X_09848_ _09848_/D clk _09848_/Q vdd vdd vss vss gf180mcu_fd_sc_mcu7t5v0__dffq_1
XTAP_490 vdd vss gf180mcu_fd_sc_mcu7t5v0__filltie
X_09779_ _09779_/D clk _09779_/Q vdd vdd vss vss gf180mcu_fd_sc_mcu7t5v0__dffq_1
XTAP_1601 vdd vss gf180mcu_fd_sc_mcu7t5v0__filltie
XTAP_1612 vdd vss gf180mcu_fd_sc_mcu7t5v0__filltie
XTAP_1623 vdd vss gf180mcu_fd_sc_mcu7t5v0__filltie
XTAP_1656 vdd vss gf180mcu_fd_sc_mcu7t5v0__filltie
XTAP_1667 vdd vss gf180mcu_fd_sc_mcu7t5v0__filltie
XTAP_1634 vdd vss gf180mcu_fd_sc_mcu7t5v0__filltie
XTAP_1645 vdd vss gf180mcu_fd_sc_mcu7t5v0__filltie
XTAP_1689 vdd vss gf180mcu_fd_sc_mcu7t5v0__filltie
XTAP_1678 vdd vss gf180mcu_fd_sc_mcu7t5v0__filltie
X_05460_ _08791_/B _05460_/A2 _09551_/D vdd vdd vss vss gf180mcu_fd_sc_mcu7t5v0__and2_1
X_05391_ _09013_/A1 _05399_/A2 _05399_/B1 vdd vdd vss vss gf180mcu_fd_sc_mcu7t5v0__nand2_2
X_07130_ _07131_/A1 _07131_/A2 _07130_/B _07184_/A2 vdd vdd vss vss
+ gf180mcu_fd_sc_mcu7t5v0__aoi21_1
X_07061_ _09713_/Q _07000_/Z _07103_/A1 vdd vdd vss vss gf180mcu_fd_sc_mcu7t5v0__nand2_1
X_06012_ _09559_/Q _05985_/Z _06012_/Z vdd vdd vss vss gf180mcu_fd_sc_mcu7t5v0__and2_1
X_07963_ _08005_/A2 _08006_/A1 _07963_/Z vdd vdd vss vss gf180mcu_fd_sc_mcu7t5v0__xor2_1
X_07894_ _07878_/Z _07897_/A3 _07926_/A2 vdd vdd vss vss gf180mcu_fd_sc_mcu7t5v0__nor2_1
X_09702_ _09702_/D clk _09702_/Q vdd vdd vss vss gf180mcu_fd_sc_mcu7t5v0__dffq_1
X_06914_ _06864_/Z _06914_/A2 _06914_/B _06948_/B vdd vdd vss vss
+ gf180mcu_fd_sc_mcu7t5v0__aoi21_1
X_06845_ _09563_/Q _09631_/Q _09673_/Q _09880_/Q _09625_/Q _09624_/Q _06845_/Z vdd
+ vdd vss vss gf180mcu_fd_sc_mcu7t5v0__mux4_4
X_09633_ _09633_/D clk _09633_/Q vdd vdd vss vss gf180mcu_fd_sc_mcu7t5v0__dffq_2
X_09564_ _09564_/D clk _09564_/Q vdd vdd vss vss gf180mcu_fd_sc_mcu7t5v0__dffq_2
X_08515_ _09705_/Q _08517_/A2 _08515_/A3 _08515_/Z vdd vdd vss vss
+ gf180mcu_fd_sc_mcu7t5v0__xor3_1
X_06776_ _09713_/Q _06752_/I _06780_/B2 vdd vdd vss vss gf180mcu_fd_sc_mcu7t5v0__nor2_1
X_05727_ _05763_/A1 _05725_/Z _05728_/A2 vdd vdd vss vss gf180mcu_fd_sc_mcu7t5v0__nand2_1
X_09495_ _09495_/D clk _09495_/Q vdd vdd vss vss gf180mcu_fd_sc_mcu7t5v0__dffq_1
X_08446_ _08446_/A1 _08444_/Z _08447_/B1 vdd vdd vss vss gf180mcu_fd_sc_mcu7t5v0__xnor2_1
X_05658_ _05666_/A2 _05930_/B2 _05694_/B _05658_/B _05662_/B1 vdd vdd
+ vss vss gf180mcu_fd_sc_mcu7t5v0__oai31_1
X_08377_ _09089_/B _08385_/A2 _08385_/B1 vdd vdd vss vss gf180mcu_fd_sc_mcu7t5v0__nand2_2
X_05589_ _09741_/Q _05627_/A2 _05627_/B1 _09873_/Q _05591_/A1 vdd vdd
+ vss vss gf180mcu_fd_sc_mcu7t5v0__aoi22_1
X_07328_ _09656_/Q _09655_/Q _07611_/A1 vdd vdd vss vss gf180mcu_fd_sc_mcu7t5v0__nand2_4
X_07259_ _08682_/A1 _09638_/Q _09637_/Q _07260_/C vdd vdd vss vss
+ gf180mcu_fd_sc_mcu7t5v0__aoi21_1
XTAP_1420 vdd vss gf180mcu_fd_sc_mcu7t5v0__filltie
XTAP_1442 vdd vss gf180mcu_fd_sc_mcu7t5v0__filltie
XTAP_1431 vdd vss gf180mcu_fd_sc_mcu7t5v0__filltie
XTAP_1453 vdd vss gf180mcu_fd_sc_mcu7t5v0__filltie
XTAP_1464 vdd vss gf180mcu_fd_sc_mcu7t5v0__filltie
XTAP_1475 vdd vss gf180mcu_fd_sc_mcu7t5v0__filltie
XTAP_1486 vdd vss gf180mcu_fd_sc_mcu7t5v0__filltie
XTAP_1497 vdd vss gf180mcu_fd_sc_mcu7t5v0__filltie
X_04960_ _09537_/Q _05385_/B2 vdd vdd vss vss gf180mcu_fd_sc_mcu7t5v0__clkinv_1
X_06630_ _06630_/A1 _06630_/A2 _06630_/B _06630_/C _06631_/A2 vdd vdd
+ vss vss gf180mcu_fd_sc_mcu7t5v0__oai211_1
X_04891_ _09427_/Q _05268_/B2 vdd vdd vss vss gf180mcu_fd_sc_mcu7t5v0__clkinv_1
X_06561_ _09716_/Q _06608_/A2 _06564_/A3 vdd vdd vss vss gf180mcu_fd_sc_mcu7t5v0__nand2_1
X_06492_ _09714_/Q _06555_/A2 _06493_/B1 vdd vdd vss vss gf180mcu_fd_sc_mcu7t5v0__nand2_1
X_08300_ _08245_/Z _08302_/A3 _08327_/B vdd vdd vss vss gf180mcu_fd_sc_mcu7t5v0__nand2_1
X_05512_ _09445_/Q _05628_/A2 _05628_/B1 _09429_/Q _05513_/A2 vdd vdd
+ vss vss gf180mcu_fd_sc_mcu7t5v0__aoi22_1
X_09280_ _09393_/A1 _09286_/A2 _09280_/B _09399_/C _09965_/D vdd vdd vss
+ vss gf180mcu_fd_sc_mcu7t5v0__aoi211_1
X_08231_ _08229_/B _08189_/Z _08230_/B _08275_/A2 vdd vdd vss vss
+ gf180mcu_fd_sc_mcu7t5v0__nand3_1
X_05443_ _05443_/A1 _05443_/A2 _05457_/B1 vdd vdd vss vss gf180mcu_fd_sc_mcu7t5v0__nand2_1
X_05374_ _09404_/A1 _05379_/A2 _05379_/B1 _05374_/B2 _09528_/D vdd vdd
+ vss vss gf180mcu_fd_sc_mcu7t5v0__oai22_1
X_08162_ _09713_/Q _08338_/A2 _08166_/B2 vdd vdd vss vss gf180mcu_fd_sc_mcu7t5v0__nor2_1
X_08093_ _09693_/Q _09628_/Q _08095_/A2 vdd vdd vss vss gf180mcu_fd_sc_mcu7t5v0__nor2_1
X_07113_ _07113_/A1 _07113_/A2 _07113_/A3 _07114_/I vdd vdd vss vss
+ gf180mcu_fd_sc_mcu7t5v0__xnor3_1
X_07044_ _07044_/A1 _07044_/A2 _07044_/Z vdd vdd vss vss gf180mcu_fd_sc_mcu7t5v0__and2_1
X_08995_ _09403_/A1 _09001_/A2 _09001_/B1 _08995_/B2 _09844_/D vdd vdd
+ vss vss gf180mcu_fd_sc_mcu7t5v0__oai22_1
X_07946_ _07947_/A1 _07989_/S _07945_/Z _07996_/A1 vdd vdd vss vss
+ gf180mcu_fd_sc_mcu7t5v0__nor3_1
X_07877_ _07877_/A1 _07877_/A2 _07877_/B _07877_/C _07927_/A2 vdd vdd
+ vss vss gf180mcu_fd_sc_mcu7t5v0__oai211_1
X_06828_ _09618_/Q _08565_/C _06875_/A1 vdd vdd vss vss gf180mcu_fd_sc_mcu7t5v0__nand2_1
X_09616_ _09616_/D clk _09616_/Q vdd vdd vss vss gf180mcu_fd_sc_mcu7t5v0__dffq_2
X_09547_ _09547_/D clk _09547_/Q vdd vdd vss vss gf180mcu_fd_sc_mcu7t5v0__dffq_1
X_06759_ _06760_/A1 _06760_/A2 _06760_/B _06786_/B vdd vdd vss vss
+ gf180mcu_fd_sc_mcu7t5v0__or3_1
X_09478_ _09478_/D clk _09478_/Q vdd vdd vss vss gf180mcu_fd_sc_mcu7t5v0__dffq_1
X_08429_ _08631_/A2 _08425_/Z _08429_/B _08430_/A2 vdd vdd vss vss
+ gf180mcu_fd_sc_mcu7t5v0__oai21_1
XTAP_1250 vdd vss gf180mcu_fd_sc_mcu7t5v0__filltie
XTAP_1261 vdd vss gf180mcu_fd_sc_mcu7t5v0__filltie
XTAP_1272 vdd vss gf180mcu_fd_sc_mcu7t5v0__filltie
XTAP_1283 vdd vss gf180mcu_fd_sc_mcu7t5v0__filltie
XTAP_1294 vdd vss gf180mcu_fd_sc_mcu7t5v0__filltie
X_05090_ _09533_/Q _05379_/B2 vdd vdd vss vss gf180mcu_fd_sc_mcu7t5v0__clkinv_1
X_07800_ _09671_/Q _07798_/Z _07819_/B vdd vdd vss vss gf180mcu_fd_sc_mcu7t5v0__nand2_1
X_08780_ _08780_/A1 _08782_/A2 _08780_/B _09752_/D vdd vdd vss vss
+ gf180mcu_fd_sc_mcu7t5v0__aoi21_1
X_07731_ _07731_/A1 _07731_/A2 _07771_/C _07738_/B1 vdd vdd vss vss
+ gf180mcu_fd_sc_mcu7t5v0__oai21_1
X_05992_ _05992_/A1 _06039_/A1 _06008_/A2 vdd vdd vss vss gf180mcu_fd_sc_mcu7t5v0__nand2_1
X_04943_ _09902_/Q _09109_/B2 vdd vdd vss vss gf180mcu_fd_sc_mcu7t5v0__clkinv_1
X_04874_ _09639_/Q _07305_/B2 vdd vdd vss vss gf180mcu_fd_sc_mcu7t5v0__clkinv_1
X_07662_ _07662_/A1 _09073_/A2 _07662_/B _09657_/D vdd vdd vss vss
+ gf180mcu_fd_sc_mcu7t5v0__aoi21_1
X_06613_ _09712_/Q _06613_/A2 _06615_/A2 vdd vdd vss vss gf180mcu_fd_sc_mcu7t5v0__nand2_1
X_09401_ _09401_/A1 _09409_/A2 _09409_/B1 vdd vdd vss vss gf180mcu_fd_sc_mcu7t5v0__nand2_2
X_07593_ _07536_/Z _07619_/A1 _07593_/A3 _07595_/A2 vdd vdd vss vss
+ gf180mcu_fd_sc_mcu7t5v0__xnor3_1
X_06544_ _09598_/Q _08565_/C _06595_/A1 vdd vdd vss vss gf180mcu_fd_sc_mcu7t5v0__nand2_1
X_09332_ _09988_/Q _09333_/A2 _09333_/B vdd vdd vss vss gf180mcu_fd_sc_mcu7t5v0__nor2_1
X_06475_ _06475_/A1 _06475_/A2 _06480_/A2 vdd vdd vss vss gf180mcu_fd_sc_mcu7t5v0__xnor2_1
X_09263_ _09909_/Q _09908_/Q _09262_/Z _09356_/A2 vdd vdd vss vss
+ gf180mcu_fd_sc_mcu7t5v0__nand3_4
X_08214_ _09714_/Q _08359_/A2 _08215_/A2 _08319_/B2 _08359_/B _08215_/B vdd
+ vdd vss vss gf180mcu_fd_sc_mcu7t5v0__aoi221_1
X_05426_ _05426_/A1 _05426_/A2 _05428_/C2 vdd vdd vss vss gf180mcu_fd_sc_mcu7t5v0__nand2_1
X_09194_ _09554_/Q _09209_/A2 _09194_/B1 _09209_/B2 _09254_/A2 vdd vdd
+ vss vss gf180mcu_fd_sc_mcu7t5v0__aoi22_4
X_05357_ _09407_/A1 _05359_/A2 _05359_/B1 _05357_/B2 _09511_/D vdd vdd
+ vss vss gf180mcu_fd_sc_mcu7t5v0__oai22_1
X_08145_ _08145_/A1 _08145_/A2 _08145_/A3 _08172_/B vdd vdd vss vss
+ gf180mcu_fd_sc_mcu7t5v0__xnor3_1
X_08076_ _08076_/A1 _08076_/A2 _08083_/B1 vdd vdd vss vss gf180mcu_fd_sc_mcu7t5v0__xnor2_1
X_05288_ _08791_/B _05296_/A2 _05296_/B1 vdd vdd vss vss gf180mcu_fd_sc_mcu7t5v0__nand2_2
X_07027_ _09628_/Q _08565_/C _07058_/A1 vdd vdd vss vss gf180mcu_fd_sc_mcu7t5v0__nand2_1
X_08978_ _09406_/A1 _08981_/A2 _08981_/B1 _08978_/B2 _09831_/D vdd vdd
+ vss vss gf180mcu_fd_sc_mcu7t5v0__oai22_1
X_07929_ _09715_/Q _07712_/Z _07979_/A1 vdd vdd vss vss gf180mcu_fd_sc_mcu7t5v0__nand2_1
XTAP_319 vdd vss gf180mcu_fd_sc_mcu7t5v0__filltie
XTAP_308 vdd vss gf180mcu_fd_sc_mcu7t5v0__filltie
XTAP_1080 vdd vss gf180mcu_fd_sc_mcu7t5v0__filltie
XTAP_1091 vdd vss gf180mcu_fd_sc_mcu7t5v0__filltie
X_06260_ _06260_/A1 _06260_/A2 _06260_/B _06261_/B vdd vdd vss vss
+ gf180mcu_fd_sc_mcu7t5v0__oai21_1
X_05211_ _09899_/Q _09032_/A2 _09897_/Q _09100_/A1 vdd vdd vss vss
+ gf180mcu_fd_sc_mcu7t5v0__nand3_1
X_06191_ _09576_/Q _06189_/Z _06211_/B vdd vdd vss vss gf180mcu_fd_sc_mcu7t5v0__nand2_1
X_05142_ _09259_/B _09471_/Q _05143_/A2 vdd vdd vss vss gf180mcu_fd_sc_mcu7t5v0__nand2_1
X_05073_ _09800_/Q _08912_/B2 vdd vdd vss vss gf180mcu_fd_sc_mcu7t5v0__clkinv_1
X_09950_ _09950_/D clk _09950_/Q vdd vdd vss vss gf180mcu_fd_sc_mcu7t5v0__dffq_1
X_08901_ _09525_/Q _08901_/A2 _08903_/A2 vdd vdd vss vss gf180mcu_fd_sc_mcu7t5v0__nor2_1
XTAP_820 vdd vss gf180mcu_fd_sc_mcu7t5v0__filltie
XTAP_831 vdd vss gf180mcu_fd_sc_mcu7t5v0__filltie
XTAP_842 vdd vss gf180mcu_fd_sc_mcu7t5v0__filltie
XTAP_853 vdd vss gf180mcu_fd_sc_mcu7t5v0__filltie
X_09881_ _09881_/D clk _09881_/Q vdd vdd vss vss gf180mcu_fd_sc_mcu7t5v0__dffq_2
XTAP_875 vdd vss gf180mcu_fd_sc_mcu7t5v0__filltie
XTAP_864 vdd vss gf180mcu_fd_sc_mcu7t5v0__filltie
XTAP_886 vdd vss gf180mcu_fd_sc_mcu7t5v0__filltie
X_08832_ _09772_/Q _08829_/Z _08832_/Z vdd vdd vss vss gf180mcu_fd_sc_mcu7t5v0__and2_1
XTAP_897 vdd vss gf180mcu_fd_sc_mcu7t5v0__filltie
X_08763_ _09744_/Q _08760_/I _08763_/Z vdd vdd vss vss gf180mcu_fd_sc_mcu7t5v0__xor2_1
X_05975_ _10017_/Q _09104_/A2 _09278_/C _05976_/B vdd vdd vss vss
+ gf180mcu_fd_sc_mcu7t5v0__oai21_1
X_07714_ _09676_/Q _07715_/A2 _07909_/B vdd vdd vss vss gf180mcu_fd_sc_mcu7t5v0__and2_1
X_04926_ _09452_/Q _05301_/B2 vdd vdd vss vss gf180mcu_fd_sc_mcu7t5v0__clkinv_1
X_08694_ _09709_/Q _08694_/A2 _08693_/Z _08707_/A2 vdd vdd vss vss
+ gf180mcu_fd_sc_mcu7t5v0__xnor3_1
X_04857_ _09542_/Q _05392_/B2 vdd vdd vss vss gf180mcu_fd_sc_mcu7t5v0__clkinv_1
X_07645_ _07645_/A1 _07645_/A2 _07646_/A3 vdd vdd vss vss gf180mcu_fd_sc_mcu7t5v0__nand2_1
X_04788_ _09657_/Q _07662_/A1 vdd vdd vss vss gf180mcu_fd_sc_mcu7t5v0__clkinv_3
X_07576_ _09713_/Q _07475_/I _07635_/A2 vdd vdd vss vss gf180mcu_fd_sc_mcu7t5v0__nand2_1
X_06527_ _09597_/Q _06525_/Z _06545_/B vdd vdd vss vss gf180mcu_fd_sc_mcu7t5v0__and2_1
X_09315_ _09980_/Q _09322_/A2 _09316_/B vdd vdd vss vss gf180mcu_fd_sc_mcu7t5v0__nor2_1
X_09246_ _09467_/Q _09246_/A2 _09246_/B _09951_/D vdd vdd vss vss
+ gf180mcu_fd_sc_mcu7t5v0__aoi21_1
X_06458_ _09887_/Q _06387_/B _09603_/Q _06459_/C vdd vdd vss vss gf180mcu_fd_sc_mcu7t5v0__aoi21_2
X_05409_ _05409_/A1 _05409_/A2 _05428_/A2 vdd vdd vss vss gf180mcu_fd_sc_mcu7t5v0__nand2_1
X_06389_ _08452_/A1 _06605_/A2 _06389_/B1 _06389_/B2 _06603_/A2 vdd vdd
+ vss vss gf180mcu_fd_sc_mcu7t5v0__aoi22_4
X_09177_ _09399_/C _09177_/A2 _09926_/D vdd vdd vss vss gf180mcu_fd_sc_mcu7t5v0__nor2_1
X_08128_ _08128_/I _08225_/A1 vdd vdd vss vss gf180mcu_fd_sc_mcu7t5v0__clkinv_1
X_08059_ _09693_/Q _09627_/Q _08060_/B1 vdd vdd vss vss gf180mcu_fd_sc_mcu7t5v0__nor2_2
X_10021_ _10021_/D clk _10021_/Q vdd vdd vss vss gf180mcu_fd_sc_mcu7t5v0__dffq_1
XPHY_130 vdd vss gf180mcu_fd_sc_mcu7t5v0__endcap
XPHY_141 vdd vss gf180mcu_fd_sc_mcu7t5v0__endcap
XPHY_152 vdd vss gf180mcu_fd_sc_mcu7t5v0__endcap
XPHY_163 vdd vss gf180mcu_fd_sc_mcu7t5v0__endcap
XPHY_174 vdd vss gf180mcu_fd_sc_mcu7t5v0__endcap
XPHY_185 vdd vss gf180mcu_fd_sc_mcu7t5v0__endcap
XPHY_196 vdd vss gf180mcu_fd_sc_mcu7t5v0__endcap
X_05760_ _09561_/Q _05758_/Z _05761_/B vdd vdd vss vss gf180mcu_fd_sc_mcu7t5v0__xnor2_1
X_04711_ _09963_/Q _09274_/A1 vdd vdd vss vss gf180mcu_fd_sc_mcu7t5v0__clkinv_1
X_05691_ _05688_/Z _05691_/A2 _09711_/Q _05721_/A2 vdd vdd vss vss
+ gf180mcu_fd_sc_mcu7t5v0__aoi21_1
X_07430_ _07421_/Z _07526_/A2 _07526_/B _09710_/Q _07480_/A1 vdd vdd vss
+ vss gf180mcu_fd_sc_mcu7t5v0__oai211_2
X_07361_ _07556_/B2 _07388_/A1 _07361_/Z vdd vdd vss vss gf180mcu_fd_sc_mcu7t5v0__and2_1
X_09100_ _09100_/A1 _09100_/A2 _09399_/C _09896_/D vdd vdd vss vss
+ gf180mcu_fd_sc_mcu7t5v0__aoi21_1
X_06312_ _10013_/Q _09073_/A2 _09072_/B _06313_/B vdd vdd vss vss
+ gf180mcu_fd_sc_mcu7t5v0__oai21_1
X_09031_ _09409_/A1 _09031_/A2 _09031_/B1 _09031_/B2 _09874_/D vdd vdd
+ vss vss gf180mcu_fd_sc_mcu7t5v0__oai22_1
X_07292_ _08708_/B _07292_/A2 _07291_/Z _09633_/D vdd vdd vss vss
+ gf180mcu_fd_sc_mcu7t5v0__and3_1
X_06243_ _06267_/B2 _06242_/Z _06266_/A2 vdd vdd vss vss gf180mcu_fd_sc_mcu7t5v0__xnor2_1
X_06174_ _06174_/A1 _06224_/A2 _06218_/A1 vdd vdd vss vss gf180mcu_fd_sc_mcu7t5v0__nor2_1
X_05125_ _09784_/Q _09783_/Q _09782_/Q _05121_/Z _08858_/B vdd vdd vss
+ vss gf180mcu_fd_sc_mcu7t5v0__nand4_2
X_09933_ _09933_/D clk _09933_/Q vdd vdd vss vss gf180mcu_fd_sc_mcu7t5v0__dffq_1
X_05056_ _09540_/Q _05388_/B2 vdd vdd vss vss gf180mcu_fd_sc_mcu7t5v0__clkinv_1
XTAP_661 vdd vss gf180mcu_fd_sc_mcu7t5v0__filltie
XTAP_650 vdd vss gf180mcu_fd_sc_mcu7t5v0__filltie
X_09864_ _09864_/D clk _09864_/Q vdd vdd vss vss gf180mcu_fd_sc_mcu7t5v0__dffq_1
XTAP_694 vdd vss gf180mcu_fd_sc_mcu7t5v0__filltie
XTAP_683 vdd vss gf180mcu_fd_sc_mcu7t5v0__filltie
XTAP_672 vdd vss gf180mcu_fd_sc_mcu7t5v0__filltie
X_08815_ _08820_/A1 _08814_/Z _09766_/D vdd vdd vss vss gf180mcu_fd_sc_mcu7t5v0__nor2_1
X_09795_ _09795_/D clk _09795_/Q vdd vdd vss vss gf180mcu_fd_sc_mcu7t5v0__dffq_1
X_08746_ _09002_/A1 _09105_/A2 _08755_/A2 vdd vdd vss vss gf180mcu_fd_sc_mcu7t5v0__nand2_4
X_05958_ _09716_/Q _05923_/Z _05958_/B _05963_/A1 vdd vdd vss vss
+ gf180mcu_fd_sc_mcu7t5v0__aoi21_1
XTAP_1816 vdd vss gf180mcu_fd_sc_mcu7t5v0__filltie
XTAP_1805 vdd vss gf180mcu_fd_sc_mcu7t5v0__filltie
X_05889_ _09714_/Q _05711_/I _05897_/A1 vdd vdd vss vss gf180mcu_fd_sc_mcu7t5v0__nand2_1
X_04909_ _09419_/Q _05254_/B2 vdd vdd vss vss gf180mcu_fd_sc_mcu7t5v0__clkinv_1
X_08677_ _09714_/Q _08677_/A2 _08679_/A2 vdd vdd vss vss gf180mcu_fd_sc_mcu7t5v0__nand2_1
XTAP_1849 vdd vss gf180mcu_fd_sc_mcu7t5v0__filltie
XTAP_1838 vdd vss gf180mcu_fd_sc_mcu7t5v0__filltie
XTAP_1827 vdd vss gf180mcu_fd_sc_mcu7t5v0__filltie
X_07628_ _07628_/A1 _07628_/A2 _07646_/A2 vdd vdd vss vss gf180mcu_fd_sc_mcu7t5v0__nand2_2
X_07559_ _07396_/B _07559_/A2 _07554_/Z _07559_/A4 _07561_/B1 vdd vdd
+ vss vss gf180mcu_fd_sc_mcu7t5v0__nand4_1
X_09229_ _09943_/Q _09244_/A2 _09259_/B _09230_/B vdd vdd vss vss
+ gf180mcu_fd_sc_mcu7t5v0__oai21_1
X_10004_ _10004_/D clk _10004_/Q vdd vdd vss vss gf180mcu_fd_sc_mcu7t5v0__dffq_1
Xrepeater10 _09023_/A1 _08806_/B vdd vdd vss vss gf180mcu_fd_sc_mcu7t5v0__buf_8
X_06930_ _09714_/Q _06752_/I _06934_/A2 vdd vdd vss vss gf180mcu_fd_sc_mcu7t5v0__nand2_1
X_08600_ _08626_/A2 _08552_/Z _08703_/B _08659_/A1 vdd vdd vss vss
+ gf180mcu_fd_sc_mcu7t5v0__oai21_1
X_06861_ _06669_/I _06857_/Z _06873_/A2 vdd vdd vss vss gf180mcu_fd_sc_mcu7t5v0__nand2_1
X_09580_ _09580_/D clk _09580_/Q vdd vdd vss vss gf180mcu_fd_sc_mcu7t5v0__dffq_2
X_05812_ _05922_/B _05812_/A2 _05814_/A2 vdd vdd vss vss gf180mcu_fd_sc_mcu7t5v0__nand2_1
X_06792_ _09562_/Q _09630_/Q _09672_/Q _09879_/Q _09625_/Q _09624_/Q _06792_/Z vdd
+ vdd vss vss gf180mcu_fd_sc_mcu7t5v0__mux4_4
X_05743_ _09711_/Q _05711_/I _05752_/A1 vdd vdd vss vss gf180mcu_fd_sc_mcu7t5v0__nand2_1
X_08531_ _09713_/Q _09710_/Q _08688_/A2 _08626_/A2 _08572_/S vdd vdd vss
+ vss gf180mcu_fd_sc_mcu7t5v0__and4_1
X_08462_ _09704_/Q _08477_/A2 _08514_/A1 vdd vdd vss vss gf180mcu_fd_sc_mcu7t5v0__nand2_1
X_05674_ _09884_/Q _09614_/Q _09572_/Q _09876_/Q _09569_/Q _09570_/Q _05689_/B vdd
+ vdd vss vss gf180mcu_fd_sc_mcu7t5v0__mux4_4
X_07413_ _08670_/B _07413_/A2 _09649_/D vdd vdd vss vss gf180mcu_fd_sc_mcu7t5v0__nor2_1
X_08393_ _08731_/A1 _09719_/Q _08405_/A2 vdd vdd vss vss gf180mcu_fd_sc_mcu7t5v0__nor2_1
X_07344_ _08391_/A1 _08565_/C _08670_/B _07344_/C _09647_/D vdd vdd vss
+ vss gf180mcu_fd_sc_mcu7t5v0__aoi211_1
X_07275_ _07275_/A1 _07275_/A2 _07274_/Z _07275_/Z vdd vdd vss vss
+ gf180mcu_fd_sc_mcu7t5v0__xor3_1
X_09014_ _09402_/A1 _09021_/A2 _09021_/B1 _09014_/B2 _09859_/D vdd vdd
+ vss vss gf180mcu_fd_sc_mcu7t5v0__oai22_1
X_06226_ _09632_/Q _06313_/A1 _09582_/Q _06226_/Z vdd vdd vss vss
+ gf180mcu_fd_sc_mcu7t5v0__and3_1
X_06157_ _06072_/C _06157_/A2 _06152_/Z _06157_/A4 _06158_/B vdd vdd vss
+ vss gf180mcu_fd_sc_mcu7t5v0__nand4_1
X_06088_ _06089_/A1 _06174_/A1 _06123_/A2 vdd vdd vss vss gf180mcu_fd_sc_mcu7t5v0__nor2_1
X_05108_ _09911_/Q _09910_/Q _05108_/Z vdd vdd vss vss gf180mcu_fd_sc_mcu7t5v0__or2_4
X_05039_ _09905_/Q _09112_/B2 vdd vdd vss vss gf180mcu_fd_sc_mcu7t5v0__clkinv_1
X_09916_ _09916_/D clk _09916_/Q vdd vdd vss vss gf180mcu_fd_sc_mcu7t5v0__dffq_2
X_09847_ _09847_/D clk _09847_/Q vdd vdd vss vss gf180mcu_fd_sc_mcu7t5v0__dffq_1
XTAP_480 vdd vss gf180mcu_fd_sc_mcu7t5v0__filltie
XTAP_491 vdd vss gf180mcu_fd_sc_mcu7t5v0__filltie
X_09778_ _09778_/D clk _09778_/Q vdd vdd vss vss gf180mcu_fd_sc_mcu7t5v0__dffq_1
X_08729_ _08729_/A1 _09073_/A2 _08729_/B _09719_/D vdd vdd vss vss
+ gf180mcu_fd_sc_mcu7t5v0__aoi21_1
XTAP_1602 vdd vss gf180mcu_fd_sc_mcu7t5v0__filltie
XTAP_1613 vdd vss gf180mcu_fd_sc_mcu7t5v0__filltie
XTAP_1624 vdd vss gf180mcu_fd_sc_mcu7t5v0__filltie
XTAP_1657 vdd vss gf180mcu_fd_sc_mcu7t5v0__filltie
XTAP_1635 vdd vss gf180mcu_fd_sc_mcu7t5v0__filltie
XTAP_1646 vdd vss gf180mcu_fd_sc_mcu7t5v0__filltie
XTAP_1679 vdd vss gf180mcu_fd_sc_mcu7t5v0__filltie
XTAP_1668 vdd vss gf180mcu_fd_sc_mcu7t5v0__filltie
X_05390_ _09012_/A1 _08972_/A1 _05399_/A2 vdd vdd vss vss gf180mcu_fd_sc_mcu7t5v0__nand2_4
X_07060_ _09713_/Q _07003_/B _07063_/A2 vdd vdd vss vss gf180mcu_fd_sc_mcu7t5v0__nand2_1
X_06011_ _08291_/B _05987_/I _06023_/A1 vdd vdd vss vss gf180mcu_fd_sc_mcu7t5v0__nand2_1
X_07962_ _07803_/B _07988_/A2 _07962_/B _08006_/A1 vdd vdd vss vss
+ gf180mcu_fd_sc_mcu7t5v0__aoi21_1
X_09701_ _09701_/D clk _09701_/Q vdd vdd vss vss gf180mcu_fd_sc_mcu7t5v0__dffq_1
X_07893_ _07893_/A1 _07944_/A1 _07897_/A3 vdd vdd vss vss gf180mcu_fd_sc_mcu7t5v0__xnor2_1
X_06913_ _06864_/Z _06914_/A2 _06914_/B _06913_/Z vdd vdd vss vss
+ gf180mcu_fd_sc_mcu7t5v0__and3_1
X_06844_ _06844_/A1 _06882_/A1 _06939_/A1 _06928_/A1 vdd vdd vss vss
+ gf180mcu_fd_sc_mcu7t5v0__xnor3_1
X_09632_ _09632_/D clk _09632_/Q vdd vdd vss vss gf180mcu_fd_sc_mcu7t5v0__dffq_2
X_09563_ _09563_/D clk _09563_/Q vdd vdd vss vss gf180mcu_fd_sc_mcu7t5v0__dffq_4
X_08514_ _08514_/A1 _08514_/A2 _08514_/B _08514_/C _08548_/A2 vdd vdd
+ vss vss gf180mcu_fd_sc_mcu7t5v0__aoi211_1
X_06775_ _06958_/A1 _06817_/A2 _06782_/A2 vdd vdd vss vss gf180mcu_fd_sc_mcu7t5v0__nand2_1
X_05726_ _05763_/A1 _05725_/Z _05735_/A1 vdd vdd vss vss gf180mcu_fd_sc_mcu7t5v0__nor2_1
X_09494_ _09494_/D clk _09494_/Q vdd vdd vss vss gf180mcu_fd_sc_mcu7t5v0__dffq_1
X_08445_ _09702_/Q _08639_/A1 _08444_/Z _08450_/A2 vdd vdd vss vss
+ gf180mcu_fd_sc_mcu7t5v0__nand3_1
X_05657_ _05666_/A2 _05964_/B2 _05966_/A1 _05658_/B vdd vdd vss vss
+ gf180mcu_fd_sc_mcu7t5v0__nand3_1
X_08376_ _09022_/A1 _08736_/A2 _08385_/A2 vdd vdd vss vss gf180mcu_fd_sc_mcu7t5v0__nand2_4
X_05588_ _05588_/A1 _05588_/A2 _05602_/B1 vdd vdd vss vss gf180mcu_fd_sc_mcu7t5v0__nand2_1
X_07327_ _09657_/Q _09656_/Q _07352_/A2 vdd vdd vss vss gf180mcu_fd_sc_mcu7t5v0__nor2_1
X_07258_ _07269_/A2 _07258_/A2 _07258_/Z vdd vdd vss vss gf180mcu_fd_sc_mcu7t5v0__xor2_1
X_06209_ _08670_/B _06209_/A2 _09576_/D vdd vdd vss vss gf180mcu_fd_sc_mcu7t5v0__nor2_1
X_07189_ _09715_/Q _07160_/Z _07189_/B _07190_/A4 vdd vdd vss vss
+ gf180mcu_fd_sc_mcu7t5v0__oai21_1
XTAP_1410 vdd vss gf180mcu_fd_sc_mcu7t5v0__filltie
XTAP_1421 vdd vss gf180mcu_fd_sc_mcu7t5v0__filltie
XTAP_1432 vdd vss gf180mcu_fd_sc_mcu7t5v0__filltie
XTAP_1443 vdd vss gf180mcu_fd_sc_mcu7t5v0__filltie
XTAP_1454 vdd vss gf180mcu_fd_sc_mcu7t5v0__filltie
XTAP_1465 vdd vss gf180mcu_fd_sc_mcu7t5v0__filltie
XTAP_1476 vdd vss gf180mcu_fd_sc_mcu7t5v0__filltie
XTAP_1487 vdd vss gf180mcu_fd_sc_mcu7t5v0__filltie
XTAP_1498 vdd vss gf180mcu_fd_sc_mcu7t5v0__filltie
X_04890_ _09411_/Q _05228_/A1 vdd vdd vss vss gf180mcu_fd_sc_mcu7t5v0__clkinv_1
X_06560_ _09714_/Q _06603_/A2 _06614_/B2 vdd vdd vss vss gf180mcu_fd_sc_mcu7t5v0__nand2_1
X_06491_ _06491_/A1 _06491_/A2 _06493_/A2 vdd vdd vss vss gf180mcu_fd_sc_mcu7t5v0__nand2_1
X_05511_ _09453_/Q _05627_/A2 _05627_/B1 _09437_/Q _05513_/A1 vdd vdd
+ vss vss gf180mcu_fd_sc_mcu7t5v0__aoi22_1
X_08230_ _08229_/B _08189_/Z _08230_/B _08275_/B vdd vdd vss vss gf180mcu_fd_sc_mcu7t5v0__aoi21_1
X_05442_ _09795_/Q _05628_/A2 _05628_/B1 _09901_/Q _05443_/A2 vdd vdd
+ vss vss gf180mcu_fd_sc_mcu7t5v0__aoi22_1
X_05373_ _09403_/A1 _05379_/A2 _05379_/B1 _05373_/B2 _09527_/D vdd vdd
+ vss vss gf180mcu_fd_sc_mcu7t5v0__oai22_1
X_08161_ _08161_/A1 _08161_/A2 _08168_/A1 vdd vdd vss vss gf180mcu_fd_sc_mcu7t5v0__nand2_1
X_08092_ _08463_/A1 _09693_/Q _08180_/B _08283_/A2 vdd vdd vss vss
+ gf180mcu_fd_sc_mcu7t5v0__nand3_4
X_07112_ _07104_/Z _07145_/A2 _07113_/A3 _07196_/A1 vdd vdd vss vss
+ gf180mcu_fd_sc_mcu7t5v0__nor3_2
X_07043_ _07041_/Z _07059_/B _07057_/A2 vdd vdd vss vss gf180mcu_fd_sc_mcu7t5v0__nor2_1
X_08994_ _09402_/A1 _09001_/A2 _09001_/B1 _08994_/B2 _09843_/D vdd vdd
+ vss vss gf180mcu_fd_sc_mcu7t5v0__oai22_1
X_07945_ _07947_/A2 _07947_/A3 _07945_/Z vdd vdd vss vss gf180mcu_fd_sc_mcu7t5v0__and2_1
X_07876_ _09714_/Q _07712_/Z _07878_/A3 _07927_/B vdd vdd vss vss
+ gf180mcu_fd_sc_mcu7t5v0__and3_1
X_09615_ _09615_/D clk _09615_/Q vdd vdd vss vss gf180mcu_fd_sc_mcu7t5v0__dffq_2
X_06827_ _08670_/B _06827_/A2 _09617_/D vdd vdd vss vss gf180mcu_fd_sc_mcu7t5v0__nor2_1
X_09546_ _09546_/D clk _09546_/Q vdd vdd vss vss gf180mcu_fd_sc_mcu7t5v0__dffq_1
X_06758_ _06758_/A1 _06758_/A2 _06756_/Z _06760_/B vdd vdd vss vss
+ gf180mcu_fd_sc_mcu7t5v0__xnor3_1
X_05709_ _08715_/A1 _05645_/I _05709_/B _05713_/A3 vdd vdd vss vss
+ gf180mcu_fd_sc_mcu7t5v0__oai21_1
X_09477_ _09477_/D clk _09477_/Q vdd vdd vss vss gf180mcu_fd_sc_mcu7t5v0__dffq_1
X_08428_ _08685_/A2 _08688_/A2 _08703_/B _08430_/A1 vdd vdd vss vss
+ gf180mcu_fd_sc_mcu7t5v0__nand3_1
X_06689_ _09711_/Q _06688_/Z _06732_/A1 vdd vdd vss vss gf180mcu_fd_sc_mcu7t5v0__nand2_1
X_08359_ _09717_/Q _08359_/A2 _08359_/B _08360_/A2 vdd vdd vss vss
+ gf180mcu_fd_sc_mcu7t5v0__aoi21_1
XTAP_1240 vdd vss gf180mcu_fd_sc_mcu7t5v0__filltie
XTAP_1251 vdd vss gf180mcu_fd_sc_mcu7t5v0__filltie
XTAP_1262 vdd vss gf180mcu_fd_sc_mcu7t5v0__filltie
XTAP_1273 vdd vss gf180mcu_fd_sc_mcu7t5v0__filltie
XTAP_1284 vdd vss gf180mcu_fd_sc_mcu7t5v0__filltie
XTAP_1295 vdd vss gf180mcu_fd_sc_mcu7t5v0__filltie
X_07730_ _07720_/Z _07730_/A2 _07733_/A2 _07862_/A1 _07730_/C _07731_/A2 vdd
+ vdd vss vss gf180mcu_fd_sc_mcu7t5v0__oai221_1
X_05991_ _09571_/Q _06005_/B _06039_/A1 vdd vdd vss vss gf180mcu_fd_sc_mcu7t5v0__nand2_1
X_04942_ _09853_/Q _09006_/B2 vdd vdd vss vss gf180mcu_fd_sc_mcu7t5v0__clkinv_1
X_04873_ _09660_/Q _07669_/B2 vdd vdd vss vss gf180mcu_fd_sc_mcu7t5v0__clkinv_1
X_07661_ _09991_/Q _09073_/A2 _08734_/B _07662_/B vdd vdd vss vss
+ gf180mcu_fd_sc_mcu7t5v0__oai21_1
X_06612_ _06610_/Z _06611_/Z _06612_/Z vdd vdd vss vss gf180mcu_fd_sc_mcu7t5v0__xor2_1
X_09400_ _09400_/A1 _09400_/A2 _09409_/A2 vdd vdd vss vss gf180mcu_fd_sc_mcu7t5v0__nand2_4
X_07592_ _07536_/Z _07593_/A3 _07619_/A2 vdd vdd vss vss gf180mcu_fd_sc_mcu7t5v0__nor2_1
X_06543_ _06543_/A1 _06543_/A2 _08670_/B _09597_/D vdd vdd vss vss
+ gf180mcu_fd_sc_mcu7t5v0__aoi21_1
X_09331_ _09397_/A1 _09333_/A2 _09331_/B _09399_/C _09987_/D vdd vdd vss
+ vss gf180mcu_fd_sc_mcu7t5v0__aoi211_1
X_06474_ _06474_/A1 _06433_/Z _06475_/A2 _06525_/A1 vdd vdd vss vss
+ gf180mcu_fd_sc_mcu7t5v0__nor3_2
X_09262_ _09912_/Q _09916_/Q _09299_/A4 _09262_/Z vdd vdd vss vss
+ gf180mcu_fd_sc_mcu7t5v0__and3_2
X_05425_ _09418_/Q _05628_/A2 _05628_/B1 _09605_/Q _05426_/A2 vdd vdd
+ vss vss gf180mcu_fd_sc_mcu7t5v0__aoi22_1
X_08213_ _09714_/Q _08284_/A2 _08215_/A2 vdd vdd vss vss gf180mcu_fd_sc_mcu7t5v0__nand2_1
X_09193_ _09193_/I _09194_/B1 vdd vdd vss vss gf180mcu_fd_sc_mcu7t5v0__clkinv_1
X_08144_ _08224_/A1 _08144_/A2 _08145_/A3 _08224_/A2 vdd vdd vss vss
+ gf180mcu_fd_sc_mcu7t5v0__nor3_1
X_05356_ _09406_/A1 _05359_/A2 _05359_/B1 _05356_/B2 _09510_/D vdd vdd
+ vss vss gf180mcu_fd_sc_mcu7t5v0__oai22_1
X_08075_ _08076_/A1 _08076_/A2 _08075_/Z vdd vdd vss vss gf180mcu_fd_sc_mcu7t5v0__or2_1
X_05287_ _08972_/A1 _05631_/B2 _05296_/A2 vdd vdd vss vss gf180mcu_fd_sc_mcu7t5v0__nand2_4
X_07026_ _07348_/A2 _08565_/C _07026_/B1 _07026_/B2 _08670_/B _09627_/D vdd
+ vdd vss vss gf180mcu_fd_sc_mcu7t5v0__aoi221_1
X_08977_ _09405_/A1 _08981_/A2 _08981_/B1 _08977_/B2 _09830_/D vdd vdd
+ vss vss gf180mcu_fd_sc_mcu7t5v0__oai22_1
X_07928_ _09716_/Q _07681_/Z _07950_/A1 vdd vdd vss vss gf180mcu_fd_sc_mcu7t5v0__nand2_1
X_07859_ _09714_/Q _08012_/A2 _07860_/A2 _07970_/B2 _07970_/C _07860_/B vdd
+ vdd vss vss gf180mcu_fd_sc_mcu7t5v0__aoi221_1
X_09529_ _09529_/D clk _09529_/Q vdd vdd vss vss gf180mcu_fd_sc_mcu7t5v0__dffq_1
XTAP_309 vdd vss gf180mcu_fd_sc_mcu7t5v0__filltie
XTAP_1081 vdd vss gf180mcu_fd_sc_mcu7t5v0__filltie
XTAP_1070 vdd vss gf180mcu_fd_sc_mcu7t5v0__filltie
XTAP_1092 vdd vss gf180mcu_fd_sc_mcu7t5v0__filltie
X_06190_ _09576_/Q _06189_/Z _06211_/A2 vdd vdd vss vss gf180mcu_fd_sc_mcu7t5v0__nor2_1
X_05210_ _09032_/A2 _09897_/Q _09103_/A1 vdd vdd vss vss gf180mcu_fd_sc_mcu7t5v0__nand2_2
X_05141_ _09467_/Q _09259_/B _05143_/B vdd vdd vss vss gf180mcu_fd_sc_mcu7t5v0__nand2_1
X_05072_ _09873_/Q _09030_/B2 vdd vdd vss vss gf180mcu_fd_sc_mcu7t5v0__clkinv_1
XTAP_810 vdd vss gf180mcu_fd_sc_mcu7t5v0__filltie
X_09880_ _09880_/D clk _09880_/Q vdd vdd vss vss gf180mcu_fd_sc_mcu7t5v0__dffq_2
X_08900_ _08900_/I _09792_/D vdd vdd vss vss gf180mcu_fd_sc_mcu7t5v0__clkinv_1
XTAP_821 vdd vss gf180mcu_fd_sc_mcu7t5v0__filltie
XTAP_832 vdd vss gf180mcu_fd_sc_mcu7t5v0__filltie
XTAP_843 vdd vss gf180mcu_fd_sc_mcu7t5v0__filltie
X_08831_ _08829_/Z _08831_/A2 _09771_/D vdd vdd vss vss gf180mcu_fd_sc_mcu7t5v0__nor2_1
XTAP_854 vdd vss gf180mcu_fd_sc_mcu7t5v0__filltie
XTAP_876 vdd vss gf180mcu_fd_sc_mcu7t5v0__filltie
XTAP_865 vdd vss gf180mcu_fd_sc_mcu7t5v0__filltie
XTAP_887 vdd vss gf180mcu_fd_sc_mcu7t5v0__filltie
XTAP_898 vdd vss gf180mcu_fd_sc_mcu7t5v0__filltie
X_08762_ _08791_/B _08758_/B _08766_/A1 vdd vdd vss vss gf180mcu_fd_sc_mcu7t5v0__nand2_1
X_05974_ _05974_/A1 _09104_/A2 _05974_/B _09568_/D vdd vdd vss vss
+ gf180mcu_fd_sc_mcu7t5v0__aoi21_1
X_07713_ _07727_/A2 _07727_/A3 _07781_/A2 vdd vdd vss vss gf180mcu_fd_sc_mcu7t5v0__nand2_1
X_08693_ _08693_/A1 _08693_/A2 _08692_/Z _08693_/Z vdd vdd vss vss
+ gf180mcu_fd_sc_mcu7t5v0__xor3_1
X_04925_ _09444_/Q _05291_/B2 vdd vdd vss vss gf180mcu_fd_sc_mcu7t5v0__clkinv_1
X_07644_ _07443_/B _07644_/A2 _07645_/A2 vdd vdd vss vss gf180mcu_fd_sc_mcu7t5v0__nand2_1
X_04856_ _09843_/Q _08994_/B2 vdd vdd vss vss gf180mcu_fd_sc_mcu7t5v0__clkinv_1
X_04787_ _09658_/Q _07664_/A1 vdd vdd vss vss gf180mcu_fd_sc_mcu7t5v0__clkinv_4
X_07575_ _09714_/Q _07575_/A2 _07575_/A3 _07635_/B2 vdd vdd vss vss
+ gf180mcu_fd_sc_mcu7t5v0__nand3_1
X_06526_ _09597_/Q _06525_/Z _06526_/Z vdd vdd vss vss gf180mcu_fd_sc_mcu7t5v0__or2_1
X_09314_ _09391_/A1 _09322_/A2 _09314_/B _09399_/C _09979_/D vdd vdd vss
+ vss gf180mcu_fd_sc_mcu7t5v0__aoi211_1
X_06457_ _06463_/A1 _06432_/Z _06457_/B _06473_/A1 vdd vdd vss vss
+ gf180mcu_fd_sc_mcu7t5v0__aoi21_2
X_09245_ _09467_/Q _09951_/Q _09259_/B _09246_/B vdd vdd vss vss gf180mcu_fd_sc_mcu7t5v0__oai21_1
X_05408_ _09660_/Q _05628_/A2 _05628_/B1 _09723_/Q _05409_/A2 vdd vdd
+ vss vss gf180mcu_fd_sc_mcu7t5v0__aoi22_1
X_06388_ _09603_/Q _09573_/Q _06389_/B2 vdd vdd vss vss gf180mcu_fd_sc_mcu7t5v0__nand2_1
X_09176_ _09926_/Q _09228_/A2 _09176_/B _09177_/A2 vdd vdd vss vss
+ gf180mcu_fd_sc_mcu7t5v0__aoi21_1
X_08127_ _09713_/Q _08061_/Z _08128_/I vdd vdd vss vss gf180mcu_fd_sc_mcu7t5v0__nand2_1
X_05339_ _09409_/A1 _05339_/A2 _05339_/B1 _05339_/B2 _09497_/D vdd vdd
+ vss vss gf180mcu_fd_sc_mcu7t5v0__oai22_1
X_08058_ _08058_/A1 _09693_/Q _08180_/B _08074_/A2 vdd vdd vss vss
+ gf180mcu_fd_sc_mcu7t5v0__nand3_4
X_07009_ _07284_/B _07044_/A2 _07008_/Z _07022_/C vdd vdd vss vss
+ gf180mcu_fd_sc_mcu7t5v0__nand3_1
X_10020_ _10020_/D clk _10020_/Q vdd vdd vss vss gf180mcu_fd_sc_mcu7t5v0__dffq_1
XPHY_120 vdd vss gf180mcu_fd_sc_mcu7t5v0__endcap
XPHY_131 vdd vss gf180mcu_fd_sc_mcu7t5v0__endcap
XPHY_142 vdd vss gf180mcu_fd_sc_mcu7t5v0__endcap
XPHY_153 vdd vss gf180mcu_fd_sc_mcu7t5v0__endcap
XPHY_164 vdd vss gf180mcu_fd_sc_mcu7t5v0__endcap
XPHY_175 vdd vss gf180mcu_fd_sc_mcu7t5v0__endcap
XPHY_186 vdd vss gf180mcu_fd_sc_mcu7t5v0__endcap
XPHY_197 vdd vss gf180mcu_fd_sc_mcu7t5v0__endcap
X_04710_ _09964_/Q _09278_/A1 vdd vdd vss vss gf180mcu_fd_sc_mcu7t5v0__clkinv_1
X_05690_ _09711_/Q _05688_/Z _05691_/A2 _05721_/B vdd vdd vss vss
+ gf180mcu_fd_sc_mcu7t5v0__nand3_1
XPHY_0 vdd vss gf180mcu_fd_sc_mcu7t5v0__endcap
X_07360_ _09711_/Q _07364_/A2 _07364_/A3 _07388_/A1 vdd vdd vss vss
+ gf180mcu_fd_sc_mcu7t5v0__nand3_4
X_06311_ _06280_/B _09104_/A2 _06311_/B _09582_/D vdd vdd vss vss
+ gf180mcu_fd_sc_mcu7t5v0__aoi21_1
X_09030_ _09408_/A1 _09031_/A2 _09031_/B1 _09030_/B2 _09873_/D vdd vdd
+ vss vss gf180mcu_fd_sc_mcu7t5v0__oai22_1
X_07291_ _09633_/Q _08706_/B _07291_/Z vdd vdd vss vss gf180mcu_fd_sc_mcu7t5v0__or2_1
X_06242_ _06267_/A1 _06220_/Z _06242_/A3 _06242_/Z vdd vdd vss vss
+ gf180mcu_fd_sc_mcu7t5v0__xor3_1
X_06173_ _09712_/Q _06125_/Z _06224_/A2 vdd vdd vss vss gf180mcu_fd_sc_mcu7t5v0__nand2_1
X_05124_ _09226_/B _05124_/A2 _08902_/B _09522_/D vdd vdd vss vss
+ gf180mcu_fd_sc_mcu7t5v0__nand3_1
X_05055_ _09480_/Q _05316_/B2 vdd vdd vss vss gf180mcu_fd_sc_mcu7t5v0__clkinv_1
X_09932_ _09932_/D clk _09932_/Q vdd vdd vss vss gf180mcu_fd_sc_mcu7t5v0__dffq_1
XTAP_640 vdd vss gf180mcu_fd_sc_mcu7t5v0__filltie
XTAP_651 vdd vss gf180mcu_fd_sc_mcu7t5v0__filltie
X_09863_ _09863_/D clk _09863_/Q vdd vdd vss vss gf180mcu_fd_sc_mcu7t5v0__dffq_1
XTAP_695 vdd vss gf180mcu_fd_sc_mcu7t5v0__filltie
XTAP_684 vdd vss gf180mcu_fd_sc_mcu7t5v0__filltie
XTAP_673 vdd vss gf180mcu_fd_sc_mcu7t5v0__filltie
XTAP_662 vdd vss gf180mcu_fd_sc_mcu7t5v0__filltie
X_09794_ _09794_/D clk _09794_/Q vdd vdd vss vss gf180mcu_fd_sc_mcu7t5v0__dffq_1
X_08814_ _09766_/Q _08814_/A2 _08814_/Z vdd vdd vss vss gf180mcu_fd_sc_mcu7t5v0__xor2_1
X_08745_ _09409_/A1 _08745_/A2 _08745_/B1 _08745_/B2 _09730_/D vdd vdd
+ vss vss gf180mcu_fd_sc_mcu7t5v0__oai22_1
X_05957_ _05698_/C _05956_/Z _05968_/B1 vdd vdd vss vss gf180mcu_fd_sc_mcu7t5v0__nand2_1
XTAP_1806 vdd vss gf180mcu_fd_sc_mcu7t5v0__filltie
X_05888_ _05888_/A1 _05888_/A2 _05888_/B _05909_/A2 vdd vdd vss vss
+ gf180mcu_fd_sc_mcu7t5v0__aoi21_2
X_04908_ _09585_/Q _06317_/B2 vdd vdd vss vss gf180mcu_fd_sc_mcu7t5v0__clkinv_1
X_08676_ _08436_/S _08608_/I _08676_/B1 _08629_/Z _08679_/A1 vdd vdd vss
+ vss gf180mcu_fd_sc_mcu7t5v0__oai22_1
XTAP_1839 vdd vss gf180mcu_fd_sc_mcu7t5v0__filltie
XTAP_1828 vdd vss gf180mcu_fd_sc_mcu7t5v0__filltie
XTAP_1817 vdd vss gf180mcu_fd_sc_mcu7t5v0__filltie
X_07627_ _09633_/Q _07420_/Z _07627_/B1 _09599_/Q _07628_/A2 vdd vdd vss
+ vss gf180mcu_fd_sc_mcu7t5v0__aoi22_1
X_04839_ _09567_/Q _05972_/A1 vdd vdd vss vss gf180mcu_fd_sc_mcu7t5v0__clkinv_2
X_07558_ _09715_/Q _07633_/B _07558_/B _07559_/A4 vdd vdd vss vss
+ gf180mcu_fd_sc_mcu7t5v0__oai21_1
X_06509_ _06509_/A1 _06507_/Z _06553_/A1 vdd vdd vss vss gf180mcu_fd_sc_mcu7t5v0__xnor2_1
X_07489_ _07516_/A1 _07515_/A1 _07486_/Z _07492_/B vdd vdd vss vss
+ gf180mcu_fd_sc_mcu7t5v0__xnor3_1
X_09228_ _09228_/A1 _09228_/A2 _09244_/A2 vdd vdd vss vss gf180mcu_fd_sc_mcu7t5v0__nor2_4
X_09159_ _09399_/C _09159_/A2 _09921_/D vdd vdd vss vss gf180mcu_fd_sc_mcu7t5v0__nor2_1
X_10003_ _10003_/D clk _10003_/Q vdd vdd vss vss gf180mcu_fd_sc_mcu7t5v0__dffq_1
Xrepeater11 _09401_/A1 _09013_/A1 vdd vdd vss vss gf180mcu_fd_sc_mcu7t5v0__buf_8
X_06860_ _09618_/Q _06876_/A1 _06857_/Z _06860_/Z vdd vdd vss vss
+ gf180mcu_fd_sc_mcu7t5v0__xor3_1
X_05811_ _05645_/I _05811_/A2 _05835_/A2 _05943_/A2 _05812_/A2 vdd vdd
+ vss vss gf180mcu_fd_sc_mcu7t5v0__nand4_1
X_06791_ _06791_/I _06798_/A1 vdd vdd vss vss gf180mcu_fd_sc_mcu7t5v0__clkinv_1
X_05742_ _07452_/C _05645_/I _05742_/B _05753_/A2 vdd vdd vss vss
+ gf180mcu_fd_sc_mcu7t5v0__oai21_1
X_08530_ _09713_/Q _08626_/A2 _08690_/A1 vdd vdd vss vss gf180mcu_fd_sc_mcu7t5v0__nand2_1
X_08461_ _08461_/I _08477_/A2 vdd vdd vss vss gf180mcu_fd_sc_mcu7t5v0__clkinv_1
X_05673_ _08430_/B _05645_/I _05679_/A1 vdd vdd vss vss gf180mcu_fd_sc_mcu7t5v0__nor2_1
X_07412_ _09649_/Q _08565_/C _07412_/B _07413_/A2 vdd vdd vss vss
+ gf180mcu_fd_sc_mcu7t5v0__aoi21_1
X_08392_ _08291_/B _08631_/A2 _08639_/A1 vdd vdd vss vss gf180mcu_fd_sc_mcu7t5v0__nor2_4
X_07343_ _07396_/B _07343_/A2 _07343_/B _08565_/C _07344_/C vdd vdd vss
+ vss gf180mcu_fd_sc_mcu7t5v0__aoi211_1
X_07274_ _07274_/A1 _07268_/Z _07273_/Z _07274_/Z vdd vdd vss vss
+ gf180mcu_fd_sc_mcu7t5v0__xor3_1
X_06225_ _09711_/Q _06178_/Z _06237_/A2 vdd vdd vss vss gf180mcu_fd_sc_mcu7t5v0__nand2_1
X_09013_ _09013_/A1 _09021_/A2 _09021_/B1 vdd vdd vss vss gf180mcu_fd_sc_mcu7t5v0__nand2_2
X_06156_ _09714_/Q _06125_/Z _06156_/B _06157_/A4 vdd vdd vss vss
+ gf180mcu_fd_sc_mcu7t5v0__oai21_1
X_06087_ _09711_/Q _06085_/Z _06174_/A1 vdd vdd vss vss gf180mcu_fd_sc_mcu7t5v0__nand2_1
X_05107_ _09911_/Q _09910_/Q _09378_/A1 vdd vdd vss vss gf180mcu_fd_sc_mcu7t5v0__nor2_1
X_05038_ _09856_/Q _09009_/B2 vdd vdd vss vss gf180mcu_fd_sc_mcu7t5v0__clkinv_1
X_09915_ _09915_/D clk _09915_/Q vdd vdd vss vss gf180mcu_fd_sc_mcu7t5v0__dffq_2
X_09846_ _09846_/D clk _09846_/Q vdd vdd vss vss gf180mcu_fd_sc_mcu7t5v0__dffq_1
XTAP_470 vdd vss gf180mcu_fd_sc_mcu7t5v0__filltie
XTAP_481 vdd vss gf180mcu_fd_sc_mcu7t5v0__filltie
XTAP_492 vdd vss gf180mcu_fd_sc_mcu7t5v0__filltie
X_06989_ _09634_/Q _07053_/A2 _07286_/I1 vdd vdd vss vss gf180mcu_fd_sc_mcu7t5v0__nor2_2
X_09777_ _09777_/D clk _09777_/Q vdd vdd vss vss gf180mcu_fd_sc_mcu7t5v0__dffq_1
X_08728_ _09975_/Q _09073_/A2 _08734_/B _08729_/B vdd vdd vss vss
+ gf180mcu_fd_sc_mcu7t5v0__oai21_1
X_08659_ _08659_/A1 _08659_/A2 _08703_/A2 vdd vdd vss vss gf180mcu_fd_sc_mcu7t5v0__nand2_1
XTAP_1603 vdd vss gf180mcu_fd_sc_mcu7t5v0__filltie
XTAP_1614 vdd vss gf180mcu_fd_sc_mcu7t5v0__filltie
XTAP_1658 vdd vss gf180mcu_fd_sc_mcu7t5v0__filltie
XTAP_1625 vdd vss gf180mcu_fd_sc_mcu7t5v0__filltie
XTAP_1636 vdd vss gf180mcu_fd_sc_mcu7t5v0__filltie
XTAP_1647 vdd vss gf180mcu_fd_sc_mcu7t5v0__filltie
XTAP_1669 vdd vss gf180mcu_fd_sc_mcu7t5v0__filltie
X_06010_ _06010_/I _09571_/D vdd vdd vss vss gf180mcu_fd_sc_mcu7t5v0__clkinv_1
X_07961_ _08001_/A1 _07956_/Z _07977_/A2 _07973_/A2 vdd vdd vss vss
+ gf180mcu_fd_sc_mcu7t5v0__nand3_1
X_09700_ _09700_/D clk _09700_/Q vdd vdd vss vss gf180mcu_fd_sc_mcu7t5v0__dffq_1
X_06912_ _07611_/B _06911_/Z _06914_/B vdd vdd vss vss gf180mcu_fd_sc_mcu7t5v0__xor2_1
X_07892_ _09710_/Q _07893_/A1 _07988_/A2 _07949_/A1 vdd vdd vss vss
+ gf180mcu_fd_sc_mcu7t5v0__nand3_1
X_06843_ _06844_/A1 _06939_/A1 _06882_/A2 vdd vdd vss vss gf180mcu_fd_sc_mcu7t5v0__nand2_1
X_09631_ _09631_/D clk _09631_/Q vdd vdd vss vss gf180mcu_fd_sc_mcu7t5v0__dffq_2
X_09562_ _09562_/D clk _09562_/Q vdd vdd vss vss gf180mcu_fd_sc_mcu7t5v0__dffq_4
X_06774_ _06774_/A1 _06774_/A2 _06774_/B _06817_/A2 vdd vdd vss vss
+ gf180mcu_fd_sc_mcu7t5v0__oai21_1
X_05725_ _09712_/Q _05723_/Z _05725_/Z vdd vdd vss vss gf180mcu_fd_sc_mcu7t5v0__xor2_1
X_08513_ _08521_/A1 _08517_/A2 _08514_/C vdd vdd vss vss gf180mcu_fd_sc_mcu7t5v0__nor2_1
X_09493_ _09493_/D clk _09493_/Q vdd vdd vss vss gf180mcu_fd_sc_mcu7t5v0__dffq_1
X_08444_ _09703_/Q _08440_/Z _08444_/Z vdd vdd vss vss gf180mcu_fd_sc_mcu7t5v0__xor2_1
X_05656_ _09568_/Q _05972_/A1 _09566_/Q _05966_/A1 vdd vdd vss vss
+ gf180mcu_fd_sc_mcu7t5v0__nand3_2
X_05587_ _09448_/Q _05628_/A2 _05628_/B1 _09432_/Q _05588_/A2 vdd vdd
+ vss vss gf180mcu_fd_sc_mcu7t5v0__aoi22_1
X_08375_ _08375_/A1 _09073_/A2 _08375_/B _09693_/D vdd vdd vss vss
+ gf180mcu_fd_sc_mcu7t5v0__aoi21_1
X_07326_ _07662_/A1 _09656_/Q _07658_/A1 _07650_/I0 vdd vdd vss vss
+ gf180mcu_fd_sc_mcu7t5v0__nand3_4
X_07257_ _09714_/Q _07065_/Z _07258_/A2 vdd vdd vss vss gf180mcu_fd_sc_mcu7t5v0__nand2_1
X_06208_ _09576_/Q _08565_/C _06208_/B1 _06208_/B2 _06209_/A2 vdd vdd
+ vss vss gf180mcu_fd_sc_mcu7t5v0__aoi22_1
X_07188_ _07247_/A1 _07188_/A2 _07188_/B _07189_/B vdd vdd vss vss
+ gf180mcu_fd_sc_mcu7t5v0__oai21_1
X_06139_ _06139_/A1 _06095_/Z _06139_/B _06142_/A3 vdd vdd vss vss
+ gf180mcu_fd_sc_mcu7t5v0__aoi21_2
X_09829_ _09829_/D clk _09829_/Q vdd vdd vss vss gf180mcu_fd_sc_mcu7t5v0__dffq_1
XTAP_1400 vdd vss gf180mcu_fd_sc_mcu7t5v0__filltie
XTAP_1411 vdd vss gf180mcu_fd_sc_mcu7t5v0__filltie
XTAP_1422 vdd vss gf180mcu_fd_sc_mcu7t5v0__filltie
XTAP_1433 vdd vss gf180mcu_fd_sc_mcu7t5v0__filltie
XTAP_1444 vdd vss gf180mcu_fd_sc_mcu7t5v0__filltie
XTAP_1455 vdd vss gf180mcu_fd_sc_mcu7t5v0__filltie
XTAP_1466 vdd vss gf180mcu_fd_sc_mcu7t5v0__filltie
XTAP_1477 vdd vss gf180mcu_fd_sc_mcu7t5v0__filltie
XTAP_1488 vdd vss gf180mcu_fd_sc_mcu7t5v0__filltie
XTAP_1499 vdd vss gf180mcu_fd_sc_mcu7t5v0__filltie
X_06490_ _06628_/A1 _06555_/A2 _06491_/A2 vdd vdd vss vss gf180mcu_fd_sc_mcu7t5v0__nand2_1
X_05510_ _05510_/A1 _05510_/A2 _05514_/B1 vdd vdd vss vss gf180mcu_fd_sc_mcu7t5v0__nand2_1
X_05441_ _09736_/Q _05627_/A2 _05627_/B1 _09868_/Q _05443_/A1 vdd vdd
+ vss vss gf180mcu_fd_sc_mcu7t5v0__aoi22_1
X_08160_ _08362_/A1 _08211_/A2 _08161_/A2 vdd vdd vss vss gf180mcu_fd_sc_mcu7t5v0__nor2_1
X_05372_ _09402_/A1 _05379_/A2 _05379_/B1 _05372_/B2 _09526_/D vdd vdd
+ vss vss gf180mcu_fd_sc_mcu7t5v0__oai22_1
X_07111_ _07052_/Z _07156_/A1 _07111_/A3 _07113_/A3 vdd vdd vss vss
+ gf180mcu_fd_sc_mcu7t5v0__xnor3_1
X_08091_ _08099_/A1 _08129_/A3 _08091_/Z vdd vdd vss vss gf180mcu_fd_sc_mcu7t5v0__and2_1
X_07042_ _07042_/A1 _07042_/A2 _07042_/B _07059_/B vdd vdd vss vss
+ gf180mcu_fd_sc_mcu7t5v0__aoi21_1
X_08993_ _09013_/A1 _09001_/A2 _09001_/B1 vdd vdd vss vss gf180mcu_fd_sc_mcu7t5v0__nand2_2
X_07944_ _07944_/A1 _07985_/A1 _07989_/S vdd vdd vss vss gf180mcu_fd_sc_mcu7t5v0__nor2_1
X_07875_ _07877_/A1 _07877_/A2 _07877_/B _07878_/A3 vdd vdd vss vss
+ gf180mcu_fd_sc_mcu7t5v0__oai21_1
X_06826_ _09617_/Q _08565_/C _06826_/B1 _06826_/B2 _06827_/A2 vdd vdd
+ vss vss gf180mcu_fd_sc_mcu7t5v0__aoi22_1
X_09614_ _09614_/D clk _09614_/Q vdd vdd vss vss gf180mcu_fd_sc_mcu7t5v0__dffq_2
X_09545_ _09545_/D clk _09545_/Q vdd vdd vss vss gf180mcu_fd_sc_mcu7t5v0__dffq_1
X_06757_ _06749_/Z _06756_/Z _06801_/A1 vdd vdd vss vss gf180mcu_fd_sc_mcu7t5v0__nand2_1
X_05708_ _08715_/A1 _05645_/I _05709_/B _05708_/Z vdd vdd vss vss
+ gf180mcu_fd_sc_mcu7t5v0__or3_1
X_09476_ _09476_/D clk _09476_/Q vdd vdd vss vss gf180mcu_fd_sc_mcu7t5v0__dffq_1
X_06688_ _06941_/A2 _06687_/Z _06688_/Z vdd vdd vss vss gf180mcu_fd_sc_mcu7t5v0__xor2_1
X_08427_ _08685_/A2 _08703_/B _08431_/A3 vdd vdd vss vss gf180mcu_fd_sc_mcu7t5v0__nand2_1
X_05639_ _09570_/Q _09569_/Q _05639_/Z vdd vdd vss vss gf180mcu_fd_sc_mcu7t5v0__or2_2
X_08358_ _08358_/I0 _08358_/I1 _08358_/S _08358_/Z vdd vdd vss vss
+ gf180mcu_fd_sc_mcu7t5v0__mux2_1
X_08289_ _09674_/Q _08132_/Z _08331_/B1 _09632_/Q _08291_/A2 vdd vdd vss
+ vss gf180mcu_fd_sc_mcu7t5v0__aoi22_2
X_07309_ _09406_/A1 _07312_/A2 _07312_/B1 _07309_/B2 _09643_/D vdd vdd
+ vss vss gf180mcu_fd_sc_mcu7t5v0__oai22_1
XTAP_1230 vdd vss gf180mcu_fd_sc_mcu7t5v0__filltie
XTAP_1241 vdd vss gf180mcu_fd_sc_mcu7t5v0__filltie
XTAP_1252 vdd vss gf180mcu_fd_sc_mcu7t5v0__filltie
XTAP_1263 vdd vss gf180mcu_fd_sc_mcu7t5v0__filltie
XTAP_1274 vdd vss gf180mcu_fd_sc_mcu7t5v0__filltie
XTAP_1296 vdd vss gf180mcu_fd_sc_mcu7t5v0__filltie
XTAP_1285 vdd vss gf180mcu_fd_sc_mcu7t5v0__filltie
X_05990_ _05990_/A1 _06004_/B _05992_/A1 vdd vdd vss vss gf180mcu_fd_sc_mcu7t5v0__nand2_1
X_04941_ _09420_/Q _05255_/B2 vdd vdd vss vss gf180mcu_fd_sc_mcu7t5v0__clkinv_1
X_04872_ _09694_/Q _08378_/B2 vdd vdd vss vss gf180mcu_fd_sc_mcu7t5v0__clkinv_1
X_07660_ _07660_/A1 _09073_/A2 _07660_/B _09656_/D vdd vdd vss vss
+ gf180mcu_fd_sc_mcu7t5v0__aoi21_1
X_06611_ _06611_/A1 _06611_/A2 _06611_/A3 _06611_/Z vdd vdd vss vss
+ gf180mcu_fd_sc_mcu7t5v0__xor3_1
X_07591_ _07536_/Z _07593_/A3 _07619_/B vdd vdd vss vss gf180mcu_fd_sc_mcu7t5v0__nand2_1
X_06542_ _06350_/C _06528_/Z _06542_/B _08706_/B _06543_/A2 vdd vdd vss
+ vss gf180mcu_fd_sc_mcu7t5v0__oai211_1
X_09330_ _09987_/Q _09333_/A2 _09331_/B vdd vdd vss vss gf180mcu_fd_sc_mcu7t5v0__nor2_1
X_09261_ _09911_/Q _09311_/A2 _09300_/A1 vdd vdd vss vss gf180mcu_fd_sc_mcu7t5v0__nand2_4
X_06473_ _06473_/A1 _06473_/A2 _06475_/A2 vdd vdd vss vss gf180mcu_fd_sc_mcu7t5v0__xnor2_1
X_08212_ _08069_/B _08256_/A2 _08217_/B2 vdd vdd vss vss gf180mcu_fd_sc_mcu7t5v0__nand2_1
X_05424_ _09851_/Q _05627_/A2 _05627_/B1 _09584_/Q _05426_/A1 vdd vdd
+ vss vss gf180mcu_fd_sc_mcu7t5v0__aoi22_1
X_09192_ _09789_/Q _09299_/A3 _09378_/A2 _09758_/Q _09193_/I vdd vdd vss
+ vss gf180mcu_fd_sc_mcu7t5v0__aoi22_1
X_08143_ _08143_/A1 _08188_/A1 _08145_/A3 vdd vdd vss vss gf180mcu_fd_sc_mcu7t5v0__xnor2_1
X_05355_ _09405_/A1 _05359_/A2 _05359_/B1 _05355_/B2 _09509_/D vdd vdd
+ vss vss gf180mcu_fd_sc_mcu7t5v0__oai22_1
X_08074_ _09710_/Q _08074_/A2 _08074_/A3 _08076_/A2 vdd vdd vss vss
+ gf180mcu_fd_sc_mcu7t5v0__nand3_1
X_07025_ _07042_/A2 _07025_/A2 _08565_/C _07026_/B2 vdd vdd vss vss
+ gf180mcu_fd_sc_mcu7t5v0__aoi21_1
X_05286_ _09409_/A1 _05286_/A2 _05286_/B1 _05286_/B2 _09441_/D vdd vdd
+ vss vss gf180mcu_fd_sc_mcu7t5v0__oai22_1
X_08976_ _09404_/A1 _08981_/A2 _08981_/B1 _08976_/B2 _09829_/D vdd vdd
+ vss vss gf180mcu_fd_sc_mcu7t5v0__oai22_1
X_07927_ _07927_/A1 _07927_/A2 _07927_/B _07978_/A1 vdd vdd vss vss
+ gf180mcu_fd_sc_mcu7t5v0__aoi21_1
X_07858_ _09714_/Q _07830_/I _07860_/A2 vdd vdd vss vss gf180mcu_fd_sc_mcu7t5v0__nand2_1
X_07789_ _09710_/Q _07784_/Z _07881_/A3 _07834_/A1 vdd vdd vss vss
+ gf180mcu_fd_sc_mcu7t5v0__nand3_2
X_06809_ _09617_/Q _06829_/A1 _06806_/Z _06809_/Z vdd vdd vss vss
+ gf180mcu_fd_sc_mcu7t5v0__xor3_1
X_09528_ _09528_/D clk _09528_/Q vdd vdd vss vss gf180mcu_fd_sc_mcu7t5v0__dffq_1
X_09459_ _09459_/D clk _09459_/Q vdd vdd vss vss gf180mcu_fd_sc_mcu7t5v0__dffq_1
XTAP_1060 vdd vss gf180mcu_fd_sc_mcu7t5v0__filltie
XTAP_1082 vdd vss gf180mcu_fd_sc_mcu7t5v0__filltie
XTAP_1071 vdd vss gf180mcu_fd_sc_mcu7t5v0__filltie
XTAP_1093 vdd vss gf180mcu_fd_sc_mcu7t5v0__filltie
X_05140_ _09209_/B2 _05140_/A2 _05217_/S _05175_/A2 _09209_/A2 _09550_/Q _09246_/A2
+ vdd vdd vss vss gf180mcu_fd_sc_mcu7t5v0__aoi222_4
X_05071_ _09906_/Q _09113_/B2 vdd vdd vss vss gf180mcu_fd_sc_mcu7t5v0__clkinv_1
XTAP_800 vdd vss gf180mcu_fd_sc_mcu7t5v0__filltie
XTAP_822 vdd vss gf180mcu_fd_sc_mcu7t5v0__filltie
XTAP_811 vdd vss gf180mcu_fd_sc_mcu7t5v0__filltie
XTAP_833 vdd vss gf180mcu_fd_sc_mcu7t5v0__filltie
XTAP_844 vdd vss gf180mcu_fd_sc_mcu7t5v0__filltie
X_08830_ _09771_/Q _08826_/Z _08845_/B _08831_/A2 vdd vdd vss vss
+ gf180mcu_fd_sc_mcu7t5v0__oai21_1
XTAP_866 vdd vss gf180mcu_fd_sc_mcu7t5v0__filltie
XTAP_855 vdd vss gf180mcu_fd_sc_mcu7t5v0__filltie
XTAP_877 vdd vss gf180mcu_fd_sc_mcu7t5v0__filltie
XTAP_888 vdd vss gf180mcu_fd_sc_mcu7t5v0__filltie
XTAP_899 vdd vss gf180mcu_fd_sc_mcu7t5v0__filltie
X_08761_ _08761_/A1 _08782_/A2 _08761_/B _09399_/C _09743_/D vdd vdd vss
+ vss gf180mcu_fd_sc_mcu7t5v0__aoi211_1
X_05973_ _10016_/Q _09104_/A2 _09259_/B _05974_/B vdd vdd vss vss
+ gf180mcu_fd_sc_mcu7t5v0__oai21_1
X_07712_ _07727_/A2 _07727_/A3 _07712_/Z vdd vdd vss vss gf180mcu_fd_sc_mcu7t5v0__and2_4
X_08692_ _08692_/A1 _08692_/A2 _08691_/Z _08692_/Z vdd vdd vss vss
+ gf180mcu_fd_sc_mcu7t5v0__xor3_1
X_04924_ _09436_/Q _05281_/B2 vdd vdd vss vss gf180mcu_fd_sc_mcu7t5v0__clkinv_1
X_04855_ _09859_/Q _09014_/B2 vdd vdd vss vss gf180mcu_fd_sc_mcu7t5v0__clkinv_1
X_07643_ _09717_/Q _07646_/A2 _07650_/S vdd vdd vss vss gf180mcu_fd_sc_mcu7t5v0__nand2_1
X_09313_ _09979_/Q _09322_/A2 _09314_/B vdd vdd vss vss gf180mcu_fd_sc_mcu7t5v0__nor2_1
X_04786_ _09659_/Q _07472_/B vdd vdd vss vss gf180mcu_fd_sc_mcu7t5v0__inv_4
X_07574_ _07590_/A1 _07590_/A2 _07621_/A1 vdd vdd vss vss gf180mcu_fd_sc_mcu7t5v0__xnor2_1
X_06525_ _06525_/A1 _06523_/Z _06525_/Z vdd vdd vss vss gf180mcu_fd_sc_mcu7t5v0__xor2_1
X_06456_ _06456_/A1 _06437_/Z _06456_/B _06498_/A1 vdd vdd vss vss
+ gf180mcu_fd_sc_mcu7t5v0__aoi21_1
X_09244_ _09260_/A2 _09244_/A2 _09244_/B _09950_/D vdd vdd vss vss
+ gf180mcu_fd_sc_mcu7t5v0__aoi21_1
X_05407_ _09639_/Q _05627_/A2 _05627_/B1 _09694_/Q _05409_/A1 vdd vdd
+ vss vss gf180mcu_fd_sc_mcu7t5v0__aoi22_1
X_09175_ _09926_/Q _09228_/A2 _09175_/A3 _09176_/B vdd vdd vss vss
+ gf180mcu_fd_sc_mcu7t5v0__nor3_4
X_08126_ _09713_/Q _08030_/Z _08145_/A2 vdd vdd vss vss gf180mcu_fd_sc_mcu7t5v0__nand2_1
X_06387_ _09885_/Q _09603_/Q _06387_/B _06389_/B1 vdd vdd vss vss
+ gf180mcu_fd_sc_mcu7t5v0__oai21_2
X_05338_ _09408_/A1 _05339_/A2 _05339_/B1 _05338_/B2 _09496_/D vdd vdd
+ vss vss gf180mcu_fd_sc_mcu7t5v0__oai22_1
X_08057_ _08291_/B _08030_/Z _08070_/A1 vdd vdd vss vss gf180mcu_fd_sc_mcu7t5v0__nand2_1
X_05269_ _09404_/A1 _05274_/A2 _05274_/B1 _05269_/B2 _09428_/D vdd vdd
+ vss vss gf180mcu_fd_sc_mcu7t5v0__oai22_1
X_07008_ _07008_/A1 _07006_/Z _07008_/Z vdd vdd vss vss gf180mcu_fd_sc_mcu7t5v0__or2_1
X_08959_ _09822_/Q _08955_/Z _08968_/B _08960_/A2 vdd vdd vss vss
+ gf180mcu_fd_sc_mcu7t5v0__oai21_1
XPHY_110 vdd vss gf180mcu_fd_sc_mcu7t5v0__endcap
XPHY_121 vdd vss gf180mcu_fd_sc_mcu7t5v0__endcap
XPHY_132 vdd vss gf180mcu_fd_sc_mcu7t5v0__endcap
XPHY_143 vdd vss gf180mcu_fd_sc_mcu7t5v0__endcap
XPHY_154 vdd vss gf180mcu_fd_sc_mcu7t5v0__endcap
XPHY_165 vdd vss gf180mcu_fd_sc_mcu7t5v0__endcap
XPHY_176 vdd vss gf180mcu_fd_sc_mcu7t5v0__endcap
XPHY_187 vdd vss gf180mcu_fd_sc_mcu7t5v0__endcap
XPHY_198 vdd vss gf180mcu_fd_sc_mcu7t5v0__endcap
XPHY_1 vdd vss gf180mcu_fd_sc_mcu7t5v0__endcap
X_07290_ _07289_/B _07277_/Z _07290_/B _08706_/B _07292_/A2 vdd vdd vss
+ vss gf180mcu_fd_sc_mcu7t5v0__oai211_1
X_06310_ _10012_/Q _09104_/A2 _09072_/B _06311_/B vdd vdd vss vss
+ gf180mcu_fd_sc_mcu7t5v0__oai21_1
X_06241_ _06220_/Z _06242_/A3 _06267_/A3 vdd vdd vss vss gf180mcu_fd_sc_mcu7t5v0__nor2_1
X_06172_ _09712_/Q _06085_/Z _06275_/A1 vdd vdd vss vss gf180mcu_fd_sc_mcu7t5v0__nand2_1
X_05123_ _09525_/Q _05121_/Z _08902_/B vdd vdd vss vss gf180mcu_fd_sc_mcu7t5v0__nand2_1
X_09931_ _09931_/D clk _09931_/Q vdd vdd vss vss gf180mcu_fd_sc_mcu7t5v0__dffq_1
X_05054_ _09456_/Q _05305_/B2 vdd vdd vss vss gf180mcu_fd_sc_mcu7t5v0__clkinv_1
X_09862_ _09862_/D clk _09862_/Q vdd vdd vss vss gf180mcu_fd_sc_mcu7t5v0__dffq_1
XTAP_641 vdd vss gf180mcu_fd_sc_mcu7t5v0__filltie
XTAP_652 vdd vss gf180mcu_fd_sc_mcu7t5v0__filltie
XTAP_630 vdd vss gf180mcu_fd_sc_mcu7t5v0__filltie
XTAP_685 vdd vss gf180mcu_fd_sc_mcu7t5v0__filltie
XTAP_674 vdd vss gf180mcu_fd_sc_mcu7t5v0__filltie
XTAP_663 vdd vss gf180mcu_fd_sc_mcu7t5v0__filltie
X_08813_ _08813_/A1 _08814_/A2 _08819_/A2 vdd vdd vss vss gf180mcu_fd_sc_mcu7t5v0__nor2_1
X_09793_ _09793_/D clk _09793_/Q vdd vdd vss vss gf180mcu_fd_sc_mcu7t5v0__dffq_1
XTAP_696 vdd vss gf180mcu_fd_sc_mcu7t5v0__filltie
X_08744_ _09408_/A1 _08745_/A2 _08745_/B1 _08744_/B2 _09729_/D vdd vdd
+ vss vss gf180mcu_fd_sc_mcu7t5v0__oai22_1
X_05956_ _09565_/Q _05956_/A2 _05966_/A2 _05956_/Z vdd vdd vss vss
+ gf180mcu_fd_sc_mcu7t5v0__xor3_1
X_04907_ _09606_/Q _06646_/B2 vdd vdd vss vss gf180mcu_fd_sc_mcu7t5v0__clkinv_1
X_05887_ _05954_/A1 _05887_/A2 _05939_/A1 vdd vdd vss vss gf180mcu_fd_sc_mcu7t5v0__nor2_1
XTAP_1807 vdd vss gf180mcu_fd_sc_mcu7t5v0__filltie
X_08675_ _08509_/I _08675_/A2 _08675_/B _08692_/A2 vdd vdd vss vss
+ gf180mcu_fd_sc_mcu7t5v0__oai21_1
XTAP_1829 vdd vss gf180mcu_fd_sc_mcu7t5v0__filltie
XTAP_1818 vdd vss gf180mcu_fd_sc_mcu7t5v0__filltie
X_07626_ _09709_/Q _07626_/A2 _07628_/A1 vdd vdd vss vss gf180mcu_fd_sc_mcu7t5v0__nand2_1
X_04838_ _09568_/Q _05974_/A1 vdd vdd vss vss gf180mcu_fd_sc_mcu7t5v0__clkinv_3
X_04769_ _09702_/Q _08027_/A1 vdd vdd vss vss gf180mcu_fd_sc_mcu7t5v0__inv_2
X_07557_ _07650_/I0 _07557_/A2 _07557_/B _07558_/B vdd vdd vss vss
+ gf180mcu_fd_sc_mcu7t5v0__oai21_1
X_06508_ _09710_/Q _06613_/A2 _06507_/Z _06550_/B vdd vdd vss vss
+ gf180mcu_fd_sc_mcu7t5v0__and3_1
X_07488_ _07516_/A1 _07516_/B _07488_/Z vdd vdd vss vss gf180mcu_fd_sc_mcu7t5v0__and2_1
X_06439_ _06608_/A2 _06562_/A2 _06603_/A2 _06439_/B _06482_/A1 vdd vdd
+ vss vss gf180mcu_fd_sc_mcu7t5v0__oai31_1
X_09227_ _09176_/B _09260_/A2 _09227_/B _09942_/D vdd vdd vss vss
+ gf180mcu_fd_sc_mcu7t5v0__aoi21_1
X_09158_ _09947_/Q _09137_/Z _09170_/B1 _09921_/Q _09158_/C _09159_/A2 vdd vdd
+ vss vss gf180mcu_fd_sc_mcu7t5v0__aoi221_1
X_08109_ _08030_/Z _08061_/Z _08154_/B _08110_/A2 vdd vdd vss vss
+ gf180mcu_fd_sc_mcu7t5v0__oai21_1
X_09089_ _09893_/Q _09098_/A1 _09089_/B _09090_/B vdd vdd vss vss
+ gf180mcu_fd_sc_mcu7t5v0__oai21_1
X_10002_ _10002_/D clk _10002_/Q vdd vdd vss vss gf180mcu_fd_sc_mcu7t5v0__dffq_1
Xrepeater12 _09023_/A1 _09401_/A1 vdd vdd vss vss gf180mcu_fd_sc_mcu7t5v0__buf_8
X_05810_ _05810_/A1 _05767_/Z _05810_/B _05863_/A1 vdd vdd vss vss
+ gf180mcu_fd_sc_mcu7t5v0__oai21_1
X_06790_ _06790_/A1 _06755_/Z _06831_/A1 _06791_/I vdd vdd vss vss
+ gf180mcu_fd_sc_mcu7t5v0__xor3_1
X_05741_ _07452_/C _05645_/I _05742_/B _05741_/Z vdd vdd vss vss gf180mcu_fd_sc_mcu7t5v0__or3_1
X_08460_ _08460_/A1 _08494_/A1 _08460_/A3 _08461_/I vdd vdd vss vss
+ gf180mcu_fd_sc_mcu7t5v0__xor3_1
X_05672_ _05672_/A1 _05672_/A2 _09558_/D vdd vdd vss vss gf180mcu_fd_sc_mcu7t5v0__nor2_1
X_08391_ _08391_/A1 _08389_/Z _08391_/B _08685_/A2 vdd vdd vss vss
+ gf180mcu_fd_sc_mcu7t5v0__oai21_4
X_07411_ _07411_/A1 _07411_/A2 _07412_/B vdd vdd vss vss gf180mcu_fd_sc_mcu7t5v0__nor2_1
X_07342_ _09647_/Q _07336_/B _07342_/B _07343_/B vdd vdd vss vss gf180mcu_fd_sc_mcu7t5v0__aoi21_1
X_07273_ _07273_/A1 _07272_/Z _07273_/Z vdd vdd vss vss gf180mcu_fd_sc_mcu7t5v0__xor2_1
X_06224_ _06224_/A1 _06224_/A2 _06275_/B2 _06224_/Z vdd vdd vss vss
+ gf180mcu_fd_sc_mcu7t5v0__xor3_1
X_09012_ _09012_/A1 _09400_/A1 _09021_/A2 vdd vdd vss vss gf180mcu_fd_sc_mcu7t5v0__nand2_4
X_06155_ _06260_/A1 _06155_/A2 _06155_/B _06156_/B vdd vdd vss vss
+ gf180mcu_fd_sc_mcu7t5v0__oai21_1
X_05106_ _09742_/Q _08755_/B2 vdd vdd vss vss gf180mcu_fd_sc_mcu7t5v0__clkinv_1
X_06086_ _09710_/Q _06085_/Z _06129_/A1 vdd vdd vss vss gf180mcu_fd_sc_mcu7t5v0__nand2_1
X_05037_ _09423_/Q _05258_/B2 vdd vdd vss vss gf180mcu_fd_sc_mcu7t5v0__clkinv_1
X_09914_ _09914_/D clk _09914_/Q vdd vdd vss vss gf180mcu_fd_sc_mcu7t5v0__dffq_1
XTAP_460 vdd vss gf180mcu_fd_sc_mcu7t5v0__filltie
X_09845_ _09845_/D clk _09845_/Q vdd vdd vss vss gf180mcu_fd_sc_mcu7t5v0__dffq_1
XTAP_471 vdd vss gf180mcu_fd_sc_mcu7t5v0__filltie
XTAP_482 vdd vss gf180mcu_fd_sc_mcu7t5v0__filltie
XTAP_493 vdd vss gf180mcu_fd_sc_mcu7t5v0__filltie
X_06988_ _07294_/A1 _07053_/A2 _07278_/A1 vdd vdd vss vss gf180mcu_fd_sc_mcu7t5v0__nor2_4
X_09776_ _09776_/D clk _09776_/Q vdd vdd vss vss gf180mcu_fd_sc_mcu7t5v0__dffq_1
X_05939_ _05939_/A1 _05939_/A2 _05939_/B _05954_/A2 vdd vdd vss vss
+ gf180mcu_fd_sc_mcu7t5v0__aoi21_1
X_08727_ _08727_/A1 _09073_/A2 _08727_/B _09718_/D vdd vdd vss vss
+ gf180mcu_fd_sc_mcu7t5v0__aoi21_1
X_08658_ _08703_/B _08689_/A2 _08659_/A2 vdd vdd vss vss gf180mcu_fd_sc_mcu7t5v0__nand2_1
XTAP_1604 vdd vss gf180mcu_fd_sc_mcu7t5v0__filltie
XTAP_1615 vdd vss gf180mcu_fd_sc_mcu7t5v0__filltie
XTAP_1648 vdd vss gf180mcu_fd_sc_mcu7t5v0__filltie
X_07609_ _07648_/A2 _07609_/A2 _07614_/A3 vdd vdd vss vss gf180mcu_fd_sc_mcu7t5v0__nand2_1
XTAP_1626 vdd vss gf180mcu_fd_sc_mcu7t5v0__filltie
XTAP_1637 vdd vss gf180mcu_fd_sc_mcu7t5v0__filltie
X_08589_ _08589_/A1 _08587_/Z _08617_/A2 vdd vdd vss vss gf180mcu_fd_sc_mcu7t5v0__xnor2_1
XTAP_1659 vdd vss gf180mcu_fd_sc_mcu7t5v0__filltie
X_07960_ _07976_/A1 _07976_/A2 _07960_/Z vdd vdd vss vss gf180mcu_fd_sc_mcu7t5v0__xor2_1
X_06911_ _06890_/Z _06953_/A1 _06911_/Z vdd vdd vss vss gf180mcu_fd_sc_mcu7t5v0__xor2_1
X_07891_ _09710_/Q _07988_/A2 _07944_/A1 vdd vdd vss vss gf180mcu_fd_sc_mcu7t5v0__nand2_1
X_06842_ _06842_/A1 _06889_/A2 _06882_/B vdd vdd vss vss gf180mcu_fd_sc_mcu7t5v0__nor2_1
X_09630_ _09630_/D clk _09630_/Q vdd vdd vss vss gf180mcu_fd_sc_mcu7t5v0__dffq_2
X_09561_ _09561_/D clk _09561_/Q vdd vdd vss vss gf180mcu_fd_sc_mcu7t5v0__dffq_4
X_06773_ _06774_/A1 _06774_/A2 _06774_/B _06782_/A1 vdd vdd vss vss
+ gf180mcu_fd_sc_mcu7t5v0__nor3_1
X_05724_ _09712_/Q _05723_/Z _05763_/B vdd vdd vss vss gf180mcu_fd_sc_mcu7t5v0__and2_1
X_08512_ _08521_/A1 _08517_/A2 _08514_/B vdd vdd vss vss gf180mcu_fd_sc_mcu7t5v0__and2_1
X_09492_ _09492_/D clk _09492_/Q vdd vdd vss vss gf180mcu_fd_sc_mcu7t5v0__dffq_1
X_08443_ _09703_/Q _08440_/Z _08450_/A1 vdd vdd vss vss gf180mcu_fd_sc_mcu7t5v0__nand2_1
X_05655_ _05970_/A1 _05964_/A2 _05862_/A1 vdd vdd vss vss gf180mcu_fd_sc_mcu7t5v0__nor2_2
X_08374_ _09983_/Q _09073_/A2 _08734_/B _08375_/B vdd vdd vss vss
+ gf180mcu_fd_sc_mcu7t5v0__oai21_1
X_05586_ _09456_/Q _05627_/A2 _05627_/B1 _09440_/Q _05588_/A1 vdd vdd
+ vss vss gf180mcu_fd_sc_mcu7t5v0__aoi22_1
X_07325_ _09657_/Q _07337_/A2 _07610_/A1 vdd vdd vss vss gf180mcu_fd_sc_mcu7t5v0__nor2_1
X_07256_ _07204_/Z _07224_/Z _07256_/B _07275_/A2 vdd vdd vss vss
+ gf180mcu_fd_sc_mcu7t5v0__aoi21_1
X_06207_ _06207_/A1 _06192_/Z _08565_/C _06208_/B2 vdd vdd vss vss
+ gf180mcu_fd_sc_mcu7t5v0__aoi21_1
X_07187_ _09715_/Q _06984_/B _07286_/I1 _07188_/A2 _07287_/C _07188_/B vdd vdd
+ vss vss gf180mcu_fd_sc_mcu7t5v0__aoi221_1
X_06138_ _06055_/I _06096_/Z _06137_/Z _06142_/A2 vdd vdd vss vss
+ gf180mcu_fd_sc_mcu7t5v0__nor3_2
X_06069_ _06297_/I1 _06072_/A2 _06069_/Z vdd vdd vss vss gf180mcu_fd_sc_mcu7t5v0__and2_1
X_09828_ _09828_/D clk _09828_/Q vdd vdd vss vss gf180mcu_fd_sc_mcu7t5v0__dffq_1
XTAP_290 vdd vss gf180mcu_fd_sc_mcu7t5v0__filltie
X_09759_ _09759_/D clk _09759_/Q vdd vdd vss vss gf180mcu_fd_sc_mcu7t5v0__dffq_1
XTAP_1401 vdd vss gf180mcu_fd_sc_mcu7t5v0__filltie
XTAP_1412 vdd vss gf180mcu_fd_sc_mcu7t5v0__filltie
XTAP_1423 vdd vss gf180mcu_fd_sc_mcu7t5v0__filltie
XTAP_1445 vdd vss gf180mcu_fd_sc_mcu7t5v0__filltie
XTAP_1434 vdd vss gf180mcu_fd_sc_mcu7t5v0__filltie
XTAP_1456 vdd vss gf180mcu_fd_sc_mcu7t5v0__filltie
XTAP_1467 vdd vss gf180mcu_fd_sc_mcu7t5v0__filltie
XTAP_1478 vdd vss gf180mcu_fd_sc_mcu7t5v0__filltie
XTAP_1489 vdd vss gf180mcu_fd_sc_mcu7t5v0__filltie
X_05440_ _05440_/A1 _05440_/A2 _05456_/A2 vdd vdd vss vss gf180mcu_fd_sc_mcu7t5v0__nand2_1
XTAP_1990 vdd vss gf180mcu_fd_sc_mcu7t5v0__filltie
X_05371_ _09401_/A1 _05379_/A2 _05379_/B1 vdd vdd vss vss gf180mcu_fd_sc_mcu7t5v0__nand2_2
X_07110_ _07110_/A1 _07157_/A1 _07149_/B vdd vdd vss vss gf180mcu_fd_sc_mcu7t5v0__nor2_1
X_08090_ _08099_/A1 _08129_/A3 _08172_/A1 vdd vdd vss vss gf180mcu_fd_sc_mcu7t5v0__nor2_2
X_07041_ _07042_/A1 _07042_/A2 _07042_/B _07041_/Z vdd vdd vss vss
+ gf180mcu_fd_sc_mcu7t5v0__and3_1
X_08992_ _09012_/A1 _09022_/A1 _09001_/A2 vdd vdd vss vss gf180mcu_fd_sc_mcu7t5v0__nand2_4
X_07943_ _09711_/Q _08005_/A2 _07985_/A1 vdd vdd vss vss gf180mcu_fd_sc_mcu7t5v0__nand2_1
X_07874_ _09714_/Q _07712_/Z _07877_/C vdd vdd vss vss gf180mcu_fd_sc_mcu7t5v0__nand2_1
X_06825_ _06781_/C _06809_/Z _08565_/C _06826_/B2 vdd vdd vss vss
+ gf180mcu_fd_sc_mcu7t5v0__aoi21_1
X_09613_ _09613_/D clk _09613_/Q vdd vdd vss vss gf180mcu_fd_sc_mcu7t5v0__dffq_2
X_09544_ _09544_/D clk _09544_/Q vdd vdd vss vss gf180mcu_fd_sc_mcu7t5v0__dffq_1
X_06756_ _06756_/A1 _06796_/A1 _06756_/Z vdd vdd vss vss gf180mcu_fd_sc_mcu7t5v0__xor2_1
X_05707_ _08715_/A1 _05645_/I _05709_/B _05758_/A1 vdd vdd vss vss
+ gf180mcu_fd_sc_mcu7t5v0__nor3_2
X_09475_ _09475_/D clk _09475_/Q vdd vdd vss vss gf180mcu_fd_sc_mcu7t5v0__dffq_1
X_06687_ _06658_/I _06910_/B _06687_/Z vdd vdd vss vss gf180mcu_fd_sc_mcu7t5v0__and2_1
X_08426_ _09718_/Q _08426_/A2 _08703_/B vdd vdd vss vss gf180mcu_fd_sc_mcu7t5v0__nand2_4
X_05638_ _09710_/Q _05974_/A1 _05638_/B _05662_/B2 vdd vdd vss vss
+ gf180mcu_fd_sc_mcu7t5v0__oai21_1
X_05569_ _09531_/Q _05627_/A2 _05627_/B1 _09539_/Q _05571_/A1 vdd vdd
+ vss vss gf180mcu_fd_sc_mcu7t5v0__aoi22_1
X_08357_ _08357_/A1 _08356_/Z _08357_/Z vdd vdd vss vss gf180mcu_fd_sc_mcu7t5v0__xor2_1
X_07308_ _09405_/A1 _07312_/A2 _07312_/B1 _07308_/B2 _09642_/D vdd vdd
+ vss vss gf180mcu_fd_sc_mcu7t5v0__oai22_1
X_08288_ _09708_/Q _09693_/Q _08180_/B _08291_/A1 vdd vdd vss vss
+ gf180mcu_fd_sc_mcu7t5v0__nand3_1
X_07239_ _07245_/A2 _07282_/B _07239_/Z vdd vdd vss vss gf180mcu_fd_sc_mcu7t5v0__xor2_1
XTAP_1220 vdd vss gf180mcu_fd_sc_mcu7t5v0__filltie
XTAP_1231 vdd vss gf180mcu_fd_sc_mcu7t5v0__filltie
XTAP_1242 vdd vss gf180mcu_fd_sc_mcu7t5v0__filltie
XTAP_1253 vdd vss gf180mcu_fd_sc_mcu7t5v0__filltie
XTAP_1264 vdd vss gf180mcu_fd_sc_mcu7t5v0__filltie
XTAP_1275 vdd vss gf180mcu_fd_sc_mcu7t5v0__filltie
XTAP_1297 vdd vss gf180mcu_fd_sc_mcu7t5v0__filltie
XTAP_1286 vdd vss gf180mcu_fd_sc_mcu7t5v0__filltie
X_04940_ _09586_/Q _06318_/B2 vdd vdd vss vss gf180mcu_fd_sc_mcu7t5v0__clkinv_1
X_04871_ _09723_/Q _08738_/B2 vdd vdd vss vss gf180mcu_fd_sc_mcu7t5v0__clkinv_1
X_06610_ _06614_/A2 _06602_/Z _06610_/A3 _06610_/Z vdd vdd vss vss
+ gf180mcu_fd_sc_mcu7t5v0__xor3_1
X_07590_ _07590_/A1 _07590_/A2 _07589_/Z _07593_/A3 vdd vdd vss vss
+ gf180mcu_fd_sc_mcu7t5v0__xnor3_1
X_06541_ _06350_/C _06541_/A2 _06536_/Z _06541_/A4 _06542_/B vdd vdd vss
+ vss gf180mcu_fd_sc_mcu7t5v0__nand4_1
X_06472_ _06473_/A1 _06473_/A2 _06575_/A1 vdd vdd vss vss gf180mcu_fd_sc_mcu7t5v0__nor2_2
X_09260_ _09467_/Q _09260_/A2 _09260_/B _09958_/D vdd vdd vss vss
+ gf180mcu_fd_sc_mcu7t5v0__aoi21_1
X_05423_ _05423_/A1 _05423_/A2 _05427_/B2 vdd vdd vss vss gf180mcu_fd_sc_mcu7t5v0__nand2_1
X_08211_ _08156_/Z _08211_/A2 _08210_/B _08217_/B1 vdd vdd vss vss
+ gf180mcu_fd_sc_mcu7t5v0__nor3_1
X_09191_ _09173_/B _09252_/A2 _09191_/B _09930_/D vdd vdd vss vss
+ gf180mcu_fd_sc_mcu7t5v0__aoi21_1
X_05354_ _09404_/A1 _05359_/A2 _05359_/B1 _05354_/B2 _09508_/D vdd vdd
+ vss vss gf180mcu_fd_sc_mcu7t5v0__oai22_1
X_08142_ _08143_/A1 _08188_/A1 _08225_/A2 vdd vdd vss vss gf180mcu_fd_sc_mcu7t5v0__nor2_2
X_08073_ _09711_/Q _08088_/A2 _08088_/A3 _08076_/A1 vdd vdd vss vss
+ gf180mcu_fd_sc_mcu7t5v0__nand3_1
X_05285_ _09408_/A1 _05286_/A2 _05286_/B1 _05285_/B2 _09440_/D vdd vdd
+ vss vss gf180mcu_fd_sc_mcu7t5v0__oai22_1
X_07024_ _07289_/B _07024_/A2 _07025_/A2 vdd vdd vss vss gf180mcu_fd_sc_mcu7t5v0__nor2_1
X_08975_ _09403_/A1 _08981_/A2 _08981_/B1 _08975_/B2 _09828_/D vdd vdd
+ vss vss gf180mcu_fd_sc_mcu7t5v0__oai22_1
X_07926_ _07926_/A1 _07926_/A2 _07895_/Z _07926_/B1 _07926_/B2 _07955_/A1 vdd
+ vdd vss vss gf180mcu_fd_sc_mcu7t5v0__oai32_1
X_07857_ _07721_/B _07914_/A2 _07862_/B2 vdd vdd vss vss gf180mcu_fd_sc_mcu7t5v0__nand2_1
X_07788_ _07784_/Z _07881_/A3 _07788_/Z vdd vdd vss vss gf180mcu_fd_sc_mcu7t5v0__and2_2
X_06808_ _09617_/Q _06806_/Z _06829_/B vdd vdd vss vss gf180mcu_fd_sc_mcu7t5v0__nand2_1
X_09527_ _09527_/D clk _09527_/Q vdd vdd vss vss gf180mcu_fd_sc_mcu7t5v0__dffq_1
X_06739_ _06957_/A1 _06735_/I _06739_/B _06739_/C _06740_/C vdd vdd vss
+ vss gf180mcu_fd_sc_mcu7t5v0__oai211_1
X_09458_ _09458_/D clk _09458_/Q vdd vdd vss vss gf180mcu_fd_sc_mcu7t5v0__dffq_1
X_08409_ _09720_/Q _08729_/A1 _08727_/A1 _08510_/B vdd vdd vss vss
+ gf180mcu_fd_sc_mcu7t5v0__nor3_4
X_09389_ _05108_/Z _09389_/A2 _09399_/A2 vdd vdd vss vss gf180mcu_fd_sc_mcu7t5v0__nor2_4
XTAP_1050 vdd vss gf180mcu_fd_sc_mcu7t5v0__filltie
XTAP_1061 vdd vss gf180mcu_fd_sc_mcu7t5v0__filltie
XTAP_1083 vdd vss gf180mcu_fd_sc_mcu7t5v0__filltie
XTAP_1072 vdd vss gf180mcu_fd_sc_mcu7t5v0__filltie
XTAP_1094 vdd vss gf180mcu_fd_sc_mcu7t5v0__filltie
X_05070_ _09857_/Q _09010_/B2 vdd vdd vss vss gf180mcu_fd_sc_mcu7t5v0__clkinv_1
XTAP_801 vdd vss gf180mcu_fd_sc_mcu7t5v0__filltie
XTAP_823 vdd vss gf180mcu_fd_sc_mcu7t5v0__filltie
XTAP_812 vdd vss gf180mcu_fd_sc_mcu7t5v0__filltie
XTAP_834 vdd vss gf180mcu_fd_sc_mcu7t5v0__filltie
XTAP_845 vdd vss gf180mcu_fd_sc_mcu7t5v0__filltie
XTAP_867 vdd vss gf180mcu_fd_sc_mcu7t5v0__filltie
XTAP_856 vdd vss gf180mcu_fd_sc_mcu7t5v0__filltie
XTAP_878 vdd vss gf180mcu_fd_sc_mcu7t5v0__filltie
XTAP_889 vdd vss gf180mcu_fd_sc_mcu7t5v0__filltie
X_08760_ _08760_/I _08761_/B vdd vdd vss vss gf180mcu_fd_sc_mcu7t5v0__clkinv_1
X_05972_ _05972_/A1 _09104_/A2 _05972_/B _09567_/D vdd vdd vss vss
+ gf180mcu_fd_sc_mcu7t5v0__aoi21_1
X_04923_ _09428_/Q _05269_/B2 vdd vdd vss vss gf180mcu_fd_sc_mcu7t5v0__clkinv_1
X_07711_ _09679_/Q _07711_/A2 _07711_/B _07727_/A3 vdd vdd vss vss
+ gf180mcu_fd_sc_mcu7t5v0__oai21_2
X_08691_ _08691_/A1 _08687_/Z _08690_/Z _08691_/Z vdd vdd vss vss
+ gf180mcu_fd_sc_mcu7t5v0__xor3_1
X_04854_ _09835_/Q _08984_/B2 vdd vdd vss vss gf180mcu_fd_sc_mcu7t5v0__clkinv_1
X_07642_ _09717_/Q _07646_/A2 _07652_/B vdd vdd vss vss gf180mcu_fd_sc_mcu7t5v0__nor2_1
X_04785_ _09668_/Q _08029_/A2 vdd vdd vss vss gf180mcu_fd_sc_mcu7t5v0__clkinv_2
X_09312_ _09356_/A2 _09311_/Z _09322_/A2 vdd vdd vss vss gf180mcu_fd_sc_mcu7t5v0__nor2_4
X_07573_ _09716_/Q _07317_/Z _07590_/A2 _07620_/A2 vdd vdd vss vss
+ gf180mcu_fd_sc_mcu7t5v0__nand3_1
X_06524_ _06525_/A1 _06523_/Z _06597_/A1 vdd vdd vss vss gf180mcu_fd_sc_mcu7t5v0__nand2_1
X_06455_ _06455_/A1 _06455_/A2 _08670_/B _09595_/D vdd vdd vss vss
+ gf180mcu_fd_sc_mcu7t5v0__aoi21_1
X_09243_ _09950_/Q _09244_/A2 _09259_/B _09244_/B vdd vdd vss vss
+ gf180mcu_fd_sc_mcu7t5v0__oai21_1
X_06386_ _06351_/Z _06380_/Z _06386_/B _06417_/A1 vdd vdd vss vss
+ gf180mcu_fd_sc_mcu7t5v0__aoi21_1
X_05406_ _05413_/A1 _05318_/Z _08736_/A2 vdd vdd vss vss gf180mcu_fd_sc_mcu7t5v0__nor2_4
X_09174_ _09399_/C _09174_/A2 _09925_/D vdd vdd vss vss gf180mcu_fd_sc_mcu7t5v0__nor2_1
X_08125_ _08125_/A1 _08125_/A2 _08125_/Z vdd vdd vss vss gf180mcu_fd_sc_mcu7t5v0__and2_1
X_05337_ _09407_/A1 _05339_/A2 _05339_/B1 _05337_/B2 _09495_/D vdd vdd
+ vss vss gf180mcu_fd_sc_mcu7t5v0__oai22_1
X_08056_ _08056_/A1 _08056_/A2 _09681_/D vdd vdd vss vss gf180mcu_fd_sc_mcu7t5v0__nor2_1
X_05268_ _09403_/A1 _05274_/A2 _05274_/B1 _05268_/B2 _09427_/D vdd vdd
+ vss vss gf180mcu_fd_sc_mcu7t5v0__oai22_1
X_07007_ _07008_/A1 _07006_/Z _07044_/A2 vdd vdd vss vss gf180mcu_fd_sc_mcu7t5v0__nand2_1
X_05199_ _09259_/B _09458_/Q _09466_/D vdd vdd vss vss gf180mcu_fd_sc_mcu7t5v0__and2_1
X_08958_ _09822_/Q _08955_/Z _08958_/Z vdd vdd vss vss gf180mcu_fd_sc_mcu7t5v0__and2_1
X_07909_ _07909_/A1 _07909_/A2 _07909_/B _07962_/B vdd vdd vss vss
+ gf180mcu_fd_sc_mcu7t5v0__aoi21_1
X_08889_ _08899_/A2 _08889_/A2 _08890_/B vdd vdd vss vss gf180mcu_fd_sc_mcu7t5v0__nand2_1
XPHY_100 vdd vss gf180mcu_fd_sc_mcu7t5v0__endcap
XPHY_111 vdd vss gf180mcu_fd_sc_mcu7t5v0__endcap
XPHY_122 vdd vss gf180mcu_fd_sc_mcu7t5v0__endcap
XPHY_133 vdd vss gf180mcu_fd_sc_mcu7t5v0__endcap
XPHY_144 vdd vss gf180mcu_fd_sc_mcu7t5v0__endcap
XPHY_155 vdd vss gf180mcu_fd_sc_mcu7t5v0__endcap
XPHY_166 vdd vss gf180mcu_fd_sc_mcu7t5v0__endcap
XPHY_177 vdd vss gf180mcu_fd_sc_mcu7t5v0__endcap
XPHY_188 vdd vss gf180mcu_fd_sc_mcu7t5v0__endcap
XPHY_199 vdd vss gf180mcu_fd_sc_mcu7t5v0__endcap
XPHY_2 vdd vss gf180mcu_fd_sc_mcu7t5v0__endcap
X_06240_ _06220_/Z _06242_/A3 _06240_/Z vdd vdd vss vss gf180mcu_fd_sc_mcu7t5v0__and2_1
X_06171_ _09713_/Q _06050_/I _06177_/A1 vdd vdd vss vss gf180mcu_fd_sc_mcu7t5v0__nand2_1
X_05122_ _09399_/C _05121_/Z _08926_/B vdd vdd vss vss gf180mcu_fd_sc_mcu7t5v0__nor2_2
X_09930_ _09930_/D clk _09930_/Q vdd vdd vss vss gf180mcu_fd_sc_mcu7t5v0__dffq_1
X_05053_ _09448_/Q _05295_/B2 vdd vdd vss vss gf180mcu_fd_sc_mcu7t5v0__clkinv_1
XTAP_642 vdd vss gf180mcu_fd_sc_mcu7t5v0__filltie
XTAP_631 vdd vss gf180mcu_fd_sc_mcu7t5v0__filltie
X_09861_ _09861_/D clk _09861_/Q vdd vdd vss vss gf180mcu_fd_sc_mcu7t5v0__dffq_1
XTAP_620 vdd vss gf180mcu_fd_sc_mcu7t5v0__filltie
XTAP_686 vdd vss gf180mcu_fd_sc_mcu7t5v0__filltie
XTAP_675 vdd vss gf180mcu_fd_sc_mcu7t5v0__filltie
XTAP_664 vdd vss gf180mcu_fd_sc_mcu7t5v0__filltie
XTAP_653 vdd vss gf180mcu_fd_sc_mcu7t5v0__filltie
X_08812_ _05165_/B _08812_/A2 _08812_/B _08812_/C _09765_/D vdd vdd vss
+ vss gf180mcu_fd_sc_mcu7t5v0__aoi211_1
X_09792_ _09792_/D clk _09792_/Q vdd vdd vss vss gf180mcu_fd_sc_mcu7t5v0__dffq_1
X_05955_ _05955_/A1 _05955_/A2 _05954_/Z _05966_/A2 vdd vdd vss vss
+ gf180mcu_fd_sc_mcu7t5v0__xnor3_1
XTAP_697 vdd vss gf180mcu_fd_sc_mcu7t5v0__filltie
X_08743_ _09407_/A1 _08745_/A2 _08745_/B1 _08743_/B2 _09728_/D vdd vdd
+ vss vss gf180mcu_fd_sc_mcu7t5v0__oai22_1
X_04906_ _09640_/Q _07306_/B2 vdd vdd vss vss gf180mcu_fd_sc_mcu7t5v0__clkinv_1
X_05886_ _09716_/Q _05940_/A2 _05689_/B _09715_/Q _05887_/A2 vdd vdd vss
+ vss gf180mcu_fd_sc_mcu7t5v0__aoi22_1
X_08674_ _08674_/A1 _08674_/A2 _08674_/B _08692_/A1 vdd vdd vss vss
+ gf180mcu_fd_sc_mcu7t5v0__oai21_1
XTAP_1819 vdd vss gf180mcu_fd_sc_mcu7t5v0__filltie
XTAP_1808 vdd vss gf180mcu_fd_sc_mcu7t5v0__filltie
X_07625_ _07625_/A1 _07624_/Z _07625_/Z vdd vdd vss vss gf180mcu_fd_sc_mcu7t5v0__xor2_1
X_04837_ _09569_/Q _05976_/A1 vdd vdd vss vss gf180mcu_fd_sc_mcu7t5v0__inv_4
X_04768_ _09703_/Q _08058_/A1 vdd vdd vss vss gf180mcu_fd_sc_mcu7t5v0__inv_2
X_07556_ _09715_/Q _07651_/A2 _07557_/A2 _07556_/B2 _07651_/B _07557_/B vdd
+ vdd vss vss gf180mcu_fd_sc_mcu7t5v0__aoi221_1
X_06507_ _06460_/Z _06505_/Z _06507_/Z vdd vdd vss vss gf180mcu_fd_sc_mcu7t5v0__xor2_1
X_09226_ _09942_/Q _09176_/B _09226_/B _09227_/B vdd vdd vss vss gf180mcu_fd_sc_mcu7t5v0__oai21_1
X_07487_ _07516_/A1 _07486_/Z _07515_/A2 vdd vdd vss vss gf180mcu_fd_sc_mcu7t5v0__nor2_1
X_06438_ _06456_/A1 _06437_/Z _06438_/Z vdd vdd vss vss gf180mcu_fd_sc_mcu7t5v0__xor2_1
X_06369_ _09711_/Q _06562_/A2 _06394_/A1 vdd vdd vss vss gf180mcu_fd_sc_mcu7t5v0__nand2_1
X_09157_ _09137_/Z _09157_/A2 _09158_/C vdd vdd vss vss gf180mcu_fd_sc_mcu7t5v0__nor2_1
X_08108_ _08430_/B _08066_/Z _08108_/B _08114_/A1 vdd vdd vss vss
+ gf180mcu_fd_sc_mcu7t5v0__oai21_1
X_09088_ _09966_/Q _09095_/A2 _09096_/B1 _09971_/Q _09088_/C _09090_/A2 vdd
+ vdd vss vss gf180mcu_fd_sc_mcu7t5v0__aoi221_2
X_08039_ _08040_/A2 _08358_/I0 _08044_/A2 _08362_/A1 vdd vdd vss vss
+ gf180mcu_fd_sc_mcu7t5v0__nand3_2
X_10001_ _10001_/D clk _10001_/Q vdd vdd vss vss gf180mcu_fd_sc_mcu7t5v0__dffq_1
X_05740_ _09713_/Q _05689_/B _05784_/A1 vdd vdd vss vss gf180mcu_fd_sc_mcu7t5v0__nand2_1
X_05671_ _09558_/Q _08706_/B _08708_/B _05672_/A2 vdd vdd vss vss
+ gf180mcu_fd_sc_mcu7t5v0__oai21_1
X_08390_ _09681_/Q _08386_/Z _08423_/B1 _09647_/Q _08631_/A2 vdd vdd vss
+ vss gf180mcu_fd_sc_mcu7t5v0__aoi22_4
X_07410_ _07341_/B _07410_/A2 _08706_/B _07411_/A2 vdd vdd vss vss
+ gf180mcu_fd_sc_mcu7t5v0__oai21_1
X_07341_ _09647_/Q _07336_/B _07341_/B _07342_/B vdd vdd vss vss gf180mcu_fd_sc_mcu7t5v0__oai21_1
X_07272_ _07272_/A1 _07272_/A2 _07272_/A3 _07272_/Z vdd vdd vss vss
+ gf180mcu_fd_sc_mcu7t5v0__xor3_1
X_06223_ _06224_/A1 _06224_/A2 _06223_/Z vdd vdd vss vss gf180mcu_fd_sc_mcu7t5v0__and2_1
X_09011_ _09409_/A1 _09011_/A2 _09011_/B1 _09011_/B2 _09858_/D vdd vdd
+ vss vss gf180mcu_fd_sc_mcu7t5v0__oai22_1
X_06154_ _09714_/Q _05996_/B _06297_/I1 _06155_/A2 _06259_/C _06155_/B vdd vdd
+ vss vss gf180mcu_fd_sc_mcu7t5v0__aoi221_1
X_05105_ _09801_/Q _08913_/B2 vdd vdd vss vss gf180mcu_fd_sc_mcu7t5v0__clkinv_1
X_06085_ _09886_/Q _09629_/Q _09595_/Q _09561_/Q _09582_/Q _09583_/Q _06085_/Z vdd
+ vdd vss vss gf180mcu_fd_sc_mcu7t5v0__mux4_4
X_05036_ _09589_/Q _06321_/B2 vdd vdd vss vss gf180mcu_fd_sc_mcu7t5v0__clkinv_1
X_09913_ _09913_/D clk _09913_/Q vdd vdd vss vss gf180mcu_fd_sc_mcu7t5v0__dffq_2
X_09844_ _09844_/D clk _09844_/Q vdd vdd vss vss gf180mcu_fd_sc_mcu7t5v0__dffq_1
XTAP_450 vdd vss gf180mcu_fd_sc_mcu7t5v0__filltie
XTAP_461 vdd vss gf180mcu_fd_sc_mcu7t5v0__filltie
XTAP_472 vdd vss gf180mcu_fd_sc_mcu7t5v0__filltie
XTAP_483 vdd vss gf180mcu_fd_sc_mcu7t5v0__filltie
XTAP_494 vdd vss gf180mcu_fd_sc_mcu7t5v0__filltie
X_06987_ _09636_/Q _07296_/A1 _07053_/A2 vdd vdd vss vss gf180mcu_fd_sc_mcu7t5v0__nand2_2
X_09775_ _09775_/D clk _09775_/Q vdd vdd vss vss gf180mcu_fd_sc_mcu7t5v0__dffq_1
X_05938_ _05938_/A1 _05938_/A2 _05955_/A2 vdd vdd vss vss gf180mcu_fd_sc_mcu7t5v0__nand2_1
X_08726_ _09974_/Q _09073_/A2 _08734_/B _08727_/B vdd vdd vss vss
+ gf180mcu_fd_sc_mcu7t5v0__oai21_1
X_08657_ _08657_/A1 _08657_/A2 _08702_/A1 vdd vdd vss vss gf180mcu_fd_sc_mcu7t5v0__nand2_1
X_05869_ _05694_/B _05868_/Z _05870_/B vdd vdd vss vss gf180mcu_fd_sc_mcu7t5v0__nand2_1
XTAP_1605 vdd vss gf180mcu_fd_sc_mcu7t5v0__filltie
XTAP_1649 vdd vss gf180mcu_fd_sc_mcu7t5v0__filltie
X_07608_ _07649_/A1 _07608_/A2 _07609_/A2 vdd vdd vss vss gf180mcu_fd_sc_mcu7t5v0__nor2_1
XTAP_1616 vdd vss gf180mcu_fd_sc_mcu7t5v0__filltie
XTAP_1627 vdd vss gf180mcu_fd_sc_mcu7t5v0__filltie
XTAP_1638 vdd vss gf180mcu_fd_sc_mcu7t5v0__filltie
X_08588_ _08589_/A1 _08587_/Z _08617_/B vdd vdd vss vss gf180mcu_fd_sc_mcu7t5v0__or2_1
X_07539_ _07566_/B2 _07537_/Z _07539_/Z vdd vdd vss vss gf180mcu_fd_sc_mcu7t5v0__xor2_1
X_09209_ _09557_/Q _09209_/A2 _09209_/B1 _09209_/B2 _09260_/A2 vdd vdd
+ vss vss gf180mcu_fd_sc_mcu7t5v0__aoi22_2
X_06910_ _06792_/Z _06910_/A2 _06845_/Z _06910_/B _06953_/A1 vdd vdd vss
+ vss gf180mcu_fd_sc_mcu7t5v0__oai31_1
X_07890_ _07890_/A1 _07890_/A2 _07988_/A2 vdd vdd vss vss gf180mcu_fd_sc_mcu7t5v0__nand2_4
X_06841_ _09712_/Q _06792_/Z _06889_/A2 vdd vdd vss vss gf180mcu_fd_sc_mcu7t5v0__nand2_1
X_09560_ _09560_/D clk _09560_/Q vdd vdd vss vss gf180mcu_fd_sc_mcu7t5v0__dffq_4
X_06772_ _09713_/Q _06752_/I _06772_/A3 _06774_/B vdd vdd vss vss
+ gf180mcu_fd_sc_mcu7t5v0__xor3_1
X_05723_ _05835_/A2 _05723_/A2 _05723_/Z vdd vdd vss vss gf180mcu_fd_sc_mcu7t5v0__xor2_1
X_09491_ _09491_/D clk _09491_/Q vdd vdd vss vss gf180mcu_fd_sc_mcu7t5v0__dffq_1
X_08511_ _08514_/A1 _08514_/A2 _08515_/A3 vdd vdd vss vss gf180mcu_fd_sc_mcu7t5v0__nand2_1
X_08442_ _08442_/A1 _08442_/A2 _08442_/B _08476_/C _08447_/A2 vdd vdd
+ vss vss gf180mcu_fd_sc_mcu7t5v0__oai211_1
X_05654_ _05769_/B _05694_/B vdd vdd vss vss gf180mcu_fd_sc_mcu7t5v0__clkinv_2
X_05585_ _05585_/A1 _05585_/A2 _05601_/A2 vdd vdd vss vss gf180mcu_fd_sc_mcu7t5v0__nand2_1
X_08373_ _08180_/B _09073_/A2 _08373_/B _09692_/D vdd vdd vss vss
+ gf180mcu_fd_sc_mcu7t5v0__aoi21_1
X_07324_ _09656_/Q _07658_/A1 _07337_/A2 vdd vdd vss vss gf180mcu_fd_sc_mcu7t5v0__nand2_1
X_07255_ _07255_/A1 _07255_/A2 _07255_/B _07275_/A1 vdd vdd vss vss
+ gf180mcu_fd_sc_mcu7t5v0__aoi21_1
X_06206_ _06072_/C _06206_/A2 _06206_/A3 _06206_/A4 _06208_/B1 vdd vdd
+ vss vss gf180mcu_fd_sc_mcu7t5v0__nand4_1
X_07186_ _09715_/Q _07160_/Z _07188_/A2 vdd vdd vss vss gf180mcu_fd_sc_mcu7t5v0__nand2_1
X_06137_ _06082_/Z _06161_/A1 _06137_/A3 _06137_/Z vdd vdd vss vss
+ gf180mcu_fd_sc_mcu7t5v0__xor3_1
X_06068_ _09712_/Q _06050_/I _06072_/A2 vdd vdd vss vss gf180mcu_fd_sc_mcu7t5v0__nand2_1
X_05019_ _09431_/Q _05272_/B2 vdd vdd vss vss gf180mcu_fd_sc_mcu7t5v0__clkinv_1
XTAP_291 vdd vss gf180mcu_fd_sc_mcu7t5v0__filltie
XTAP_280 vdd vss gf180mcu_fd_sc_mcu7t5v0__filltie
X_09827_ _09827_/D clk _09827_/Q vdd vdd vss vss gf180mcu_fd_sc_mcu7t5v0__dffq_1
X_09758_ _09758_/D clk _09758_/Q vdd vdd vss vss gf180mcu_fd_sc_mcu7t5v0__dffq_1
X_08709_ _08709_/A1 _08709_/A2 _09709_/D vdd vdd vss vss gf180mcu_fd_sc_mcu7t5v0__nor2_1
X_09689_ _09689_/D clk _09689_/Q vdd vdd vss vss gf180mcu_fd_sc_mcu7t5v0__dffq_4
XTAP_1402 vdd vss gf180mcu_fd_sc_mcu7t5v0__filltie
XTAP_1413 vdd vss gf180mcu_fd_sc_mcu7t5v0__filltie
XTAP_1424 vdd vss gf180mcu_fd_sc_mcu7t5v0__filltie
XTAP_1446 vdd vss gf180mcu_fd_sc_mcu7t5v0__filltie
XTAP_1435 vdd vss gf180mcu_fd_sc_mcu7t5v0__filltie
XTAP_1457 vdd vss gf180mcu_fd_sc_mcu7t5v0__filltie
XTAP_1468 vdd vss gf180mcu_fd_sc_mcu7t5v0__filltie
XTAP_1479 vdd vss gf180mcu_fd_sc_mcu7t5v0__filltie
XTAP_1991 vdd vss gf180mcu_fd_sc_mcu7t5v0__filltie
XTAP_1980 vdd vss gf180mcu_fd_sc_mcu7t5v0__filltie
X_05370_ _09002_/A1 _05631_/C1 _05379_/A2 vdd vdd vss vss gf180mcu_fd_sc_mcu7t5v0__nand2_4
X_07040_ _09628_/Q _07039_/Z _07042_/B vdd vdd vss vss gf180mcu_fd_sc_mcu7t5v0__xnor2_1
X_08991_ _09409_/A1 _08991_/A2 _08991_/B1 _08991_/B2 _09842_/D vdd vdd
+ vss vss gf180mcu_fd_sc_mcu7t5v0__oai22_1
X_07942_ _09710_/Q _08005_/A2 _07947_/A3 vdd vdd vss vss gf180mcu_fd_sc_mcu7t5v0__nand2_1
X_07873_ _07873_/I _07927_/A1 vdd vdd vss vss gf180mcu_fd_sc_mcu7t5v0__clkinv_1
X_09612_ _09612_/D clk _09612_/Q vdd vdd vss vss gf180mcu_fd_sc_mcu7t5v0__dffq_1
X_06824_ _06739_/C _06824_/A2 _06824_/A3 _06824_/A4 _06826_/B1 vdd vdd
+ vss vss gf180mcu_fd_sc_mcu7t5v0__nand4_1
X_09543_ _09543_/D clk _09543_/Q vdd vdd vss vss gf180mcu_fd_sc_mcu7t5v0__dffq_1
X_06755_ _06760_/A2 _06842_/A1 _06755_/Z vdd vdd vss vss gf180mcu_fd_sc_mcu7t5v0__or2_1
X_05706_ _09712_/Q _05689_/B _05742_/B vdd vdd vss vss gf180mcu_fd_sc_mcu7t5v0__nand2_1
X_09474_ _09474_/D clk _09474_/Q vdd vdd vss vss gf180mcu_fd_sc_mcu7t5v0__dffq_1
X_06686_ _09621_/Q _06728_/A2 _06910_/B vdd vdd vss vss gf180mcu_fd_sc_mcu7t5v0__nand2_2
X_08425_ _09718_/Q _08426_/A2 _08425_/Z vdd vdd vss vss gf180mcu_fd_sc_mcu7t5v0__and2_1
X_05637_ _09568_/Q _05928_/B _05930_/C vdd vdd vss vss gf180mcu_fd_sc_mcu7t5v0__nor2_2
X_08356_ _09717_/Q _08361_/A2 _08356_/A3 _08356_/Z vdd vdd vss vss
+ gf180mcu_fd_sc_mcu7t5v0__xor3_1
X_05568_ _05568_/A1 _05568_/A2 _05572_/B1 vdd vdd vss vss gf180mcu_fd_sc_mcu7t5v0__nand2_1
X_07307_ _09404_/A1 _07312_/A2 _07312_/B1 _07307_/B2 _09641_/D vdd vdd
+ vss vss gf180mcu_fd_sc_mcu7t5v0__oai22_1
X_05499_ _09854_/Q _05627_/A2 _05627_/B1 _09587_/Q _05501_/A1 vdd vdd
+ vss vss gf180mcu_fd_sc_mcu7t5v0__aoi22_1
X_08287_ _08287_/A1 _08287_/A2 _08430_/B _08294_/A1 vdd vdd vss vss
+ gf180mcu_fd_sc_mcu7t5v0__aoi21_1
X_07238_ _07178_/B _07160_/Z _07238_/B _07282_/B vdd vdd vss vss gf180mcu_fd_sc_mcu7t5v0__aoi21_1
X_07169_ _07170_/A1 _07170_/A2 _07196_/B vdd vdd vss vss gf180mcu_fd_sc_mcu7t5v0__nor2_1
XTAP_1221 vdd vss gf180mcu_fd_sc_mcu7t5v0__filltie
XTAP_1210 vdd vss gf180mcu_fd_sc_mcu7t5v0__filltie
XTAP_1232 vdd vss gf180mcu_fd_sc_mcu7t5v0__filltie
XTAP_1243 vdd vss gf180mcu_fd_sc_mcu7t5v0__filltie
XTAP_1254 vdd vss gf180mcu_fd_sc_mcu7t5v0__filltie
XTAP_1265 vdd vss gf180mcu_fd_sc_mcu7t5v0__filltie
XTAP_1276 vdd vss gf180mcu_fd_sc_mcu7t5v0__filltie
XTAP_1298 vdd vss gf180mcu_fd_sc_mcu7t5v0__filltie
XTAP_1287 vdd vss gf180mcu_fd_sc_mcu7t5v0__filltie
X_04870_ _09490_/Q _05332_/B2 vdd vdd vss vss gf180mcu_fd_sc_mcu7t5v0__clkinv_1
X_06540_ _09715_/Q _06613_/A2 _06540_/B _06541_/A4 vdd vdd vss vss
+ gf180mcu_fd_sc_mcu7t5v0__oai21_1
X_06471_ _06499_/A1 _06499_/A2 _06473_/A2 vdd vdd vss vss gf180mcu_fd_sc_mcu7t5v0__xnor2_1
X_05422_ _09827_/Q _05628_/A2 _05628_/B1 _10019_/Q _05423_/A2 vdd vdd
+ vss vss gf180mcu_fd_sc_mcu7t5v0__aoi22_1
X_08210_ _08156_/Z _08211_/A2 _08210_/B _08256_/A2 vdd vdd vss vss
+ gf180mcu_fd_sc_mcu7t5v0__oai21_1
X_09190_ _09930_/Q _09173_/B _09257_/B _09191_/B vdd vdd vss vss gf180mcu_fd_sc_mcu7t5v0__oai21_1
X_05353_ _09403_/A1 _05359_/A2 _05359_/B1 _05353_/B2 _09507_/D vdd vdd
+ vss vss gf180mcu_fd_sc_mcu7t5v0__oai22_1
X_08141_ _09711_/Q _08338_/A2 _08278_/A1 vdd vdd vss vss gf180mcu_fd_sc_mcu7t5v0__nand2_1
X_08072_ _08319_/B2 _08099_/A1 _08359_/B _08082_/B vdd vdd vss vss
+ gf180mcu_fd_sc_mcu7t5v0__aoi21_1
X_05284_ _09407_/A1 _05286_/A2 _05286_/B1 _05284_/B2 _09439_/D vdd vdd
+ vss vss gf180mcu_fd_sc_mcu7t5v0__oai22_1
X_07023_ _07289_/B _07023_/A2 _07026_/B1 vdd vdd vss vss gf180mcu_fd_sc_mcu7t5v0__nand2_1
X_08974_ _09402_/A1 _08981_/A2 _08981_/B1 _08974_/B2 _09827_/D vdd vdd
+ vss vss gf180mcu_fd_sc_mcu7t5v0__oai22_1
X_07925_ _07957_/A1 _07901_/Z _07959_/A2 vdd vdd vss vss gf180mcu_fd_sc_mcu7t5v0__nor2_1
X_07856_ _07805_/Z _07856_/A2 _07855_/B _07862_/B1 vdd vdd vss vss
+ gf180mcu_fd_sc_mcu7t5v0__nor3_1
X_04999_ _09727_/Q _08742_/B2 vdd vdd vss vss gf180mcu_fd_sc_mcu7t5v0__clkinv_1
X_07787_ _09679_/Q _07787_/A2 _07787_/B _07881_/A3 vdd vdd vss vss
+ gf180mcu_fd_sc_mcu7t5v0__oai21_4
X_06807_ _09617_/Q _06806_/Z _06829_/A2 vdd vdd vss vss gf180mcu_fd_sc_mcu7t5v0__nor2_1
X_09526_ _09526_/D clk _09526_/Q vdd vdd vss vss gf180mcu_fd_sc_mcu7t5v0__dffq_1
X_06738_ _09712_/Q _06956_/A2 _06739_/B vdd vdd vss vss gf180mcu_fd_sc_mcu7t5v0__nand2_1
X_09457_ _09457_/D clk _09457_/Q vdd vdd vss vss gf180mcu_fd_sc_mcu7t5v0__dffq_1
X_08408_ _08731_/A1 _08729_/A1 _08727_/A1 _08700_/A2 vdd vdd vss vss
+ gf180mcu_fd_sc_mcu7t5v0__nor3_4
X_06669_ _06669_/I _06959_/A1 vdd vdd vss vss gf180mcu_fd_sc_mcu7t5v0__clkinv_1
X_09388_ _09399_/A1 _09378_/Z _09388_/B _09399_/C _10013_/D vdd vdd vss
+ vss gf180mcu_fd_sc_mcu7t5v0__aoi211_1
X_08339_ _08341_/A2 _08339_/A2 _08339_/A3 _08339_/Z vdd vdd vss vss
+ gf180mcu_fd_sc_mcu7t5v0__xor3_1
XTAP_1040 vdd vss gf180mcu_fd_sc_mcu7t5v0__filltie
XTAP_1051 vdd vss gf180mcu_fd_sc_mcu7t5v0__filltie
XTAP_1062 vdd vss gf180mcu_fd_sc_mcu7t5v0__filltie
XTAP_1073 vdd vss gf180mcu_fd_sc_mcu7t5v0__filltie
XTAP_1084 vdd vss gf180mcu_fd_sc_mcu7t5v0__filltie
XTAP_1095 vdd vss gf180mcu_fd_sc_mcu7t5v0__filltie
XTAP_824 vdd vss gf180mcu_fd_sc_mcu7t5v0__filltie
XTAP_813 vdd vss gf180mcu_fd_sc_mcu7t5v0__filltie
XTAP_802 vdd vss gf180mcu_fd_sc_mcu7t5v0__filltie
XTAP_835 vdd vss gf180mcu_fd_sc_mcu7t5v0__filltie
XTAP_846 vdd vss gf180mcu_fd_sc_mcu7t5v0__filltie
XTAP_868 vdd vss gf180mcu_fd_sc_mcu7t5v0__filltie
XTAP_857 vdd vss gf180mcu_fd_sc_mcu7t5v0__filltie
XTAP_879 vdd vss gf180mcu_fd_sc_mcu7t5v0__filltie
X_07710_ _09876_/Q _09680_/Q _07711_/B vdd vdd vss vss gf180mcu_fd_sc_mcu7t5v0__nand2_1
X_05971_ _10015_/Q _09104_/A2 _09259_/B _05972_/B vdd vdd vss vss
+ gf180mcu_fd_sc_mcu7t5v0__oai21_1
X_04922_ _09412_/Q _05231_/A1 vdd vdd vss vss gf180mcu_fd_sc_mcu7t5v0__clkinv_1
X_08690_ _08690_/A1 _08690_/A2 _08690_/A3 _08690_/Z vdd vdd vss vss
+ gf180mcu_fd_sc_mcu7t5v0__xor3_1
X_04853_ _09827_/Q _08974_/B2 vdd vdd vss vss gf180mcu_fd_sc_mcu7t5v0__clkinv_1
X_07641_ _08682_/A1 _07641_/A2 _07640_/Z _07641_/Z vdd vdd vss vss
+ gf180mcu_fd_sc_mcu7t5v0__xor3_1
X_07572_ _07572_/A1 _07572_/A2 _07590_/A2 vdd vdd vss vss gf180mcu_fd_sc_mcu7t5v0__xnor2_1
X_06523_ _06546_/A1 _06575_/A1 _06546_/A2 _06523_/Z vdd vdd vss vss
+ gf180mcu_fd_sc_mcu7t5v0__xor3_1
X_04784_ _09669_/Q _08060_/A2 vdd vdd vss vss gf180mcu_fd_sc_mcu7t5v0__clkinv_4
X_09311_ _09911_/Q _09311_/A2 _09311_/Z vdd vdd vss vss gf180mcu_fd_sc_mcu7t5v0__or2_4
X_06454_ _06350_/C _06438_/Z _06454_/B _08706_/B _06455_/A2 vdd vdd vss
+ vss gf180mcu_fd_sc_mcu7t5v0__oai211_1
X_09242_ _09258_/A2 _09244_/A2 _09242_/B _09949_/D vdd vdd vss vss
+ gf180mcu_fd_sc_mcu7t5v0__aoi21_1
X_05405_ _05405_/A1 _05405_/A2 _05429_/A2 vdd vdd vss vss gf180mcu_fd_sc_mcu7t5v0__nand2_1
X_06385_ _09594_/Q _08565_/C _06415_/A1 vdd vdd vss vss gf180mcu_fd_sc_mcu7t5v0__nand2_1
X_09173_ _09228_/A2 _09925_/Q _09173_/B _09174_/A2 vdd vdd vss vss
+ gf180mcu_fd_sc_mcu7t5v0__aoi21_1
X_08124_ _09684_/Q _08565_/C _08170_/A1 vdd vdd vss vss gf180mcu_fd_sc_mcu7t5v0__nand2_1
X_05336_ _09406_/A1 _05339_/A2 _05339_/B1 _05336_/B2 _09494_/D vdd vdd
+ vss vss gf180mcu_fd_sc_mcu7t5v0__oai22_1
X_08055_ _09681_/Q _08706_/B _08708_/B _08056_/A2 vdd vdd vss vss
+ gf180mcu_fd_sc_mcu7t5v0__oai21_1
X_05267_ _09402_/A1 _05274_/A2 _05274_/B1 _05267_/B2 _09426_/D vdd vdd
+ vss vss gf180mcu_fd_sc_mcu7t5v0__oai22_1
X_07006_ _09711_/Q _07000_/Z _07006_/A3 _07006_/Z vdd vdd vss vss
+ gf180mcu_fd_sc_mcu7t5v0__xor3_1
X_05198_ _09259_/B _09459_/Q _09467_/D vdd vdd vss vss gf180mcu_fd_sc_mcu7t5v0__and2_1
X_08957_ _08955_/Z _08957_/A2 _09821_/D vdd vdd vss vss gf180mcu_fd_sc_mcu7t5v0__nor2_1
X_07908_ _07914_/A1 _07914_/A2 _07915_/A1 vdd vdd vss vss gf180mcu_fd_sc_mcu7t5v0__nand2_1
X_08888_ _09790_/Q _08899_/A2 _09226_/B _08891_/A1 vdd vdd vss vss
+ gf180mcu_fd_sc_mcu7t5v0__oai21_1
X_07839_ _07870_/A2 _07839_/A2 _07835_/Z _07839_/Z vdd vdd vss vss
+ gf180mcu_fd_sc_mcu7t5v0__xor3_1
X_09509_ _09509_/D clk _09509_/Q vdd vdd vss vss gf180mcu_fd_sc_mcu7t5v0__dffq_1
XPHY_101 vdd vss gf180mcu_fd_sc_mcu7t5v0__endcap
XPHY_112 vdd vss gf180mcu_fd_sc_mcu7t5v0__endcap
XPHY_123 vdd vss gf180mcu_fd_sc_mcu7t5v0__endcap
XPHY_134 vdd vss gf180mcu_fd_sc_mcu7t5v0__endcap
XPHY_145 vdd vss gf180mcu_fd_sc_mcu7t5v0__endcap
XPHY_156 vdd vss gf180mcu_fd_sc_mcu7t5v0__endcap
XPHY_167 vdd vss gf180mcu_fd_sc_mcu7t5v0__endcap
XPHY_178 vdd vss gf180mcu_fd_sc_mcu7t5v0__endcap
XPHY_189 vdd vss gf180mcu_fd_sc_mcu7t5v0__endcap
XPHY_3 vdd vss gf180mcu_fd_sc_mcu7t5v0__endcap
X_06170_ _06165_/I _06170_/A2 _06169_/B _06170_/Z vdd vdd vss vss
+ gf180mcu_fd_sc_mcu7t5v0__xor3_1
X_05121_ _09812_/Q _05121_/A2 _05121_/A3 _05121_/A4 _05121_/Z vdd vdd
+ vss vss gf180mcu_fd_sc_mcu7t5v0__and4_2
X_05052_ _09440_/Q _05285_/B2 vdd vdd vss vss gf180mcu_fd_sc_mcu7t5v0__clkinv_1
X_09860_ _09860_/D clk _09860_/Q vdd vdd vss vss gf180mcu_fd_sc_mcu7t5v0__dffq_1
XTAP_643 vdd vss gf180mcu_fd_sc_mcu7t5v0__filltie
XTAP_632 vdd vss gf180mcu_fd_sc_mcu7t5v0__filltie
XTAP_621 vdd vss gf180mcu_fd_sc_mcu7t5v0__filltie
XTAP_610 vdd vss gf180mcu_fd_sc_mcu7t5v0__filltie
XTAP_676 vdd vss gf180mcu_fd_sc_mcu7t5v0__filltie
XTAP_665 vdd vss gf180mcu_fd_sc_mcu7t5v0__filltie
XTAP_654 vdd vss gf180mcu_fd_sc_mcu7t5v0__filltie
X_08811_ _08806_/B _08814_/A2 _08812_/C vdd vdd vss vss gf180mcu_fd_sc_mcu7t5v0__nand2_1
X_09791_ _09791_/D clk _09791_/Q vdd vdd vss vss gf180mcu_fd_sc_mcu7t5v0__dffq_1
X_05954_ _05954_/A1 _05954_/A2 _05953_/Z _05954_/Z vdd vdd vss vss
+ gf180mcu_fd_sc_mcu7t5v0__xor3_1
XTAP_698 vdd vss gf180mcu_fd_sc_mcu7t5v0__filltie
XTAP_687 vdd vss gf180mcu_fd_sc_mcu7t5v0__filltie
X_08742_ _09406_/A1 _08745_/A2 _08745_/B1 _08742_/B2 _09727_/D vdd vdd
+ vss vss gf180mcu_fd_sc_mcu7t5v0__oai22_1
X_08673_ _08673_/A1 _08673_/A2 _08673_/B _08693_/A2 vdd vdd vss vss
+ gf180mcu_fd_sc_mcu7t5v0__oai21_1
X_04905_ _09661_/Q _07670_/B2 vdd vdd vss vss gf180mcu_fd_sc_mcu7t5v0__clkinv_1
X_05885_ _05831_/Z _05952_/A1 _05954_/A1 vdd vdd vss vss gf180mcu_fd_sc_mcu7t5v0__nor2_1
X_07624_ _07635_/A2 _07624_/A2 _07624_/A3 _07624_/Z vdd vdd vss vss
+ gf180mcu_fd_sc_mcu7t5v0__xor3_1
XTAP_1809 vdd vss gf180mcu_fd_sc_mcu7t5v0__filltie
X_04836_ _09570_/Q _05978_/A1 vdd vdd vss vss gf180mcu_fd_sc_mcu7t5v0__clkinv_3
X_04767_ _09704_/Q _08463_/A1 vdd vdd vss vss gf180mcu_fd_sc_mcu7t5v0__inv_2
X_07555_ _09715_/Q _07633_/B _07557_/A2 vdd vdd vss vss gf180mcu_fd_sc_mcu7t5v0__nand2_1
X_06506_ _09712_/Q _06555_/A2 _06506_/Z vdd vdd vss vss gf180mcu_fd_sc_mcu7t5v0__and2_1
X_07486_ _07516_/A2 _07468_/Z _07482_/Z _07486_/Z vdd vdd vss vss
+ gf180mcu_fd_sc_mcu7t5v0__xor3_1
X_06437_ _09595_/Q _06435_/Z _06437_/Z vdd vdd vss vss gf180mcu_fd_sc_mcu7t5v0__xor2_1
X_09225_ _09176_/B _09258_/A2 _09225_/B _09941_/D vdd vdd vss vss
+ gf180mcu_fd_sc_mcu7t5v0__aoi21_1
X_06368_ _09711_/Q _06562_/A2 _06378_/B1 vdd vdd vss vss gf180mcu_fd_sc_mcu7t5v0__nor2_1
X_09156_ _09955_/Q _09461_/Q _09157_/A2 vdd vdd vss vss gf180mcu_fd_sc_mcu7t5v0__nand2_1
X_06299_ _09717_/Q _06299_/A2 _06297_/Z _06299_/B2 _06300_/A3 vdd vdd
+ vss vss gf180mcu_fd_sc_mcu7t5v0__oai22_1
X_08107_ _08105_/Z _08125_/A2 _08107_/B _08121_/B vdd vdd vss vss
+ gf180mcu_fd_sc_mcu7t5v0__aoi21_1
X_05319_ _05207_/Z _05318_/Z _05632_/C2 vdd vdd vss vss gf180mcu_fd_sc_mcu7t5v0__nor2_4
X_09087_ _09961_/Q _08706_/B _09088_/C vdd vdd vss vss gf180mcu_fd_sc_mcu7t5v0__and2_1
X_08038_ _08040_/A2 _08358_/I0 _08044_/A2 _08069_/B vdd vdd vss vss
+ gf180mcu_fd_sc_mcu7t5v0__and3_2
X_10000_ _10000_/D clk _10000_/Q vdd vdd vss vss gf180mcu_fd_sc_mcu7t5v0__dffq_1
X_09989_ _09989_/D clk _09989_/Q vdd vdd vss vss gf180mcu_fd_sc_mcu7t5v0__dffq_1
X_05670_ _09072_/B _09073_/A2 _08670_/B vdd vdd vss vss gf180mcu_fd_sc_mcu7t5v0__nand2_4
X_07340_ _07340_/A1 _07340_/A2 _07343_/A2 vdd vdd vss vss gf180mcu_fd_sc_mcu7t5v0__nand2_1
X_09010_ _09408_/A1 _09011_/A2 _09011_/B1 _09010_/B2 _09857_/D vdd vdd
+ vss vss gf180mcu_fd_sc_mcu7t5v0__oai22_1
X_07271_ _09716_/Q _07000_/Z _07272_/A3 vdd vdd vss vss gf180mcu_fd_sc_mcu7t5v0__nand2_1
X_06222_ _09713_/Q _06125_/Z _06279_/A1 vdd vdd vss vss gf180mcu_fd_sc_mcu7t5v0__nand2_1
X_06153_ _09714_/Q _06125_/Z _06155_/A2 vdd vdd vss vss gf180mcu_fd_sc_mcu7t5v0__nand2_1
X_05104_ _09874_/Q _09031_/B2 vdd vdd vss vss gf180mcu_fd_sc_mcu7t5v0__clkinv_1
X_06084_ _09711_/Q _06050_/I _06090_/A1 vdd vdd vss vss gf180mcu_fd_sc_mcu7t5v0__nand2_1
X_05035_ _09610_/Q _06650_/B2 vdd vdd vss vss gf180mcu_fd_sc_mcu7t5v0__clkinv_1
X_09912_ _09912_/D clk _09912_/Q vdd vdd vss vss gf180mcu_fd_sc_mcu7t5v0__dffq_2
X_09843_ _09843_/D clk _09843_/Q vdd vdd vss vss gf180mcu_fd_sc_mcu7t5v0__dffq_1
XTAP_440 vdd vss gf180mcu_fd_sc_mcu7t5v0__filltie
XTAP_451 vdd vss gf180mcu_fd_sc_mcu7t5v0__filltie
XTAP_462 vdd vss gf180mcu_fd_sc_mcu7t5v0__filltie
XTAP_473 vdd vss gf180mcu_fd_sc_mcu7t5v0__filltie
XTAP_484 vdd vss gf180mcu_fd_sc_mcu7t5v0__filltie
XTAP_495 vdd vss gf180mcu_fd_sc_mcu7t5v0__filltie
X_06986_ _07298_/A1 _06986_/A2 _07247_/A1 vdd vdd vss vss gf180mcu_fd_sc_mcu7t5v0__nand2_2
X_09774_ _09774_/D clk _09774_/Q vdd vdd vss vss gf180mcu_fd_sc_mcu7t5v0__dffq_1
X_05937_ _05937_/A1 _05913_/Z _05937_/B _05955_/A1 vdd vdd vss vss
+ gf180mcu_fd_sc_mcu7t5v0__aoi21_1
X_08725_ _06623_/B _09073_/A2 _08725_/B _09717_/D vdd vdd vss vss
+ gf180mcu_fd_sc_mcu7t5v0__aoi21_1
X_08656_ _08656_/A1 _08650_/Z _08668_/A1 vdd vdd vss vss gf180mcu_fd_sc_mcu7t5v0__nand2_1
X_05868_ _05870_/A1 _05867_/Z _05868_/Z vdd vdd vss vss gf180mcu_fd_sc_mcu7t5v0__or2_1
XTAP_1606 vdd vss gf180mcu_fd_sc_mcu7t5v0__filltie
X_08587_ _08587_/A1 _08572_/Z _08586_/Z _08587_/Z vdd vdd vss vss
+ gf180mcu_fd_sc_mcu7t5v0__xor3_1
X_04819_ _09604_/Q _06387_/B vdd vdd vss vss gf180mcu_fd_sc_mcu7t5v0__inv_4
X_07607_ _07550_/Z _07607_/A2 _07606_/B _07608_/A2 vdd vdd vss vss
+ gf180mcu_fd_sc_mcu7t5v0__nor3_1
XTAP_1617 vdd vss gf180mcu_fd_sc_mcu7t5v0__filltie
XTAP_1628 vdd vss gf180mcu_fd_sc_mcu7t5v0__filltie
XTAP_1639 vdd vss gf180mcu_fd_sc_mcu7t5v0__filltie
X_05799_ _05830_/A1 _05798_/Z _05829_/B vdd vdd vss vss gf180mcu_fd_sc_mcu7t5v0__xor2_1
X_07538_ _07484_/I _07524_/Z _07538_/A3 _07566_/B1 vdd vdd vss vss
+ gf180mcu_fd_sc_mcu7t5v0__xnor3_1
X_07469_ _09630_/Q _07420_/Z _07469_/Z vdd vdd vss vss gf180mcu_fd_sc_mcu7t5v0__and2_1
X_09208_ _09208_/I _09209_/B1 vdd vdd vss vss gf180mcu_fd_sc_mcu7t5v0__clkinv_1
X_09139_ _09399_/C _09170_/B1 _09916_/D vdd vdd vss vss gf180mcu_fd_sc_mcu7t5v0__nor2_1
X_06840_ _09712_/Q _06752_/I _06939_/A1 vdd vdd vss vss gf180mcu_fd_sc_mcu7t5v0__nand2_1
X_06771_ _09713_/Q _06770_/Z _06817_/A1 vdd vdd vss vss gf180mcu_fd_sc_mcu7t5v0__nand2_1
X_05722_ _05645_/I _05811_/A2 _05722_/B _05723_/A2 vdd vdd vss vss
+ gf180mcu_fd_sc_mcu7t5v0__aoi21_1
X_09490_ _09490_/D clk _09490_/Q vdd vdd vss vss gf180mcu_fd_sc_mcu7t5v0__dffq_1
X_08510_ _08510_/A1 _08509_/I _08510_/B _08517_/B2 vdd vdd vss vss
+ gf180mcu_fd_sc_mcu7t5v0__aoi21_1
X_08441_ _08656_/A1 _08440_/Z _08442_/B vdd vdd vss vss gf180mcu_fd_sc_mcu7t5v0__nand2_1
X_05653_ _05928_/B _05964_/A2 _05964_/B2 _05769_/B vdd vdd vss vss
+ gf180mcu_fd_sc_mcu7t5v0__nand3_2
X_05584_ _09833_/Q _05628_/A2 _05628_/B1 _10025_/Q _05585_/A2 vdd vdd
+ vss vss gf180mcu_fd_sc_mcu7t5v0__aoi22_1
X_08372_ _09982_/Q _09073_/A2 _08734_/B _08373_/B vdd vdd vss vss
+ gf180mcu_fd_sc_mcu7t5v0__oai21_1
X_07323_ _07658_/A1 _07331_/A2 _07612_/B vdd vdd vss vss gf180mcu_fd_sc_mcu7t5v0__nand2_2
X_07254_ _07254_/A1 _07254_/A2 _07254_/B _07276_/A2 vdd vdd vss vss
+ gf180mcu_fd_sc_mcu7t5v0__oai21_1
X_06205_ _09715_/Q _06178_/Z _06205_/B _06206_/A4 vdd vdd vss vss
+ gf180mcu_fd_sc_mcu7t5v0__oai21_1
X_07185_ _07284_/B _07183_/Z _07237_/A2 _07190_/A3 vdd vdd vss vss
+ gf180mcu_fd_sc_mcu7t5v0__nand3_1
X_06136_ _06162_/A1 _06161_/A1 _06137_/A3 _06139_/B vdd vdd vss vss
+ gf180mcu_fd_sc_mcu7t5v0__xor3_1
X_06067_ _08715_/A1 _06101_/A3 _06167_/A1 vdd vdd vss vss gf180mcu_fd_sc_mcu7t5v0__nor2_1
X_05018_ _09415_/Q _05240_/A1 vdd vdd vss vss gf180mcu_fd_sc_mcu7t5v0__clkinv_1
XTAP_292 vdd vss gf180mcu_fd_sc_mcu7t5v0__filltie
XTAP_281 vdd vss gf180mcu_fd_sc_mcu7t5v0__filltie
XTAP_270 vdd vss gf180mcu_fd_sc_mcu7t5v0__filltie
X_09826_ _09826_/D clk _09826_/Q vdd vdd vss vss gf180mcu_fd_sc_mcu7t5v0__dffq_1
X_09757_ _09757_/D clk _09757_/Q vdd vdd vss vss gf180mcu_fd_sc_mcu7t5v0__dffq_1
X_06969_ _06969_/A1 _09104_/A2 _06969_/B _09624_/D vdd vdd vss vss
+ gf180mcu_fd_sc_mcu7t5v0__aoi21_1
X_08708_ _09709_/Q _08706_/B _08708_/B _08709_/A2 vdd vdd vss vss
+ gf180mcu_fd_sc_mcu7t5v0__oai21_1
X_09688_ _09688_/D clk _09688_/Q vdd vdd vss vss gf180mcu_fd_sc_mcu7t5v0__dffq_2
XTAP_1403 vdd vss gf180mcu_fd_sc_mcu7t5v0__filltie
XTAP_1414 vdd vss gf180mcu_fd_sc_mcu7t5v0__filltie
X_08639_ _08639_/A1 _08667_/B1 _08639_/B _08639_/C _08691_/A1 vdd vdd
+ vss vss gf180mcu_fd_sc_mcu7t5v0__aoi211_1
XTAP_1425 vdd vss gf180mcu_fd_sc_mcu7t5v0__filltie
XTAP_1447 vdd vss gf180mcu_fd_sc_mcu7t5v0__filltie
XTAP_1436 vdd vss gf180mcu_fd_sc_mcu7t5v0__filltie
XTAP_1458 vdd vss gf180mcu_fd_sc_mcu7t5v0__filltie
XTAP_1469 vdd vss gf180mcu_fd_sc_mcu7t5v0__filltie
XTAP_1970 vdd vss gf180mcu_fd_sc_mcu7t5v0__filltie
XTAP_1992 vdd vss gf180mcu_fd_sc_mcu7t5v0__filltie
XTAP_1981 vdd vss gf180mcu_fd_sc_mcu7t5v0__filltie
X_08990_ _09408_/A1 _08991_/A2 _08991_/B1 _08990_/B2 _09841_/D vdd vdd
+ vss vss gf180mcu_fd_sc_mcu7t5v0__oai22_1
X_07941_ _08308_/A1 _08026_/A1 _09679_/Q _07941_/B _08005_/A2 vdd vdd
+ vss vss gf180mcu_fd_sc_mcu7t5v0__oai31_4
X_07872_ _09715_/Q _07681_/Z _07873_/I vdd vdd vss vss gf180mcu_fd_sc_mcu7t5v0__nand2_1
X_09611_ _09611_/D clk _09611_/Q vdd vdd vss vss gf180mcu_fd_sc_mcu7t5v0__dffq_1
X_06823_ _09714_/Q _06792_/Z _06823_/B _06824_/A4 vdd vdd vss vss
+ gf180mcu_fd_sc_mcu7t5v0__oai21_1
X_09542_ _09542_/D clk _09542_/Q vdd vdd vss vss gf180mcu_fd_sc_mcu7t5v0__dffq_1
X_06754_ _09711_/Q _06752_/I _06842_/A1 vdd vdd vss vss gf180mcu_fd_sc_mcu7t5v0__nand2_1
X_05705_ _08715_/A1 _05645_/I _05714_/A2 vdd vdd vss vss gf180mcu_fd_sc_mcu7t5v0__nor2_1
X_06685_ _06747_/A1 _06747_/A2 _06747_/C _06941_/A2 vdd vdd vss vss
+ gf180mcu_fd_sc_mcu7t5v0__oai21_4
X_09473_ _09473_/D clk _09473_/Q vdd vdd vss vss gf180mcu_fd_sc_mcu7t5v0__dffq_1
X_08424_ _08424_/A1 _08389_/Z _08424_/B _08688_/A2 vdd vdd vss vss
+ gf180mcu_fd_sc_mcu7t5v0__oai21_4
X_05636_ _09567_/Q _09566_/Q _05928_/B vdd vdd vss vss gf180mcu_fd_sc_mcu7t5v0__nand2_2
X_05567_ _09547_/Q _05628_/A2 _05628_/B1 _09864_/Q _05568_/A2 vdd vdd
+ vss vss gf180mcu_fd_sc_mcu7t5v0__aoi22_1
X_08355_ _08355_/A1 _08355_/A2 _08356_/A3 vdd vdd vss vss gf180mcu_fd_sc_mcu7t5v0__nand2_1
X_07306_ _09403_/A1 _07312_/A2 _07312_/B1 _07306_/B2 _09640_/D vdd vdd
+ vss vss gf180mcu_fd_sc_mcu7t5v0__oai22_1
X_05498_ _05498_/A1 _05498_/A2 _05515_/C2 vdd vdd vss vss gf180mcu_fd_sc_mcu7t5v0__nand2_1
X_08286_ _08286_/A1 _08286_/A2 _08341_/B2 _08296_/A1 vdd vdd vss vss
+ gf180mcu_fd_sc_mcu7t5v0__xnor3_1
X_07237_ _07237_/A1 _07237_/A2 _07243_/A1 vdd vdd vss vss gf180mcu_fd_sc_mcu7t5v0__nand2_1
X_07168_ _07196_/A1 _07196_/A2 _07170_/A2 vdd vdd vss vss gf180mcu_fd_sc_mcu7t5v0__xnor2_1
X_06119_ _06119_/A1 _06119_/A2 _06119_/B _06160_/A1 vdd vdd vss vss
+ gf180mcu_fd_sc_mcu7t5v0__oai21_1
X_07099_ _07099_/A1 _07036_/Z _07099_/B _07100_/I vdd vdd vss vss
+ gf180mcu_fd_sc_mcu7t5v0__aoi21_1
X_09809_ _09809_/D clk _09809_/Q vdd vdd vss vss gf180mcu_fd_sc_mcu7t5v0__dffq_1
XTAP_1200 vdd vss gf180mcu_fd_sc_mcu7t5v0__filltie
XTAP_1222 vdd vss gf180mcu_fd_sc_mcu7t5v0__filltie
XTAP_1211 vdd vss gf180mcu_fd_sc_mcu7t5v0__filltie
XTAP_1233 vdd vss gf180mcu_fd_sc_mcu7t5v0__filltie
XTAP_1244 vdd vss gf180mcu_fd_sc_mcu7t5v0__filltie
XTAP_1255 vdd vss gf180mcu_fd_sc_mcu7t5v0__filltie
XTAP_1266 vdd vss gf180mcu_fd_sc_mcu7t5v0__filltie
XTAP_1277 vdd vss gf180mcu_fd_sc_mcu7t5v0__filltie
XTAP_1299 vdd vss gf180mcu_fd_sc_mcu7t5v0__filltie
XTAP_1288 vdd vss gf180mcu_fd_sc_mcu7t5v0__filltie
X_06470_ _06470_/A1 _06469_/B _06499_/A2 vdd vdd vss vss gf180mcu_fd_sc_mcu7t5v0__xnor2_1
X_05421_ _09835_/Q _05627_/A2 _05627_/B1 _09803_/Q _05423_/A1 vdd vdd
+ vss vss gf180mcu_fd_sc_mcu7t5v0__aoi22_1
X_08140_ _08133_/Z _08234_/A2 _08234_/B _09710_/Q _08188_/A1 vdd vdd vss
+ vss gf180mcu_fd_sc_mcu7t5v0__oai211_4
X_05352_ _09402_/A1 _05359_/A2 _05359_/B1 _05352_/B2 _09506_/D vdd vdd
+ vss vss gf180mcu_fd_sc_mcu7t5v0__oai22_1
X_08071_ _09711_/Q _08074_/A2 _08074_/A3 _08099_/A1 vdd vdd vss vss
+ gf180mcu_fd_sc_mcu7t5v0__nand3_2
X_05283_ _09406_/A1 _05286_/A2 _05286_/B1 _05283_/B2 _09438_/D vdd vdd
+ vss vss gf180mcu_fd_sc_mcu7t5v0__oai22_1
X_07022_ _07022_/A1 _07022_/A2 _07022_/B _07022_/C _07023_/A2 vdd vdd
+ vss vss gf180mcu_fd_sc_mcu7t5v0__oai211_1
X_08973_ _09401_/A1 _08981_/A2 _08981_/B1 vdd vdd vss vss gf180mcu_fd_sc_mcu7t5v0__nand2_2
X_07924_ _07924_/A1 _07924_/A2 _07924_/B _07976_/A1 vdd vdd vss vss
+ gf180mcu_fd_sc_mcu7t5v0__oai21_1
X_07855_ _07805_/Z _07856_/A2 _07855_/B _07914_/A2 vdd vdd vss vss
+ gf180mcu_fd_sc_mcu7t5v0__oai21_1
X_04998_ _09494_/Q _05336_/B2 vdd vdd vss vss gf180mcu_fd_sc_mcu7t5v0__clkinv_1
X_07786_ _09878_/Q _09680_/Q _07787_/B vdd vdd vss vss gf180mcu_fd_sc_mcu7t5v0__nand2_1
X_06806_ _06763_/Z _06830_/A3 _06806_/Z vdd vdd vss vss gf180mcu_fd_sc_mcu7t5v0__xor2_1
X_06737_ _09712_/Q _06719_/I _06736_/Z _06918_/C _06741_/B1 vdd vdd vss
+ vss gf180mcu_fd_sc_mcu7t5v0__oai22_1
X_09525_ _09525_/D clk _09525_/Q vdd vdd vss vss gf180mcu_fd_sc_mcu7t5v0__dffq_2
X_09456_ _09456_/D clk _09456_/Q vdd vdd vss vss gf180mcu_fd_sc_mcu7t5v0__dffq_1
X_06668_ _06967_/A1 _09622_/Q _06963_/A1 _06669_/I vdd vdd vss vss
+ gf180mcu_fd_sc_mcu7t5v0__nor3_4
X_05619_ _09425_/Q _05628_/A2 _05628_/B1 _09612_/Q _05620_/A2 vdd vdd
+ vss vss gf180mcu_fd_sc_mcu7t5v0__aoi22_1
X_08407_ _08639_/A1 _08510_/A1 _08432_/B _08407_/B _08411_/A1 vdd vdd
+ vss vss gf180mcu_fd_sc_mcu7t5v0__oai31_1
X_06599_ _06599_/A1 _06599_/A2 _06600_/A2 vdd vdd vss vss gf180mcu_fd_sc_mcu7t5v0__nand2_1
X_09387_ _10013_/Q _09378_/Z _09388_/B vdd vdd vss vss gf180mcu_fd_sc_mcu7t5v0__nor2_1
X_08338_ _09714_/Q _08338_/A2 _08339_/A3 vdd vdd vss vss gf180mcu_fd_sc_mcu7t5v0__nand2_1
X_08269_ _09686_/Q _08565_/C _08269_/B1 _08269_/B2 _08270_/A2 vdd vdd
+ vss vss gf180mcu_fd_sc_mcu7t5v0__aoi22_1
XTAP_1030 vdd vss gf180mcu_fd_sc_mcu7t5v0__filltie
XTAP_1041 vdd vss gf180mcu_fd_sc_mcu7t5v0__filltie
XTAP_1052 vdd vss gf180mcu_fd_sc_mcu7t5v0__filltie
XTAP_1074 vdd vss gf180mcu_fd_sc_mcu7t5v0__filltie
XTAP_1063 vdd vss gf180mcu_fd_sc_mcu7t5v0__filltie
XTAP_1085 vdd vss gf180mcu_fd_sc_mcu7t5v0__filltie
XTAP_1096 vdd vss gf180mcu_fd_sc_mcu7t5v0__filltie
XTAP_825 vdd vss gf180mcu_fd_sc_mcu7t5v0__filltie
XTAP_814 vdd vss gf180mcu_fd_sc_mcu7t5v0__filltie
XTAP_803 vdd vss gf180mcu_fd_sc_mcu7t5v0__filltie
XTAP_836 vdd vss gf180mcu_fd_sc_mcu7t5v0__filltie
XTAP_847 vdd vss gf180mcu_fd_sc_mcu7t5v0__filltie
XTAP_858 vdd vss gf180mcu_fd_sc_mcu7t5v0__filltie
X_05970_ _05970_/A1 _09104_/A2 _05970_/B _09566_/D vdd vdd vss vss
+ gf180mcu_fd_sc_mcu7t5v0__aoi21_1
X_04921_ _09544_/Q _05394_/B2 vdd vdd vss vss gf180mcu_fd_sc_mcu7t5v0__clkinv_1
XTAP_869 vdd vss gf180mcu_fd_sc_mcu7t5v0__filltie
X_04852_ _09803_/Q _08918_/B2 vdd vdd vss vss gf180mcu_fd_sc_mcu7t5v0__clkinv_1
X_07640_ _07640_/A1 _07639_/Z _07640_/Z vdd vdd vss vss gf180mcu_fd_sc_mcu7t5v0__xor2_1
X_04783_ _09672_/Q _07847_/B vdd vdd vss vss gf180mcu_fd_sc_mcu7t5v0__clkinv_1
X_07571_ _09715_/Q _07349_/Z _07572_/A2 _07620_/A1 vdd vdd vss vss
+ gf180mcu_fd_sc_mcu7t5v0__nand3_1
X_06522_ _06575_/A1 _06521_/Z _06576_/A1 vdd vdd vss vss gf180mcu_fd_sc_mcu7t5v0__nand2_1
X_09310_ _09399_/A1 _09310_/A2 _09310_/B _09399_/C _09978_/D vdd vdd vss
+ vss gf180mcu_fd_sc_mcu7t5v0__aoi211_1
X_06453_ _06487_/A2 _06453_/A2 _06453_/B _06454_/B vdd vdd vss vss
+ gf180mcu_fd_sc_mcu7t5v0__oai21_1
X_09241_ _09949_/Q _09244_/A2 _09257_/B _09242_/B vdd vdd vss vss
+ gf180mcu_fd_sc_mcu7t5v0__oai21_1
X_05404_ _09482_/Q _05628_/A2 _05628_/B1 _09498_/Q _05405_/A2 vdd vdd
+ vss vss gf180mcu_fd_sc_mcu7t5v0__aoi22_1
X_09172_ _09926_/Q _09228_/A2 _09925_/Q _09173_/B vdd vdd vss vss
+ gf180mcu_fd_sc_mcu7t5v0__nor3_4
X_06384_ _08706_/B _06384_/A2 _06384_/B _09593_/D vdd vdd vss vss
+ gf180mcu_fd_sc_mcu7t5v0__aoi21_1
X_08123_ _08670_/B _08123_/A2 _09683_/D vdd vdd vss vss gf180mcu_fd_sc_mcu7t5v0__nor2_1
X_05335_ _09405_/A1 _05339_/A2 _05339_/B1 _05335_/B2 _09493_/D vdd vdd
+ vss vss gf180mcu_fd_sc_mcu7t5v0__oai22_1
X_08054_ _08107_/B _08054_/A2 _08081_/A1 _08054_/B2 _08565_/C _08056_/A1 vdd
+ vdd vss vss gf180mcu_fd_sc_mcu7t5v0__aoi221_1
X_05266_ _08791_/B _05274_/A2 _05274_/B1 vdd vdd vss vss gf180mcu_fd_sc_mcu7t5v0__nand2_2
X_07005_ _09711_/Q _07004_/Z _07044_/A1 vdd vdd vss vss gf180mcu_fd_sc_mcu7t5v0__nand2_1
X_05197_ _09928_/Q _05200_/A2 _05200_/A3 _09468_/D vdd vdd vss vss
+ gf180mcu_fd_sc_mcu7t5v0__nor3_1
X_08956_ _09821_/Q _08952_/Z _08968_/B _08957_/A2 vdd vdd vss vss
+ gf180mcu_fd_sc_mcu7t5v0__oai21_1
X_07907_ _08001_/A1 _07902_/Z _07920_/C vdd vdd vss vss gf180mcu_fd_sc_mcu7t5v0__nand2_1
X_08887_ _09791_/Q _09523_/Q _08889_/A2 vdd vdd vss vss gf180mcu_fd_sc_mcu7t5v0__nand2_1
X_07838_ _07839_/A2 _07835_/Z _07870_/B vdd vdd vss vss gf180mcu_fd_sc_mcu7t5v0__xor2_1
X_09508_ _09508_/D clk _09508_/Q vdd vdd vss vss gf180mcu_fd_sc_mcu7t5v0__dffq_1
X_07769_ _08715_/A1 _07879_/A2 _07769_/B _07774_/B1 vdd vdd vss vss
+ gf180mcu_fd_sc_mcu7t5v0__aoi21_1
XPHY_102 vdd vss gf180mcu_fd_sc_mcu7t5v0__endcap
XPHY_113 vdd vss gf180mcu_fd_sc_mcu7t5v0__endcap
XPHY_124 vdd vss gf180mcu_fd_sc_mcu7t5v0__endcap
X_09439_ _09439_/D clk _09439_/Q vdd vdd vss vss gf180mcu_fd_sc_mcu7t5v0__dffq_1
XPHY_135 vdd vss gf180mcu_fd_sc_mcu7t5v0__endcap
XPHY_146 vdd vss gf180mcu_fd_sc_mcu7t5v0__endcap
XPHY_157 vdd vss gf180mcu_fd_sc_mcu7t5v0__endcap
XPHY_168 vdd vss gf180mcu_fd_sc_mcu7t5v0__endcap
XPHY_179 vdd vss gf180mcu_fd_sc_mcu7t5v0__endcap
XPHY_4 vdd vss gf180mcu_fd_sc_mcu7t5v0__endcap
X_05120_ _09814_/Q _05120_/A2 _05120_/A3 _05121_/A4 vdd vdd vss vss
+ gf180mcu_fd_sc_mcu7t5v0__nor3_1
X_05051_ _09432_/Q _05273_/B2 vdd vdd vss vss gf180mcu_fd_sc_mcu7t5v0__clkinv_1
XTAP_600 vdd vss gf180mcu_fd_sc_mcu7t5v0__filltie
XTAP_633 vdd vss gf180mcu_fd_sc_mcu7t5v0__filltie
XTAP_622 vdd vss gf180mcu_fd_sc_mcu7t5v0__filltie
XTAP_611 vdd vss gf180mcu_fd_sc_mcu7t5v0__filltie
X_08810_ _09765_/Q _09764_/Q _05157_/Z _08814_/A2 vdd vdd vss vss
+ gf180mcu_fd_sc_mcu7t5v0__nand3_2
XTAP_677 vdd vss gf180mcu_fd_sc_mcu7t5v0__filltie
XTAP_666 vdd vss gf180mcu_fd_sc_mcu7t5v0__filltie
XTAP_644 vdd vss gf180mcu_fd_sc_mcu7t5v0__filltie
XTAP_655 vdd vss gf180mcu_fd_sc_mcu7t5v0__filltie
X_09790_ _09790_/D clk _09790_/Q vdd vdd vss vss gf180mcu_fd_sc_mcu7t5v0__dffq_1
X_05953_ _05953_/A1 _05953_/A2 _05953_/A3 _05953_/Z vdd vdd vss vss
+ gf180mcu_fd_sc_mcu7t5v0__xor3_1
XTAP_699 vdd vss gf180mcu_fd_sc_mcu7t5v0__filltie
XTAP_688 vdd vss gf180mcu_fd_sc_mcu7t5v0__filltie
X_08741_ _09405_/A1 _08745_/A2 _08745_/B1 _08741_/B2 _09726_/D vdd vdd
+ vss vss gf180mcu_fd_sc_mcu7t5v0__oai22_1
X_05884_ _09716_/Q _05689_/B _05952_/A1 vdd vdd vss vss gf180mcu_fd_sc_mcu7t5v0__nand2_1
X_08672_ _08672_/A1 _08672_/A2 _08672_/B _08693_/A1 vdd vdd vss vss
+ gf180mcu_fd_sc_mcu7t5v0__aoi21_1
X_04904_ _09695_/Q _08379_/B2 vdd vdd vss vss gf180mcu_fd_sc_mcu7t5v0__clkinv_1
X_07623_ _09714_/Q _07623_/A2 _07624_/A3 vdd vdd vss vss gf180mcu_fd_sc_mcu7t5v0__nand2_1
X_04835_ _09571_/Q _05990_/A1 vdd vdd vss vss gf180mcu_fd_sc_mcu7t5v0__clkinv_1
X_04766_ _09705_/Q _08521_/A1 vdd vdd vss vss gf180mcu_fd_sc_mcu7t5v0__clkinv_3
X_07554_ _07649_/A1 _07607_/A2 _07553_/Z _07554_/Z vdd vdd vss vss
+ gf180mcu_fd_sc_mcu7t5v0__or3_1
X_06505_ _09712_/Q _06601_/A2 _06505_/Z vdd vdd vss vss gf180mcu_fd_sc_mcu7t5v0__and2_1
X_07485_ _07468_/Z _07482_/Z _07516_/B vdd vdd vss vss gf180mcu_fd_sc_mcu7t5v0__xor2_1
X_06436_ _09595_/Q _06435_/Z _06456_/B vdd vdd vss vss gf180mcu_fd_sc_mcu7t5v0__and2_1
X_09224_ _09941_/Q _09176_/B _09226_/B _09225_/B vdd vdd vss vss gf180mcu_fd_sc_mcu7t5v0__oai21_1
X_06367_ _06367_/A1 _06365_/Z _06367_/B _06378_/A2 vdd vdd vss vss
+ gf180mcu_fd_sc_mcu7t5v0__oai21_1
X_09155_ _09399_/C _09155_/A2 _09920_/D vdd vdd vss vss gf180mcu_fd_sc_mcu7t5v0__nor2_1
X_06298_ _06623_/B _09581_/Q _06298_/B _06299_/B2 vdd vdd vss vss
+ gf180mcu_fd_sc_mcu7t5v0__aoi21_1
X_08106_ _08106_/A1 _08106_/A2 _08106_/B _08125_/A2 vdd vdd vss vss
+ gf180mcu_fd_sc_mcu7t5v0__oai21_1
X_05318_ _05318_/A1 _05204_/Z _05318_/Z vdd vdd vss vss gf180mcu_fd_sc_mcu7t5v0__or2_2
X_09086_ _09098_/A1 _09086_/A2 _09086_/B _09892_/D vdd vdd vss vss
+ gf180mcu_fd_sc_mcu7t5v0__aoi21_1
X_08037_ _09690_/Q _09689_/Q _08044_/A2 vdd vdd vss vss gf180mcu_fd_sc_mcu7t5v0__nand2_2
X_05249_ _05250_/A2 _05218_/I _05628_/A2 vdd vdd vss vss gf180mcu_fd_sc_mcu7t5v0__nor2_4
X_09988_ _09988_/D clk _09988_/Q vdd vdd vss vss gf180mcu_fd_sc_mcu7t5v0__dffq_1
X_08939_ _08927_/I _08939_/A2 _08938_/Z _09815_/D vdd vdd vss vss
+ gf180mcu_fd_sc_mcu7t5v0__nor3_1
X_07270_ _09717_/Q _07003_/B _07272_/A2 vdd vdd vss vss gf180mcu_fd_sc_mcu7t5v0__nand2_1
X_06221_ _09714_/Q _06050_/I _06275_/B2 vdd vdd vss vss gf180mcu_fd_sc_mcu7t5v0__nand2_1
X_06152_ _05996_/B _06297_/I0 _06152_/A3 _06151_/Z _06152_/Z vdd vdd vss
+ vss gf180mcu_fd_sc_mcu7t5v0__or4_1
X_06083_ _08715_/A1 _06016_/I _06083_/B _06092_/A2 vdd vdd vss vss
+ gf180mcu_fd_sc_mcu7t5v0__oai21_1
X_05103_ _09907_/Q _09114_/B2 vdd vdd vss vss gf180mcu_fd_sc_mcu7t5v0__clkinv_1
X_05034_ _09644_/Q _07310_/B2 vdd vdd vss vss gf180mcu_fd_sc_mcu7t5v0__clkinv_1
X_09911_ _09911_/D clk _09911_/Q vdd vdd vss vss gf180mcu_fd_sc_mcu7t5v0__dffq_2
X_09842_ _09842_/D clk _09842_/Q vdd vdd vss vss gf180mcu_fd_sc_mcu7t5v0__dffq_1
XTAP_441 vdd vss gf180mcu_fd_sc_mcu7t5v0__filltie
XTAP_430 vdd vss gf180mcu_fd_sc_mcu7t5v0__filltie
XTAP_452 vdd vss gf180mcu_fd_sc_mcu7t5v0__filltie
XTAP_463 vdd vss gf180mcu_fd_sc_mcu7t5v0__filltie
XTAP_474 vdd vss gf180mcu_fd_sc_mcu7t5v0__filltie
XTAP_485 vdd vss gf180mcu_fd_sc_mcu7t5v0__filltie
X_09773_ _09773_/D clk _09773_/Q vdd vdd vss vss gf180mcu_fd_sc_mcu7t5v0__dffq_1
XTAP_496 vdd vss gf180mcu_fd_sc_mcu7t5v0__filltie
X_06985_ _09636_/Q _06985_/A2 _07286_/I0 vdd vdd vss vss gf180mcu_fd_sc_mcu7t5v0__nor2_2
X_08724_ _09882_/Q _09073_/A2 _09072_/B _08725_/B vdd vdd vss vss
+ gf180mcu_fd_sc_mcu7t5v0__oai21_1
X_05936_ _05936_/A1 _05936_/A2 _05936_/B _05956_/A2 vdd vdd vss vss
+ gf180mcu_fd_sc_mcu7t5v0__aoi21_1
X_08655_ _08653_/Z _08671_/A2 _08655_/Z vdd vdd vss vss gf180mcu_fd_sc_mcu7t5v0__and2_1
X_05867_ _08721_/A1 _05865_/Z _05867_/Z vdd vdd vss vss gf180mcu_fd_sc_mcu7t5v0__xor2_1
X_08586_ _08534_/Z _08582_/Z _08586_/A3 _08586_/Z vdd vdd vss vss
+ gf180mcu_fd_sc_mcu7t5v0__xor3_1
X_04818_ _09613_/Q _06679_/A1 vdd vdd vss vss gf180mcu_fd_sc_mcu7t5v0__clkinv_1
X_07606_ _07550_/Z _07607_/A2 _07606_/B _07648_/A2 vdd vdd vss vss
+ gf180mcu_fd_sc_mcu7t5v0__oai21_1
XTAP_1607 vdd vss gf180mcu_fd_sc_mcu7t5v0__filltie
XTAP_1618 vdd vss gf180mcu_fd_sc_mcu7t5v0__filltie
XTAP_1629 vdd vss gf180mcu_fd_sc_mcu7t5v0__filltie
X_05798_ _05798_/A1 _05798_/A2 _05798_/Z vdd vdd vss vss gf180mcu_fd_sc_mcu7t5v0__xor2_1
X_07537_ _07484_/I _07524_/Z _07538_/A3 _07537_/Z vdd vdd vss vss
+ gf180mcu_fd_sc_mcu7t5v0__xor3_1
X_04749_ _09746_/Q _08768_/A1 vdd vdd vss vss gf180mcu_fd_sc_mcu7t5v0__clkinv_1
X_07468_ _07467_/B _07468_/A2 _07517_/A1 _07468_/Z vdd vdd vss vss
+ gf180mcu_fd_sc_mcu7t5v0__xor3_1
X_09207_ _09792_/Q _09299_/A3 _09378_/A2 _09761_/Q _09208_/I vdd vdd vss
+ vss gf180mcu_fd_sc_mcu7t5v0__aoi22_1
X_06419_ _09604_/Q _06419_/A2 _06605_/A2 _08483_/A1 _06419_/C _06601_/A2 vdd
+ vdd vss vss gf180mcu_fd_sc_mcu7t5v0__aoi221_4
X_07399_ _09712_/Q _07399_/A2 _07449_/A1 vdd vdd vss vss gf180mcu_fd_sc_mcu7t5v0__nand2_1
X_09138_ _09461_/Q _09137_/Z _09170_/B1 vdd vdd vss vss gf180mcu_fd_sc_mcu7t5v0__nor2_4
X_09069_ _09069_/A1 _09073_/A2 _09069_/B _09888_/D vdd vdd vss vss
+ gf180mcu_fd_sc_mcu7t5v0__aoi21_1
X_06770_ _06752_/I _06772_/A3 _06770_/Z vdd vdd vss vss gf180mcu_fd_sc_mcu7t5v0__xor2_1
X_05721_ _05721_/A1 _05721_/A2 _05721_/B _05763_/A1 vdd vdd vss vss
+ gf180mcu_fd_sc_mcu7t5v0__oai21_2
X_08440_ _08460_/A1 _08440_/A2 _08440_/Z vdd vdd vss vss gf180mcu_fd_sc_mcu7t5v0__and2_1
X_05652_ _09568_/Q _09567_/Q _05686_/A2 vdd vdd vss vss gf180mcu_fd_sc_mcu7t5v0__nor2_1
X_05583_ _09841_/Q _05627_/A2 _05627_/B1 _09809_/Q _05585_/A1 vdd vdd
+ vss vss gf180mcu_fd_sc_mcu7t5v0__aoi22_1
X_08371_ _08371_/A1 _09073_/A2 _08371_/B _09691_/D vdd vdd vss vss
+ gf180mcu_fd_sc_mcu7t5v0__aoi21_1
X_07322_ _09655_/Q _07330_/A2 _07556_/B2 vdd vdd vss vss gf180mcu_fd_sc_mcu7t5v0__nor2_1
X_07253_ _07253_/A1 _07253_/A2 _07253_/B _07276_/A1 vdd vdd vss vss
+ gf180mcu_fd_sc_mcu7t5v0__aoi21_1
X_06204_ _06260_/A1 _06204_/A2 _06204_/B _06205_/B vdd vdd vss vss
+ gf180mcu_fd_sc_mcu7t5v0__oai21_1
X_07184_ _07128_/Z _07184_/A2 _07184_/B _07237_/A2 vdd vdd vss vss
+ gf180mcu_fd_sc_mcu7t5v0__oai21_1
X_06135_ _06082_/Z _06137_/A3 _06161_/A3 vdd vdd vss vss gf180mcu_fd_sc_mcu7t5v0__nor2_1
X_06066_ _06066_/A1 _06065_/B _06073_/B1 vdd vdd vss vss gf180mcu_fd_sc_mcu7t5v0__xnor2_1
X_05017_ _09547_/Q _05397_/B2 vdd vdd vss vss gf180mcu_fd_sc_mcu7t5v0__clkinv_1
X_09825_ _09825_/D clk _09825_/Q vdd vdd vss vss gf180mcu_fd_sc_mcu7t5v0__dffq_1
XTAP_293 vdd vss gf180mcu_fd_sc_mcu7t5v0__filltie
XTAP_282 vdd vss gf180mcu_fd_sc_mcu7t5v0__filltie
XTAP_271 vdd vss gf180mcu_fd_sc_mcu7t5v0__filltie
X_09756_ _09756_/D clk _09756_/Q vdd vdd vss vss gf180mcu_fd_sc_mcu7t5v0__dffq_1
X_06968_ _10002_/Q _09104_/A2 _09278_/C _06969_/B vdd vdd vss vss
+ gf180mcu_fd_sc_mcu7t5v0__oai21_1
X_09687_ _09687_/D clk _09687_/Q vdd vdd vss vss gf180mcu_fd_sc_mcu7t5v0__dffq_1
X_08707_ _08667_/C _08707_/A2 _08707_/B _08709_/A1 vdd vdd vss vss
+ gf180mcu_fd_sc_mcu7t5v0__aoi21_1
X_05919_ _09564_/Q _05936_/A1 _05916_/Z _05919_/Z vdd vdd vss vss
+ gf180mcu_fd_sc_mcu7t5v0__xor3_1
X_06899_ _06885_/Z _06899_/A2 _06901_/B vdd vdd vss vss gf180mcu_fd_sc_mcu7t5v0__xor2_1
X_08638_ _09710_/Q _08703_/A1 _08638_/B _08639_/B vdd vdd vss vss
+ gf180mcu_fd_sc_mcu7t5v0__aoi21_1
XTAP_1404 vdd vss gf180mcu_fd_sc_mcu7t5v0__filltie
XTAP_1415 vdd vss gf180mcu_fd_sc_mcu7t5v0__filltie
XTAP_1426 vdd vss gf180mcu_fd_sc_mcu7t5v0__filltie
XTAP_1448 vdd vss gf180mcu_fd_sc_mcu7t5v0__filltie
XTAP_1437 vdd vss gf180mcu_fd_sc_mcu7t5v0__filltie
X_08569_ _08569_/A1 _08569_/A2 _08569_/B _08616_/B2 vdd vdd vss vss
+ gf180mcu_fd_sc_mcu7t5v0__aoi21_2
XTAP_1459 vdd vss gf180mcu_fd_sc_mcu7t5v0__filltie
XTAP_1960 vdd vss gf180mcu_fd_sc_mcu7t5v0__filltie
XTAP_1993 vdd vss gf180mcu_fd_sc_mcu7t5v0__filltie
XTAP_1982 vdd vss gf180mcu_fd_sc_mcu7t5v0__filltie
XTAP_1971 vdd vss gf180mcu_fd_sc_mcu7t5v0__filltie
X_07940_ _09881_/Q _07886_/Z _07982_/B1 _09619_/Q _07941_/B vdd vdd vss
+ vss gf180mcu_fd_sc_mcu7t5v0__aoi22_2
X_07871_ _07871_/A1 _07871_/A2 _07871_/B _07926_/B2 vdd vdd vss vss
+ gf180mcu_fd_sc_mcu7t5v0__aoi21_2
X_09610_ _09610_/D clk _09610_/Q vdd vdd vss vss gf180mcu_fd_sc_mcu7t5v0__dffq_1
X_06822_ _06957_/A1 _06822_/A2 _06822_/B _06823_/B vdd vdd vss vss
+ gf180mcu_fd_sc_mcu7t5v0__oai21_1
X_09541_ _09541_/D clk _09541_/Q vdd vdd vss vss gf180mcu_fd_sc_mcu7t5v0__dffq_1
X_06753_ _09710_/Q _06752_/I _06796_/A1 vdd vdd vss vss gf180mcu_fd_sc_mcu7t5v0__nand2_1
X_05704_ _05704_/A1 _05704_/A2 _05704_/B _05720_/A1 vdd vdd vss vss
+ gf180mcu_fd_sc_mcu7t5v0__oai21_1
X_06684_ _07348_/A2 _06971_/A1 _09624_/Q _06684_/B _06747_/A2 vdd vdd
+ vss vss gf180mcu_fd_sc_mcu7t5v0__oai31_4
X_09472_ _09472_/D clk _09472_/Q vdd vdd vss vss gf180mcu_fd_sc_mcu7t5v0__dffq_1
X_08423_ _09682_/Q _08386_/Z _08423_/B1 _09648_/Q _08429_/B vdd vdd vss
+ vss gf180mcu_fd_sc_mcu7t5v0__aoi22_4
X_05635_ _05972_/A1 _05970_/A1 _05638_/B vdd vdd vss vss gf180mcu_fd_sc_mcu7t5v0__nor2_1
X_05566_ _09415_/Q _05627_/A2 _05627_/B1 _09848_/Q _05568_/A1 vdd vdd
+ vss vss gf180mcu_fd_sc_mcu7t5v0__aoi22_1
X_08354_ _08154_/B _08354_/A2 _08355_/A2 vdd vdd vss vss gf180mcu_fd_sc_mcu7t5v0__nand2_1
X_07305_ _09402_/A1 _07312_/A2 _07312_/B1 _07305_/B2 _09639_/D vdd vdd
+ vss vss gf180mcu_fd_sc_mcu7t5v0__oai22_1
X_05497_ _09517_/Q _05628_/A2 _05628_/B1 _09477_/Q _05498_/A2 vdd vdd
+ vss vss gf180mcu_fd_sc_mcu7t5v0__aoi22_1
X_08285_ _08286_/A1 _08286_/A2 _08285_/Z vdd vdd vss vss gf180mcu_fd_sc_mcu7t5v0__and2_1
X_07236_ _07278_/A1 _07232_/Z _07249_/C vdd vdd vss vss gf180mcu_fd_sc_mcu7t5v0__nand2_1
X_07167_ _07152_/Z _07164_/I _07196_/A2 vdd vdd vss vss gf180mcu_fd_sc_mcu7t5v0__xnor2_1
X_06118_ _09575_/Q _08565_/C _06159_/A1 vdd vdd vss vss gf180mcu_fd_sc_mcu7t5v0__nand2_1
X_07098_ _07098_/A1 _07098_/A2 _07098_/B _07142_/A1 vdd vdd vss vss
+ gf180mcu_fd_sc_mcu7t5v0__oai21_1
X_06049_ _09885_/Q _09628_/Q _09594_/Q _09560_/Q _09582_/Q _09583_/Q _06050_/I vdd
+ vdd vss vss gf180mcu_fd_sc_mcu7t5v0__mux4_4
X_09808_ _09808_/D clk _09808_/Q vdd vdd vss vss gf180mcu_fd_sc_mcu7t5v0__dffq_1
X_09739_ _09739_/D clk _09739_/Q vdd vdd vss vss gf180mcu_fd_sc_mcu7t5v0__dffq_1
XTAP_1201 vdd vss gf180mcu_fd_sc_mcu7t5v0__filltie
XTAP_1223 vdd vss gf180mcu_fd_sc_mcu7t5v0__filltie
XTAP_1212 vdd vss gf180mcu_fd_sc_mcu7t5v0__filltie
XTAP_1234 vdd vss gf180mcu_fd_sc_mcu7t5v0__filltie
XTAP_1245 vdd vss gf180mcu_fd_sc_mcu7t5v0__filltie
XTAP_1256 vdd vss gf180mcu_fd_sc_mcu7t5v0__filltie
XTAP_1267 vdd vss gf180mcu_fd_sc_mcu7t5v0__filltie
XTAP_1278 vdd vss gf180mcu_fd_sc_mcu7t5v0__filltie
XTAP_1289 vdd vss gf180mcu_fd_sc_mcu7t5v0__filltie
X_05420_ _05203_/I _05204_/Z _05207_/Z _09400_/A2 vdd vdd vss vss
+ gf180mcu_fd_sc_mcu7t5v0__nor3_4
XTAP_1790 vdd vss gf180mcu_fd_sc_mcu7t5v0__filltie
X_05351_ _09013_/A1 _05359_/A2 _05359_/B1 vdd vdd vss vss gf180mcu_fd_sc_mcu7t5v0__nand2_2
X_08070_ _08070_/A1 _08067_/Z _08070_/B _08084_/A1 vdd vdd vss vss
+ gf180mcu_fd_sc_mcu7t5v0__aoi21_1
X_05282_ _09405_/A1 _05286_/A2 _05286_/B1 _05282_/B2 _09437_/D vdd vdd
+ vss vss gf180mcu_fd_sc_mcu7t5v0__oai22_1
X_07021_ _09711_/Q _07287_/A2 _07011_/Z _07286_/I0 _07021_/C1 _07278_/A1 _07022_/B
+ vdd vdd vss vss gf180mcu_fd_sc_mcu7t5v0__aoi222_1
X_08972_ _08972_/A1 _09400_/A2 _08981_/A2 vdd vdd vss vss gf180mcu_fd_sc_mcu7t5v0__nand2_4
X_07923_ _09674_/Q _08565_/C _07975_/A1 vdd vdd vss vss gf180mcu_fd_sc_mcu7t5v0__nand2_1
X_07854_ _09714_/Q _07852_/Z _07855_/B vdd vdd vss vss gf180mcu_fd_sc_mcu7t5v0__xor2_1
X_06805_ _06805_/A1 _06803_/Z _06830_/A3 vdd vdd vss vss gf180mcu_fd_sc_mcu7t5v0__xnor2_1
X_04997_ _09486_/Q _05326_/B2 vdd vdd vss vss gf180mcu_fd_sc_mcu7t5v0__clkinv_1
X_07785_ _09680_/Q _09616_/Q _07787_/A2 vdd vdd vss vss gf180mcu_fd_sc_mcu7t5v0__nor2_1
X_06736_ _06955_/A1 _06735_/I _06736_/Z vdd vdd vss vss gf180mcu_fd_sc_mcu7t5v0__and2_1
X_09524_ _09524_/D clk _09524_/Q vdd vdd vss vss gf180mcu_fd_sc_mcu7t5v0__dffq_1
X_09455_ _09455_/D clk _09455_/Q vdd vdd vss vss gf180mcu_fd_sc_mcu7t5v0__dffq_1
X_06667_ _06967_/A1 _06667_/A2 _06957_/A1 vdd vdd vss vss gf180mcu_fd_sc_mcu7t5v0__nand2_2
X_05618_ _09858_/Q _05627_/A2 _05627_/B1 _09591_/Q _05620_/A1 vdd vdd
+ vss vss gf180mcu_fd_sc_mcu7t5v0__aoi22_1
X_08406_ _08639_/A1 _08476_/A1 _08695_/A1 _08407_/B vdd vdd vss vss
+ gf180mcu_fd_sc_mcu7t5v0__nand3_1
X_06598_ _06598_/A1 _06598_/A2 _06598_/B _06600_/A1 vdd vdd vss vss
+ gf180mcu_fd_sc_mcu7t5v0__oai21_1
X_09386_ _09397_/A1 _09378_/Z _09386_/B _09399_/C _10012_/D vdd vdd vss
+ vss gf180mcu_fd_sc_mcu7t5v0__aoi211_1
X_05549_ _09832_/Q _05628_/A2 _05628_/B1 _10024_/Q _05550_/A2 vdd vdd
+ vss vss gf180mcu_fd_sc_mcu7t5v0__aoi22_1
X_08337_ _09715_/Q _08096_/Z _08339_/A2 vdd vdd vss vss gf180mcu_fd_sc_mcu7t5v0__nand2_1
X_08268_ _08167_/C _08255_/Z _08565_/C _08269_/B2 vdd vdd vss vss
+ gf180mcu_fd_sc_mcu7t5v0__aoi21_1
X_07219_ _07219_/A1 _07264_/A1 _07267_/S vdd vdd vss vss gf180mcu_fd_sc_mcu7t5v0__nor2_1
X_08199_ _08223_/B2 _08223_/B3 _08198_/Z _08203_/A2 vdd vdd vss vss
+ gf180mcu_fd_sc_mcu7t5v0__nor3_2
XTAP_1020 vdd vss gf180mcu_fd_sc_mcu7t5v0__filltie
XTAP_1031 vdd vss gf180mcu_fd_sc_mcu7t5v0__filltie
XTAP_1042 vdd vss gf180mcu_fd_sc_mcu7t5v0__filltie
XTAP_1053 vdd vss gf180mcu_fd_sc_mcu7t5v0__filltie
XTAP_1064 vdd vss gf180mcu_fd_sc_mcu7t5v0__filltie
XTAP_1075 vdd vss gf180mcu_fd_sc_mcu7t5v0__filltie
XTAP_1086 vdd vss gf180mcu_fd_sc_mcu7t5v0__filltie
XTAP_1097 vdd vss gf180mcu_fd_sc_mcu7t5v0__filltie
XTAP_826 vdd vss gf180mcu_fd_sc_mcu7t5v0__filltie
XTAP_815 vdd vss gf180mcu_fd_sc_mcu7t5v0__filltie
XTAP_804 vdd vss gf180mcu_fd_sc_mcu7t5v0__filltie
XTAP_837 vdd vss gf180mcu_fd_sc_mcu7t5v0__filltie
XTAP_848 vdd vss gf180mcu_fd_sc_mcu7t5v0__filltie
XTAP_859 vdd vss gf180mcu_fd_sc_mcu7t5v0__filltie
X_04920_ _09845_/Q _08996_/B2 vdd vdd vss vss gf180mcu_fd_sc_mcu7t5v0__clkinv_1
X_04851_ _10019_/Q _09402_/B2 vdd vdd vss vss gf180mcu_fd_sc_mcu7t5v0__clkinv_1
X_04782_ _09676_/Q _08018_/A1 vdd vdd vss vss gf180mcu_fd_sc_mcu7t5v0__clkinv_3
X_07570_ _07570_/A1 _07578_/A2 _07528_/Z _07570_/B2 _07572_/A2 vdd vdd
+ vss vss gf180mcu_fd_sc_mcu7t5v0__oai22_2
X_06521_ _06546_/A1 _06546_/A2 _06521_/Z vdd vdd vss vss gf180mcu_fd_sc_mcu7t5v0__xor2_1
X_09240_ _09256_/A2 _09244_/A2 _09240_/B _09948_/D vdd vdd vss vss
+ gf180mcu_fd_sc_mcu7t5v0__aoi21_1
X_06452_ _06580_/A1 _06435_/Z _06452_/B _06453_/B vdd vdd vss vss
+ gf180mcu_fd_sc_mcu7t5v0__aoi21_1
X_05403_ _09490_/Q _05627_/A2 _05627_/B1 _09506_/Q _05405_/A1 vdd vdd
+ vss vss gf180mcu_fd_sc_mcu7t5v0__aoi22_1
X_09171_ _09399_/C _09171_/A2 _09924_/D vdd vdd vss vss gf180mcu_fd_sc_mcu7t5v0__nor2_1
X_06383_ _09593_/Q _08706_/B _08708_/B _06384_/B vdd vdd vss vss gf180mcu_fd_sc_mcu7t5v0__oai21_1
X_08122_ _09683_/Q _08565_/C _08122_/B _08123_/A2 vdd vdd vss vss
+ gf180mcu_fd_sc_mcu7t5v0__aoi21_1
X_05334_ _09404_/A1 _05339_/A2 _05339_/B1 _05334_/B2 _09492_/D vdd vdd
+ vss vss gf180mcu_fd_sc_mcu7t5v0__oai22_1
X_08053_ _08107_/B _08053_/A2 _08054_/B2 vdd vdd vss vss gf180mcu_fd_sc_mcu7t5v0__nor2_1
X_05265_ _05631_/B2 _09400_/A1 _05274_/A2 vdd vdd vss vss gf180mcu_fd_sc_mcu7t5v0__nand2_4
X_07004_ _07000_/Z _07006_/A3 _07004_/Z vdd vdd vss vss gf180mcu_fd_sc_mcu7t5v0__xor2_1
X_05196_ _09257_/B _09461_/Q _09469_/D vdd vdd vss vss gf180mcu_fd_sc_mcu7t5v0__and2_1
X_08955_ _09821_/Q _08952_/Z _08955_/Z vdd vdd vss vss gf180mcu_fd_sc_mcu7t5v0__and2_1
X_07906_ _07813_/B _07905_/Z _07921_/B vdd vdd vss vss gf180mcu_fd_sc_mcu7t5v0__nand2_1
X_08886_ _08899_/A2 _08886_/A2 _08886_/B _09789_/D vdd vdd vss vss
+ gf180mcu_fd_sc_mcu7t5v0__aoi21_1
X_07837_ _07837_/I _07926_/A1 vdd vdd vss vss gf180mcu_fd_sc_mcu7t5v0__clkinv_1
X_07768_ _07970_/B2 _07877_/A1 _07970_/C _07769_/B vdd vdd vss vss
+ gf180mcu_fd_sc_mcu7t5v0__aoi21_1
X_09507_ _09507_/D clk _09507_/Q vdd vdd vss vss gf180mcu_fd_sc_mcu7t5v0__dffq_1
X_06719_ _06719_/I _06839_/A2 vdd vdd vss vss gf180mcu_fd_sc_mcu7t5v0__inv_1
X_07699_ _08022_/A1 _08020_/A1 _09676_/Q _07813_/B vdd vdd vss vss
+ gf180mcu_fd_sc_mcu7t5v0__nor3_4
XPHY_103 vdd vss gf180mcu_fd_sc_mcu7t5v0__endcap
XPHY_114 vdd vss gf180mcu_fd_sc_mcu7t5v0__endcap
XPHY_125 vdd vss gf180mcu_fd_sc_mcu7t5v0__endcap
X_09438_ _09438_/D clk _09438_/Q vdd vdd vss vss gf180mcu_fd_sc_mcu7t5v0__dffq_1
XPHY_136 vdd vss gf180mcu_fd_sc_mcu7t5v0__endcap
XPHY_147 vdd vss gf180mcu_fd_sc_mcu7t5v0__endcap
XPHY_158 vdd vss gf180mcu_fd_sc_mcu7t5v0__endcap
XPHY_169 vdd vss gf180mcu_fd_sc_mcu7t5v0__endcap
X_09369_ _09391_/A1 _09377_/A2 _09369_/B _09399_/C _10004_/D vdd vdd vss
+ vss gf180mcu_fd_sc_mcu7t5v0__aoi211_1
XPHY_5 vdd vss gf180mcu_fd_sc_mcu7t5v0__endcap
X_05050_ _09416_/Q _05243_/A1 vdd vdd vss vss gf180mcu_fd_sc_mcu7t5v0__clkinv_1
XTAP_634 vdd vss gf180mcu_fd_sc_mcu7t5v0__filltie
XTAP_623 vdd vss gf180mcu_fd_sc_mcu7t5v0__filltie
XTAP_612 vdd vss gf180mcu_fd_sc_mcu7t5v0__filltie
XTAP_601 vdd vss gf180mcu_fd_sc_mcu7t5v0__filltie
XTAP_667 vdd vss gf180mcu_fd_sc_mcu7t5v0__filltie
XTAP_656 vdd vss gf180mcu_fd_sc_mcu7t5v0__filltie
XTAP_645 vdd vss gf180mcu_fd_sc_mcu7t5v0__filltie
X_05952_ _05952_/A1 _05952_/A2 _05951_/Z _05953_/A3 vdd vdd vss vss
+ gf180mcu_fd_sc_mcu7t5v0__xnor3_1
XTAP_689 vdd vss gf180mcu_fd_sc_mcu7t5v0__filltie
XTAP_678 vdd vss gf180mcu_fd_sc_mcu7t5v0__filltie
X_08740_ _09404_/A1 _08745_/A2 _08745_/B1 _08740_/B2 _09725_/D vdd vdd
+ vss vss gf180mcu_fd_sc_mcu7t5v0__oai22_1
X_05883_ _05883_/A1 _05883_/A2 _05883_/B _05911_/A1 vdd vdd vss vss
+ gf180mcu_fd_sc_mcu7t5v0__oai21_1
X_04903_ _09724_/Q _08739_/B2 vdd vdd vss vss gf180mcu_fd_sc_mcu7t5v0__clkinv_1
X_08671_ _08671_/A1 _08671_/A2 _08694_/A2 vdd vdd vss vss gf180mcu_fd_sc_mcu7t5v0__nand2_1
X_07622_ _09715_/Q _07385_/Z _07624_/A2 vdd vdd vss vss gf180mcu_fd_sc_mcu7t5v0__nand2_1
X_04834_ _09574_/Q _06419_/A2 vdd vdd vss vss gf180mcu_fd_sc_mcu7t5v0__clkinv_3
X_04765_ _09706_/Q _08546_/A1 vdd vdd vss vss gf180mcu_fd_sc_mcu7t5v0__inv_2
X_07553_ _07553_/A1 _07553_/A2 _07552_/B _07553_/Z vdd vdd vss vss
+ gf180mcu_fd_sc_mcu7t5v0__and3_1
X_06504_ _09710_/Q _06613_/A2 _06509_/A1 vdd vdd vss vss gf180mcu_fd_sc_mcu7t5v0__nand2_1
X_07484_ _07484_/I _07566_/A1 vdd vdd vss vss gf180mcu_fd_sc_mcu7t5v0__clkinv_1
X_06435_ _06474_/A1 _06433_/Z _06435_/Z vdd vdd vss vss gf180mcu_fd_sc_mcu7t5v0__xor2_1
X_09223_ _09176_/B _09256_/A2 _09223_/B _09940_/D vdd vdd vss vss
+ gf180mcu_fd_sc_mcu7t5v0__aoi21_1
X_09154_ _09946_/Q _09137_/Z _09170_/B1 _09920_/Q _09154_/C _09155_/A2 vdd vdd
+ vss vss gf180mcu_fd_sc_mcu7t5v0__aoi221_1
X_06366_ _06367_/A1 _06365_/Z _06366_/Z vdd vdd vss vss gf180mcu_fd_sc_mcu7t5v0__and2_1
X_08105_ _08106_/A1 _08106_/A2 _08106_/B _08105_/Z vdd vdd vss vss
+ gf180mcu_fd_sc_mcu7t5v0__or3_1
X_06297_ _06297_/I0 _06297_/I1 _06297_/S _06297_/Z vdd vdd vss vss
+ gf180mcu_fd_sc_mcu7t5v0__mux2_1
X_05317_ _09409_/A1 _05317_/A2 _05317_/B1 _05317_/B2 _09481_/D vdd vdd
+ vss vss gf180mcu_fd_sc_mcu7t5v0__oai22_1
X_09085_ _09892_/Q _09098_/A1 _09278_/C _09086_/B vdd vdd vss vss
+ gf180mcu_fd_sc_mcu7t5v0__oai21_1
X_05248_ _05207_/Z _05413_/A2 _09002_/A2 vdd vdd vss vss gf180mcu_fd_sc_mcu7t5v0__nor2_4
X_08036_ _09691_/Q _09690_/Q _08064_/A2 vdd vdd vss vss gf180mcu_fd_sc_mcu7t5v0__nor2_1
X_05179_ _09927_/Q _05180_/A3 _05180_/A4 _05200_/A2 vdd vdd vss vss
+ gf180mcu_fd_sc_mcu7t5v0__nand3_1
X_09987_ _09987_/D clk _09987_/Q vdd vdd vss vss gf180mcu_fd_sc_mcu7t5v0__dffq_1
X_08938_ _09815_/Q _08935_/Z _08938_/Z vdd vdd vss vss gf180mcu_fd_sc_mcu7t5v0__and2_1
X_08869_ _09785_/Q _08899_/A2 _09226_/B _08870_/B vdd vdd vss vss
+ gf180mcu_fd_sc_mcu7t5v0__oai21_1
X_06220_ _06268_/A1 _06218_/B _06220_/A3 _06220_/Z vdd vdd vss vss
+ gf180mcu_fd_sc_mcu7t5v0__xor3_1
X_06151_ _06151_/A1 _06150_/B _06151_/Z vdd vdd vss vss gf180mcu_fd_sc_mcu7t5v0__xor2_1
X_06082_ _07452_/C _06016_/I _06048_/B _06082_/Z vdd vdd vss vss gf180mcu_fd_sc_mcu7t5v0__or3_1
X_05102_ _09858_/Q _09011_/B2 vdd vdd vss vss gf180mcu_fd_sc_mcu7t5v0__clkinv_1
X_05033_ _09665_/Q _07674_/B2 vdd vdd vss vss gf180mcu_fd_sc_mcu7t5v0__clkinv_1
X_09910_ _09910_/D clk _09910_/Q vdd vdd vss vss gf180mcu_fd_sc_mcu7t5v0__dffq_2
XTAP_420 vdd vss gf180mcu_fd_sc_mcu7t5v0__filltie
XTAP_442 vdd vss gf180mcu_fd_sc_mcu7t5v0__filltie
XTAP_431 vdd vss gf180mcu_fd_sc_mcu7t5v0__filltie
X_09841_ _09841_/D clk _09841_/Q vdd vdd vss vss gf180mcu_fd_sc_mcu7t5v0__dffq_1
XTAP_453 vdd vss gf180mcu_fd_sc_mcu7t5v0__filltie
XTAP_464 vdd vss gf180mcu_fd_sc_mcu7t5v0__filltie
XTAP_475 vdd vss gf180mcu_fd_sc_mcu7t5v0__filltie
X_06984_ _09710_/Q _07298_/A1 _06984_/B _06995_/C vdd vdd vss vss
+ gf180mcu_fd_sc_mcu7t5v0__oai21_1
X_09772_ _09772_/D clk _09772_/Q vdd vdd vss vss gf180mcu_fd_sc_mcu7t5v0__dffq_1
XTAP_486 vdd vss gf180mcu_fd_sc_mcu7t5v0__filltie
XTAP_497 vdd vss gf180mcu_fd_sc_mcu7t5v0__filltie
X_08723_ _07611_/B _09073_/A2 _08723_/B _09716_/D vdd vdd vss vss
+ gf180mcu_fd_sc_mcu7t5v0__aoi21_1
X_05935_ _05935_/A1 _05935_/A2 _08670_/B _09564_/D vdd vdd vss vss
+ gf180mcu_fd_sc_mcu7t5v0__aoi21_1
X_08654_ _08594_/Z _08654_/A2 _08654_/B _08671_/A2 vdd vdd vss vss
+ gf180mcu_fd_sc_mcu7t5v0__oai21_1
X_05866_ _09715_/Q _05865_/Z _05926_/A1 vdd vdd vss vss gf180mcu_fd_sc_mcu7t5v0__nand2_1
X_05797_ _05798_/A1 _05798_/A2 _05830_/A2 vdd vdd vss vss gf180mcu_fd_sc_mcu7t5v0__nor2_1
X_08585_ _08582_/Z _08586_/A3 _08643_/A1 vdd vdd vss vss gf180mcu_fd_sc_mcu7t5v0__nor2_2
X_04817_ _09616_/Q _05746_/A1 vdd vdd vss vss gf180mcu_fd_sc_mcu7t5v0__clkinv_1
X_07605_ _09716_/Q _07603_/Z _07606_/B vdd vdd vss vss gf180mcu_fd_sc_mcu7t5v0__xor2_1
XTAP_1608 vdd vss gf180mcu_fd_sc_mcu7t5v0__filltie
XTAP_1619 vdd vss gf180mcu_fd_sc_mcu7t5v0__filltie
X_04748_ _09754_/Q _08784_/A1 vdd vdd vss vss gf180mcu_fd_sc_mcu7t5v0__clkinv_1
X_07536_ _07524_/Z _07538_/A3 _07536_/Z vdd vdd vss vss gf180mcu_fd_sc_mcu7t5v0__and2_1
X_09206_ _09173_/B _09258_/A2 _09206_/B _09933_/D vdd vdd vss vss
+ gf180mcu_fd_sc_mcu7t5v0__aoi21_1
X_07467_ _07467_/A1 _07570_/A1 _07467_/B _07517_/A2 vdd vdd vss vss
+ gf180mcu_fd_sc_mcu7t5v0__oai21_1
X_07398_ _07385_/Z _07400_/A3 _07399_/A2 vdd vdd vss vss gf180mcu_fd_sc_mcu7t5v0__xnor2_1
X_06418_ _09886_/Q _06387_/B _09603_/Q _06419_/C vdd vdd vss vss gf180mcu_fd_sc_mcu7t5v0__aoi21_2
X_06349_ _09602_/Q _09601_/Q _06634_/A1 _06350_/C vdd vdd vss vss
+ gf180mcu_fd_sc_mcu7t5v0__nand3_4
X_09137_ _09465_/Q _09468_/Q _09137_/Z vdd vdd vss vss gf180mcu_fd_sc_mcu7t5v0__or2_4
X_09068_ _09555_/Q _09073_/A2 _09072_/B _09069_/B vdd vdd vss vss
+ gf180mcu_fd_sc_mcu7t5v0__oai21_1
X_08019_ _09985_/Q _09104_/A2 _09089_/B _08020_/B vdd vdd vss vss
+ gf180mcu_fd_sc_mcu7t5v0__oai21_1
X_05720_ _05720_/A1 _05718_/Z _05720_/Z vdd vdd vss vss gf180mcu_fd_sc_mcu7t5v0__xor2_1
X_05651_ _05974_/A1 _09567_/Q _05970_/A1 _05964_/B2 vdd vdd vss vss
+ gf180mcu_fd_sc_mcu7t5v0__nand3_4
X_08370_ _09981_/Q _09073_/A2 _08734_/B _08371_/B vdd vdd vss vss
+ gf180mcu_fd_sc_mcu7t5v0__oai21_1
X_05582_ _05582_/A1 _05582_/A2 _05602_/A2 vdd vdd vss vss gf180mcu_fd_sc_mcu7t5v0__nand2_1
X_07321_ _09657_/Q _07660_/A1 _07330_/A2 vdd vdd vss vss gf180mcu_fd_sc_mcu7t5v0__nand2_2
X_07252_ _07252_/A1 _07234_/Z _07252_/B _07277_/A2 vdd vdd vss vss
+ gf180mcu_fd_sc_mcu7t5v0__aoi21_1
X_06203_ _09715_/Q _05996_/B _06297_/I1 _06204_/A2 _06259_/C _06204_/B vdd vdd
+ vss vss gf180mcu_fd_sc_mcu7t5v0__aoi221_1
X_07183_ _07128_/Z _07184_/A2 _07184_/B _07183_/Z vdd vdd vss vss
+ gf180mcu_fd_sc_mcu7t5v0__or3_1
X_06134_ _06082_/Z _06137_/A3 _06134_/Z vdd vdd vss vss gf180mcu_fd_sc_mcu7t5v0__and2_1
X_06065_ _06065_/A1 _06065_/A2 _06065_/B _06107_/A2 vdd vdd vss vss
+ gf180mcu_fd_sc_mcu7t5v0__aoi21_1
X_05016_ _09848_/Q _08999_/B2 vdd vdd vss vss gf180mcu_fd_sc_mcu7t5v0__clkinv_1
X_09824_ _09824_/D clk _09824_/Q vdd vdd vss vss gf180mcu_fd_sc_mcu7t5v0__dffq_1
XTAP_283 vdd vss gf180mcu_fd_sc_mcu7t5v0__filltie
XTAP_272 vdd vss gf180mcu_fd_sc_mcu7t5v0__filltie
XTAP_294 vdd vss gf180mcu_fd_sc_mcu7t5v0__filltie
X_09755_ _09755_/D clk _09755_/Q vdd vdd vss vss gf180mcu_fd_sc_mcu7t5v0__dffq_1
X_06967_ _06967_/A1 _09104_/A2 _06967_/B _09623_/D vdd vdd vss vss
+ gf180mcu_fd_sc_mcu7t5v0__aoi21_1
X_09686_ _09686_/D clk _09686_/Q vdd vdd vss vss gf180mcu_fd_sc_mcu7t5v0__dffq_2
X_06898_ _06885_/Z _06899_/A2 _06928_/B vdd vdd vss vss gf180mcu_fd_sc_mcu7t5v0__nand2_1
X_08706_ _08667_/C _08706_/A2 _08706_/B _08707_/B vdd vdd vss vss
+ gf180mcu_fd_sc_mcu7t5v0__oai21_1
X_05918_ _05918_/A1 _05916_/Z _05936_/A2 vdd vdd vss vss gf180mcu_fd_sc_mcu7t5v0__nand2_1
X_05849_ _05794_/Z _05834_/I _05846_/Z _05849_/Z vdd vdd vss vss gf180mcu_fd_sc_mcu7t5v0__xor3_1
X_08637_ _08639_/A1 _08667_/B1 _08686_/S vdd vdd vss vss gf180mcu_fd_sc_mcu7t5v0__nand2_1
XTAP_1405 vdd vss gf180mcu_fd_sc_mcu7t5v0__filltie
XTAP_1416 vdd vss gf180mcu_fd_sc_mcu7t5v0__filltie
XTAP_1438 vdd vss gf180mcu_fd_sc_mcu7t5v0__filltie
XTAP_1427 vdd vss gf180mcu_fd_sc_mcu7t5v0__filltie
X_08568_ _09707_/Q _08565_/C _08614_/A1 vdd vdd vss vss gf180mcu_fd_sc_mcu7t5v0__nand2_1
XTAP_1449 vdd vss gf180mcu_fd_sc_mcu7t5v0__filltie
X_08499_ _09713_/Q _08685_/A2 _08688_/A2 _09712_/Q _08502_/B2 vdd vdd
+ vss vss gf180mcu_fd_sc_mcu7t5v0__aoi22_1
X_07519_ _07519_/I _07567_/A1 vdd vdd vss vss gf180mcu_fd_sc_mcu7t5v0__clkinv_1
XTAP_1961 vdd vss gf180mcu_fd_sc_mcu7t5v0__filltie
XTAP_1950 vdd vss gf180mcu_fd_sc_mcu7t5v0__filltie
XTAP_1994 vdd vss gf180mcu_fd_sc_mcu7t5v0__filltie
XTAP_1983 vdd vss gf180mcu_fd_sc_mcu7t5v0__filltie
XTAP_1972 vdd vss gf180mcu_fd_sc_mcu7t5v0__filltie
X_07870_ _07870_/A1 _07870_/A2 _07870_/B _07900_/A1 vdd vdd vss vss
+ gf180mcu_fd_sc_mcu7t5v0__oai21_1
X_06821_ _09714_/Q _06672_/B _06955_/A1 _06822_/A2 _06918_/C _06822_/B vdd vdd
+ vss vss gf180mcu_fd_sc_mcu7t5v0__aoi221_1
X_09540_ _09540_/D clk _09540_/Q vdd vdd vss vss gf180mcu_fd_sc_mcu7t5v0__dffq_1
X_06752_ _06752_/I _06811_/A4 vdd vdd vss vss gf180mcu_fd_sc_mcu7t5v0__clkinv_1
X_05703_ _09560_/Q _08565_/C _05737_/A1 vdd vdd vss vss gf180mcu_fd_sc_mcu7t5v0__nand2_1
X_09471_ _09471_/D clk _09471_/Q vdd vdd vss vss gf180mcu_fd_sc_mcu7t5v0__dffq_1
X_08422_ _09722_/Q _09721_/Q _09682_/Q _08424_/B vdd vdd vss vss gf180mcu_fd_sc_mcu7t5v0__nand3_2
X_06683_ _08060_/A2 _09624_/Q _09625_/Q _06747_/A1 vdd vdd vss vss
+ gf180mcu_fd_sc_mcu7t5v0__aoi21_4
X_05634_ _08791_/B _05634_/A2 _09557_/D vdd vdd vss vss gf180mcu_fd_sc_mcu7t5v0__and2_1
X_08353_ _09717_/Q _08361_/A2 _08358_/S vdd vdd vss vss gf180mcu_fd_sc_mcu7t5v0__nand2_1
X_05565_ _05565_/A1 _05565_/A2 _05574_/C1 vdd vdd vss vss gf180mcu_fd_sc_mcu7t5v0__nand2_1
X_08284_ _09713_/Q _08284_/A2 _08341_/A2 vdd vdd vss vss gf180mcu_fd_sc_mcu7t5v0__nand2_1
X_07304_ _09089_/B _07312_/A2 _07312_/B1 vdd vdd vss vss gf180mcu_fd_sc_mcu7t5v0__nand2_2
X_05496_ _09529_/Q _05627_/A2 _05627_/B1 _09537_/Q _05498_/A1 vdd vdd
+ vss vss gf180mcu_fd_sc_mcu7t5v0__aoi22_1
X_07235_ _09632_/Q _07252_/A1 _07232_/Z _07235_/Z vdd vdd vss vss
+ gf180mcu_fd_sc_mcu7t5v0__xor3_1
X_07166_ _07166_/I _07227_/A1 vdd vdd vss vss gf180mcu_fd_sc_mcu7t5v0__clkinv_1
X_07097_ _09630_/Q _08565_/C _07140_/A1 vdd vdd vss vss gf180mcu_fd_sc_mcu7t5v0__nand2_1
X_06117_ _06117_/A1 _06117_/A2 _08670_/B _09574_/D vdd vdd vss vss
+ gf180mcu_fd_sc_mcu7t5v0__aoi21_1
X_06048_ _08430_/B _06016_/I _06048_/B _06052_/A3 vdd vdd vss vss
+ gf180mcu_fd_sc_mcu7t5v0__oai21_1
X_07999_ _09675_/Q _07999_/A2 _07998_/Z _07999_/Z vdd vdd vss vss
+ gf180mcu_fd_sc_mcu7t5v0__xor3_1
X_09807_ _09807_/D clk _09807_/Q vdd vdd vss vss gf180mcu_fd_sc_mcu7t5v0__dffq_1
X_09738_ _09738_/D clk _09738_/Q vdd vdd vss vss gf180mcu_fd_sc_mcu7t5v0__dffq_1
X_09669_ _09669_/D clk _09669_/Q vdd vdd vss vss gf180mcu_fd_sc_mcu7t5v0__dffq_1
XTAP_1202 vdd vss gf180mcu_fd_sc_mcu7t5v0__filltie
XTAP_1213 vdd vss gf180mcu_fd_sc_mcu7t5v0__filltie
XTAP_1224 vdd vss gf180mcu_fd_sc_mcu7t5v0__filltie
XTAP_1235 vdd vss gf180mcu_fd_sc_mcu7t5v0__filltie
XTAP_1246 vdd vss gf180mcu_fd_sc_mcu7t5v0__filltie
XTAP_1257 vdd vss gf180mcu_fd_sc_mcu7t5v0__filltie
XTAP_1268 vdd vss gf180mcu_fd_sc_mcu7t5v0__filltie
XTAP_1279 vdd vss gf180mcu_fd_sc_mcu7t5v0__filltie
XTAP_1791 vdd vss gf180mcu_fd_sc_mcu7t5v0__filltie
XTAP_1780 vdd vss gf180mcu_fd_sc_mcu7t5v0__filltie
X_05350_ _09022_/A1 _05632_/C2 _05359_/A2 vdd vdd vss vss gf180mcu_fd_sc_mcu7t5v0__nand2_4
X_05281_ _09404_/A1 _05286_/A2 _05286_/B1 _05281_/B2 _09436_/D vdd vdd
+ vss vss gf180mcu_fd_sc_mcu7t5v0__oai22_1
X_07020_ _09626_/Q _06993_/B _07020_/B _07024_/A2 vdd vdd vss vss
+ gf180mcu_fd_sc_mcu7t5v0__aoi21_1
X_08971_ _08927_/I _08970_/Z _09826_/D vdd vdd vss vss gf180mcu_fd_sc_mcu7t5v0__nor2_1
X_07922_ _07922_/A1 _07922_/A2 _08670_/B _09673_/D vdd vdd vss vss
+ gf180mcu_fd_sc_mcu7t5v0__aoi21_1
X_07853_ _09714_/Q _07852_/Z _07914_/A1 vdd vdd vss vss gf180mcu_fd_sc_mcu7t5v0__nand2_1
X_06804_ _06805_/A1 _06803_/Z _06830_/B vdd vdd vss vss gf180mcu_fd_sc_mcu7t5v0__nand2_1
X_04996_ _09510_/Q _05356_/B2 vdd vdd vss vss gf180mcu_fd_sc_mcu7t5v0__clkinv_1
X_07784_ _09684_/Q _08026_/A1 _09679_/Q _07784_/Z vdd vdd vss vss
+ gf180mcu_fd_sc_mcu7t5v0__or3_2
X_06735_ _06735_/I _06834_/A1 vdd vdd vss vss gf180mcu_fd_sc_mcu7t5v0__clkinv_1
X_09523_ _09523_/D clk _09523_/Q vdd vdd vss vss gf180mcu_fd_sc_mcu7t5v0__dffq_4
X_09454_ _09454_/D clk _09454_/Q vdd vdd vss vss gf180mcu_fd_sc_mcu7t5v0__dffq_1
X_06666_ _09623_/Q _06666_/A2 _06672_/C vdd vdd vss vss gf180mcu_fd_sc_mcu7t5v0__nor2_2
X_05617_ _05617_/A1 _05617_/A2 _05632_/A2 vdd vdd vss vss gf180mcu_fd_sc_mcu7t5v0__nand2_1
X_08405_ _09718_/Q _08405_/A2 _08695_/A1 vdd vdd vss vss gf180mcu_fd_sc_mcu7t5v0__nand2_1
X_09385_ _10012_/Q _09378_/Z _09386_/B vdd vdd vss vss gf180mcu_fd_sc_mcu7t5v0__nor2_1
X_06597_ _06597_/A1 _06597_/A2 _06597_/B _06619_/A1 vdd vdd vss vss
+ gf180mcu_fd_sc_mcu7t5v0__oai21_1
X_08336_ _09712_/Q _08336_/I1 _08336_/S _08336_/Z vdd vdd vss vss
+ gf180mcu_fd_sc_mcu7t5v0__mux2_1
X_05548_ _09840_/Q _05627_/A2 _05627_/B1 _09808_/Q _05550_/A1 vdd vdd
+ vss vss gf180mcu_fd_sc_mcu7t5v0__aoi22_1
X_08267_ _08107_/B _08267_/A2 _08269_/B1 vdd vdd vss vss gf180mcu_fd_sc_mcu7t5v0__nand2_1
X_05479_ _09492_/Q _05627_/A2 _05627_/B1 _09508_/Q _05481_/A1 vdd vdd
+ vss vss gf180mcu_fd_sc_mcu7t5v0__aoi22_1
X_08198_ _08224_/A1 _08223_/A1 _08194_/Z _08198_/Z vdd vdd vss vss
+ gf180mcu_fd_sc_mcu7t5v0__xor3_1
X_07218_ _09711_/Q _07245_/A2 _07264_/A1 vdd vdd vss vss gf180mcu_fd_sc_mcu7t5v0__nand2_1
X_07149_ _07052_/Z _07149_/A2 _07149_/B _07152_/A3 vdd vdd vss vss
+ gf180mcu_fd_sc_mcu7t5v0__aoi21_2
XTAP_1010 vdd vss gf180mcu_fd_sc_mcu7t5v0__filltie
XTAP_1021 vdd vss gf180mcu_fd_sc_mcu7t5v0__filltie
XTAP_1032 vdd vss gf180mcu_fd_sc_mcu7t5v0__filltie
XTAP_1043 vdd vss gf180mcu_fd_sc_mcu7t5v0__filltie
XTAP_1054 vdd vss gf180mcu_fd_sc_mcu7t5v0__filltie
XTAP_1065 vdd vss gf180mcu_fd_sc_mcu7t5v0__filltie
XTAP_1076 vdd vss gf180mcu_fd_sc_mcu7t5v0__filltie
XTAP_1087 vdd vss gf180mcu_fd_sc_mcu7t5v0__filltie
XTAP_1098 vdd vss gf180mcu_fd_sc_mcu7t5v0__filltie
XTAP_816 vdd vss gf180mcu_fd_sc_mcu7t5v0__filltie
XTAP_805 vdd vss gf180mcu_fd_sc_mcu7t5v0__filltie
XTAP_827 vdd vss gf180mcu_fd_sc_mcu7t5v0__filltie
XTAP_838 vdd vss gf180mcu_fd_sc_mcu7t5v0__filltie
XTAP_849 vdd vss gf180mcu_fd_sc_mcu7t5v0__filltie
X_04850_ _09731_/Q _08757_/A2 vdd vdd vss vss gf180mcu_fd_sc_mcu7t5v0__clkinv_1
X_04781_ _09677_/Q _08020_/A1 vdd vdd vss vss gf180mcu_fd_sc_mcu7t5v0__inv_2
X_06520_ _06520_/A1 _06520_/A2 _06546_/A2 vdd vdd vss vss gf180mcu_fd_sc_mcu7t5v0__xnor2_1
X_06451_ _06451_/A1 _06451_/A2 _06452_/B vdd vdd vss vss gf180mcu_fd_sc_mcu7t5v0__nand2_1
X_05402_ _05402_/A1 _05402_/A2 _05427_/A2 vdd vdd vss vss gf180mcu_fd_sc_mcu7t5v0__nand2_1
X_06382_ _06350_/C _06381_/Z _06382_/B _06384_/A2 vdd vdd vss vss
+ gf180mcu_fd_sc_mcu7t5v0__oai21_1
X_09170_ _09950_/Q _09137_/Z _09170_/B1 _09924_/Q _09170_/C _09171_/A2 vdd vdd
+ vss vss gf180mcu_fd_sc_mcu7t5v0__aoi221_1
X_05333_ _09403_/A1 _05339_/A2 _05339_/B1 _05333_/B2 _09491_/D vdd vdd
+ vss vss gf180mcu_fd_sc_mcu7t5v0__oai22_1
X_08121_ _08107_/B _08121_/A2 _08121_/B _08565_/C _08122_/B vdd vdd
+ vss vss gf180mcu_fd_sc_mcu7t5v0__aoi211_1
X_08052_ _09681_/Q _08046_/B _08081_/A1 vdd vdd vss vss gf180mcu_fd_sc_mcu7t5v0__nand2_1
X_05264_ _05276_/A1 _05216_/I _05218_/I _09400_/A1 vdd vdd vss vss
+ gf180mcu_fd_sc_mcu7t5v0__nor3_4
X_07003_ _09636_/Q _09635_/Q _07294_/A1 _07003_/B _07006_/A3 vdd vdd vss
+ vss gf180mcu_fd_sc_mcu7t5v0__oai31_2
X_05195_ _09257_/B _09462_/Q _09470_/D vdd vdd vss vss gf180mcu_fd_sc_mcu7t5v0__and2_1
X_08954_ _08952_/Z _08954_/A2 _09820_/D vdd vdd vss vss gf180mcu_fd_sc_mcu7t5v0__nor2_1
X_07905_ _09673_/Q _07924_/A1 _07902_/Z _07905_/Z vdd vdd vss vss
+ gf180mcu_fd_sc_mcu7t5v0__xor3_1
X_08885_ _09789_/Q _08899_/A2 _09226_/B _08886_/B vdd vdd vss vss
+ gf180mcu_fd_sc_mcu7t5v0__oai21_1
X_07836_ _07839_/A2 _07835_/Z _07837_/I vdd vdd vss vss gf180mcu_fd_sc_mcu7t5v0__nor2_1
X_07767_ _09712_/Q _07749_/Z _07877_/A1 vdd vdd vss vss gf180mcu_fd_sc_mcu7t5v0__nand2_2
X_04979_ _10023_/Q _09406_/B2 vdd vdd vss vss gf180mcu_fd_sc_mcu7t5v0__clkinv_1
X_09506_ _09506_/D clk _09506_/Q vdd vdd vss vss gf180mcu_fd_sc_mcu7t5v0__dffq_1
X_06718_ _09560_/Q _09628_/Q _09670_/Q _09877_/Q _09625_/Q _09624_/Q _06719_/I vdd
+ vdd vss vss gf180mcu_fd_sc_mcu7t5v0__mux4_4
X_07698_ _08011_/B2 _07920_/A1 _07698_/B _07701_/B2 vdd vdd vss vss
+ gf180mcu_fd_sc_mcu7t5v0__aoi21_1
XPHY_104 vdd vss gf180mcu_fd_sc_mcu7t5v0__endcap
XPHY_115 vdd vss gf180mcu_fd_sc_mcu7t5v0__endcap
X_06649_ _09406_/A1 _06652_/A2 _06652_/B1 _06649_/B2 _09609_/D vdd vdd
+ vss vss gf180mcu_fd_sc_mcu7t5v0__oai22_1
XPHY_126 vdd vss gf180mcu_fd_sc_mcu7t5v0__endcap
X_09437_ _09437_/D clk _09437_/Q vdd vdd vss vss gf180mcu_fd_sc_mcu7t5v0__dffq_1
XPHY_137 vdd vss gf180mcu_fd_sc_mcu7t5v0__endcap
XPHY_148 vdd vss gf180mcu_fd_sc_mcu7t5v0__endcap
XPHY_159 vdd vss gf180mcu_fd_sc_mcu7t5v0__endcap
X_09368_ _10004_/Q _09377_/A2 _09369_/B vdd vdd vss vss gf180mcu_fd_sc_mcu7t5v0__nor2_1
X_08319_ _09716_/Q _08359_/A2 _08320_/A2 _08319_/B2 _08359_/B _08320_/B vdd
+ vdd vss vss gf180mcu_fd_sc_mcu7t5v0__aoi221_1
X_09299_ _09912_/Q _09916_/Q _09299_/A3 _09299_/A4 _09389_/A2 vdd vdd
+ vss vss gf180mcu_fd_sc_mcu7t5v0__nand4_4
XPHY_6 vdd vss gf180mcu_fd_sc_mcu7t5v0__endcap
XTAP_624 vdd vss gf180mcu_fd_sc_mcu7t5v0__filltie
XTAP_613 vdd vss gf180mcu_fd_sc_mcu7t5v0__filltie
XTAP_602 vdd vss gf180mcu_fd_sc_mcu7t5v0__filltie
XTAP_668 vdd vss gf180mcu_fd_sc_mcu7t5v0__filltie
XTAP_657 vdd vss gf180mcu_fd_sc_mcu7t5v0__filltie
XTAP_635 vdd vss gf180mcu_fd_sc_mcu7t5v0__filltie
XTAP_646 vdd vss gf180mcu_fd_sc_mcu7t5v0__filltie
XTAP_679 vdd vss gf180mcu_fd_sc_mcu7t5v0__filltie
X_05951_ _05948_/Z _05951_/A2 _05951_/A3 _05951_/Z vdd vdd vss vss
+ gf180mcu_fd_sc_mcu7t5v0__xor3_1
X_05882_ _05882_/A1 _05882_/A2 _05937_/A1 vdd vdd vss vss gf180mcu_fd_sc_mcu7t5v0__nand2_1
X_04902_ _09491_/Q _05333_/B2 vdd vdd vss vss gf180mcu_fd_sc_mcu7t5v0__clkinv_1
X_08670_ _08670_/A1 _08670_/A2 _08670_/B _09708_/D vdd vdd vss vss
+ gf180mcu_fd_sc_mcu7t5v0__aoi21_1
X_04833_ _09575_/Q _06141_/B vdd vdd vss vss gf180mcu_fd_sc_mcu7t5v0__clkinv_3
X_07621_ _07621_/A1 _07589_/Z _07621_/B _07638_/A1 vdd vdd vss vss
+ gf180mcu_fd_sc_mcu7t5v0__aoi21_1
X_07552_ _07553_/A1 _07553_/A2 _07552_/B _07607_/A2 vdd vdd vss vss
+ gf180mcu_fd_sc_mcu7t5v0__aoi21_1
X_04764_ _09707_/Q _08595_/A1 vdd vdd vss vss gf180mcu_fd_sc_mcu7t5v0__clkinv_2
X_06503_ _06503_/A1 _06503_/A2 _06613_/A2 vdd vdd vss vss gf180mcu_fd_sc_mcu7t5v0__nand2_4
X_07483_ _07468_/Z _07482_/Z _07484_/I vdd vdd vss vss gf180mcu_fd_sc_mcu7t5v0__nor2_1
X_06434_ _06474_/A1 _06433_/Z _06475_/A1 vdd vdd vss vss gf180mcu_fd_sc_mcu7t5v0__nor2_1
X_09222_ _09940_/Q _09176_/B _09259_/B _09223_/B vdd vdd vss vss gf180mcu_fd_sc_mcu7t5v0__oai21_1
X_06365_ _08430_/B _06562_/A2 _06365_/A3 _06365_/Z vdd vdd vss vss
+ gf180mcu_fd_sc_mcu7t5v0__xor3_1
X_09153_ _09137_/Z _09153_/A2 _09154_/C vdd vdd vss vss gf180mcu_fd_sc_mcu7t5v0__nor2_1
X_05316_ _09408_/A1 _05317_/A2 _05317_/B1 _05316_/B2 _09480_/D vdd vdd
+ vss vss gf180mcu_fd_sc_mcu7t5v0__oai22_1
X_08104_ _09683_/Q _08102_/Z _08106_/B vdd vdd vss vss gf180mcu_fd_sc_mcu7t5v0__xor2_1
X_06296_ _06296_/A1 _06295_/Z _06300_/A2 vdd vdd vss vss gf180mcu_fd_sc_mcu7t5v0__nand2_1
X_09084_ _09960_/Q _08706_/B _09096_/B1 _09970_/Q _09084_/C _09086_/A2 vdd vdd
+ vss vss gf180mcu_fd_sc_mcu7t5v0__aoi221_2
X_05247_ _05203_/I _05204_/Z _05413_/A2 vdd vdd vss vss gf180mcu_fd_sc_mcu7t5v0__nand2_2
X_08035_ _08371_/A1 _09690_/Q _08367_/A1 _08358_/I0 vdd vdd vss vss
+ gf180mcu_fd_sc_mcu7t5v0__nand3_4
X_05178_ _09930_/Q _09929_/Q _05180_/A4 vdd vdd vss vss gf180mcu_fd_sc_mcu7t5v0__nor2_1
X_09986_ _09986_/D clk _09986_/Q vdd vdd vss vss gf180mcu_fd_sc_mcu7t5v0__dffq_1
X_08937_ _09815_/Q _08935_/Z _08939_/A2 vdd vdd vss vss gf180mcu_fd_sc_mcu7t5v0__nor2_1
X_08868_ _09786_/Q _09523_/Q _08868_/B _08870_/A2 vdd vdd vss vss
+ gf180mcu_fd_sc_mcu7t5v0__aoi21_1
X_07819_ _07819_/A1 _07819_/A2 _07819_/B _07868_/A1 vdd vdd vss vss
+ gf180mcu_fd_sc_mcu7t5v0__oai21_1
X_08799_ _09732_/Q _09734_/Q _08812_/A2 vdd vdd vss vss gf180mcu_fd_sc_mcu7t5v0__nor2_2
X_06150_ _06150_/A1 _06150_/A2 _06150_/B _06200_/A2 vdd vdd vss vss
+ gf180mcu_fd_sc_mcu7t5v0__aoi21_1
X_06081_ _07452_/C _06016_/I _06048_/B _06162_/A1 vdd vdd vss vss
+ gf180mcu_fd_sc_mcu7t5v0__nor3_1
X_05101_ _09425_/Q _05260_/B2 vdd vdd vss vss gf180mcu_fd_sc_mcu7t5v0__clkinv_1
X_05032_ _09699_/Q _08383_/B2 vdd vdd vss vss gf180mcu_fd_sc_mcu7t5v0__clkinv_1
XTAP_410 vdd vss gf180mcu_fd_sc_mcu7t5v0__filltie
XTAP_421 vdd vss gf180mcu_fd_sc_mcu7t5v0__filltie
XTAP_432 vdd vss gf180mcu_fd_sc_mcu7t5v0__filltie
X_09840_ _09840_/D clk _09840_/Q vdd vdd vss vss gf180mcu_fd_sc_mcu7t5v0__dffq_1
XTAP_443 vdd vss gf180mcu_fd_sc_mcu7t5v0__filltie
XTAP_454 vdd vss gf180mcu_fd_sc_mcu7t5v0__filltie
XTAP_465 vdd vss gf180mcu_fd_sc_mcu7t5v0__filltie
XTAP_476 vdd vss gf180mcu_fd_sc_mcu7t5v0__filltie
X_06983_ _09636_/Q _06994_/A2 _07287_/C vdd vdd vss vss gf180mcu_fd_sc_mcu7t5v0__nor2_2
X_09771_ _09771_/D clk _09771_/Q vdd vdd vss vss gf180mcu_fd_sc_mcu7t5v0__dffq_1
XTAP_487 vdd vss gf180mcu_fd_sc_mcu7t5v0__filltie
XTAP_498 vdd vss gf180mcu_fd_sc_mcu7t5v0__filltie
X_08722_ _09881_/Q _09073_/A2 _09072_/B _08723_/B vdd vdd vss vss
+ gf180mcu_fd_sc_mcu7t5v0__oai21_1
X_05934_ _05698_/C _05934_/A2 _05934_/B _08706_/B _05935_/A2 vdd vdd vss
+ vss gf180mcu_fd_sc_mcu7t5v0__oai211_1
X_08653_ _08594_/Z _08654_/A2 _08654_/B _08653_/Z vdd vdd vss vss
+ gf180mcu_fd_sc_mcu7t5v0__or3_1
X_05865_ _05836_/Z _05865_/A2 _05865_/Z vdd vdd vss vss gf180mcu_fd_sc_mcu7t5v0__xor2_1
X_05796_ _05798_/A1 _05798_/A2 _05830_/B vdd vdd vss vss gf180mcu_fd_sc_mcu7t5v0__nand2_1
X_08584_ _08582_/Z _08586_/A3 _08584_/Z vdd vdd vss vss gf180mcu_fd_sc_mcu7t5v0__and2_1
X_04816_ _09617_/Q _05787_/A1 vdd vdd vss vss gf180mcu_fd_sc_mcu7t5v0__clkinv_1
X_07604_ _09716_/Q _07603_/Z _07648_/A1 vdd vdd vss vss gf180mcu_fd_sc_mcu7t5v0__nand2_1
XTAP_1609 vdd vss gf180mcu_fd_sc_mcu7t5v0__filltie
X_04747_ _09747_/Q _08770_/A1 vdd vdd vss vss gf180mcu_fd_sc_mcu7t5v0__clkinv_1
X_07535_ _07524_/Z _07538_/A3 _07566_/A2 vdd vdd vss vss gf180mcu_fd_sc_mcu7t5v0__nor2_1
X_07466_ _07467_/A1 _07467_/B _07570_/A1 _07517_/B vdd vdd vss vss
+ gf180mcu_fd_sc_mcu7t5v0__nor3_1
X_09205_ _09933_/Q _09173_/B _09257_/B _09206_/B vdd vdd vss vss
+ gf180mcu_fd_sc_mcu7t5v0__oai21_1
X_06417_ _06417_/A1 _06417_/A2 _06417_/B _06456_/A1 vdd vdd vss vss
+ gf180mcu_fd_sc_mcu7t5v0__oai21_1
X_07397_ _07465_/A2 _07417_/A2 _07548_/B _07400_/A3 vdd vdd vss vss
+ gf180mcu_fd_sc_mcu7t5v0__aoi21_2
X_06348_ _06638_/A1 _06348_/A2 _06450_/C vdd vdd vss vss gf180mcu_fd_sc_mcu7t5v0__nor2_4
X_09136_ _09136_/A1 _09136_/A2 _09136_/B1 _09136_/B2 _09399_/C _09915_/D vdd
+ vdd vss vss gf180mcu_fd_sc_mcu7t5v0__aoi221_1
X_06279_ _06279_/A1 _06279_/A2 _06279_/Z vdd vdd vss vss gf180mcu_fd_sc_mcu7t5v0__xor2_1
X_09067_ _09067_/A1 _09104_/A2 _09067_/B _09887_/D vdd vdd vss vss
+ gf180mcu_fd_sc_mcu7t5v0__aoi21_1
X_08018_ _08018_/A1 _09104_/A2 _08018_/B _09676_/D vdd vdd vss vss
+ gf180mcu_fd_sc_mcu7t5v0__aoi21_1
X_09969_ _09969_/D clk _09969_/Q vdd vdd vss vss gf180mcu_fd_sc_mcu7t5v0__dffq_1
X_05650_ _09568_/Q _05660_/A2 _05773_/C2 vdd vdd vss vss gf180mcu_fd_sc_mcu7t5v0__nor2_1
X_05581_ _09666_/Q _05628_/A2 _05628_/B1 _09729_/Q _05582_/A2 vdd vdd
+ vss vss gf180mcu_fd_sc_mcu7t5v0__aoi22_1
X_07320_ _07662_/A1 _09656_/Q _07331_/A2 vdd vdd vss vss gf180mcu_fd_sc_mcu7t5v0__nor2_1
X_07251_ _07251_/A1 _07251_/A2 _08670_/B _09632_/D vdd vdd vss vss
+ gf180mcu_fd_sc_mcu7t5v0__aoi21_1
X_06202_ _09715_/Q _06178_/Z _06204_/A2 vdd vdd vss vss gf180mcu_fd_sc_mcu7t5v0__nand2_1
X_07182_ _09715_/Q _07180_/Z _07184_/B vdd vdd vss vss gf180mcu_fd_sc_mcu7t5v0__xor2_1
X_06133_ _06092_/Z _06124_/Z _06130_/Z _06137_/A3 vdd vdd vss vss
+ gf180mcu_fd_sc_mcu7t5v0__xnor3_1
X_06064_ _08715_/A1 _06101_/A3 _06064_/A3 _06065_/B vdd vdd vss vss
+ gf180mcu_fd_sc_mcu7t5v0__xor3_1
X_05015_ _09864_/Q _09019_/B2 vdd vdd vss vss gf180mcu_fd_sc_mcu7t5v0__clkinv_1
X_09823_ _09823_/D clk _09823_/Q vdd vdd vss vss gf180mcu_fd_sc_mcu7t5v0__dffq_1
XTAP_284 vdd vss gf180mcu_fd_sc_mcu7t5v0__filltie
XTAP_273 vdd vss gf180mcu_fd_sc_mcu7t5v0__filltie
XTAP_295 vdd vss gf180mcu_fd_sc_mcu7t5v0__filltie
X_09754_ _09754_/D clk _09754_/Q vdd vdd vss vss gf180mcu_fd_sc_mcu7t5v0__dffq_1
X_06966_ _10001_/Q _09104_/A2 _09072_/B _06967_/B vdd vdd vss vss
+ gf180mcu_fd_sc_mcu7t5v0__oai21_1
X_09685_ _09685_/D clk _09685_/Q vdd vdd vss vss gf180mcu_fd_sc_mcu7t5v0__dffq_2
X_06897_ _06897_/A1 _06896_/Z _06899_/A2 vdd vdd vss vss gf180mcu_fd_sc_mcu7t5v0__xnor2_1
X_08705_ _08432_/B _08704_/Z _08705_/B _08705_/C _08706_/A2 vdd vdd vss
+ vss gf180mcu_fd_sc_mcu7t5v0__aoi211_1
X_05917_ _05918_/A1 _05916_/Z _05936_/B vdd vdd vss vss gf180mcu_fd_sc_mcu7t5v0__nor2_1
X_05848_ _05794_/Z _05846_/Z _05883_/A2 vdd vdd vss vss gf180mcu_fd_sc_mcu7t5v0__nor2_1
X_08636_ _08636_/I _08667_/B1 vdd vdd vss vss gf180mcu_fd_sc_mcu7t5v0__inv_1
XTAP_1406 vdd vss gf180mcu_fd_sc_mcu7t5v0__filltie
XTAP_1417 vdd vss gf180mcu_fd_sc_mcu7t5v0__filltie
XTAP_1439 vdd vss gf180mcu_fd_sc_mcu7t5v0__filltie
XTAP_1428 vdd vss gf180mcu_fd_sc_mcu7t5v0__filltie
X_05779_ _05759_/Z _05808_/A2 _05809_/A1 vdd vdd vss vss gf180mcu_fd_sc_mcu7t5v0__nor2_1
X_08567_ _08670_/B _08567_/A2 _09706_/D vdd vdd vss vss gf180mcu_fd_sc_mcu7t5v0__nor2_1
X_08498_ _08502_/A2 _08535_/A1 _08498_/Z vdd vdd vss vss gf180mcu_fd_sc_mcu7t5v0__or2_1
X_07518_ _09715_/Q _07317_/Z _07519_/I vdd vdd vss vss gf180mcu_fd_sc_mcu7t5v0__nand2_1
X_07449_ _07449_/A1 _07449_/A2 _07449_/B _07503_/A2 vdd vdd vss vss
+ gf180mcu_fd_sc_mcu7t5v0__aoi21_2
X_09119_ _09462_/Q _09121_/B2 _09136_/A2 vdd vdd vss vss gf180mcu_fd_sc_mcu7t5v0__nor2_4
XTAP_1940 vdd vss gf180mcu_fd_sc_mcu7t5v0__filltie
XTAP_1951 vdd vss gf180mcu_fd_sc_mcu7t5v0__filltie
XTAP_1995 vdd vss gf180mcu_fd_sc_mcu7t5v0__filltie
XTAP_1984 vdd vss gf180mcu_fd_sc_mcu7t5v0__filltie
XTAP_1973 vdd vss gf180mcu_fd_sc_mcu7t5v0__filltie
XTAP_1962 vdd vss gf180mcu_fd_sc_mcu7t5v0__filltie
X_06820_ _09714_/Q _06792_/Z _06822_/A2 vdd vdd vss vss gf180mcu_fd_sc_mcu7t5v0__nand2_1
X_06751_ _09561_/Q _09629_/Q _09671_/Q _09878_/Q _09625_/Q _09624_/Q _06752_/I vdd
+ vdd vss vss gf180mcu_fd_sc_mcu7t5v0__mux4_4
X_06682_ _09876_/Q _09625_/Q _09624_/Q _06684_/B vdd vdd vss vss gf180mcu_fd_sc_mcu7t5v0__nand3_2
X_05702_ _08706_/B _05702_/A2 _05702_/B _09559_/D vdd vdd vss vss
+ gf180mcu_fd_sc_mcu7t5v0__aoi21_1
X_09470_ _09470_/D clk _09470_/Q vdd vdd vss vss gf180mcu_fd_sc_mcu7t5v0__dffq_1
X_08421_ _08291_/B _08685_/A2 _08466_/A1 vdd vdd vss vss gf180mcu_fd_sc_mcu7t5v0__nand2_1
X_05633_ _05633_/A1 _05633_/A2 _05633_/A3 _05634_/A2 vdd vdd vss vss
+ gf180mcu_fd_sc_mcu7t5v0__nand3_1
X_05564_ _09799_/Q _05628_/A2 _05628_/B1 _09905_/Q _05565_/A2 vdd vdd
+ vss vss gf180mcu_fd_sc_mcu7t5v0__aoi22_1
X_08352_ _08352_/A1 _08352_/A2 _08352_/B _08357_/A1 vdd vdd vss vss
+ gf180mcu_fd_sc_mcu7t5v0__oai21_1
X_05495_ _05495_/A1 _05495_/A2 _05516_/A2 vdd vdd vss vss gf180mcu_fd_sc_mcu7t5v0__nand2_1
X_08283_ _09714_/Q _08283_/A2 _08283_/A3 _08341_/B2 vdd vdd vss vss
+ gf180mcu_fd_sc_mcu7t5v0__nand3_1
X_07303_ _09002_/A1 _08736_/A2 _07312_/A2 vdd vdd vss vss gf180mcu_fd_sc_mcu7t5v0__nand2_4
X_07234_ _09632_/Q _07232_/Z _07234_/Z vdd vdd vss vss gf180mcu_fd_sc_mcu7t5v0__or2_1
X_07165_ _07152_/Z _07165_/A2 _07166_/I vdd vdd vss vss gf180mcu_fd_sc_mcu7t5v0__nand2_1
X_07096_ _08670_/B _07096_/A2 _09629_/D vdd vdd vss vss gf180mcu_fd_sc_mcu7t5v0__nor2_1
X_06116_ _06072_/C _06100_/Z _06116_/B _06117_/A2 vdd vdd vss vss
+ gf180mcu_fd_sc_mcu7t5v0__oai21_1
X_06047_ _08430_/B _06016_/I _06048_/B _06047_/Z vdd vdd vss vss gf180mcu_fd_sc_mcu7t5v0__or3_1
X_07998_ _07998_/A1 _07998_/A2 _07997_/Z _07998_/Z vdd vdd vss vss
+ gf180mcu_fd_sc_mcu7t5v0__xor3_1
X_09806_ _09806_/D clk _09806_/Q vdd vdd vss vss gf180mcu_fd_sc_mcu7t5v0__dffq_1
X_09737_ _09737_/D clk _09737_/Q vdd vdd vss vss gf180mcu_fd_sc_mcu7t5v0__dffq_1
X_06949_ _09717_/Q _06931_/Z _06949_/Z vdd vdd vss vss gf180mcu_fd_sc_mcu7t5v0__or2_1
X_09668_ _09668_/D clk _09668_/Q vdd vdd vss vss gf180mcu_fd_sc_mcu7t5v0__dffq_1
XTAP_1203 vdd vss gf180mcu_fd_sc_mcu7t5v0__filltie
XTAP_1214 vdd vss gf180mcu_fd_sc_mcu7t5v0__filltie
X_09599_ _09599_/D clk _09599_/Q vdd vdd vss vss gf180mcu_fd_sc_mcu7t5v0__dffq_1
X_08619_ _08534_/Z _08584_/Z _08643_/A1 _08586_/Z _08574_/Z _08618_/B _08645_/A1 vdd
+ vdd vss vss gf180mcu_fd_sc_mcu7t5v0__oai33_2
XTAP_1225 vdd vss gf180mcu_fd_sc_mcu7t5v0__filltie
XTAP_1236 vdd vss gf180mcu_fd_sc_mcu7t5v0__filltie
XTAP_1247 vdd vss gf180mcu_fd_sc_mcu7t5v0__filltie
XTAP_1258 vdd vss gf180mcu_fd_sc_mcu7t5v0__filltie
XTAP_1269 vdd vss gf180mcu_fd_sc_mcu7t5v0__filltie
XTAP_1770 vdd vss gf180mcu_fd_sc_mcu7t5v0__filltie
XTAP_1792 vdd vss gf180mcu_fd_sc_mcu7t5v0__filltie
XTAP_1781 vdd vss gf180mcu_fd_sc_mcu7t5v0__filltie
X_05280_ _09403_/A1 _05286_/A2 _05286_/B1 _05280_/B2 _09435_/D vdd vdd
+ vss vss gf180mcu_fd_sc_mcu7t5v0__oai22_1
X_08970_ _09826_/Q _08970_/A2 _08970_/Z vdd vdd vss vss gf180mcu_fd_sc_mcu7t5v0__xor2_1
X_07921_ _07813_/B _07921_/A2 _07921_/B _08706_/B _07922_/A2 vdd vdd vss
+ vss gf180mcu_fd_sc_mcu7t5v0__oai211_1
X_07852_ _07909_/A1 _07852_/A2 _07852_/Z vdd vdd vss vss gf180mcu_fd_sc_mcu7t5v0__xor2_1
X_06803_ _06803_/A1 _06803_/A2 _06803_/Z vdd vdd vss vss gf180mcu_fd_sc_mcu7t5v0__xor2_1
X_07783_ _09711_/Q _07745_/Z _07934_/A3 _07792_/A1 vdd vdd vss vss
+ gf180mcu_fd_sc_mcu7t5v0__nand3_2
X_04995_ _09502_/Q _05346_/B2 vdd vdd vss vss gf180mcu_fd_sc_mcu7t5v0__clkinv_1
X_09522_ _09522_/D clk _09522_/Q vdd vdd vss vss gf180mcu_fd_sc_mcu7t5v0__dffq_2
X_06734_ _09712_/Q _06719_/I _06735_/I vdd vdd vss vss gf180mcu_fd_sc_mcu7t5v0__nand2_1
X_09453_ _09453_/D clk _09453_/Q vdd vdd vss vss gf180mcu_fd_sc_mcu7t5v0__dffq_1
X_06665_ _09710_/Q _06967_/A1 _06672_/B _06676_/C vdd vdd vss vss
+ gf180mcu_fd_sc_mcu7t5v0__oai21_1
X_05616_ _09549_/Q _05628_/A2 _05628_/B1 _09866_/Q _05617_/A2 vdd vdd
+ vss vss gf180mcu_fd_sc_mcu7t5v0__aoi22_1
X_08404_ _08727_/A1 _08404_/A2 _08656_/A1 vdd vdd vss vss gf180mcu_fd_sc_mcu7t5v0__nor2_2
X_09384_ _09395_/A1 _09378_/Z _09384_/B _09399_/C _10011_/D vdd vdd vss
+ vss gf180mcu_fd_sc_mcu7t5v0__aoi211_1
X_06596_ _06596_/A1 _06596_/A2 _06596_/B _06620_/A2 vdd vdd vss vss
+ gf180mcu_fd_sc_mcu7t5v0__oai21_1
X_08335_ _09712_/Q _08335_/A2 _08336_/I1 vdd vdd vss vss gf180mcu_fd_sc_mcu7t5v0__nand2_1
X_05547_ _08791_/B _05547_/A2 _09554_/D vdd vdd vss vss gf180mcu_fd_sc_mcu7t5v0__and2_1
X_05478_ _05478_/A1 _05478_/A2 _05487_/B1 vdd vdd vss vss gf180mcu_fd_sc_mcu7t5v0__nand2_1
X_08266_ _08351_/A1 _08252_/Z _08266_/B1 _08266_/B2 _08261_/Z _08069_/B _08267_/A2
+ vdd vdd vss vss gf180mcu_fd_sc_mcu7t5v0__aoi222_2
X_08197_ _08224_/A1 _08223_/A1 _08194_/Z _08200_/B vdd vdd vss vss
+ gf180mcu_fd_sc_mcu7t5v0__xnor3_1
X_07217_ _08291_/B _07282_/A2 _07220_/B vdd vdd vss vss gf180mcu_fd_sc_mcu7t5v0__nor2_1
X_07148_ _09714_/Q _07000_/Z _07152_/A2 vdd vdd vss vss gf180mcu_fd_sc_mcu7t5v0__nand2_1
X_07079_ _07044_/Z _07079_/A2 _07079_/B _07086_/A1 vdd vdd vss vss
+ gf180mcu_fd_sc_mcu7t5v0__oai21_1
XTAP_1011 vdd vss gf180mcu_fd_sc_mcu7t5v0__filltie
XTAP_1000 vdd vss gf180mcu_fd_sc_mcu7t5v0__filltie
XTAP_1022 vdd vss gf180mcu_fd_sc_mcu7t5v0__filltie
XTAP_1033 vdd vss gf180mcu_fd_sc_mcu7t5v0__filltie
XTAP_1044 vdd vss gf180mcu_fd_sc_mcu7t5v0__filltie
XTAP_1055 vdd vss gf180mcu_fd_sc_mcu7t5v0__filltie
XTAP_1077 vdd vss gf180mcu_fd_sc_mcu7t5v0__filltie
XTAP_1066 vdd vss gf180mcu_fd_sc_mcu7t5v0__filltie
XTAP_1088 vdd vss gf180mcu_fd_sc_mcu7t5v0__filltie
XTAP_1099 vdd vss gf180mcu_fd_sc_mcu7t5v0__filltie
XTAP_817 vdd vss gf180mcu_fd_sc_mcu7t5v0__filltie
XTAP_806 vdd vss gf180mcu_fd_sc_mcu7t5v0__filltie
XTAP_828 vdd vss gf180mcu_fd_sc_mcu7t5v0__filltie
XTAP_839 vdd vss gf180mcu_fd_sc_mcu7t5v0__filltie
X_04780_ _09678_/Q _08022_/A1 vdd vdd vss vss gf180mcu_fd_sc_mcu7t5v0__clkinv_3
X_06450_ _09713_/Q _06629_/A2 _06447_/Z _06628_/A1 _06450_/C _06451_/A2 vdd
+ vdd vss vss gf180mcu_fd_sc_mcu7t5v0__aoi221_1
X_05401_ _09514_/Q _05628_/A2 _05628_/B1 _09474_/Q _05402_/A2 vdd vdd
+ vss vss gf180mcu_fd_sc_mcu7t5v0__aoi22_1
X_06381_ _06351_/Z _06380_/Z _06381_/Z vdd vdd vss vss gf180mcu_fd_sc_mcu7t5v0__xor2_1
X_08120_ _08351_/A1 _08102_/Z _08114_/Z _08069_/B _08120_/C _08121_/A2 vdd vdd
+ vss vss gf180mcu_fd_sc_mcu7t5v0__aoi221_2
X_05332_ _09402_/A1 _05339_/A2 _05339_/B1 _05332_/B2 _09490_/D vdd vdd
+ vss vss gf180mcu_fd_sc_mcu7t5v0__oai22_1
X_08051_ _09681_/Q _08046_/B _08053_/A2 vdd vdd vss vss gf180mcu_fd_sc_mcu7t5v0__nor2_1
X_05263_ _05216_/I _05218_/I _05628_/B1 vdd vdd vss vss gf180mcu_fd_sc_mcu7t5v0__nor2_4
X_07002_ _09634_/Q _07002_/A2 _07178_/B vdd vdd vss vss gf180mcu_fd_sc_mcu7t5v0__nand2_1
X_05194_ _09259_/B _09463_/Q _09471_/D vdd vdd vss vss gf180mcu_fd_sc_mcu7t5v0__and2_1
X_08953_ _09820_/Q _08949_/Z _08968_/B _08954_/A2 vdd vdd vss vss
+ gf180mcu_fd_sc_mcu7t5v0__oai21_1
X_07904_ _09673_/Q _07902_/Z _07924_/B vdd vdd vss vss gf180mcu_fd_sc_mcu7t5v0__nand2_1
X_08884_ _09790_/Q _09523_/Q _08884_/B _08886_/A2 vdd vdd vss vss
+ gf180mcu_fd_sc_mcu7t5v0__aoi21_1
X_07835_ _07877_/A1 _07835_/A2 _07835_/A3 _07835_/Z vdd vdd vss vss
+ gf180mcu_fd_sc_mcu7t5v0__xor3_1
X_07766_ _07766_/A1 _07765_/B _07766_/Z vdd vdd vss vss gf180mcu_fd_sc_mcu7t5v0__xor2_1
X_04978_ _09738_/Q _08751_/B2 vdd vdd vss vss gf180mcu_fd_sc_mcu7t5v0__clkinv_1
X_09505_ _09505_/D clk _09505_/Q vdd vdd vss vss gf180mcu_fd_sc_mcu7t5v0__dffq_1
X_06717_ _06696_/S _06786_/A2 _06760_/A1 vdd vdd vss vss gf180mcu_fd_sc_mcu7t5v0__xnor2_1
X_07697_ _07698_/B _07697_/A2 _08012_/A2 _09710_/Q _07702_/A1 vdd vdd
+ vss vss gf180mcu_fd_sc_mcu7t5v0__aoi22_1
XPHY_105 vdd vss gf180mcu_fd_sc_mcu7t5v0__endcap
XPHY_116 vdd vss gf180mcu_fd_sc_mcu7t5v0__endcap
X_09436_ _09436_/D clk _09436_/Q vdd vdd vss vss gf180mcu_fd_sc_mcu7t5v0__dffq_1
X_06648_ _09405_/A1 _06652_/A2 _06652_/B1 _06648_/B2 _09608_/D vdd vdd
+ vss vss gf180mcu_fd_sc_mcu7t5v0__oai22_1
XPHY_127 vdd vss gf180mcu_fd_sc_mcu7t5v0__endcap
XPHY_138 vdd vss gf180mcu_fd_sc_mcu7t5v0__endcap
XPHY_149 vdd vss gf180mcu_fd_sc_mcu7t5v0__endcap
X_06579_ _06579_/A1 _06596_/A1 _06576_/Z _06579_/Z vdd vdd vss vss
+ gf180mcu_fd_sc_mcu7t5v0__xor3_1
X_09367_ _05108_/Z _09367_/A2 _09377_/A2 vdd vdd vss vss gf180mcu_fd_sc_mcu7t5v0__nor2_4
X_08318_ _09716_/Q _08354_/A2 _08320_/A2 vdd vdd vss vss gf180mcu_fd_sc_mcu7t5v0__nand2_1
X_09298_ _09399_/A1 _09298_/A2 _09298_/B _09399_/C _09973_/D vdd vdd vss
+ vss gf180mcu_fd_sc_mcu7t5v0__aoi211_1
X_08249_ _08250_/A1 _08248_/Z _08306_/A1 vdd vdd vss vss gf180mcu_fd_sc_mcu7t5v0__nor2_1
XPHY_7 vdd vss gf180mcu_fd_sc_mcu7t5v0__endcap
XTAP_625 vdd vss gf180mcu_fd_sc_mcu7t5v0__filltie
XTAP_614 vdd vss gf180mcu_fd_sc_mcu7t5v0__filltie
XTAP_603 vdd vss gf180mcu_fd_sc_mcu7t5v0__filltie
XTAP_658 vdd vss gf180mcu_fd_sc_mcu7t5v0__filltie
XTAP_636 vdd vss gf180mcu_fd_sc_mcu7t5v0__filltie
XTAP_647 vdd vss gf180mcu_fd_sc_mcu7t5v0__filltie
XTAP_669 vdd vss gf180mcu_fd_sc_mcu7t5v0__filltie
X_05950_ _05950_/A1 _05950_/A2 _05902_/Z _05900_/Z _05951_/A3 vdd vdd
+ vss vss gf180mcu_fd_sc_mcu7t5v0__aoi22_1
X_05881_ _05915_/A1 _05915_/A2 _05916_/A1 vdd vdd vss vss gf180mcu_fd_sc_mcu7t5v0__nand2_1
X_04901_ _09483_/Q _05323_/B2 vdd vdd vss vss gf180mcu_fd_sc_mcu7t5v0__clkinv_1
X_04832_ _09577_/Q _06548_/A3 vdd vdd vss vss gf180mcu_fd_sc_mcu7t5v0__inv_1
X_07620_ _07620_/A1 _07620_/A2 _07639_/A2 vdd vdd vss vss gf180mcu_fd_sc_mcu7t5v0__nand2_1
X_07551_ _08721_/A1 _07551_/A2 _07552_/B vdd vdd vss vss gf180mcu_fd_sc_mcu7t5v0__xor2_1
X_04763_ _09710_/Q _08291_/B vdd vdd vss vss gf180mcu_fd_sc_mcu7t5v0__inv_12
X_06502_ _09652_/Q _06605_/A2 _06605_/B1 _09888_/Q _06503_/A2 vdd vdd
+ vss vss gf180mcu_fd_sc_mcu7t5v0__aoi22_2
X_07482_ _07521_/A1 _07570_/A1 _07482_/A3 _07482_/Z vdd vdd vss vss
+ gf180mcu_fd_sc_mcu7t5v0__xor3_1
X_06433_ _06421_/I _06432_/Z _06433_/Z vdd vdd vss vss gf180mcu_fd_sc_mcu7t5v0__xor2_1
X_09221_ _09176_/B _09254_/A2 _09221_/B _09939_/D vdd vdd vss vss
+ gf180mcu_fd_sc_mcu7t5v0__aoi21_1
X_06364_ _08430_/B _06363_/Z _06406_/A1 vdd vdd vss vss gf180mcu_fd_sc_mcu7t5v0__nor2_1
X_09152_ _09954_/Q _09461_/Q _09153_/A2 vdd vdd vss vss gf180mcu_fd_sc_mcu7t5v0__nand2_1
X_08103_ _09683_/Q _08102_/Z _08125_/A1 vdd vdd vss vss gf180mcu_fd_sc_mcu7t5v0__nand2_1
X_05315_ _09407_/A1 _05317_/A2 _05317_/B1 _05315_/B2 _09479_/D vdd vdd
+ vss vss gf180mcu_fd_sc_mcu7t5v0__oai22_1
X_06295_ _06295_/A1 _06294_/Z _06295_/Z vdd vdd vss vss gf180mcu_fd_sc_mcu7t5v0__xor2_1
X_09083_ _09965_/Q _09095_/A2 _09084_/C vdd vdd vss vss gf180mcu_fd_sc_mcu7t5v0__and2_1
X_05246_ _05246_/A1 _05246_/A2 _09409_/A1 _05246_/B2 _09417_/D vdd vdd
+ vss vss gf180mcu_fd_sc_mcu7t5v0__oai22_1
X_08034_ _09691_/Q _08369_/A1 _08367_/A1 _08358_/I1 vdd vdd vss vss
+ gf180mcu_fd_sc_mcu7t5v0__nand3_1
X_05177_ _09934_/Q _09933_/Q _09932_/Q _09931_/Q _05180_/A3 vdd vdd vss
+ vss gf180mcu_fd_sc_mcu7t5v0__nor4_2
X_09985_ _09985_/D clk _09985_/Q vdd vdd vss vss gf180mcu_fd_sc_mcu7t5v0__dffq_1
X_08936_ _08927_/I _08936_/A2 _08935_/Z _09814_/D vdd vdd vss vss
+ gf180mcu_fd_sc_mcu7t5v0__nor3_1
X_08867_ _09391_/A1 _09523_/Q _08868_/B vdd vdd vss vss gf180mcu_fd_sc_mcu7t5v0__nor2_1
X_07818_ _07818_/A1 _07818_/A2 _08670_/B _09671_/D vdd vdd vss vss
+ gf180mcu_fd_sc_mcu7t5v0__aoi21_1
X_08798_ _08798_/A1 _08851_/A1 _08798_/B _09761_/D vdd vdd vss vss
+ gf180mcu_fd_sc_mcu7t5v0__aoi21_1
X_07749_ _07745_/Z _07934_/A3 _07749_/Z vdd vdd vss vss gf180mcu_fd_sc_mcu7t5v0__and2_2
X_09419_ _09419_/D clk _09419_/Q vdd vdd vss vss gf180mcu_fd_sc_mcu7t5v0__dffq_1
X_06080_ _07452_/C _06016_/I _06124_/A1 vdd vdd vss vss gf180mcu_fd_sc_mcu7t5v0__nor2_1
X_05100_ _09591_/Q _06323_/B2 vdd vdd vss vss gf180mcu_fd_sc_mcu7t5v0__clkinv_1
X_05031_ _09728_/Q _08743_/B2 vdd vdd vss vss gf180mcu_fd_sc_mcu7t5v0__clkinv_1
XTAP_400 vdd vss gf180mcu_fd_sc_mcu7t5v0__filltie
XTAP_411 vdd vss gf180mcu_fd_sc_mcu7t5v0__filltie
XTAP_422 vdd vss gf180mcu_fd_sc_mcu7t5v0__filltie
XTAP_433 vdd vss gf180mcu_fd_sc_mcu7t5v0__filltie
XTAP_444 vdd vss gf180mcu_fd_sc_mcu7t5v0__filltie
XTAP_455 vdd vss gf180mcu_fd_sc_mcu7t5v0__filltie
XTAP_466 vdd vss gf180mcu_fd_sc_mcu7t5v0__filltie
X_06982_ _09635_/Q _09634_/Q _06994_/A2 vdd vdd vss vss gf180mcu_fd_sc_mcu7t5v0__nand2_1
X_09770_ _09770_/D clk _09770_/Q vdd vdd vss vss gf180mcu_fd_sc_mcu7t5v0__dffq_1
XTAP_477 vdd vss gf180mcu_fd_sc_mcu7t5v0__filltie
XTAP_488 vdd vss gf180mcu_fd_sc_mcu7t5v0__filltie
XTAP_499 vdd vss gf180mcu_fd_sc_mcu7t5v0__filltie
X_08721_ _08721_/A1 _09073_/A2 _08721_/B _09715_/D vdd vdd vss vss
+ gf180mcu_fd_sc_mcu7t5v0__aoi21_1
X_05933_ _05966_/A1 _05916_/Z _05927_/Z _05769_/B _05933_/C _05934_/A2 vdd vdd
+ vss vss gf180mcu_fd_sc_mcu7t5v0__oai221_2
X_08652_ _09708_/Q _08650_/Z _08654_/B vdd vdd vss vss gf180mcu_fd_sc_mcu7t5v0__xor2_1
X_07603_ _07644_/A2 _07645_/A1 _07603_/Z vdd vdd vss vss gf180mcu_fd_sc_mcu7t5v0__xor2_1
X_05864_ _05922_/B _05922_/A1 _05865_/A2 vdd vdd vss vss gf180mcu_fd_sc_mcu7t5v0__nand2_1
X_05795_ _05795_/A1 _05795_/A2 _05795_/A3 _05798_/A2 vdd vdd vss vss
+ gf180mcu_fd_sc_mcu7t5v0__xnor3_1
X_08583_ _09715_/Q _08685_/A2 _08586_/A3 vdd vdd vss vss gf180mcu_fd_sc_mcu7t5v0__nand2_1
X_04815_ _09619_/Q _05892_/A1 vdd vdd vss vss gf180mcu_fd_sc_mcu7t5v0__clkinv_1
X_04746_ _09755_/Q _08786_/A1 vdd vdd vss vss gf180mcu_fd_sc_mcu7t5v0__clkinv_1
X_07534_ _07534_/A1 _07634_/A2 _07538_/A3 vdd vdd vss vss gf180mcu_fd_sc_mcu7t5v0__xnor2_1
X_07465_ _07506_/B _07465_/A2 _07517_/A1 vdd vdd vss vss gf180mcu_fd_sc_mcu7t5v0__nor2_1
X_06416_ _09595_/Q _08565_/C _06455_/A1 vdd vdd vss vss gf180mcu_fd_sc_mcu7t5v0__nand2_1
X_09204_ _09556_/Q _09209_/A2 _09204_/B1 _09209_/B2 _09258_/A2 vdd vdd
+ vss vss gf180mcu_fd_sc_mcu7t5v0__aoi22_4
X_07396_ _07394_/Z _07414_/A2 _07396_/B _07411_/A1 vdd vdd vss vss
+ gf180mcu_fd_sc_mcu7t5v0__aoi21_1
X_06347_ _06347_/A1 _06347_/A2 _06350_/B vdd vdd vss vss gf180mcu_fd_sc_mcu7t5v0__nand2_1
X_09135_ _09942_/Q _09135_/A2 _09136_/B1 vdd vdd vss vss gf180mcu_fd_sc_mcu7t5v0__nor2_1
X_06278_ _09714_/Q _06085_/Z _06279_/A2 vdd vdd vss vss gf180mcu_fd_sc_mcu7t5v0__nand2_1
X_09066_ _09554_/Q _09104_/A2 _09072_/B _09067_/B vdd vdd vss vss
+ gf180mcu_fd_sc_mcu7t5v0__oai21_1
X_08017_ _09984_/Q _09104_/A2 _09089_/B _08018_/B vdd vdd vss vss
+ gf180mcu_fd_sc_mcu7t5v0__oai21_1
X_05229_ _09395_/A1 _05217_/S _05230_/B vdd vdd vss vss gf180mcu_fd_sc_mcu7t5v0__nor2_1
X_09968_ _09968_/D clk _09968_/Q vdd vdd vss vss gf180mcu_fd_sc_mcu7t5v0__dffq_1
X_08919_ _09403_/A1 _08925_/A2 _08925_/B1 _08919_/B2 _09804_/D vdd vdd
+ vss vss gf180mcu_fd_sc_mcu7t5v0__oai22_1
X_09899_ _09899_/D clk _09899_/Q vdd vdd vss vss gf180mcu_fd_sc_mcu7t5v0__dffq_4
X_10039_ _10039_/ZN vdd vdd vss vss gf180mcu_fd_sc_mcu7t5v0__tiel
X_05580_ _09645_/Q _05627_/A2 _05627_/B1 _09700_/Q _05582_/A1 vdd vdd
+ vss vss gf180mcu_fd_sc_mcu7t5v0__aoi22_1
X_07250_ _07289_/B _07235_/Z _07250_/B _08706_/B _07251_/A2 vdd vdd vss
+ vss gf180mcu_fd_sc_mcu7t5v0__oai211_1
X_06201_ _06296_/A1 _06199_/Z _06255_/A2 _06206_/A3 vdd vdd vss vss
+ gf180mcu_fd_sc_mcu7t5v0__nand3_1
X_07181_ _09715_/Q _07180_/Z _07237_/A1 vdd vdd vss vss gf180mcu_fd_sc_mcu7t5v0__nand2_1
X_06132_ _06124_/Z _06130_/Z _06162_/B vdd vdd vss vss gf180mcu_fd_sc_mcu7t5v0__xor2_1
X_06063_ _08715_/A1 _06062_/Z _06107_/A1 vdd vdd vss vss gf180mcu_fd_sc_mcu7t5v0__nor2_1
X_05014_ _09840_/Q _08989_/B2 vdd vdd vss vss gf180mcu_fd_sc_mcu7t5v0__clkinv_1
X_09822_ _09822_/D clk _09822_/Q vdd vdd vss vss gf180mcu_fd_sc_mcu7t5v0__dffq_1
XTAP_274 vdd vss gf180mcu_fd_sc_mcu7t5v0__filltie
X_09753_ _09753_/D clk _09753_/Q vdd vdd vss vss gf180mcu_fd_sc_mcu7t5v0__dffq_1
XTAP_285 vdd vss gf180mcu_fd_sc_mcu7t5v0__filltie
XTAP_296 vdd vss gf180mcu_fd_sc_mcu7t5v0__filltie
X_08704_ _08704_/A1 _08704_/A2 _08704_/A3 _08704_/Z vdd vdd vss vss
+ gf180mcu_fd_sc_mcu7t5v0__xor3_1
X_06965_ _06965_/A1 _09104_/A2 _06965_/B _09622_/D vdd vdd vss vss
+ gf180mcu_fd_sc_mcu7t5v0__aoi21_1
X_05916_ _05916_/A1 _05915_/B _05916_/Z vdd vdd vss vss gf180mcu_fd_sc_mcu7t5v0__xor2_2
X_09684_ _09684_/D clk _09684_/Q vdd vdd vss vss gf180mcu_fd_sc_mcu7t5v0__dffq_2
X_06896_ _06889_/Z _06896_/A2 _06896_/Z vdd vdd vss vss gf180mcu_fd_sc_mcu7t5v0__xor2_1
X_05847_ _05794_/Z _05846_/Z _05883_/B vdd vdd vss vss gf180mcu_fd_sc_mcu7t5v0__nand2_1
X_08635_ _09716_/Q _08703_/A1 _08636_/I vdd vdd vss vss gf180mcu_fd_sc_mcu7t5v0__nand2_1
X_08566_ _09706_/Q _08565_/C _08566_/B _08567_/A2 vdd vdd vss vss
+ gf180mcu_fd_sc_mcu7t5v0__aoi21_1
XTAP_1407 vdd vss gf180mcu_fd_sc_mcu7t5v0__filltie
XTAP_1418 vdd vss gf180mcu_fd_sc_mcu7t5v0__filltie
XTAP_1429 vdd vss gf180mcu_fd_sc_mcu7t5v0__filltie
X_05778_ _08670_/B _05778_/A2 _09561_/D vdd vdd vss vss gf180mcu_fd_sc_mcu7t5v0__nor2_1
X_07517_ _07517_/A1 _07517_/A2 _07517_/B _07566_/B2 vdd vdd vss vss
+ gf180mcu_fd_sc_mcu7t5v0__aoi21_2
X_08497_ _07452_/C _08715_/A1 _08631_/A2 _08429_/B _08502_/B1 vdd vdd
+ vss vss gf180mcu_fd_sc_mcu7t5v0__nor4_2
X_04729_ _09885_/Q _09063_/A1 vdd vdd vss vss gf180mcu_fd_sc_mcu7t5v0__clkinv_1
X_07448_ _07449_/A1 _07449_/A2 _07449_/B _07458_/A1 vdd vdd vss vss
+ gf180mcu_fd_sc_mcu7t5v0__nand3_1
X_07379_ _07388_/A1 _07417_/A3 _07464_/A1 vdd vdd vss vss gf180mcu_fd_sc_mcu7t5v0__nor2_4
X_09118_ _09135_/A2 _09136_/B2 _09121_/B2 vdd vdd vss vss gf180mcu_fd_sc_mcu7t5v0__nand2_2
X_09049_ _09555_/Q _09033_/I _09051_/A1 vdd vdd vss vss gf180mcu_fd_sc_mcu7t5v0__nand2_1
XTAP_1941 vdd vss gf180mcu_fd_sc_mcu7t5v0__filltie
XTAP_1952 vdd vss gf180mcu_fd_sc_mcu7t5v0__filltie
XTAP_1930 vdd vss gf180mcu_fd_sc_mcu7t5v0__filltie
XTAP_1985 vdd vss gf180mcu_fd_sc_mcu7t5v0__filltie
XTAP_1974 vdd vss gf180mcu_fd_sc_mcu7t5v0__filltie
XTAP_1963 vdd vss gf180mcu_fd_sc_mcu7t5v0__filltie
XTAP_1996 vdd vss gf180mcu_fd_sc_mcu7t5v0__filltie
X_06750_ _09711_/Q _06719_/I _06756_/A1 vdd vdd vss vss gf180mcu_fd_sc_mcu7t5v0__nand2_1
X_06681_ _09625_/Q _09624_/Q _09559_/Q _06747_/C vdd vdd vss vss gf180mcu_fd_sc_mcu7t5v0__or3_4
X_05701_ _09559_/Q _08706_/B _08708_/B _05702_/B vdd vdd vss vss gf180mcu_fd_sc_mcu7t5v0__oai21_1
X_05632_ _09012_/A1 _05632_/A2 _05632_/B1 _09400_/A2 _05632_/C1 _05632_/C2 _05633_/A3
+ vdd vdd vss vss gf180mcu_fd_sc_mcu7t5v0__aoi222_2
X_08420_ _08420_/I _09702_/D vdd vdd vss vss gf180mcu_fd_sc_mcu7t5v0__clkinv_1
X_08351_ _08351_/A1 _08348_/Z _08362_/C vdd vdd vss vss gf180mcu_fd_sc_mcu7t5v0__nand2_1
X_05563_ _09740_/Q _05627_/A2 _05627_/B1 _09872_/Q _05565_/A1 vdd vdd
+ vss vss gf180mcu_fd_sc_mcu7t5v0__aoi22_1
X_05494_ _09485_/Q _05628_/A2 _05628_/B1 _09501_/Q _05495_/A2 vdd vdd
+ vss vss gf180mcu_fd_sc_mcu7t5v0__aoi22_1
X_08282_ _08299_/A1 _08299_/A2 _08329_/A1 vdd vdd vss vss gf180mcu_fd_sc_mcu7t5v0__xnor2_1
X_07302_ _07302_/A1 _09073_/A2 _07302_/B _09638_/D vdd vdd vss vss
+ gf180mcu_fd_sc_mcu7t5v0__aoi21_1
X_07233_ _09632_/Q _07232_/Z _07252_/B vdd vdd vss vss gf180mcu_fd_sc_mcu7t5v0__and2_1
X_07164_ _07164_/I _07165_/A2 vdd vdd vss vss gf180mcu_fd_sc_mcu7t5v0__clkinv_1
X_06115_ _08565_/C _06115_/A2 _06116_/B vdd vdd vss vss gf180mcu_fd_sc_mcu7t5v0__nor2_1
X_07095_ _09629_/Q _08565_/C _07095_/B _07096_/A2 vdd vdd vss vss
+ gf180mcu_fd_sc_mcu7t5v0__aoi21_1
X_06046_ _06026_/S _06048_/B _06120_/A1 vdd vdd vss vss gf180mcu_fd_sc_mcu7t5v0__nor2_2
X_07997_ _07997_/A1 _07997_/A2 _07996_/Z _07997_/Z vdd vdd vss vss
+ gf180mcu_fd_sc_mcu7t5v0__xor3_1
X_09805_ _09805_/D clk _09805_/Q vdd vdd vss vss gf180mcu_fd_sc_mcu7t5v0__dffq_1
X_09736_ _09736_/D clk _09736_/Q vdd vdd vss vss gf180mcu_fd_sc_mcu7t5v0__dffq_1
X_06948_ _09716_/Q _06911_/Z _06948_/B _06954_/A1 vdd vdd vss vss
+ gf180mcu_fd_sc_mcu7t5v0__aoi21_1
X_09667_ _09667_/D clk _09667_/Q vdd vdd vss vss gf180mcu_fd_sc_mcu7t5v0__dffq_1
X_08618_ _08678_/A2 _08572_/S _08618_/B _08673_/A1 vdd vdd vss vss
+ gf180mcu_fd_sc_mcu7t5v0__aoi21_1
X_06879_ _06879_/A1 _06879_/A2 _06927_/A1 vdd vdd vss vss gf180mcu_fd_sc_mcu7t5v0__nor2_1
XTAP_1204 vdd vss gf180mcu_fd_sc_mcu7t5v0__filltie
X_09598_ _09598_/D clk _09598_/Q vdd vdd vss vss gf180mcu_fd_sc_mcu7t5v0__dffq_1
XTAP_1226 vdd vss gf180mcu_fd_sc_mcu7t5v0__filltie
XTAP_1215 vdd vss gf180mcu_fd_sc_mcu7t5v0__filltie
XTAP_1237 vdd vss gf180mcu_fd_sc_mcu7t5v0__filltie
XTAP_1248 vdd vss gf180mcu_fd_sc_mcu7t5v0__filltie
X_08549_ _08547_/Z _08597_/A2 _08565_/A2 vdd vdd vss vss gf180mcu_fd_sc_mcu7t5v0__nand2_1
XTAP_1259 vdd vss gf180mcu_fd_sc_mcu7t5v0__filltie
XTAP_1760 vdd vss gf180mcu_fd_sc_mcu7t5v0__filltie
XTAP_1793 vdd vss gf180mcu_fd_sc_mcu7t5v0__filltie
XTAP_1782 vdd vss gf180mcu_fd_sc_mcu7t5v0__filltie
XTAP_1771 vdd vss gf180mcu_fd_sc_mcu7t5v0__filltie
X_07920_ _07920_/A1 _07915_/Z _07920_/B _07920_/C _07921_/A2 vdd vdd vss
+ vss gf180mcu_fd_sc_mcu7t5v0__oai211_1
X_07851_ _07909_/B _07909_/A2 _07852_/A2 vdd vdd vss vss gf180mcu_fd_sc_mcu7t5v0__nor2_1
X_07782_ _09713_/Q _07681_/Z _07712_/Z _09712_/Q _07793_/A2 vdd vdd vss
+ vss gf180mcu_fd_sc_mcu7t5v0__aoi22_1
X_06802_ _06803_/A1 _06802_/A2 _06855_/A2 vdd vdd vss vss gf180mcu_fd_sc_mcu7t5v0__nand2_1
X_09521_ _09521_/D clk _09521_/Q vdd vdd vss vss gf180mcu_fd_sc_mcu7t5v0__dffq_1
X_04994_ _09530_/Q _05376_/B2 vdd vdd vss vss gf180mcu_fd_sc_mcu7t5v0__clkinv_1
X_06733_ _06733_/A1 _06732_/B _06740_/B1 vdd vdd vss vss gf180mcu_fd_sc_mcu7t5v0__xnor2_1
X_09452_ _09452_/D clk _09452_/Q vdd vdd vss vss gf180mcu_fd_sc_mcu7t5v0__dffq_1
X_06664_ _09623_/Q _06675_/A2 _06918_/C vdd vdd vss vss gf180mcu_fd_sc_mcu7t5v0__nor2_2
X_06595_ _06595_/A1 _06595_/A2 _08670_/B _09598_/D vdd vdd vss vss
+ gf180mcu_fd_sc_mcu7t5v0__aoi21_1
X_05615_ _09417_/Q _05627_/A2 _05627_/B1 _09850_/Q _05617_/A1 vdd vdd
+ vss vss gf180mcu_fd_sc_mcu7t5v0__aoi22_1
X_08403_ _08404_/A2 _08403_/A2 _08663_/B vdd vdd vss vss gf180mcu_fd_sc_mcu7t5v0__nand2_1
X_09383_ _10011_/Q _09378_/Z _09384_/B vdd vdd vss vss gf180mcu_fd_sc_mcu7t5v0__nor2_1
X_05546_ _05546_/A1 _05546_/A2 _05546_/A3 _05547_/A2 vdd vdd vss vss
+ gf180mcu_fd_sc_mcu7t5v0__nand3_1
X_08334_ _08334_/A1 _08334_/A2 _08334_/Z vdd vdd vss vss gf180mcu_fd_sc_mcu7t5v0__xor2_1
X_05477_ _09829_/Q _05628_/A2 _05628_/B1 _10021_/Q _05478_/A2 vdd vdd
+ vss vss gf180mcu_fd_sc_mcu7t5v0__aoi22_1
X_08265_ _08358_/I0 _08265_/A2 _08265_/B _08266_/B2 vdd vdd vss vss
+ gf180mcu_fd_sc_mcu7t5v0__oai21_1
X_08196_ _08224_/A1 _08224_/B _08196_/Z vdd vdd vss vss gf180mcu_fd_sc_mcu7t5v0__and2_1
X_07216_ _09638_/Q _09637_/Q _09577_/Q _07216_/B1 _07216_/B2 _07282_/A2 vdd
+ vdd vss vss gf180mcu_fd_sc_mcu7t5v0__oai32_2
X_07147_ _07147_/I _07197_/A1 vdd vdd vss vss gf180mcu_fd_sc_mcu7t5v0__clkinv_1
X_07078_ _09629_/Q _07098_/A1 _07075_/Z _07078_/Z vdd vdd vss vss
+ gf180mcu_fd_sc_mcu7t5v0__xor3_1
X_06029_ _09711_/Q _05987_/I _06033_/B vdd vdd vss vss gf180mcu_fd_sc_mcu7t5v0__nand2_1
X_09719_ _09719_/D clk _09719_/Q vdd vdd vss vss gf180mcu_fd_sc_mcu7t5v0__dffq_2
XTAP_1012 vdd vss gf180mcu_fd_sc_mcu7t5v0__filltie
XTAP_1001 vdd vss gf180mcu_fd_sc_mcu7t5v0__filltie
XTAP_1023 vdd vss gf180mcu_fd_sc_mcu7t5v0__filltie
XTAP_1034 vdd vss gf180mcu_fd_sc_mcu7t5v0__filltie
XTAP_1045 vdd vss gf180mcu_fd_sc_mcu7t5v0__filltie
XTAP_1056 vdd vss gf180mcu_fd_sc_mcu7t5v0__filltie
XTAP_1078 vdd vss gf180mcu_fd_sc_mcu7t5v0__filltie
XTAP_1067 vdd vss gf180mcu_fd_sc_mcu7t5v0__filltie
XTAP_1089 vdd vss gf180mcu_fd_sc_mcu7t5v0__filltie
XTAP_807 vdd vss gf180mcu_fd_sc_mcu7t5v0__filltie
XTAP_818 vdd vss gf180mcu_fd_sc_mcu7t5v0__filltie
XTAP_829 vdd vss gf180mcu_fd_sc_mcu7t5v0__filltie
X_05400_ _09526_/Q _05627_/A2 _05627_/B1 _09534_/Q _05402_/A1 vdd vdd
+ vss vss gf180mcu_fd_sc_mcu7t5v0__aoi22_1
X_06380_ _09593_/Q _06376_/Z _06380_/Z vdd vdd vss vss gf180mcu_fd_sc_mcu7t5v0__xor2_1
XTAP_1590 vdd vss gf180mcu_fd_sc_mcu7t5v0__filltie
X_05331_ _09013_/A1 _05339_/A2 _05339_/B1 vdd vdd vss vss gf180mcu_fd_sc_mcu7t5v0__nand2_2
X_08050_ _08050_/A1 _08050_/A2 _08054_/A2 vdd vdd vss vss gf180mcu_fd_sc_mcu7t5v0__nand2_1
X_05262_ _05207_/Z _05307_/A2 _05631_/B2 vdd vdd vss vss gf180mcu_fd_sc_mcu7t5v0__nor2_4
X_07001_ _09634_/Q _07002_/A2 _07001_/Z vdd vdd vss vss gf180mcu_fd_sc_mcu7t5v0__and2_1
X_05193_ _05193_/A1 _05200_/A3 _09472_/D vdd vdd vss vss gf180mcu_fd_sc_mcu7t5v0__nor2_1
X_08952_ _09820_/Q _08949_/Z _08952_/Z vdd vdd vss vss gf180mcu_fd_sc_mcu7t5v0__and2_1
X_07903_ _09673_/Q _07902_/Z _07924_/A2 vdd vdd vss vss gf180mcu_fd_sc_mcu7t5v0__nor2_1
X_08883_ _09399_/A1 _09523_/Q _08884_/B vdd vdd vss vss gf180mcu_fd_sc_mcu7t5v0__nor2_1
X_07834_ _07834_/A1 _07885_/A1 _07877_/B vdd vdd vss vss gf180mcu_fd_sc_mcu7t5v0__or2_1
X_07765_ _07718_/Z _07720_/Z _07765_/B _07808_/A2 vdd vdd vss vss
+ gf180mcu_fd_sc_mcu7t5v0__oai21_1
X_04977_ _09797_/Q _08909_/B2 vdd vdd vss vss gf180mcu_fd_sc_mcu7t5v0__clkinv_1
X_09504_ _09504_/D clk _09504_/Q vdd vdd vss vss gf180mcu_fd_sc_mcu7t5v0__dffq_1
X_07696_ _09678_/Q _07725_/A3 _07970_/C vdd vdd vss vss gf180mcu_fd_sc_mcu7t5v0__nor2_4
X_06716_ _06696_/S _06786_/A2 _06762_/A1 vdd vdd vss vss gf180mcu_fd_sc_mcu7t5v0__nor2_1
X_06647_ _09404_/A1 _06652_/A2 _06652_/B1 _06647_/B2 _09607_/D vdd vdd
+ vss vss gf180mcu_fd_sc_mcu7t5v0__oai22_1
XPHY_106 vdd vss gf180mcu_fd_sc_mcu7t5v0__endcap
X_09435_ _09435_/D clk _09435_/Q vdd vdd vss vss gf180mcu_fd_sc_mcu7t5v0__dffq_1
XPHY_117 vdd vss gf180mcu_fd_sc_mcu7t5v0__endcap
XPHY_128 vdd vss gf180mcu_fd_sc_mcu7t5v0__endcap
XPHY_139 vdd vss gf180mcu_fd_sc_mcu7t5v0__endcap
X_06578_ _09598_/Q _06576_/Z _06596_/B vdd vdd vss vss gf180mcu_fd_sc_mcu7t5v0__nand2_1
X_09366_ _09399_/A1 _09366_/A2 _09366_/B _09399_/C _10003_/D vdd vdd vss
+ vss gf180mcu_fd_sc_mcu7t5v0__aoi211_1
X_08317_ _08069_/B _08316_/Z _08322_/A3 vdd vdd vss vss gf180mcu_fd_sc_mcu7t5v0__nand2_1
X_05529_ _09446_/Q _05628_/A2 _05628_/B1 _09430_/Q _05530_/A2 vdd vdd
+ vss vss gf180mcu_fd_sc_mcu7t5v0__aoi22_1
X_09297_ _09973_/Q _09298_/A2 _09298_/B vdd vdd vss vss gf180mcu_fd_sc_mcu7t5v0__nor2_1
X_08248_ _08274_/B2 _08246_/Z _08248_/Z vdd vdd vss vss gf180mcu_fd_sc_mcu7t5v0__xor2_1
X_08179_ _08546_/A1 _09693_/Q _09692_/Q _08235_/A2 vdd vdd vss vss
+ gf180mcu_fd_sc_mcu7t5v0__aoi21_2
XPHY_8 vdd vss gf180mcu_fd_sc_mcu7t5v0__endcap
XTAP_615 vdd vss gf180mcu_fd_sc_mcu7t5v0__filltie
XTAP_604 vdd vss gf180mcu_fd_sc_mcu7t5v0__filltie
XTAP_659 vdd vss gf180mcu_fd_sc_mcu7t5v0__filltie
XTAP_637 vdd vss gf180mcu_fd_sc_mcu7t5v0__filltie
XTAP_648 vdd vss gf180mcu_fd_sc_mcu7t5v0__filltie
XTAP_626 vdd vss gf180mcu_fd_sc_mcu7t5v0__filltie
X_04900_ _09507_/Q _05353_/B2 vdd vdd vss vss gf180mcu_fd_sc_mcu7t5v0__clkinv_1
X_05880_ _05828_/Z _05880_/A2 _05880_/B _05936_/A1 vdd vdd vss vss
+ gf180mcu_fd_sc_mcu7t5v0__oai21_1
X_04831_ _09579_/Q _06305_/A1 vdd vdd vss vss gf180mcu_fd_sc_mcu7t5v0__inv_2
X_04762_ _09711_/Q _08430_/B vdd vdd vss vss gf180mcu_fd_sc_mcu7t5v0__inv_8
X_07550_ _09715_/Q _07551_/A2 _07550_/Z vdd vdd vss vss gf180mcu_fd_sc_mcu7t5v0__and2_1
X_06501_ _09604_/Q _09603_/Q _06605_/B1 vdd vdd vss vss gf180mcu_fd_sc_mcu7t5v0__nor2_2
X_09220_ _09939_/Q _09176_/B _09278_/C _09221_/B vdd vdd vss vss gf180mcu_fd_sc_mcu7t5v0__oai21_1
X_07481_ _07521_/A1 _07521_/A2 _07481_/A3 _07481_/Z vdd vdd vss vss
+ gf180mcu_fd_sc_mcu7t5v0__or3_1
X_06432_ _06432_/A1 _06432_/A2 _06432_/Z vdd vdd vss vss gf180mcu_fd_sc_mcu7t5v0__xor2_1
X_06363_ _06562_/A2 _06365_/A3 _06363_/Z vdd vdd vss vss gf180mcu_fd_sc_mcu7t5v0__xor2_1
X_09151_ _09399_/C _09151_/A2 _09919_/D vdd vdd vss vss gf180mcu_fd_sc_mcu7t5v0__nor2_1
X_08102_ _08075_/Z _08099_/Z _08102_/Z vdd vdd vss vss gf180mcu_fd_sc_mcu7t5v0__xor2_2
X_05314_ _09406_/A1 _05317_/A2 _05317_/B1 _05314_/B2 _09478_/D vdd vdd
+ vss vss gf180mcu_fd_sc_mcu7t5v0__oai22_1
X_09082_ _09098_/A1 _09082_/A2 _09082_/B _09891_/D vdd vdd vss vss
+ gf180mcu_fd_sc_mcu7t5v0__aoi21_1
X_06294_ _09717_/Q _06299_/A2 _06294_/A3 _06294_/Z vdd vdd vss vss
+ gf180mcu_fd_sc_mcu7t5v0__xor3_1
X_08033_ _09689_/Q _08040_/A2 _08319_/B2 vdd vdd vss vss gf180mcu_fd_sc_mcu7t5v0__nor2_2
X_05245_ _09924_/Q _05217_/S _05245_/B _09409_/A1 vdd vdd vss vss
+ gf180mcu_fd_sc_mcu7t5v0__oai21_4
X_05176_ _09466_/Q _09248_/A2 _05186_/A2 vdd vdd vss vss gf180mcu_fd_sc_mcu7t5v0__nand2_1
X_09984_ _09984_/D clk _09984_/Q vdd vdd vss vss gf180mcu_fd_sc_mcu7t5v0__dffq_1
X_08935_ _09814_/Q _08932_/Z _08935_/Z vdd vdd vss vss gf180mcu_fd_sc_mcu7t5v0__and2_1
X_08866_ _09522_/Q _08903_/A1 _08862_/B _08866_/B2 _08899_/A2 vdd vdd
+ vss vss gf180mcu_fd_sc_mcu7t5v0__aoi22_4
X_07817_ _07817_/A1 _07817_/A2 _07818_/A2 vdd vdd vss vss gf180mcu_fd_sc_mcu7t5v0__nand2_1
X_08797_ _09753_/Q _08851_/A1 _09257_/B _08798_/B vdd vdd vss vss
+ gf180mcu_fd_sc_mcu7t5v0__oai21_1
X_07748_ _09679_/Q _07748_/A2 _07748_/B _07934_/A3 vdd vdd vss vss
+ gf180mcu_fd_sc_mcu7t5v0__oai21_4
X_07679_ _09875_/Q _09680_/Q _07680_/B vdd vdd vss vss gf180mcu_fd_sc_mcu7t5v0__nand2_1
X_09418_ _09418_/D clk _09418_/Q vdd vdd vss vss gf180mcu_fd_sc_mcu7t5v0__dffq_1
X_09349_ _09393_/A1 _09355_/A2 _09349_/B _09399_/C _09995_/D vdd vdd vss
+ vss gf180mcu_fd_sc_mcu7t5v0__aoi211_1
X_05030_ _09495_/Q _05337_/B2 vdd vdd vss vss gf180mcu_fd_sc_mcu7t5v0__clkinv_1
XTAP_401 vdd vss gf180mcu_fd_sc_mcu7t5v0__filltie
XTAP_412 vdd vss gf180mcu_fd_sc_mcu7t5v0__filltie
XTAP_423 vdd vss gf180mcu_fd_sc_mcu7t5v0__filltie
XTAP_445 vdd vss gf180mcu_fd_sc_mcu7t5v0__filltie
XTAP_434 vdd vss gf180mcu_fd_sc_mcu7t5v0__filltie
XTAP_456 vdd vss gf180mcu_fd_sc_mcu7t5v0__filltie
XTAP_467 vdd vss gf180mcu_fd_sc_mcu7t5v0__filltie
X_06981_ _07296_/A1 _07294_/A1 _06984_/B vdd vdd vss vss gf180mcu_fd_sc_mcu7t5v0__nor2_2
XTAP_478 vdd vss gf180mcu_fd_sc_mcu7t5v0__filltie
XTAP_489 vdd vss gf180mcu_fd_sc_mcu7t5v0__filltie
X_08720_ _09880_/Q _09073_/A2 _08734_/B _08721_/B vdd vdd vss vss
+ gf180mcu_fd_sc_mcu7t5v0__oai21_1
X_05932_ _09716_/Q _05932_/A2 _05932_/B _05933_/C vdd vdd vss vss
+ gf180mcu_fd_sc_mcu7t5v0__oai21_1
X_05863_ _05863_/A1 _05816_/Z _05863_/B _05870_/A1 vdd vdd vss vss
+ gf180mcu_fd_sc_mcu7t5v0__aoi21_1
X_08651_ _09708_/Q _08650_/Z _08671_/A1 vdd vdd vss vss gf180mcu_fd_sc_mcu7t5v0__nand2_1
X_04814_ _09620_/Q _06961_/A1 vdd vdd vss vss gf180mcu_fd_sc_mcu7t5v0__clkinv_1
X_07602_ _07443_/B _07633_/B _07602_/B _07645_/A1 vdd vdd vss vss
+ gf180mcu_fd_sc_mcu7t5v0__aoi21_1
X_05794_ _09712_/Q _05711_/I _05794_/A3 _05793_/Z _05794_/Z vdd vdd
+ vss vss gf180mcu_fd_sc_mcu7t5v0__and4_1
X_08582_ _08621_/A1 _08582_/A2 _08582_/A3 _08582_/Z vdd vdd vss vss
+ gf180mcu_fd_sc_mcu7t5v0__xor3_1
X_04745_ _09748_/Q _08772_/A1 vdd vdd vss vss gf180mcu_fd_sc_mcu7t5v0__clkinv_1
X_07533_ _09710_/Q _07534_/A1 _07633_/B _07589_/A1 vdd vdd vss vss
+ gf180mcu_fd_sc_mcu7t5v0__nand3_1
X_07464_ _07464_/A1 _07464_/A2 _07464_/B _07515_/A1 vdd vdd vss vss
+ gf180mcu_fd_sc_mcu7t5v0__oai21_2
X_09203_ _09203_/I _09204_/B1 vdd vdd vss vss gf180mcu_fd_sc_mcu7t5v0__clkinv_1
X_06415_ _06415_/A1 _06415_/A2 _08670_/B _09594_/D vdd vdd vss vss
+ gf180mcu_fd_sc_mcu7t5v0__aoi21_1
X_09134_ _09399_/C _09134_/A2 _09914_/D vdd vdd vss vss gf180mcu_fd_sc_mcu7t5v0__nor2_1
X_07395_ _07395_/A1 _07373_/Z _07395_/B _07414_/A2 vdd vdd vss vss
+ gf180mcu_fd_sc_mcu7t5v0__oai21_1
X_06346_ _09710_/Q _06629_/A2 _06590_/C _06347_/A2 vdd vdd vss vss
+ gf180mcu_fd_sc_mcu7t5v0__aoi21_1
X_06277_ _06271_/Z _06277_/A2 _06276_/Z _06277_/Z vdd vdd vss vss
+ gf180mcu_fd_sc_mcu7t5v0__xor3_1
X_09065_ _09065_/A1 _09104_/A2 _09065_/B _09886_/D vdd vdd vss vss
+ gf180mcu_fd_sc_mcu7t5v0__aoi21_1
X_05228_ _05228_/A1 _05246_/A2 _09403_/A1 _05246_/B2 _09411_/D vdd vdd
+ vss vss gf180mcu_fd_sc_mcu7t5v0__oai22_1
X_08016_ _08016_/A1 _08016_/A2 _09675_/D vdd vdd vss vss gf180mcu_fd_sc_mcu7t5v0__nor2_1
X_05159_ _09764_/Q _09768_/Q _05160_/A2 vdd vdd vss vss gf180mcu_fd_sc_mcu7t5v0__nor2_1
X_09967_ _09967_/D clk _09967_/Q vdd vdd vss vss gf180mcu_fd_sc_mcu7t5v0__dffq_1
X_08918_ _09402_/A1 _08925_/A2 _08925_/B1 _08918_/B2 _09803_/D vdd vdd
+ vss vss gf180mcu_fd_sc_mcu7t5v0__oai22_1
XTAP_990 vdd vss gf180mcu_fd_sc_mcu7t5v0__filltie
X_09898_ _09898_/D clk _09898_/Q vdd vdd vss vss gf180mcu_fd_sc_mcu7t5v0__dffq_2
X_08849_ _09802_/Q _09209_/B2 _09378_/A2 _08850_/A2 vdd vdd vss vss
+ gf180mcu_fd_sc_mcu7t5v0__nand3_1
X_10038_ _10038_/ZN vdd vdd vss vss gf180mcu_fd_sc_mcu7t5v0__tiel
X_06200_ _06148_/Z _06200_/A2 _06200_/B _06255_/A2 vdd vdd vss vss
+ gf180mcu_fd_sc_mcu7t5v0__oai21_1
X_07180_ _07160_/Z _07179_/I _07180_/Z vdd vdd vss vss gf180mcu_fd_sc_mcu7t5v0__xor2_1
X_06131_ _06124_/Z _06130_/Z _06131_/Z vdd vdd vss vss gf180mcu_fd_sc_mcu7t5v0__and2_1
X_06062_ _06050_/I _06064_/A3 _06062_/Z vdd vdd vss vss gf180mcu_fd_sc_mcu7t5v0__xor2_1
X_05013_ _09832_/Q _08979_/B2 vdd vdd vss vss gf180mcu_fd_sc_mcu7t5v0__clkinv_1
X_09821_ _09821_/D clk _09821_/Q vdd vdd vss vss gf180mcu_fd_sc_mcu7t5v0__dffq_1
XTAP_275 vdd vss gf180mcu_fd_sc_mcu7t5v0__filltie
X_09752_ _09752_/D clk _09752_/Q vdd vdd vss vss gf180mcu_fd_sc_mcu7t5v0__dffq_1
XTAP_286 vdd vss gf180mcu_fd_sc_mcu7t5v0__filltie
XTAP_297 vdd vss gf180mcu_fd_sc_mcu7t5v0__filltie
X_08703_ _08703_/A1 _08703_/A2 _08703_/B _08704_/A3 vdd vdd vss vss
+ gf180mcu_fd_sc_mcu7t5v0__oai21_1
X_06964_ _10000_/Q _09104_/A2 _09072_/B _06965_/B vdd vdd vss vss
+ gf180mcu_fd_sc_mcu7t5v0__oai21_1
X_05915_ _05915_/A1 _05915_/A2 _05915_/B _05937_/B vdd vdd vss vss
+ gf180mcu_fd_sc_mcu7t5v0__aoi21_1
X_09683_ _09683_/D clk _09683_/Q vdd vdd vss vss gf180mcu_fd_sc_mcu7t5v0__dffq_2
X_06895_ _06889_/Z _06937_/S _06895_/A3 _06943_/A1 vdd vdd vss vss
+ gf180mcu_fd_sc_mcu7t5v0__nor3_1
X_05846_ _05793_/Z _05888_/A1 _05846_/A3 _05846_/Z vdd vdd vss vss
+ gf180mcu_fd_sc_mcu7t5v0__xor3_1
X_08634_ _09710_/Q _08703_/A1 _08640_/A3 vdd vdd vss vss gf180mcu_fd_sc_mcu7t5v0__nand2_1
X_05777_ _09561_/Q _08565_/C _05777_/B _05778_/A2 vdd vdd vss vss
+ gf180mcu_fd_sc_mcu7t5v0__aoi21_1
X_08565_ _08667_/C _08565_/A2 _08565_/B _08565_/C _08566_/B vdd vdd vss
+ vss gf180mcu_fd_sc_mcu7t5v0__aoi211_2
XTAP_1408 vdd vss gf180mcu_fd_sc_mcu7t5v0__filltie
XTAP_1419 vdd vss gf180mcu_fd_sc_mcu7t5v0__filltie
X_04728_ _09886_/Q _09065_/A1 vdd vdd vss vss gf180mcu_fd_sc_mcu7t5v0__inv_1
X_07516_ _07516_/A1 _07516_/A2 _07516_/B _07541_/A1 vdd vdd vss vss
+ gf180mcu_fd_sc_mcu7t5v0__oai21_1
X_08496_ _09713_/Q _08688_/A2 _08535_/A1 vdd vdd vss vss gf180mcu_fd_sc_mcu7t5v0__nand2_1
X_07447_ _07452_/C _07444_/Z _07449_/B vdd vdd vss vss gf180mcu_fd_sc_mcu7t5v0__xor2_1
X_07378_ _09712_/Q _07349_/Z _07435_/A1 vdd vdd vss vss gf180mcu_fd_sc_mcu7t5v0__nand2_1
X_06329_ _09710_/Q _06608_/A2 _06329_/Z vdd vdd vss vss gf180mcu_fd_sc_mcu7t5v0__and2_1
X_09117_ _09458_/Q _09463_/Q _09461_/Q _09465_/Q _09136_/B2 vdd vdd vss
+ vss gf180mcu_fd_sc_mcu7t5v0__nor4_4
X_09048_ _09048_/A1 _09048_/A2 _09399_/C _09879_/D vdd vdd vss vss
+ gf180mcu_fd_sc_mcu7t5v0__aoi21_1
XTAP_1942 vdd vss gf180mcu_fd_sc_mcu7t5v0__filltie
XTAP_1931 vdd vss gf180mcu_fd_sc_mcu7t5v0__filltie
XTAP_1920 vdd vss gf180mcu_fd_sc_mcu7t5v0__filltie
XTAP_1986 vdd vss gf180mcu_fd_sc_mcu7t5v0__filltie
XTAP_1975 vdd vss gf180mcu_fd_sc_mcu7t5v0__filltie
XTAP_1964 vdd vss gf180mcu_fd_sc_mcu7t5v0__filltie
XTAP_1953 vdd vss gf180mcu_fd_sc_mcu7t5v0__filltie
XTAP_1997 vdd vss gf180mcu_fd_sc_mcu7t5v0__filltie
X_06680_ _08291_/B _06658_/I _06692_/A1 vdd vdd vss vss gf180mcu_fd_sc_mcu7t5v0__nand2_1
X_05700_ _05733_/C _05700_/A2 _05700_/B _05702_/A2 vdd vdd vss vss
+ gf180mcu_fd_sc_mcu7t5v0__oai21_1
X_05631_ _09002_/A2 _05631_/A2 _05631_/B1 _05631_/B2 _05631_/C1 _05631_/C2 _05633_/A2
+ vdd vdd vss vss gf180mcu_fd_sc_mcu7t5v0__aoi222_1
X_08350_ _08107_/B _08349_/Z _08363_/B vdd vdd vss vss gf180mcu_fd_sc_mcu7t5v0__nor2_1
X_05562_ _05562_/A1 _05562_/A2 _05574_/B1 vdd vdd vss vss gf180mcu_fd_sc_mcu7t5v0__nand2_1
X_07301_ _09998_/Q _09073_/A2 _08734_/B _07302_/B vdd vdd vss vss
+ gf180mcu_fd_sc_mcu7t5v0__oai21_1
X_08281_ _09716_/Q _08030_/Z _08299_/A2 _08328_/A2 vdd vdd vss vss
+ gf180mcu_fd_sc_mcu7t5v0__nand3_1
X_05493_ _09493_/Q _05627_/A2 _05627_/B1 _09509_/Q _05495_/A1 vdd vdd
+ vss vss gf180mcu_fd_sc_mcu7t5v0__aoi22_1
X_07232_ _07253_/A1 _07232_/A2 _07232_/A3 _07232_/Z vdd vdd vss vss
+ gf180mcu_fd_sc_mcu7t5v0__xor3_1
X_07163_ _07163_/A1 _07219_/A1 _07164_/I vdd vdd vss vss gf180mcu_fd_sc_mcu7t5v0__xnor2_1
X_06114_ _06290_/A1 _06097_/Z _06114_/B _06114_/C _06115_/A2 vdd vdd
+ vss vss gf180mcu_fd_sc_mcu7t5v0__aoi211_1
X_07094_ _07248_/B _07078_/Z _07094_/B1 _07094_/B2 _08565_/C _07095_/B vdd vdd
+ vss vss gf180mcu_fd_sc_mcu7t5v0__aoi221_1
X_06045_ _08715_/A1 _06016_/I _06093_/A1 vdd vdd vss vss gf180mcu_fd_sc_mcu7t5v0__nor2_1
X_09804_ _09804_/D clk _09804_/Q vdd vdd vss vss gf180mcu_fd_sc_mcu7t5v0__dffq_1
X_07996_ _07996_/A1 _07992_/Z _07995_/Z _07996_/Z vdd vdd vss vss
+ gf180mcu_fd_sc_mcu7t5v0__xor3_1
X_09735_ _09735_/D clk _09735_/Q vdd vdd vss vss gf180mcu_fd_sc_mcu7t5v0__dffq_1
X_06947_ _06781_/C _06946_/Z _06961_/B1 vdd vdd vss vss gf180mcu_fd_sc_mcu7t5v0__nand2_1
X_09666_ _09666_/D clk _09666_/Q vdd vdd vss vss gf180mcu_fd_sc_mcu7t5v0__dffq_1
X_08617_ _08524_/Z _08617_/A2 _08617_/B _08649_/A1 vdd vdd vss vss
+ gf180mcu_fd_sc_mcu7t5v0__oai21_1
X_06878_ _06878_/A1 _06878_/A2 _06878_/B _06904_/A1 vdd vdd vss vss
+ gf180mcu_fd_sc_mcu7t5v0__oai21_1
XTAP_1205 vdd vss gf180mcu_fd_sc_mcu7t5v0__filltie
X_05829_ _05741_/Z _05829_/A2 _05829_/B _05855_/A2 vdd vdd vss vss
+ gf180mcu_fd_sc_mcu7t5v0__aoi21_1
X_09597_ _09597_/D clk _09597_/Q vdd vdd vss vss gf180mcu_fd_sc_mcu7t5v0__dffq_2
XTAP_1227 vdd vss gf180mcu_fd_sc_mcu7t5v0__filltie
XTAP_1216 vdd vss gf180mcu_fd_sc_mcu7t5v0__filltie
XTAP_1238 vdd vss gf180mcu_fd_sc_mcu7t5v0__filltie
X_08548_ _08514_/C _08548_/A2 _08548_/B _08597_/A2 vdd vdd vss vss
+ gf180mcu_fd_sc_mcu7t5v0__oai21_1
XTAP_1249 vdd vss gf180mcu_fd_sc_mcu7t5v0__filltie
X_08479_ _09704_/Q _08565_/C _08479_/B _08480_/A2 vdd vdd vss vss
+ gf180mcu_fd_sc_mcu7t5v0__aoi21_1
XTAP_1761 vdd vss gf180mcu_fd_sc_mcu7t5v0__filltie
XTAP_1750 vdd vss gf180mcu_fd_sc_mcu7t5v0__filltie
XTAP_1794 vdd vss gf180mcu_fd_sc_mcu7t5v0__filltie
XTAP_1783 vdd vss gf180mcu_fd_sc_mcu7t5v0__filltie
XTAP_1772 vdd vss gf180mcu_fd_sc_mcu7t5v0__filltie
X_07850_ _07681_/Z _07712_/Z _07749_/Z _07788_/Z _07909_/A2 vdd vdd vss
+ vss gf180mcu_fd_sc_mcu7t5v0__nor4_2
X_07781_ _07452_/C _07781_/A2 _07781_/A3 _07870_/A1 vdd vdd vss vss
+ gf180mcu_fd_sc_mcu7t5v0__nor3_4
X_04993_ _09518_/Q _05366_/B2 vdd vdd vss vss gf180mcu_fd_sc_mcu7t5v0__clkinv_1
X_06801_ _06801_/A1 _06802_/A2 _06803_/A2 vdd vdd vss vss gf180mcu_fd_sc_mcu7t5v0__xnor2_1
X_09520_ _09520_/D clk _09520_/Q vdd vdd vss vss gf180mcu_fd_sc_mcu7t5v0__dffq_1
X_06732_ _06732_/A1 _06732_/A2 _06732_/B _06774_/A2 vdd vdd vss vss
+ gf180mcu_fd_sc_mcu7t5v0__aoi21_1
X_09451_ _09451_/D clk _09451_/Q vdd vdd vss vss gf180mcu_fd_sc_mcu7t5v0__dffq_1
X_06663_ _09622_/Q _09621_/Q _06675_/A2 vdd vdd vss vss gf180mcu_fd_sc_mcu7t5v0__nand2_1
X_06594_ _06350_/C _06579_/Z _06594_/B _08706_/B _06595_/A2 vdd vdd vss
+ vss gf180mcu_fd_sc_mcu7t5v0__oai211_1
X_05614_ _05614_/A1 _05614_/A2 _05630_/B1 vdd vdd vss vss gf180mcu_fd_sc_mcu7t5v0__nand2_1
X_08402_ _08404_/A2 _08403_/A2 _08432_/B vdd vdd vss vss gf180mcu_fd_sc_mcu7t5v0__and2_2
X_09382_ _09393_/A1 _09378_/Z _09382_/B _09399_/C _10010_/D vdd vdd vss
+ vss gf180mcu_fd_sc_mcu7t5v0__aoi211_1
X_08333_ _09710_/Q _08361_/A2 _08334_/A2 vdd vdd vss vss gf180mcu_fd_sc_mcu7t5v0__nand2_1
X_05545_ _08736_/A2 _05545_/A2 _05545_/B1 _09105_/A2 _05545_/C1 _05631_/B2 _05546_/A3
+ vdd vdd vss vss gf180mcu_fd_sc_mcu7t5v0__aoi222_2
X_08264_ _09715_/Q _08359_/A2 _08265_/A2 _08319_/B2 _08359_/B _08265_/B vdd
+ vdd vss vss gf180mcu_fd_sc_mcu7t5v0__aoi221_1
X_05476_ _09837_/Q _05627_/A2 _05627_/B1 _09805_/Q _05478_/A1 vdd vdd
+ vss vss gf180mcu_fd_sc_mcu7t5v0__aoi22_1
X_08195_ _08224_/A1 _08194_/Z _08223_/A2 vdd vdd vss vss gf180mcu_fd_sc_mcu7t5v0__nor2_1
X_07215_ _07215_/A1 _07215_/A2 _07245_/A2 vdd vdd vss vss gf180mcu_fd_sc_mcu7t5v0__nor2_2
X_07146_ _09715_/Q _07003_/B _07147_/I vdd vdd vss vss gf180mcu_fd_sc_mcu7t5v0__nand2_1
X_07077_ _09629_/Q _07075_/Z _07098_/B vdd vdd vss vss gf180mcu_fd_sc_mcu7t5v0__nand2_1
X_06028_ _09711_/Q _06032_/A3 _06026_/Z _06028_/B2 _06035_/A3 vdd vdd
+ vss vss gf180mcu_fd_sc_mcu7t5v0__oai22_1
X_07979_ _07979_/A1 _07979_/A2 _07979_/B _07997_/A1 vdd vdd vss vss
+ gf180mcu_fd_sc_mcu7t5v0__oai21_1
X_09718_ _09718_/D clk _09718_/Q vdd vdd vss vss gf180mcu_fd_sc_mcu7t5v0__dffq_2
XTAP_1013 vdd vss gf180mcu_fd_sc_mcu7t5v0__filltie
XTAP_1002 vdd vss gf180mcu_fd_sc_mcu7t5v0__filltie
X_09649_ _09649_/D clk _09649_/Q vdd vdd vss vss gf180mcu_fd_sc_mcu7t5v0__dffq_1
XTAP_1024 vdd vss gf180mcu_fd_sc_mcu7t5v0__filltie
XTAP_1035 vdd vss gf180mcu_fd_sc_mcu7t5v0__filltie
XTAP_1046 vdd vss gf180mcu_fd_sc_mcu7t5v0__filltie
XTAP_1057 vdd vss gf180mcu_fd_sc_mcu7t5v0__filltie
XTAP_1079 vdd vss gf180mcu_fd_sc_mcu7t5v0__filltie
XTAP_1068 vdd vss gf180mcu_fd_sc_mcu7t5v0__filltie
XTAP_808 vdd vss gf180mcu_fd_sc_mcu7t5v0__filltie
XTAP_819 vdd vss gf180mcu_fd_sc_mcu7t5v0__filltie
X_05330_ _09002_/A1 _05632_/C2 _05339_/A2 vdd vdd vss vss gf180mcu_fd_sc_mcu7t5v0__nand2_4
XTAP_1591 vdd vss gf180mcu_fd_sc_mcu7t5v0__filltie
XTAP_1580 vdd vss gf180mcu_fd_sc_mcu7t5v0__filltie
X_05261_ _05318_/A1 _05204_/Z _05307_/A2 vdd vdd vss vss gf180mcu_fd_sc_mcu7t5v0__nand2_2
X_07000_ _09572_/Q _09648_/Q _09682_/Q _09614_/Q _09638_/Q _09637_/Q _07000_/Z vdd
+ vdd vss vss gf180mcu_fd_sc_mcu7t5v0__mux4_4
X_05192_ _09259_/B _09465_/Q _09473_/D vdd vdd vss vss gf180mcu_fd_sc_mcu7t5v0__and2_1
X_08951_ _08927_/I _08949_/Z _08951_/A3 _09819_/D vdd vdd vss vss
+ gf180mcu_fd_sc_mcu7t5v0__nor3_1
X_07902_ _07902_/A1 _07900_/Z _07902_/Z vdd vdd vss vss gf180mcu_fd_sc_mcu7t5v0__xor2_1
X_08882_ _08899_/A2 _08882_/A2 _08882_/B _09788_/D vdd vdd vss vss
+ gf180mcu_fd_sc_mcu7t5v0__aoi21_1
X_07833_ _09711_/Q _07882_/A2 _07882_/A3 _07885_/A1 vdd vdd vss vss
+ gf180mcu_fd_sc_mcu7t5v0__nand3_2
X_07764_ _09712_/Q _07762_/Z _07765_/B vdd vdd vss vss gf180mcu_fd_sc_mcu7t5v0__xor2_1
X_04976_ _09870_/Q _09027_/B2 vdd vdd vss vss gf180mcu_fd_sc_mcu7t5v0__clkinv_1
X_09503_ _09503_/D clk _09503_/Q vdd vdd vss vss gf180mcu_fd_sc_mcu7t5v0__dffq_1
X_07695_ _08022_/A1 _07725_/A3 _08012_/A2 vdd vdd vss vss gf180mcu_fd_sc_mcu7t5v0__nor2_4
X_06715_ _06747_/A1 _06747_/A2 _09712_/Q _06747_/C _06758_/A1 vdd vdd
+ vss vss gf180mcu_fd_sc_mcu7t5v0__oai211_2
X_06646_ _09403_/A1 _06652_/A2 _06652_/B1 _06646_/B2 _09606_/D vdd vdd
+ vss vss gf180mcu_fd_sc_mcu7t5v0__oai22_1
XPHY_107 vdd vss gf180mcu_fd_sc_mcu7t5v0__endcap
X_09434_ _09434_/D clk _09434_/Q vdd vdd vss vss gf180mcu_fd_sc_mcu7t5v0__dffq_1
XPHY_118 vdd vss gf180mcu_fd_sc_mcu7t5v0__endcap
XPHY_129 vdd vss gf180mcu_fd_sc_mcu7t5v0__endcap
X_06577_ _09598_/Q _06576_/Z _06596_/A2 vdd vdd vss vss gf180mcu_fd_sc_mcu7t5v0__nor2_1
X_09365_ _10003_/Q _09366_/A2 _09366_/B vdd vdd vss vss gf180mcu_fd_sc_mcu7t5v0__nor2_1
X_08316_ _07611_/B _08352_/A1 _08313_/Z _08316_/Z vdd vdd vss vss
+ gf180mcu_fd_sc_mcu7t5v0__xor3_1
X_05528_ _09454_/Q _05627_/A2 _05627_/B1 _09438_/Q _05530_/A1 vdd vdd
+ vss vss gf180mcu_fd_sc_mcu7t5v0__aoi22_1
X_09296_ _09397_/A1 _09298_/A2 _09296_/B _09399_/C _09972_/D vdd vdd vss
+ vss gf180mcu_fd_sc_mcu7t5v0__aoi211_1
X_08247_ _08192_/I _08232_/Z _08247_/A3 _08274_/B1 vdd vdd vss vss
+ gf180mcu_fd_sc_mcu7t5v0__xnor3_1
X_05459_ _05459_/A1 _05459_/A2 _05459_/A3 _05460_/A2 vdd vdd vss vss
+ gf180mcu_fd_sc_mcu7t5v0__nand3_1
X_08178_ _09672_/Q _08132_/Z _08182_/B1 vdd vdd vss vss gf180mcu_fd_sc_mcu7t5v0__nand2_1
X_07129_ _07506_/B _07127_/Z _07130_/B vdd vdd vss vss gf180mcu_fd_sc_mcu7t5v0__xor2_1
XPHY_9 vdd vss gf180mcu_fd_sc_mcu7t5v0__endcap
XTAP_616 vdd vss gf180mcu_fd_sc_mcu7t5v0__filltie
XTAP_605 vdd vss gf180mcu_fd_sc_mcu7t5v0__filltie
XTAP_638 vdd vss gf180mcu_fd_sc_mcu7t5v0__filltie
XTAP_649 vdd vss gf180mcu_fd_sc_mcu7t5v0__filltie
XTAP_627 vdd vss gf180mcu_fd_sc_mcu7t5v0__filltie
X_04830_ _09580_/Q _06307_/A1 vdd vdd vss vss gf180mcu_fd_sc_mcu7t5v0__clkinv_2
X_04761_ _09712_/Q _08715_/A1 vdd vdd vss vss gf180mcu_fd_sc_mcu7t5v0__inv_8
X_07480_ _07480_/A1 _07529_/A1 _07521_/B vdd vdd vss vss gf180mcu_fd_sc_mcu7t5v0__or2_1
X_06500_ _09604_/Q _09603_/Q _09576_/Q _06503_/A1 vdd vdd vss vss
+ gf180mcu_fd_sc_mcu7t5v0__nand3_2
X_06431_ _06432_/A1 _06432_/A2 _06457_/B vdd vdd vss vss gf180mcu_fd_sc_mcu7t5v0__and2_1
X_06362_ _06362_/A1 _06362_/A2 _06362_/A3 _06360_/Z _06365_/A3 vdd vdd
+ vss vss gf180mcu_fd_sc_mcu7t5v0__nor4_4
X_09150_ _09945_/Q _09137_/Z _09170_/B1 _09919_/Q _09150_/C _09151_/A2 vdd vdd
+ vss vss gf180mcu_fd_sc_mcu7t5v0__aoi221_1
X_06293_ _09579_/Q _06293_/A2 _06293_/B1 _06293_/B2 _06294_/A3 vdd vdd
+ vss vss gf180mcu_fd_sc_mcu7t5v0__aoi22_1
X_08101_ _08101_/I _08223_/B2 vdd vdd vss vss gf180mcu_fd_sc_mcu7t5v0__clkinv_1
X_05313_ _09405_/A1 _05317_/A2 _05317_/B1 _05313_/B2 _09477_/D vdd vdd
+ vss vss gf180mcu_fd_sc_mcu7t5v0__oai22_1
X_09081_ _09891_/Q _09098_/A1 _09278_/C _09082_/B vdd vdd vss vss
+ gf180mcu_fd_sc_mcu7t5v0__oai21_1
X_08032_ _09691_/Q _08369_/A1 _08040_/A2 vdd vdd vss vss gf180mcu_fd_sc_mcu7t5v0__nand2_2
X_05244_ _05968_/A1 _05217_/S _05245_/B vdd vdd vss vss gf180mcu_fd_sc_mcu7t5v0__nand2_1
X_05175_ _09896_/Q _05175_/A2 _09209_/A2 _09551_/Q _05175_/C1 _09209_/B2 _09248_/A2
+ vdd vdd vss vss gf180mcu_fd_sc_mcu7t5v0__aoi222_4
X_09983_ _09983_/D clk _09983_/Q vdd vdd vss vss gf180mcu_fd_sc_mcu7t5v0__dffq_1
X_08934_ _09814_/Q _08932_/Z _08936_/A2 vdd vdd vss vss gf180mcu_fd_sc_mcu7t5v0__nor2_1
X_08865_ _08865_/A1 _08865_/A2 _09784_/D vdd vdd vss vss gf180mcu_fd_sc_mcu7t5v0__nor2_1
X_07816_ _08565_/C _07816_/A2 _07817_/A2 vdd vdd vss vss gf180mcu_fd_sc_mcu7t5v0__nor2_1
X_08796_ _08796_/A1 _08851_/A1 _08796_/B _09760_/D vdd vdd vss vss
+ gf180mcu_fd_sc_mcu7t5v0__aoi21_1
X_07747_ _09877_/Q _09680_/Q _07748_/B vdd vdd vss vss gf180mcu_fd_sc_mcu7t5v0__nand2_1
X_04959_ _09477_/Q _05313_/B2 vdd vdd vss vss gf180mcu_fd_sc_mcu7t5v0__clkinv_1
X_07678_ _09680_/Q _09613_/Q _07680_/A2 vdd vdd vss vss gf180mcu_fd_sc_mcu7t5v0__nor2_1
X_06629_ _09717_/Q _06629_/A2 _06590_/C _06629_/B2 _06627_/Z _06367_/B _06630_/C vdd
+ vdd vss vss gf180mcu_fd_sc_mcu7t5v0__aoi222_1
X_09417_ _09417_/D clk _09417_/Q vdd vdd vss vss gf180mcu_fd_sc_mcu7t5v0__dffq_1
X_09348_ _09995_/Q _09355_/A2 _09349_/B vdd vdd vss vss gf180mcu_fd_sc_mcu7t5v0__nor2_1
X_09279_ _09965_/Q _09286_/A2 _09280_/B vdd vdd vss vss gf180mcu_fd_sc_mcu7t5v0__nor2_1
XTAP_402 vdd vss gf180mcu_fd_sc_mcu7t5v0__filltie
XTAP_413 vdd vss gf180mcu_fd_sc_mcu7t5v0__filltie
XTAP_424 vdd vss gf180mcu_fd_sc_mcu7t5v0__filltie
XTAP_446 vdd vss gf180mcu_fd_sc_mcu7t5v0__filltie
XTAP_435 vdd vss gf180mcu_fd_sc_mcu7t5v0__filltie
XTAP_457 vdd vss gf180mcu_fd_sc_mcu7t5v0__filltie
X_06980_ _09626_/Q _06993_/B _06980_/Z vdd vdd vss vss gf180mcu_fd_sc_mcu7t5v0__xor2_1
XTAP_468 vdd vss gf180mcu_fd_sc_mcu7t5v0__filltie
XTAP_479 vdd vss gf180mcu_fd_sc_mcu7t5v0__filltie
X_05931_ _05931_/I _05932_/B vdd vdd vss vss gf180mcu_fd_sc_mcu7t5v0__clkinv_1
X_08650_ _08672_/A1 _08672_/A2 _08650_/Z vdd vdd vss vss gf180mcu_fd_sc_mcu7t5v0__xor2_1
X_05862_ _05862_/A1 _05858_/Z _05862_/Z vdd vdd vss vss gf180mcu_fd_sc_mcu7t5v0__and2_1
X_04813_ _09621_/Q _06963_/A1 vdd vdd vss vss gf180mcu_fd_sc_mcu7t5v0__inv_2
X_07601_ _07653_/A1 _07617_/A2 _07614_/A2 vdd vdd vss vss gf180mcu_fd_sc_mcu7t5v0__nand2_1
X_05793_ _05793_/A1 _05843_/A1 _05793_/Z vdd vdd vss vss gf180mcu_fd_sc_mcu7t5v0__or2_1
X_08581_ _09714_/Q _08688_/A2 _08689_/A2 _09710_/Q _08621_/A2 vdd vdd
+ vss vss gf180mcu_fd_sc_mcu7t5v0__aoi22_1
X_04744_ _09756_/Q _08788_/A1 vdd vdd vss vss gf180mcu_fd_sc_mcu7t5v0__clkinv_1
X_07532_ _09710_/Q _07633_/B _07634_/A2 vdd vdd vss vss gf180mcu_fd_sc_mcu7t5v0__nand2_1
X_07463_ _07414_/Z _07463_/A2 _07463_/B _07514_/A1 vdd vdd vss vss
+ gf180mcu_fd_sc_mcu7t5v0__oai21_1
X_06414_ _06450_/C _06414_/A2 _06414_/B _08706_/B _06415_/A2 vdd vdd vss
+ vss gf180mcu_fd_sc_mcu7t5v0__oai211_1
X_09202_ _09791_/Q _09299_/A3 _09378_/A2 _09760_/Q _09203_/I vdd vdd vss
+ vss gf180mcu_fd_sc_mcu7t5v0__aoi22_1
X_09133_ _09941_/Q _09116_/I _09136_/A2 _09914_/Q _09134_/A2 vdd vdd vss
+ vss gf180mcu_fd_sc_mcu7t5v0__aoi22_1
X_07394_ _07395_/A1 _07373_/Z _07395_/B _07394_/Z vdd vdd vss vss
+ gf180mcu_fd_sc_mcu7t5v0__or3_1
X_06345_ _09602_/Q _06491_/A1 _06590_/C vdd vdd vss vss gf180mcu_fd_sc_mcu7t5v0__nor2_2
X_06276_ _06276_/A1 _06276_/A2 _06276_/A3 _06276_/Z vdd vdd vss vss
+ gf180mcu_fd_sc_mcu7t5v0__xor3_1
X_09064_ _09553_/Q _09104_/A2 _09072_/B _09065_/B vdd vdd vss vss
+ gf180mcu_fd_sc_mcu7t5v0__oai21_1
X_08015_ _09675_/Q _08706_/B _08708_/B _08016_/A2 vdd vdd vss vss
+ gf180mcu_fd_sc_mcu7t5v0__oai21_1
X_05227_ _09559_/Q _05217_/S _05227_/B _09403_/A1 vdd vdd vss vss
+ gf180mcu_fd_sc_mcu7t5v0__aoi21_4
X_05158_ _09767_/Q _08813_/A1 _05158_/A3 _05157_/Z _05161_/A2 vdd vdd
+ vss vss gf180mcu_fd_sc_mcu7t5v0__nand4_1
X_05089_ _09521_/Q _05369_/B2 vdd vdd vss vss gf180mcu_fd_sc_mcu7t5v0__clkinv_1
X_09966_ _09966_/D clk _09966_/Q vdd vdd vss vss gf180mcu_fd_sc_mcu7t5v0__dffq_1
X_08917_ _09401_/A1 _08925_/A2 _08925_/B1 vdd vdd vss vss gf180mcu_fd_sc_mcu7t5v0__nand2_2
XTAP_980 vdd vss gf180mcu_fd_sc_mcu7t5v0__filltie
X_09897_ _09897_/D clk _09897_/Q vdd vdd vss vss gf180mcu_fd_sc_mcu7t5v0__dffq_4
XTAP_991 vdd vss gf180mcu_fd_sc_mcu7t5v0__filltie
X_08848_ _08824_/I _08847_/Z _09777_/D vdd vdd vss vss gf180mcu_fd_sc_mcu7t5v0__nor2_1
X_08779_ _09753_/Q _08782_/A2 _09257_/B _08780_/B vdd vdd vss vss
+ gf180mcu_fd_sc_mcu7t5v0__oai21_1
X_10037_ uart_tx_PU vdd vdd vss vss gf180mcu_fd_sc_mcu7t5v0__tiel
X_06130_ _06167_/A1 _06174_/A1 _06130_/A3 _06130_/Z vdd vdd vss vss
+ gf180mcu_fd_sc_mcu7t5v0__xor3_1
X_06061_ _09579_/Q _06293_/A2 _06016_/I _06101_/A1 _06064_/A3 vdd vdd
+ vss vss gf180mcu_fd_sc_mcu7t5v0__aoi22_2
X_05012_ _09808_/Q _08923_/B2 vdd vdd vss vss gf180mcu_fd_sc_mcu7t5v0__clkinv_1
X_09820_ _09820_/D clk _09820_/Q vdd vdd vss vss gf180mcu_fd_sc_mcu7t5v0__dffq_1
X_06963_ _06963_/A1 _09104_/A2 _06963_/B _09621_/D vdd vdd vss vss
+ gf180mcu_fd_sc_mcu7t5v0__aoi21_1
X_09751_ _09751_/D clk _09751_/Q vdd vdd vss vss gf180mcu_fd_sc_mcu7t5v0__dffq_1
X_05914_ _05937_/A1 _05913_/Z _05915_/B vdd vdd vss vss gf180mcu_fd_sc_mcu7t5v0__xnor2_1
XTAP_287 vdd vss gf180mcu_fd_sc_mcu7t5v0__filltie
XTAP_298 vdd vss gf180mcu_fd_sc_mcu7t5v0__filltie
XTAP_276 vdd vss gf180mcu_fd_sc_mcu7t5v0__filltie
X_08702_ _08702_/A1 _08662_/Z _08702_/B _08704_/A2 vdd vdd vss vss
+ gf180mcu_fd_sc_mcu7t5v0__aoi21_1
X_09682_ _09682_/D clk _09682_/Q vdd vdd vss vss gf180mcu_fd_sc_mcu7t5v0__dffq_2
X_06894_ _06937_/S _06895_/A3 _06896_/A2 vdd vdd vss vss gf180mcu_fd_sc_mcu7t5v0__nor2_1
X_05845_ _05793_/Z _05846_/A3 _05888_/A2 vdd vdd vss vss gf180mcu_fd_sc_mcu7t5v0__nand2_1
X_08633_ _08633_/A1 _08389_/Z _08633_/B _08703_/A1 vdd vdd vss vss
+ gf180mcu_fd_sc_mcu7t5v0__oai21_4
X_05776_ _05698_/C _05762_/Z _05776_/B _08565_/C _05777_/B vdd vdd vss
+ vss gf180mcu_fd_sc_mcu7t5v0__aoi211_1
X_08564_ _08432_/B _08558_/Z _08564_/B _08564_/C _08565_/B vdd vdd vss
+ vss gf180mcu_fd_sc_mcu7t5v0__aoi211_1
XTAP_1409 vdd vss gf180mcu_fd_sc_mcu7t5v0__filltie
X_04727_ _09887_/Q _09067_/A1 vdd vdd vss vss gf180mcu_fd_sc_mcu7t5v0__inv_1
X_07515_ _07515_/A1 _07515_/A2 _07488_/Z _07490_/Z _07515_/B2 _07515_/B3 _07543_/A1
+ vdd vdd vss vss gf180mcu_fd_sc_mcu7t5v0__oai33_2
X_08495_ _08495_/A1 _08495_/A2 _08495_/Z vdd vdd vss vss gf180mcu_fd_sc_mcu7t5v0__xor2_1
X_07446_ _07446_/I _07503_/A1 vdd vdd vss vss gf180mcu_fd_sc_mcu7t5v0__clkinv_1
X_07377_ _09712_/Q _07377_/A2 _07377_/A3 _07417_/A3 vdd vdd vss vss
+ gf180mcu_fd_sc_mcu7t5v0__nand3_4
X_06328_ _06362_/A1 _06362_/A2 _06362_/A3 _06608_/A2 vdd vdd vss vss
+ gf180mcu_fd_sc_mcu7t5v0__nor3_4
X_09116_ _09116_/I _09135_/A2 vdd vdd vss vss gf180mcu_fd_sc_mcu7t5v0__clkinv_1
X_09047_ _09879_/Q _09103_/A2 _09048_/A2 vdd vdd vss vss gf180mcu_fd_sc_mcu7t5v0__nand2_1
X_06259_ _09716_/Q _05996_/B _06297_/I1 _06260_/A2 _06259_/C _06260_/B vdd vdd
+ vss vss gf180mcu_fd_sc_mcu7t5v0__aoi221_1
X_09949_ _09949_/D clk _09949_/Q vdd vdd vss vss gf180mcu_fd_sc_mcu7t5v0__dffq_1
XTAP_1910 vdd vss gf180mcu_fd_sc_mcu7t5v0__filltie
XTAP_1943 vdd vss gf180mcu_fd_sc_mcu7t5v0__filltie
XTAP_1932 vdd vss gf180mcu_fd_sc_mcu7t5v0__filltie
XTAP_1921 vdd vss gf180mcu_fd_sc_mcu7t5v0__filltie
XTAP_1976 vdd vss gf180mcu_fd_sc_mcu7t5v0__filltie
XTAP_1965 vdd vss gf180mcu_fd_sc_mcu7t5v0__filltie
XTAP_1954 vdd vss gf180mcu_fd_sc_mcu7t5v0__filltie
XTAP_1998 vdd vss gf180mcu_fd_sc_mcu7t5v0__filltie
XTAP_1987 vdd vss gf180mcu_fd_sc_mcu7t5v0__filltie
X_05630_ _08736_/A2 _05630_/A2 _05630_/B1 _09105_/A2 _05633_/A1 vdd vdd
+ vss vss gf180mcu_fd_sc_mcu7t5v0__aoi22_1
X_05561_ _09665_/Q _05628_/A2 _05628_/B1 _09728_/Q _05562_/A2 vdd vdd
+ vss vss gf180mcu_fd_sc_mcu7t5v0__aoi22_1
X_07300_ _07300_/A1 _09073_/A2 _07300_/B _09637_/D vdd vdd vss vss
+ gf180mcu_fd_sc_mcu7t5v0__aoi21_1
X_08280_ _08280_/A1 _08280_/A2 _08299_/A2 vdd vdd vss vss gf180mcu_fd_sc_mcu7t5v0__xnor2_1
X_05492_ _05492_/A1 _05492_/A2 _05514_/A2 vdd vdd vss vss gf180mcu_fd_sc_mcu7t5v0__nand2_1
X_07231_ _07232_/A2 _07232_/A3 _07253_/A2 vdd vdd vss vss gf180mcu_fd_sc_mcu7t5v0__nand2_1
X_07162_ _07163_/A1 _07219_/A1 _07224_/A1 vdd vdd vss vss gf180mcu_fd_sc_mcu7t5v0__nor2_1
X_06113_ _06260_/A1 _06224_/A1 _06113_/B1 _06113_/B2 _06113_/C _06114_/C vdd
+ vdd vss vss gf180mcu_fd_sc_mcu7t5v0__oai221_1
X_07093_ _07278_/A1 _07075_/Z _07093_/B _07248_/B _07094_/B2 vdd vdd vss
+ vss gf180mcu_fd_sc_mcu7t5v0__aoi211_1
X_06044_ _09712_/Q _05987_/I _06048_/B vdd vdd vss vss gf180mcu_fd_sc_mcu7t5v0__nand2_2
X_09803_ _09803_/D clk _09803_/Q vdd vdd vss vss gf180mcu_fd_sc_mcu7t5v0__dffq_1
X_07995_ _07995_/A1 _07995_/A2 _07995_/A3 _07995_/Z vdd vdd vss vss
+ gf180mcu_fd_sc_mcu7t5v0__xor3_1
X_06946_ _06961_/A1 _06946_/A2 _06945_/Z _06946_/Z vdd vdd vss vss
+ gf180mcu_fd_sc_mcu7t5v0__xor3_1
X_09734_ _09734_/D clk _09734_/Q vdd vdd vss vss gf180mcu_fd_sc_mcu7t5v0__dffq_2
X_09665_ _09665_/D clk _09665_/Q vdd vdd vss vss gf180mcu_fd_sc_mcu7t5v0__dffq_1
X_06877_ _06877_/A1 _06877_/A2 _06877_/B _06926_/A1 vdd vdd vss vss
+ gf180mcu_fd_sc_mcu7t5v0__aoi21_1
X_05828_ _05828_/A1 _05828_/A2 _05828_/Z vdd vdd vss vss gf180mcu_fd_sc_mcu7t5v0__and2_1
X_08616_ _08505_/Z _08542_/Z _08592_/Z _08616_/B1 _08616_/B2 _08672_/A1 vdd
+ vdd vss vss gf180mcu_fd_sc_mcu7t5v0__oai32_2
X_09596_ _09596_/D clk _09596_/Q vdd vdd vss vss gf180mcu_fd_sc_mcu7t5v0__dffq_2
XTAP_1217 vdd vss gf180mcu_fd_sc_mcu7t5v0__filltie
XTAP_1206 vdd vss gf180mcu_fd_sc_mcu7t5v0__filltie
XTAP_1228 vdd vss gf180mcu_fd_sc_mcu7t5v0__filltie
XTAP_1239 vdd vss gf180mcu_fd_sc_mcu7t5v0__filltie
X_05759_ _09561_/Q _05758_/Z _05759_/Z vdd vdd vss vss gf180mcu_fd_sc_mcu7t5v0__and2_1
X_08547_ _08514_/C _08548_/A2 _08548_/B _08547_/Z vdd vdd vss vss
+ gf180mcu_fd_sc_mcu7t5v0__or3_1
X_08478_ _08667_/C _08478_/A2 _08478_/B1 _08478_/B2 _08565_/C _08479_/B vdd
+ vdd vss vss gf180mcu_fd_sc_mcu7t5v0__aoi221_1
X_07429_ _07452_/A1 _07452_/A2 _07452_/B _07623_/A2 vdd vdd vss vss
+ gf180mcu_fd_sc_mcu7t5v0__aoi21_4
XTAP_1751 vdd vss gf180mcu_fd_sc_mcu7t5v0__filltie
XTAP_1740 vdd vss gf180mcu_fd_sc_mcu7t5v0__filltie
XTAP_1784 vdd vss gf180mcu_fd_sc_mcu7t5v0__filltie
XTAP_1773 vdd vss gf180mcu_fd_sc_mcu7t5v0__filltie
XTAP_1762 vdd vss gf180mcu_fd_sc_mcu7t5v0__filltie
XTAP_1795 vdd vss gf180mcu_fd_sc_mcu7t5v0__filltie
X_07780_ _07780_/I _07871_/A1 vdd vdd vss vss gf180mcu_fd_sc_mcu7t5v0__clkinv_1
X_04992_ _09538_/Q _05386_/B2 vdd vdd vss vss gf180mcu_fd_sc_mcu7t5v0__clkinv_1
X_06800_ _06749_/Z _06756_/Z _06802_/A2 _06855_/A1 vdd vdd vss vss
+ gf180mcu_fd_sc_mcu7t5v0__nand3_1
X_06731_ _08715_/A1 _06839_/A2 _06731_/A3 _06732_/B vdd vdd vss vss
+ gf180mcu_fd_sc_mcu7t5v0__xor3_1
X_09450_ _09450_/D clk _09450_/Q vdd vdd vss vss gf180mcu_fd_sc_mcu7t5v0__dffq_1
X_08401_ _08731_/A1 _09718_/Q _09719_/Q _08403_/A2 vdd vdd vss vss
+ gf180mcu_fd_sc_mcu7t5v0__oai21_1
X_06662_ _06965_/A1 _06963_/A1 _06672_/B vdd vdd vss vss gf180mcu_fd_sc_mcu7t5v0__nor2_4
X_06593_ _06350_/C _06593_/A2 _06593_/A3 _06593_/A4 _06594_/B vdd vdd
+ vss vss gf180mcu_fd_sc_mcu7t5v0__nand4_1
X_09381_ _10010_/Q _09378_/Z _09382_/B vdd vdd vss vss gf180mcu_fd_sc_mcu7t5v0__nor2_1
X_05613_ _09801_/Q _05628_/A2 _05628_/B1 _09907_/Q _05614_/A2 vdd vdd
+ vss vss gf180mcu_fd_sc_mcu7t5v0__aoi22_1
X_05544_ _05631_/C1 _05544_/A2 _05544_/B1 _05632_/C2 _05544_/C1 _09400_/A2 _05546_/A2
+ vdd vdd vss vss gf180mcu_fd_sc_mcu7t5v0__aoi222_1
X_08332_ _08332_/A1 _08332_/A2 _08361_/A2 vdd vdd vss vss gf180mcu_fd_sc_mcu7t5v0__nand2_2
X_08263_ _09715_/Q _08335_/A2 _08265_/A2 vdd vdd vss vss gf180mcu_fd_sc_mcu7t5v0__nand2_1
X_05475_ _05475_/A1 _05475_/A2 _05486_/B1 vdd vdd vss vss gf180mcu_fd_sc_mcu7t5v0__nand2_1
X_07214_ _09638_/Q _09637_/Q _09577_/Q _07215_/A2 vdd vdd vss vss
+ gf180mcu_fd_sc_mcu7t5v0__nor3_1
X_08194_ _08224_/A2 _08194_/A2 _08190_/Z _08194_/Z vdd vdd vss vss
+ gf180mcu_fd_sc_mcu7t5v0__xor3_1
X_07145_ _07145_/A1 _07145_/A2 _07170_/A1 vdd vdd vss vss gf180mcu_fd_sc_mcu7t5v0__nor2_1
X_07076_ _09629_/Q _07075_/Z _07098_/A2 vdd vdd vss vss gf180mcu_fd_sc_mcu7t5v0__nor2_1
X_06027_ _08430_/B _09581_/Q _06298_/B _06028_/B2 vdd vdd vss vss
+ gf180mcu_fd_sc_mcu7t5v0__aoi21_1
X_07978_ _07978_/A1 _07978_/A2 _07978_/B _07998_/A2 vdd vdd vss vss
+ gf180mcu_fd_sc_mcu7t5v0__oai21_1
X_06929_ _06929_/A1 _06884_/Z _06929_/B _06944_/A2 vdd vdd vss vss
+ gf180mcu_fd_sc_mcu7t5v0__oai21_1
X_09717_ _09717_/D clk _09717_/Q vdd vdd vss vss gf180mcu_fd_sc_mcu7t5v0__dffq_4
XTAP_1003 vdd vss gf180mcu_fd_sc_mcu7t5v0__filltie
X_09648_ _09648_/D clk _09648_/Q vdd vdd vss vss gf180mcu_fd_sc_mcu7t5v0__dffq_2
X_09579_ _09579_/D clk _09579_/Q vdd vdd vss vss gf180mcu_fd_sc_mcu7t5v0__dffq_2
XTAP_1014 vdd vss gf180mcu_fd_sc_mcu7t5v0__filltie
XTAP_1025 vdd vss gf180mcu_fd_sc_mcu7t5v0__filltie
XTAP_1036 vdd vss gf180mcu_fd_sc_mcu7t5v0__filltie
XTAP_1047 vdd vss gf180mcu_fd_sc_mcu7t5v0__filltie
XTAP_1058 vdd vss gf180mcu_fd_sc_mcu7t5v0__filltie
XTAP_1069 vdd vss gf180mcu_fd_sc_mcu7t5v0__filltie
XTAP_809 vdd vss gf180mcu_fd_sc_mcu7t5v0__filltie
XTAP_1581 vdd vss gf180mcu_fd_sc_mcu7t5v0__filltie
XTAP_1570 vdd vss gf180mcu_fd_sc_mcu7t5v0__filltie
XTAP_1592 vdd vss gf180mcu_fd_sc_mcu7t5v0__filltie
X_05260_ _09409_/A1 _05260_/A2 _05260_/B1 _05260_/B2 _09425_/D vdd vdd
+ vss vss gf180mcu_fd_sc_mcu7t5v0__oai22_1
X_05191_ _09259_/B _09472_/Q _09459_/D vdd vdd vss vss gf180mcu_fd_sc_mcu7t5v0__and2_1
X_08950_ _09819_/Q _08946_/Z _08951_/A3 vdd vdd vss vss gf180mcu_fd_sc_mcu7t5v0__nor2_1
X_07901_ _07902_/A1 _07900_/Z _07901_/Z vdd vdd vss vss gf180mcu_fd_sc_mcu7t5v0__and2_1
X_08881_ _09788_/Q _08899_/A2 _09278_/C _08882_/B vdd vdd vss vss
+ gf180mcu_fd_sc_mcu7t5v0__oai21_1
X_07832_ _09711_/Q _07788_/Z _07830_/I _09710_/Q _07877_/A2 vdd vdd vss
+ vss gf180mcu_fd_sc_mcu7t5v0__aoi22_1
X_07763_ _09712_/Q _07762_/Z _07808_/A1 vdd vdd vss vss gf180mcu_fd_sc_mcu7t5v0__nand2_1
X_09502_ _09502_/D clk _09502_/Q vdd vdd vss vss gf180mcu_fd_sc_mcu7t5v0__dffq_1
X_04975_ _09903_/Q _09110_/B2 vdd vdd vss vss gf180mcu_fd_sc_mcu7t5v0__clkinv_1
X_07694_ _08011_/A1 _07862_/A1 _07697_/A2 vdd vdd vss vss gf180mcu_fd_sc_mcu7t5v0__nand2_1
X_06714_ _09712_/Q _06658_/I _06786_/A2 vdd vdd vss vss gf180mcu_fd_sc_mcu7t5v0__nand2_1
X_06645_ _09402_/A1 _06652_/A2 _06652_/B1 _06645_/B2 _09605_/D vdd vdd
+ vss vss gf180mcu_fd_sc_mcu7t5v0__oai22_1
X_09433_ _09433_/D clk _09433_/Q vdd vdd vss vss gf180mcu_fd_sc_mcu7t5v0__dffq_1
XPHY_108 vdd vss gf180mcu_fd_sc_mcu7t5v0__endcap
XPHY_119 vdd vss gf180mcu_fd_sc_mcu7t5v0__endcap
X_09364_ _09397_/A1 _09366_/A2 _09364_/B _09399_/C _10002_/D vdd vdd vss
+ vss gf180mcu_fd_sc_mcu7t5v0__aoi211_1
X_06576_ _06576_/A1 _06597_/A1 _06575_/B _06576_/Z vdd vdd vss vss
+ gf180mcu_fd_sc_mcu7t5v0__xor3_2
X_08315_ _09716_/Q _08313_/Z _08352_/A2 vdd vdd vss vss gf180mcu_fd_sc_mcu7t5v0__nor2_1
X_05527_ _05527_/A1 _05527_/A2 _05544_/B1 vdd vdd vss vss gf180mcu_fd_sc_mcu7t5v0__nand2_1
X_09295_ _09972_/Q _09298_/A2 _09296_/B vdd vdd vss vss gf180mcu_fd_sc_mcu7t5v0__nor2_1
X_05458_ _05631_/C1 _05458_/A2 _05458_/B1 _05632_/C2 _05458_/C1 _09002_/A2 _05459_/A3
+ vdd vdd vss vss gf180mcu_fd_sc_mcu7t5v0__aoi222_2
X_08246_ _08192_/I _08232_/Z _08247_/A3 _08246_/Z vdd vdd vss vss
+ gf180mcu_fd_sc_mcu7t5v0__xor3_1
X_08177_ _09672_/Q _08132_/Z _08177_/Z vdd vdd vss vss gf180mcu_fd_sc_mcu7t5v0__and2_1
X_05389_ _09409_/A1 _05389_/A2 _05389_/B1 _05389_/B2 _09541_/D vdd vdd
+ vss vss gf180mcu_fd_sc_mcu7t5v0__oai22_1
X_07128_ _09714_/Q _07127_/Z _07128_/Z vdd vdd vss vss gf180mcu_fd_sc_mcu7t5v0__and2_1
X_07059_ _09628_/Q _07039_/Z _07059_/B _07098_/A1 vdd vdd vss vss
+ gf180mcu_fd_sc_mcu7t5v0__aoi21_1
XTAP_606 vdd vss gf180mcu_fd_sc_mcu7t5v0__filltie
XTAP_639 vdd vss gf180mcu_fd_sc_mcu7t5v0__filltie
XTAP_628 vdd vss gf180mcu_fd_sc_mcu7t5v0__filltie
XTAP_617 vdd vss gf180mcu_fd_sc_mcu7t5v0__filltie
X_04760_ _09713_/Q _07452_/C vdd vdd vss vss gf180mcu_fd_sc_mcu7t5v0__inv_12
X_06430_ _06430_/A1 _06464_/A1 _06510_/B2 _06432_/A2 vdd vdd vss vss
+ gf180mcu_fd_sc_mcu7t5v0__xnor3_1
X_06361_ _09600_/Q _06361_/A2 _06439_/B vdd vdd vss vss gf180mcu_fd_sc_mcu7t5v0__nand2_2
X_06292_ _09717_/Q _06299_/A2 _06297_/S vdd vdd vss vss gf180mcu_fd_sc_mcu7t5v0__nand2_1
X_08100_ _08075_/Z _08099_/Z _08101_/I vdd vdd vss vss gf180mcu_fd_sc_mcu7t5v0__nor2_1
X_05312_ _09404_/A1 _05317_/A2 _05317_/B1 _05312_/B2 _09476_/D vdd vdd
+ vss vss gf180mcu_fd_sc_mcu7t5v0__oai22_1
X_09080_ _09959_/Q _08706_/B _09096_/B1 _09969_/Q _09080_/C _09082_/A2 vdd vdd
+ vss vss gf180mcu_fd_sc_mcu7t5v0__aoi221_1
X_05243_ _05243_/A1 _05246_/A2 _09408_/A1 _05246_/B2 _09416_/D vdd vdd
+ vss vss gf180mcu_fd_sc_mcu7t5v0__oai22_1
X_08031_ _09710_/Q _08030_/Z _08046_/B vdd vdd vss vss gf180mcu_fd_sc_mcu7t5v0__and2_1
X_05174_ _05174_/A1 _05174_/A2 _05175_/C1 vdd vdd vss vss gf180mcu_fd_sc_mcu7t5v0__nand2_1
X_09982_ _09982_/D clk _09982_/Q vdd vdd vss vss gf180mcu_fd_sc_mcu7t5v0__dffq_1
X_08933_ _08927_/I _08933_/A2 _08932_/Z _09813_/D vdd vdd vss vss
+ gf180mcu_fd_sc_mcu7t5v0__nor3_1
X_08864_ _09783_/Q _08860_/B _09784_/Q _08865_/A2 vdd vdd vss vss
+ gf180mcu_fd_sc_mcu7t5v0__aoi21_1
X_07815_ _08001_/A1 _07798_/Z _07815_/B1 _07815_/B2 _07815_/C _07816_/A2 vdd
+ vdd vss vss gf180mcu_fd_sc_mcu7t5v0__aoi221_2
X_08795_ _09752_/Q _08851_/A1 _09257_/B _08796_/B vdd vdd vss vss
+ gf180mcu_fd_sc_mcu7t5v0__oai21_1
X_07746_ _09680_/Q _09615_/Q _07748_/A2 vdd vdd vss vss gf180mcu_fd_sc_mcu7t5v0__nor2_1
X_04958_ _09453_/Q _05302_/B2 vdd vdd vss vss gf180mcu_fd_sc_mcu7t5v0__clkinv_1
X_09416_ _09416_/D clk _09416_/Q vdd vdd vss vss gf180mcu_fd_sc_mcu7t5v0__dffq_1
X_04889_ _09543_/Q _05393_/B2 vdd vdd vss vss gf180mcu_fd_sc_mcu7t5v0__clkinv_1
X_07677_ _09681_/Q _08026_/A1 _09679_/Q _07677_/Z vdd vdd vss vss
+ gf180mcu_fd_sc_mcu7t5v0__or3_2
X_06628_ _06628_/A1 _06628_/A2 _06625_/Z _06628_/B2 _06630_/B vdd vdd
+ vss vss gf180mcu_fd_sc_mcu7t5v0__aoi22_1
X_06559_ _06559_/A1 _06564_/A1 _06559_/B1 _06559_/B2 _06566_/A1 vdd vdd
+ vss vss gf180mcu_fd_sc_mcu7t5v0__oai22_1
X_09347_ _09391_/A1 _09355_/A2 _09347_/B _09399_/C _09994_/D vdd vdd vss
+ vss gf180mcu_fd_sc_mcu7t5v0__aoi211_1
X_09278_ _09278_/A1 _09286_/A2 _09278_/B _09278_/C _09964_/D vdd vdd vss
+ vss gf180mcu_fd_sc_mcu7t5v0__oai211_1
X_08229_ _08229_/A1 _08229_/A2 _08229_/B _08232_/A3 vdd vdd vss vss
+ gf180mcu_fd_sc_mcu7t5v0__oai21_1
XTAP_403 vdd vss gf180mcu_fd_sc_mcu7t5v0__filltie
XTAP_414 vdd vss gf180mcu_fd_sc_mcu7t5v0__filltie
XTAP_425 vdd vss gf180mcu_fd_sc_mcu7t5v0__filltie
XTAP_447 vdd vss gf180mcu_fd_sc_mcu7t5v0__filltie
XTAP_436 vdd vss gf180mcu_fd_sc_mcu7t5v0__filltie
XTAP_458 vdd vss gf180mcu_fd_sc_mcu7t5v0__filltie
XTAP_469 vdd vss gf180mcu_fd_sc_mcu7t5v0__filltie
X_05930_ _09716_/Q _05930_/A2 _05930_/B1 _05930_/B2 _05930_/C _05931_/I vdd
+ vdd vss vss gf180mcu_fd_sc_mcu7t5v0__aoi221_1
X_05861_ _09563_/Q _05828_/Z _05858_/Z _05861_/Z vdd vdd vss vss gf180mcu_fd_sc_mcu7t5v0__xor3_1
X_08580_ _09714_/Q _09710_/Q _08688_/A2 _08689_/A2 _08621_/B vdd vdd vss
+ vss gf180mcu_fd_sc_mcu7t5v0__nand4_1
X_04812_ _09622_/Q _06965_/A1 vdd vdd vss vss gf180mcu_fd_sc_mcu7t5v0__clkinv_3
X_07600_ _07600_/A1 _07598_/Z _07600_/Z vdd vdd vss vss gf180mcu_fd_sc_mcu7t5v0__xor2_1
X_07531_ _09659_/Q _07531_/A2 _07626_/A2 _08595_/A1 _07531_/C _07633_/B vdd
+ vdd vss vss gf180mcu_fd_sc_mcu7t5v0__aoi221_4
X_05792_ _05792_/A1 _05792_/A2 _05792_/B _09711_/Q _05843_/A1 vdd vdd
+ vss vss gf180mcu_fd_sc_mcu7t5v0__oai211_2
X_04743_ _09749_/Q _08774_/A1 vdd vdd vss vss gf180mcu_fd_sc_mcu7t5v0__clkinv_1
X_07462_ _08670_/B _07462_/A2 _09650_/D vdd vdd vss vss gf180mcu_fd_sc_mcu7t5v0__nor2_1
X_06413_ _06413_/A1 _06413_/A2 _06407_/Z _06413_/B _06414_/A2 vdd vdd
+ vss vss gf180mcu_fd_sc_mcu7t5v0__oai31_1
X_07393_ _09649_/Q _07391_/Z _07395_/B vdd vdd vss vss gf180mcu_fd_sc_mcu7t5v0__xor2_1
X_09201_ _09173_/B _09256_/A2 _09201_/B _09932_/D vdd vdd vss vss
+ gf180mcu_fd_sc_mcu7t5v0__aoi21_1
X_06344_ _06638_/A1 _06491_/A1 _06629_/A2 vdd vdd vss vss gf180mcu_fd_sc_mcu7t5v0__nor2_2
X_09132_ _09399_/C _09132_/A2 _09913_/D vdd vdd vss vss gf180mcu_fd_sc_mcu7t5v0__nor2_1
X_06275_ _06275_/A1 _06279_/A1 _06223_/Z _06275_/B2 _06276_/A3 vdd vdd
+ vss vss gf180mcu_fd_sc_mcu7t5v0__oai22_1
X_09063_ _09063_/A1 _09104_/A2 _09063_/B _09885_/D vdd vdd vss vss
+ gf180mcu_fd_sc_mcu7t5v0__aoi21_1
X_08014_ _07771_/C _08014_/A2 _08014_/B _08565_/C _08016_/A1 vdd vdd vss
+ vss gf180mcu_fd_sc_mcu7t5v0__aoi211_1
X_05226_ _09393_/A1 _05217_/S _05227_/B vdd vdd vss vss gf180mcu_fd_sc_mcu7t5v0__nor2_1
X_05157_ _09763_/Q _09762_/Q _05157_/Z vdd vdd vss vss gf180mcu_fd_sc_mcu7t5v0__and2_2
X_05088_ _09541_/Q _05389_/B2 vdd vdd vss vss gf180mcu_fd_sc_mcu7t5v0__clkinv_1
X_09965_ _09965_/D clk _09965_/Q vdd vdd vss vss gf180mcu_fd_sc_mcu7t5v0__dffq_1
X_08916_ _09022_/A1 _09400_/A2 _08925_/A2 vdd vdd vss vss gf180mcu_fd_sc_mcu7t5v0__nand2_4
XTAP_970 vdd vss gf180mcu_fd_sc_mcu7t5v0__filltie
X_09896_ _09896_/D clk _09896_/Q vdd vdd vss vss gf180mcu_fd_sc_mcu7t5v0__dffq_1
XTAP_981 vdd vss gf180mcu_fd_sc_mcu7t5v0__filltie
XTAP_992 vdd vss gf180mcu_fd_sc_mcu7t5v0__filltie
X_08847_ _09777_/Q _08847_/A2 _08847_/Z vdd vdd vss vss gf180mcu_fd_sc_mcu7t5v0__xor2_1
X_08778_ _08778_/A1 _08782_/A2 _08778_/B _09751_/D vdd vdd vss vss
+ gf180mcu_fd_sc_mcu7t5v0__aoi21_1
X_07729_ _07729_/A1 _07729_/A2 _07733_/A2 vdd vdd vss vss gf180mcu_fd_sc_mcu7t5v0__xnor2_1
X_10036_ _10036_/ZN vdd vdd vss vss gf180mcu_fd_sc_mcu7t5v0__tiel
X_06060_ _06065_/A1 _06065_/A2 _06066_/A1 vdd vdd vss vss gf180mcu_fd_sc_mcu7t5v0__nand2_1
X_05011_ _10024_/Q _09407_/B2 vdd vdd vss vss gf180mcu_fd_sc_mcu7t5v0__clkinv_1
X_09750_ _09750_/D clk _09750_/Q vdd vdd vss vss gf180mcu_fd_sc_mcu7t5v0__dffq_1
X_06962_ _09999_/Q _09104_/A2 _09278_/C _06963_/B vdd vdd vss vss
+ gf180mcu_fd_sc_mcu7t5v0__oai21_1
X_05913_ _05913_/A1 _05911_/Z _05913_/Z vdd vdd vss vss gf180mcu_fd_sc_mcu7t5v0__xor2_1
XTAP_288 vdd vss gf180mcu_fd_sc_mcu7t5v0__filltie
XTAP_299 vdd vss gf180mcu_fd_sc_mcu7t5v0__filltie
XTAP_277 vdd vss gf180mcu_fd_sc_mcu7t5v0__filltie
X_09681_ _09681_/D clk _09681_/Q vdd vdd vss vss gf180mcu_fd_sc_mcu7t5v0__dffq_2
X_08701_ _08561_/B _08704_/A1 _08701_/B _08701_/C _08705_/B vdd vdd vss
+ vss gf180mcu_fd_sc_mcu7t5v0__oai211_1
X_06893_ _09711_/Q _06845_/Z _06890_/Z _09710_/Q _06895_/A3 vdd vdd vss
+ vss gf180mcu_fd_sc_mcu7t5v0__aoi22_1
X_08632_ _09687_/Q _08386_/Z _08633_/B vdd vdd vss vss gf180mcu_fd_sc_mcu7t5v0__nand2_1
X_05844_ _05793_/Z _05846_/A3 _05888_/B vdd vdd vss vss gf180mcu_fd_sc_mcu7t5v0__nor2_1
X_05775_ _05862_/A1 _05758_/Z _05768_/Z _05775_/B2 _05775_/C _05776_/B vdd vdd
+ vss vss gf180mcu_fd_sc_mcu7t5v0__aoi221_1
X_08563_ _08476_/C _08563_/A2 _08564_/B vdd vdd vss vss gf180mcu_fd_sc_mcu7t5v0__nand2_1
X_08494_ _08494_/A1 _08525_/A2 _08569_/A1 vdd vdd vss vss gf180mcu_fd_sc_mcu7t5v0__nor2_1
X_04726_ _09888_/Q _09069_/A1 vdd vdd vss vss gf180mcu_fd_sc_mcu7t5v0__clkinv_1
X_07514_ _07514_/A1 _07514_/A2 _07514_/B _07564_/A1 vdd vdd vss vss
+ gf180mcu_fd_sc_mcu7t5v0__aoi21_1
X_07445_ _09713_/Q _07444_/Z _07446_/I vdd vdd vss vss gf180mcu_fd_sc_mcu7t5v0__nand2_1
X_07376_ _08424_/A1 _08565_/C _07376_/B1 _07376_/B2 _08670_/B _09648_/D vdd
+ vdd vss vss gf180mcu_fd_sc_mcu7t5v0__aoi221_1
X_06327_ _09883_/Q _06387_/B _09603_/Q _06362_/A3 vdd vdd vss vss
+ gf180mcu_fd_sc_mcu7t5v0__aoi21_4
X_09115_ _09472_/Q _09468_/Q _09459_/Q _09116_/I vdd vdd vss vss
+ gf180mcu_fd_sc_mcu7t5v0__or3_2
X_06258_ _09716_/Q _06261_/A2 _06260_/A2 vdd vdd vss vss gf180mcu_fd_sc_mcu7t5v0__nand2_1
X_09046_ _09554_/Q _09033_/I _09048_/A1 vdd vdd vss vss gf180mcu_fd_sc_mcu7t5v0__nand2_1
X_05209_ _09899_/Q _09032_/A2 _09104_/A1 vdd vdd vss vss gf180mcu_fd_sc_mcu7t5v0__nand2_2
X_06189_ _06212_/A1 _06188_/Z _06189_/Z vdd vdd vss vss gf180mcu_fd_sc_mcu7t5v0__xor2_1
X_09948_ _09948_/D clk _09948_/Q vdd vdd vss vss gf180mcu_fd_sc_mcu7t5v0__dffq_1
X_09879_ _09879_/D clk _09879_/Q vdd vdd vss vss gf180mcu_fd_sc_mcu7t5v0__dffq_2
XTAP_1900 vdd vss gf180mcu_fd_sc_mcu7t5v0__filltie
XTAP_1933 vdd vss gf180mcu_fd_sc_mcu7t5v0__filltie
XTAP_1922 vdd vss gf180mcu_fd_sc_mcu7t5v0__filltie
XTAP_1911 vdd vss gf180mcu_fd_sc_mcu7t5v0__filltie
XTAP_1977 vdd vss gf180mcu_fd_sc_mcu7t5v0__filltie
XTAP_1966 vdd vss gf180mcu_fd_sc_mcu7t5v0__filltie
XTAP_1944 vdd vss gf180mcu_fd_sc_mcu7t5v0__filltie
XTAP_1955 vdd vss gf180mcu_fd_sc_mcu7t5v0__filltie
XTAP_1999 vdd vss gf180mcu_fd_sc_mcu7t5v0__filltie
XTAP_1988 vdd vss gf180mcu_fd_sc_mcu7t5v0__filltie
X_10019_ _10019_/D clk _10019_/Q vdd vdd vss vss gf180mcu_fd_sc_mcu7t5v0__dffq_1
X_05560_ _09644_/Q _05627_/A2 _05627_/B1 _09699_/Q _05562_/A1 vdd vdd
+ vss vss gf180mcu_fd_sc_mcu7t5v0__aoi22_1
X_05491_ _09663_/Q _05628_/A2 _05628_/B1 _09726_/Q _05492_/A2 vdd vdd
+ vss vss gf180mcu_fd_sc_mcu7t5v0__aoi22_1
X_07230_ _07232_/A2 _07232_/A3 _07253_/B vdd vdd vss vss gf180mcu_fd_sc_mcu7t5v0__nor2_1
X_07161_ _09710_/Q _07160_/Z _07219_/A1 vdd vdd vss vss gf180mcu_fd_sc_mcu7t5v0__nand2_1
X_06112_ _09713_/Q _06305_/A1 _09580_/Q _09581_/Q _06113_/C vdd vdd vss
+ vss gf180mcu_fd_sc_mcu7t5v0__oai211_1
X_07092_ _07247_/A1 _07208_/A1 _07092_/B1 _07092_/B2 _07092_/C _07093_/B vdd
+ vdd vss vss gf180mcu_fd_sc_mcu7t5v0__oai221_1
X_06043_ _06043_/A1 _06043_/A2 _06078_/A1 vdd vdd vss vss gf180mcu_fd_sc_mcu7t5v0__nand2_1
X_09802_ _09802_/D clk _09802_/Q vdd vdd vss vss gf180mcu_fd_sc_mcu7t5v0__dffq_1
X_07994_ _09714_/Q _07788_/Z _07995_/A3 vdd vdd vss vss gf180mcu_fd_sc_mcu7t5v0__nand2_1
X_06945_ _06945_/A1 _06945_/A2 _06944_/Z _06945_/Z vdd vdd vss vss
+ gf180mcu_fd_sc_mcu7t5v0__xor3_1
X_09733_ _09733_/D clk _09733_/Q vdd vdd vss vss gf180mcu_fd_sc_mcu7t5v0__dffq_1
X_09664_ _09664_/D clk _09664_/Q vdd vdd vss vss gf180mcu_fd_sc_mcu7t5v0__dffq_1
X_06876_ _06876_/A1 _06858_/Z _06876_/B _06925_/A1 vdd vdd vss vss
+ gf180mcu_fd_sc_mcu7t5v0__aoi21_1
X_09595_ _09595_/D clk _09595_/Q vdd vdd vss vss gf180mcu_fd_sc_mcu7t5v0__dffq_2
X_08615_ _09708_/Q _08565_/C _08670_/A1 vdd vdd vss vss gf180mcu_fd_sc_mcu7t5v0__nand2_1
X_05827_ _09563_/Q _08565_/C _05878_/A1 vdd vdd vss vss gf180mcu_fd_sc_mcu7t5v0__nand2_1
XTAP_1218 vdd vss gf180mcu_fd_sc_mcu7t5v0__filltie
XTAP_1207 vdd vss gf180mcu_fd_sc_mcu7t5v0__filltie
XTAP_1229 vdd vss gf180mcu_fd_sc_mcu7t5v0__filltie
X_05758_ _05758_/A1 _05804_/A1 _05758_/A3 _05758_/Z vdd vdd vss vss
+ gf180mcu_fd_sc_mcu7t5v0__xor3_1
X_08546_ _08546_/A1 _08550_/A2 _08548_/B vdd vdd vss vss gf180mcu_fd_sc_mcu7t5v0__xor2_1
X_05689_ _05645_/I _05722_/B _05689_/B _05691_/A2 vdd vdd vss vss
+ gf180mcu_fd_sc_mcu7t5v0__oai21_1
X_08477_ _08656_/A1 _08477_/A2 _08471_/Z _08432_/B _08477_/C _08478_/B2 vdd
+ vdd vss vss gf180mcu_fd_sc_mcu7t5v0__aoi221_1
X_04709_ _09917_/Q _09391_/A1 vdd vdd vss vss gf180mcu_fd_sc_mcu7t5v0__clkinv_8
X_07428_ _09595_/Q _07426_/Z _07526_/B vdd vdd vss vss gf180mcu_fd_sc_mcu7t5v0__or2_1
X_07359_ _07649_/A1 _07359_/A2 _07359_/Z vdd vdd vss vss gf180mcu_fd_sc_mcu7t5v0__or2_1
X_09029_ _09407_/A1 _09031_/A2 _09031_/B1 _09029_/B2 _09872_/D vdd vdd
+ vss vss gf180mcu_fd_sc_mcu7t5v0__oai22_1
XTAP_1752 vdd vss gf180mcu_fd_sc_mcu7t5v0__filltie
XTAP_1741 vdd vss gf180mcu_fd_sc_mcu7t5v0__filltie
XTAP_1730 vdd vss gf180mcu_fd_sc_mcu7t5v0__filltie
XTAP_1785 vdd vss gf180mcu_fd_sc_mcu7t5v0__filltie
XTAP_1774 vdd vss gf180mcu_fd_sc_mcu7t5v0__filltie
XTAP_1763 vdd vss gf180mcu_fd_sc_mcu7t5v0__filltie
XTAP_1796 vdd vss gf180mcu_fd_sc_mcu7t5v0__filltie
X_04991_ _09478_/Q _05314_/B2 vdd vdd vss vss gf180mcu_fd_sc_mcu7t5v0__clkinv_1
X_06730_ _08715_/A1 _06729_/Z _06774_/A1 vdd vdd vss vss gf180mcu_fd_sc_mcu7t5v0__nor2_1
X_06661_ _09613_/Q _06674_/B _06661_/Z vdd vdd vss vss gf180mcu_fd_sc_mcu7t5v0__xor2_1
X_05612_ _09742_/Q _05627_/A2 _05627_/B1 _09874_/Q _05614_/A1 vdd vdd
+ vss vss gf180mcu_fd_sc_mcu7t5v0__aoi22_1
X_08400_ _09720_/Q _09719_/Q _08426_/A2 vdd vdd vss vss gf180mcu_fd_sc_mcu7t5v0__nor2_2
X_06592_ _09716_/Q _06626_/A2 _06592_/B _06593_/A4 vdd vdd vss vss
+ gf180mcu_fd_sc_mcu7t5v0__oai21_1
X_09380_ _09391_/A1 _09378_/Z _09380_/B _09399_/C _10009_/D vdd vdd vss
+ vss gf180mcu_fd_sc_mcu7t5v0__aoi211_1
X_05543_ _05543_/A1 _05543_/A2 _05545_/B1 vdd vdd vss vss gf180mcu_fd_sc_mcu7t5v0__nand2_1
X_08331_ _09675_/Q _08132_/Z _08331_/B1 _09633_/Q _08332_/A2 vdd vdd vss
+ vss gf180mcu_fd_sc_mcu7t5v0__aoi22_1
X_05474_ _09516_/Q _05628_/A2 _05628_/B1 _09476_/Q _05475_/A2 vdd vdd
+ vss vss gf180mcu_fd_sc_mcu7t5v0__aoi22_1
X_08262_ _08721_/A1 _08287_/A1 _08287_/A2 _08266_/B1 vdd vdd vss vss
+ gf180mcu_fd_sc_mcu7t5v0__nand3_1
X_07213_ _07216_/B1 _07216_/B2 _07215_/A1 vdd vdd vss vss gf180mcu_fd_sc_mcu7t5v0__nor2_1
X_08193_ _08194_/A2 _08190_/Z _08224_/B vdd vdd vss vss gf180mcu_fd_sc_mcu7t5v0__xor2_1
X_07144_ _07062_/Z _07144_/A2 _07144_/B _07172_/A1 vdd vdd vss vss
+ gf180mcu_fd_sc_mcu7t5v0__oai21_1
X_07075_ _07075_/A1 _07073_/Z _07075_/Z vdd vdd vss vss gf180mcu_fd_sc_mcu7t5v0__xor2_1
X_06026_ _06297_/I0 _06297_/I1 _06026_/S _06026_/Z vdd vdd vss vss
+ gf180mcu_fd_sc_mcu7t5v0__mux2_1
X_07977_ _07977_/A1 _07977_/A2 _07998_/A1 vdd vdd vss vss gf180mcu_fd_sc_mcu7t5v0__nand2_1
X_06928_ _06928_/A1 _06928_/A2 _06896_/Z _06928_/B _06944_/A1 vdd vdd
+ vss vss gf180mcu_fd_sc_mcu7t5v0__oai31_1
X_09716_ _09716_/D clk _09716_/Q vdd vdd vss vss gf180mcu_fd_sc_mcu7t5v0__dffq_4
XTAP_1004 vdd vss gf180mcu_fd_sc_mcu7t5v0__filltie
X_06859_ _09618_/Q _06857_/Z _06876_/B vdd vdd vss vss gf180mcu_fd_sc_mcu7t5v0__and2_1
X_09647_ _09647_/D clk _09647_/Q vdd vdd vss vss gf180mcu_fd_sc_mcu7t5v0__dffq_4
XTAP_1015 vdd vss gf180mcu_fd_sc_mcu7t5v0__filltie
XTAP_1026 vdd vss gf180mcu_fd_sc_mcu7t5v0__filltie
XTAP_1037 vdd vss gf180mcu_fd_sc_mcu7t5v0__filltie
X_09578_ _09578_/D clk _09578_/Q vdd vdd vss vss gf180mcu_fd_sc_mcu7t5v0__dffq_2
X_08529_ _09710_/Q _08626_/A2 _08535_/A2 vdd vdd vss vss gf180mcu_fd_sc_mcu7t5v0__nand2_1
XTAP_1048 vdd vss gf180mcu_fd_sc_mcu7t5v0__filltie
XTAP_1059 vdd vss gf180mcu_fd_sc_mcu7t5v0__filltie
XTAP_1560 vdd vss gf180mcu_fd_sc_mcu7t5v0__filltie
XTAP_1582 vdd vss gf180mcu_fd_sc_mcu7t5v0__filltie
XTAP_1571 vdd vss gf180mcu_fd_sc_mcu7t5v0__filltie
XTAP_1593 vdd vss gf180mcu_fd_sc_mcu7t5v0__filltie
X_05190_ _09228_/A1 _09925_/Q _05184_/B _09460_/D vdd vdd vss vss
+ gf180mcu_fd_sc_mcu7t5v0__nor3_1
X_07900_ _07900_/A1 _07926_/B2 _07896_/Z _07900_/Z vdd vdd vss vss
+ gf180mcu_fd_sc_mcu7t5v0__xor3_1
X_08880_ _09789_/Q _09523_/Q _08880_/B _08882_/A2 vdd vdd vss vss
+ gf180mcu_fd_sc_mcu7t5v0__aoi21_1
X_07831_ _09710_/Q _07830_/I _07835_/A3 vdd vdd vss vss gf180mcu_fd_sc_mcu7t5v0__nand2_1
X_09501_ _09501_/D clk _09501_/Q vdd vdd vss vss gf180mcu_fd_sc_mcu7t5v0__dffq_1
X_07762_ _07879_/A2 _07762_/A2 _07762_/Z vdd vdd vss vss gf180mcu_fd_sc_mcu7t5v0__xor2_1
X_04974_ _09854_/Q _09007_/B2 vdd vdd vss vss gf180mcu_fd_sc_mcu7t5v0__clkinv_1
X_07693_ _09678_/Q _08020_/A1 _09676_/Q _07862_/A1 vdd vdd vss vss
+ gf180mcu_fd_sc_mcu7t5v0__nand3_2
X_06713_ _06713_/A1 _06713_/A2 _06713_/Z vdd vdd vss vss gf180mcu_fd_sc_mcu7t5v0__and2_1
X_06644_ _09013_/A1 _06652_/A2 _06652_/B1 vdd vdd vss vss gf180mcu_fd_sc_mcu7t5v0__nand2_2
X_09432_ _09432_/D clk _09432_/Q vdd vdd vss vss gf180mcu_fd_sc_mcu7t5v0__dffq_1
X_06575_ _06575_/A1 _06521_/Z _06575_/B _06597_/A2 vdd vdd vss vss
+ gf180mcu_fd_sc_mcu7t5v0__aoi21_1
XPHY_109 vdd vss gf180mcu_fd_sc_mcu7t5v0__endcap
X_09363_ _10002_/Q _09366_/A2 _09364_/B vdd vdd vss vss gf180mcu_fd_sc_mcu7t5v0__nor2_1
X_05526_ _09486_/Q _05628_/A2 _05628_/B1 _09502_/Q _05527_/A2 vdd vdd
+ vss vss gf180mcu_fd_sc_mcu7t5v0__aoi22_1
X_08314_ _09716_/Q _08313_/Z _08352_/B vdd vdd vss vss gf180mcu_fd_sc_mcu7t5v0__nand2_1
X_09294_ _09395_/A1 _09298_/A2 _09294_/B _09399_/C _09971_/D vdd vdd vss
+ vss gf180mcu_fd_sc_mcu7t5v0__aoi211_1
X_08245_ _08232_/Z _08247_/A3 _08245_/Z vdd vdd vss vss gf180mcu_fd_sc_mcu7t5v0__and2_1
X_05457_ _05631_/B2 _05457_/A2 _05457_/B1 _09105_/A2 _05457_/C1 _09400_/A2 _05459_/A2
+ vdd vdd vss vss gf180mcu_fd_sc_mcu7t5v0__aoi222_2
X_08176_ _08128_/I _08225_/A2 _08176_/A3 _08194_/A2 vdd vdd vss vss
+ gf180mcu_fd_sc_mcu7t5v0__xnor3_1
X_05388_ _09408_/A1 _05389_/A2 _05389_/B1 _05388_/B2 _09540_/D vdd vdd
+ vss vss gf180mcu_fd_sc_mcu7t5v0__oai22_1
X_07127_ _07106_/Z _07127_/A2 _07127_/Z vdd vdd vss vss gf180mcu_fd_sc_mcu7t5v0__xor2_1
X_07058_ _07058_/A1 _07058_/A2 _08670_/B _09628_/D vdd vdd vss vss
+ gf180mcu_fd_sc_mcu7t5v0__aoi21_1
X_06009_ _09571_/Q _08706_/B _08708_/B _06009_/C _06010_/I vdd vdd vss
+ vss gf180mcu_fd_sc_mcu7t5v0__oai211_1
XTAP_607 vdd vss gf180mcu_fd_sc_mcu7t5v0__filltie
XTAP_629 vdd vss gf180mcu_fd_sc_mcu7t5v0__filltie
XTAP_618 vdd vss gf180mcu_fd_sc_mcu7t5v0__filltie
X_06360_ _09600_/Q _06361_/A2 _06360_/Z vdd vdd vss vss gf180mcu_fd_sc_mcu7t5v0__and2_1
XTAP_1390 vdd vss gf180mcu_fd_sc_mcu7t5v0__filltie
X_06291_ _09716_/Q _06252_/Z _06291_/B _06295_/A1 vdd vdd vss vss
+ gf180mcu_fd_sc_mcu7t5v0__aoi21_1
X_05311_ _09403_/A1 _05317_/A2 _05317_/B1 _05311_/B2 _09475_/D vdd vdd
+ vss vss gf180mcu_fd_sc_mcu7t5v0__oai22_1
X_08030_ _08088_/A2 _08088_/A3 _08030_/Z vdd vdd vss vss gf180mcu_fd_sc_mcu7t5v0__and2_4
X_05242_ _09923_/Q _05217_/S _05242_/B _09408_/A1 vdd vdd vss vss
+ gf180mcu_fd_sc_mcu7t5v0__oai21_4
X_05173_ _09786_/Q _09299_/A3 _05131_/Z _09778_/Q _05174_/A2 vdd vdd vss
+ vss gf180mcu_fd_sc_mcu7t5v0__aoi22_1
X_09981_ _09981_/D clk _09981_/Q vdd vdd vss vss gf180mcu_fd_sc_mcu7t5v0__dffq_1
X_08932_ _09811_/Q _09812_/Q _09813_/Q _08932_/Z vdd vdd vss vss gf180mcu_fd_sc_mcu7t5v0__and3_1
X_08863_ _09783_/Q _08860_/B _08863_/B _09783_/D vdd vdd vss vss gf180mcu_fd_sc_mcu7t5v0__aoi21_1
X_07814_ _08011_/A1 _07938_/A1 _07814_/B _07814_/C _07815_/C vdd vdd vss
+ vss gf180mcu_fd_sc_mcu7t5v0__oai211_1
X_08794_ _08794_/A1 _08851_/A1 _08794_/B _09759_/D vdd vdd vss vss
+ gf180mcu_fd_sc_mcu7t5v0__aoi21_1
X_07745_ _09683_/Q _08026_/A1 _09679_/Q _07745_/Z vdd vdd vss vss
+ gf180mcu_fd_sc_mcu7t5v0__or3_2
X_04957_ _09445_/Q _05292_/B2 vdd vdd vss vss gf180mcu_fd_sc_mcu7t5v0__clkinv_1
X_09415_ _09415_/D clk _09415_/Q vdd vdd vss vss gf180mcu_fd_sc_mcu7t5v0__dffq_1
X_04888_ _09844_/Q _08995_/B2 vdd vdd vss vss gf180mcu_fd_sc_mcu7t5v0__clkinv_1
X_07676_ _09409_/A1 _07676_/A2 _07676_/B1 _07676_/B2 _09667_/D vdd vdd
+ vss vss gf180mcu_fd_sc_mcu7t5v0__oai22_1
X_06627_ _06627_/A1 _06625_/Z _06627_/A3 _06627_/Z vdd vdd vss vss
+ gf180mcu_fd_sc_mcu7t5v0__xor3_1
X_06558_ _06447_/Z _06506_/Z _06598_/A1 _06568_/A1 vdd vdd vss vss
+ gf180mcu_fd_sc_mcu7t5v0__xnor3_1
X_09346_ _09994_/Q _09355_/A2 _09347_/B vdd vdd vss vss gf180mcu_fd_sc_mcu7t5v0__nor2_1
X_06489_ _09714_/Q _06555_/A2 _06494_/A1 vdd vdd vss vss gf180mcu_fd_sc_mcu7t5v0__nor2_1
X_05509_ _09830_/Q _05628_/A2 _05628_/B1 _10022_/Q _05510_/A2 vdd vdd
+ vss vss gf180mcu_fd_sc_mcu7t5v0__aoi22_1
X_09277_ _09917_/Q _09286_/A2 _09278_/B vdd vdd vss vss gf180mcu_fd_sc_mcu7t5v0__nand2_1
X_08228_ _09714_/Q _08061_/Z _08230_/B vdd vdd vss vss gf180mcu_fd_sc_mcu7t5v0__nand2_1
X_08159_ _08159_/A1 _08159_/A2 _08159_/B _08211_/A2 vdd vdd vss vss
+ gf180mcu_fd_sc_mcu7t5v0__aoi21_1
XTAP_404 vdd vss gf180mcu_fd_sc_mcu7t5v0__filltie
XTAP_415 vdd vss gf180mcu_fd_sc_mcu7t5v0__filltie
XTAP_437 vdd vss gf180mcu_fd_sc_mcu7t5v0__filltie
XTAP_426 vdd vss gf180mcu_fd_sc_mcu7t5v0__filltie
XTAP_448 vdd vss gf180mcu_fd_sc_mcu7t5v0__filltie
XTAP_459 vdd vss gf180mcu_fd_sc_mcu7t5v0__filltie
X_05860_ _09563_/Q _05858_/Z _05880_/B vdd vdd vss vss gf180mcu_fd_sc_mcu7t5v0__nand2_1
X_05791_ _05795_/A2 _05795_/A3 _05794_/A3 vdd vdd vss vss gf180mcu_fd_sc_mcu7t5v0__nand2_1
X_04811_ _09623_/Q _06967_/A1 vdd vdd vss vss gf180mcu_fd_sc_mcu7t5v0__clkinv_4
X_04742_ _09757_/Q _08790_/A1 vdd vdd vss vss gf180mcu_fd_sc_mcu7t5v0__clkinv_1
X_07530_ _07472_/B _09597_/Q _09658_/Q _07531_/C vdd vdd vss vss gf180mcu_fd_sc_mcu7t5v0__aoi21_2
X_07461_ _09650_/Q _08565_/C _07461_/B1 _07461_/B2 _07462_/A2 vdd vdd
+ vss vss gf180mcu_fd_sc_mcu7t5v0__aoi22_1
X_06412_ _09712_/Q _06629_/A2 _06412_/B1 _06580_/A1 _06412_/C _06413_/B vdd
+ vdd vss vss gf180mcu_fd_sc_mcu7t5v0__aoi221_1
X_07392_ _09649_/Q _07391_/Z _07414_/A1 vdd vdd vss vss gf180mcu_fd_sc_mcu7t5v0__nand2_1
X_09200_ _09932_/Q _09173_/B _09257_/B _09201_/B vdd vdd vss vss gf180mcu_fd_sc_mcu7t5v0__oai21_1
X_06343_ _06329_/Z _06628_/B2 _06367_/B _06343_/B _06347_/A1 vdd vdd vss
+ vss gf180mcu_fd_sc_mcu7t5v0__oai31_1
X_09131_ _09940_/Q _09116_/I _09136_/A2 _09913_/Q _09465_/Q _09132_/A2 vdd vdd
+ vss vss gf180mcu_fd_sc_mcu7t5v0__aoi221_1
X_09062_ _09552_/Q _09104_/A2 _09072_/B _09063_/B vdd vdd vss vss
+ gf180mcu_fd_sc_mcu7t5v0__oai21_1
X_06274_ _09715_/Q _06050_/I _06277_/A2 vdd vdd vss vss gf180mcu_fd_sc_mcu7t5v0__nand2_1
X_05225_ _05225_/A1 _05246_/A2 _09402_/A1 _05246_/B2 _09410_/D vdd vdd
+ vss vss gf180mcu_fd_sc_mcu7t5v0__oai22_1
X_08013_ _08013_/A1 _08013_/A2 _08013_/B _08013_/C _08014_/A2 vdd vdd
+ vss vss gf180mcu_fd_sc_mcu7t5v0__oai211_1
X_05156_ _09226_/B _09732_/Q _05168_/A1 _05163_/B vdd vdd vss vss
+ gf180mcu_fd_sc_mcu7t5v0__nand3_1
X_05087_ _09481_/Q _05317_/B2 vdd vdd vss vss gf180mcu_fd_sc_mcu7t5v0__clkinv_1
X_09964_ _09964_/D clk _09964_/Q vdd vdd vss vss gf180mcu_fd_sc_mcu7t5v0__dffq_1
XTAP_960 vdd vss gf180mcu_fd_sc_mcu7t5v0__filltie
XTAP_971 vdd vss gf180mcu_fd_sc_mcu7t5v0__filltie
X_09895_ _09895_/D clk _09895_/Q vdd vdd vss vss gf180mcu_fd_sc_mcu7t5v0__dffq_1
X_08915_ _09399_/C _08915_/A2 _09802_/D vdd vdd vss vss gf180mcu_fd_sc_mcu7t5v0__nor2_1
XTAP_982 vdd vss gf180mcu_fd_sc_mcu7t5v0__filltie
XTAP_993 vdd vss gf180mcu_fd_sc_mcu7t5v0__filltie
X_08846_ _09776_/Q _08841_/Z _08846_/B _09776_/D vdd vdd vss vss gf180mcu_fd_sc_mcu7t5v0__aoi21_1
X_08777_ _09752_/Q _08782_/A2 _09226_/B _08778_/B vdd vdd vss vss
+ gf180mcu_fd_sc_mcu7t5v0__oai21_1
X_05989_ _09710_/Q _05987_/I _06004_/B vdd vdd vss vss gf180mcu_fd_sc_mcu7t5v0__nand2_1
X_07728_ _09711_/Q _07698_/B _07712_/Z _07756_/A1 vdd vdd vss vss
+ gf180mcu_fd_sc_mcu7t5v0__nand3_1
X_07659_ _09990_/Q _09073_/A2 _08734_/B _07660_/B vdd vdd vss vss
+ gf180mcu_fd_sc_mcu7t5v0__oai21_1
X_09329_ _09395_/A1 _09333_/A2 _09329_/B _09399_/C _09986_/D vdd vdd vss
+ vss gf180mcu_fd_sc_mcu7t5v0__aoi211_1
X_10035_ _10035_/ZN vdd vdd vss vss gf180mcu_fd_sc_mcu7t5v0__tiel
X_05010_ _09739_/Q _08752_/B2 vdd vdd vss vss gf180mcu_fd_sc_mcu7t5v0__clkinv_1
X_06961_ _06961_/A1 _08565_/C _06961_/B1 _06961_/B2 _08670_/B _09620_/D vdd
+ vdd vss vss gf180mcu_fd_sc_mcu7t5v0__aoi221_1
X_05912_ _05913_/A1 _05911_/Z _05938_/A2 vdd vdd vss vss gf180mcu_fd_sc_mcu7t5v0__nand2_1
XTAP_289 vdd vss gf180mcu_fd_sc_mcu7t5v0__filltie
XTAP_278 vdd vss gf180mcu_fd_sc_mcu7t5v0__filltie
X_09680_ _09680_/D clk _09680_/Q vdd vdd vss vss gf180mcu_fd_sc_mcu7t5v0__dffq_4
X_08700_ _09717_/Q _08700_/A2 _08510_/B _08696_/Z _08701_/C vdd vdd vss
+ vss gf180mcu_fd_sc_mcu7t5v0__aoi22_1
X_08631_ _07611_/B _08631_/A2 _08638_/B vdd vdd vss vss gf180mcu_fd_sc_mcu7t5v0__nor2_1
X_06892_ _06928_/A2 _06933_/A1 _06937_/S vdd vdd vss vss gf180mcu_fd_sc_mcu7t5v0__nor2_1
X_05843_ _05843_/A1 _05837_/Z _05843_/A3 _05846_/A3 vdd vdd vss vss
+ gf180mcu_fd_sc_mcu7t5v0__xnor3_1
X_08562_ _08510_/B _08562_/A2 _08562_/A3 _08626_/A2 _09714_/Q _08563_/A2 vdd
+ vdd vss vss gf180mcu_fd_sc_mcu7t5v0__oai32_1
X_05774_ _05733_/C _05774_/A2 _05775_/C vdd vdd vss vss gf180mcu_fd_sc_mcu7t5v0__nand2_1
X_08493_ _09711_/Q _08677_/A2 _08525_/A2 vdd vdd vss vss gf180mcu_fd_sc_mcu7t5v0__nand2_1
X_07513_ _08670_/B _07513_/A2 _09651_/D vdd vdd vss vss gf180mcu_fd_sc_mcu7t5v0__nor2_1
X_04725_ _09889_/Q _09071_/A1 vdd vdd vss vss gf180mcu_fd_sc_mcu7t5v0__inv_1
X_07444_ _07623_/A2 _07444_/A2 _07444_/Z vdd vdd vss vss gf180mcu_fd_sc_mcu7t5v0__xor2_1
X_07375_ _08565_/C _07375_/A2 _07376_/B2 vdd vdd vss vss gf180mcu_fd_sc_mcu7t5v0__nor2_1
X_09114_ _09409_/A1 _09114_/A2 _09114_/B1 _09114_/B2 _09907_/D vdd vdd
+ vss vss gf180mcu_fd_sc_mcu7t5v0__oai22_1
X_06326_ _06387_/B _09571_/Q _06362_/A2 vdd vdd vss vss gf180mcu_fd_sc_mcu7t5v0__nor2_2
X_06257_ _06296_/A1 _06257_/A2 _06262_/A3 vdd vdd vss vss gf180mcu_fd_sc_mcu7t5v0__nand2_1
X_09045_ _09045_/A1 _09045_/A2 _09399_/C _09878_/D vdd vdd vss vss
+ gf180mcu_fd_sc_mcu7t5v0__aoi21_1
X_05208_ _05203_/I _05204_/Z _05413_/A1 _09012_/A1 vdd vdd vss vss
+ gf180mcu_fd_sc_mcu7t5v0__nor3_4
X_06188_ _06188_/A1 _06188_/A2 _06188_/Z vdd vdd vss vss gf180mcu_fd_sc_mcu7t5v0__xor2_1
X_05139_ _09915_/Q _09914_/Q _09913_/Q _09209_/A2 vdd vdd vss vss
+ gf180mcu_fd_sc_mcu7t5v0__nor3_4
X_09947_ _09947_/D clk _09947_/Q vdd vdd vss vss gf180mcu_fd_sc_mcu7t5v0__dffq_1
XTAP_790 vdd vss gf180mcu_fd_sc_mcu7t5v0__filltie
X_09878_ _09878_/D clk _09878_/Q vdd vdd vss vss gf180mcu_fd_sc_mcu7t5v0__dffq_2
X_08829_ _09771_/Q _08826_/Z _08829_/Z vdd vdd vss vss gf180mcu_fd_sc_mcu7t5v0__and2_1
XTAP_1901 vdd vss gf180mcu_fd_sc_mcu7t5v0__filltie
XTAP_1934 vdd vss gf180mcu_fd_sc_mcu7t5v0__filltie
XTAP_1923 vdd vss gf180mcu_fd_sc_mcu7t5v0__filltie
XTAP_1912 vdd vss gf180mcu_fd_sc_mcu7t5v0__filltie
XTAP_1967 vdd vss gf180mcu_fd_sc_mcu7t5v0__filltie
XTAP_1956 vdd vss gf180mcu_fd_sc_mcu7t5v0__filltie
XTAP_1945 vdd vss gf180mcu_fd_sc_mcu7t5v0__filltie
XTAP_1989 vdd vss gf180mcu_fd_sc_mcu7t5v0__filltie
XTAP_1978 vdd vss gf180mcu_fd_sc_mcu7t5v0__filltie
X_10018_ _10018_/D clk _10018_/Q vdd vdd vss vss gf180mcu_fd_sc_mcu7t5v0__dffq_1
X_05490_ _09642_/Q _05627_/A2 _05627_/B1 _09697_/Q _05492_/A1 vdd vdd
+ vss vss gf180mcu_fd_sc_mcu7t5v0__aoi22_1
X_07160_ _09576_/Q _09652_/Q _09686_/Q _09618_/Q _09638_/Q _09637_/Q _07160_/Z vdd
+ vdd vss vss gf180mcu_fd_sc_mcu7t5v0__mux4_4
X_06111_ _06297_/I1 _06224_/A1 _06259_/C _06113_/B1 vdd vdd vss vss
+ gf180mcu_fd_sc_mcu7t5v0__aoi21_1
X_07091_ _09713_/Q _07287_/A2 _07092_/C vdd vdd vss vss gf180mcu_fd_sc_mcu7t5v0__nand2_1
X_06042_ _08706_/B _06042_/A2 _06042_/B _09572_/D vdd vdd vss vss
+ gf180mcu_fd_sc_mcu7t5v0__aoi21_1
X_09801_ _09801_/D clk _09801_/Q vdd vdd vss vss gf180mcu_fd_sc_mcu7t5v0__dffq_1
X_07993_ _09715_/Q _07749_/Z _07995_/A2 vdd vdd vss vss gf180mcu_fd_sc_mcu7t5v0__nand2_1
X_09732_ _09732_/D clk _09732_/Q vdd vdd vss vss gf180mcu_fd_sc_mcu7t5v0__dffq_2
X_06944_ _06944_/A1 _06944_/A2 _06943_/Z _06944_/Z vdd vdd vss vss
+ gf180mcu_fd_sc_mcu7t5v0__xor3_1
X_09663_ _09663_/D clk _09663_/Q vdd vdd vss vss gf180mcu_fd_sc_mcu7t5v0__dffq_1
X_06875_ _06875_/A1 _06875_/A2 _08670_/B _09618_/D vdd vdd vss vss
+ gf180mcu_fd_sc_mcu7t5v0__aoi21_1
X_05826_ _08670_/B _05826_/A2 _09562_/D vdd vdd vss vss gf180mcu_fd_sc_mcu7t5v0__nor2_1
X_08614_ _08614_/A1 _08614_/A2 _08670_/B _09707_/D vdd vdd vss vss
+ gf180mcu_fd_sc_mcu7t5v0__aoi21_1
X_09594_ _09594_/D clk _09594_/Q vdd vdd vss vss gf180mcu_fd_sc_mcu7t5v0__dffq_2
X_08545_ _08546_/A1 _08550_/A2 _08545_/Z vdd vdd vss vss gf180mcu_fd_sc_mcu7t5v0__or2_1
XTAP_1219 vdd vss gf180mcu_fd_sc_mcu7t5v0__filltie
XTAP_1208 vdd vss gf180mcu_fd_sc_mcu7t5v0__filltie
X_05757_ _05804_/A1 _05756_/Z _05807_/A2 vdd vdd vss vss gf180mcu_fd_sc_mcu7t5v0__nor2_1
X_05688_ _05645_/I _05689_/B _05722_/B _05688_/Z vdd vdd vss vss gf180mcu_fd_sc_mcu7t5v0__or3_1
X_08476_ _08476_/A1 _08525_/A1 _08476_/B _08476_/C _08477_/C vdd vdd vss
+ vss gf180mcu_fd_sc_mcu7t5v0__oai211_1
X_04708_ _09918_/Q _09393_/A1 vdd vdd vss vss gf180mcu_fd_sc_mcu7t5v0__clkinv_8
X_07427_ _09595_/Q _07426_/Z _07452_/B vdd vdd vss vss gf180mcu_fd_sc_mcu7t5v0__nor2_2
X_07358_ _07358_/A1 _07356_/Z _07359_/A2 vdd vdd vss vss gf180mcu_fd_sc_mcu7t5v0__nor2_1
X_06309_ _06309_/A1 _09104_/A2 _06309_/B _09581_/D vdd vdd vss vss
+ gf180mcu_fd_sc_mcu7t5v0__aoi21_1
X_07289_ _07278_/Z _07289_/A2 _07289_/A3 _07289_/B _07290_/B vdd vdd vss
+ vss gf180mcu_fd_sc_mcu7t5v0__oai31_1
X_09028_ _09406_/A1 _09031_/A2 _09031_/B1 _09028_/B2 _09871_/D vdd vdd
+ vss vss gf180mcu_fd_sc_mcu7t5v0__oai22_1
XTAP_1742 vdd vss gf180mcu_fd_sc_mcu7t5v0__filltie
XTAP_1720 vdd vss gf180mcu_fd_sc_mcu7t5v0__filltie
XTAP_1731 vdd vss gf180mcu_fd_sc_mcu7t5v0__filltie
XTAP_1775 vdd vss gf180mcu_fd_sc_mcu7t5v0__filltie
XTAP_1764 vdd vss gf180mcu_fd_sc_mcu7t5v0__filltie
XTAP_1753 vdd vss gf180mcu_fd_sc_mcu7t5v0__filltie
XTAP_1797 vdd vss gf180mcu_fd_sc_mcu7t5v0__filltie
XTAP_1786 vdd vss gf180mcu_fd_sc_mcu7t5v0__filltie
X_04990_ _09454_/Q _05303_/B2 vdd vdd vss vss gf180mcu_fd_sc_mcu7t5v0__clkinv_1
X_06660_ _09613_/Q _06674_/B _06708_/A1 vdd vdd vss vss gf180mcu_fd_sc_mcu7t5v0__nand2_1
X_05611_ _05611_/A1 _05611_/A2 _05631_/C2 vdd vdd vss vss gf180mcu_fd_sc_mcu7t5v0__nand2_1
X_06591_ _06591_/A1 _06591_/A2 _06591_/B _06592_/B vdd vdd vss vss
+ gf180mcu_fd_sc_mcu7t5v0__oai21_1
X_05542_ _09798_/Q _05628_/A2 _05628_/B1 _09904_/Q _05543_/A2 vdd vdd
+ vss vss gf180mcu_fd_sc_mcu7t5v0__aoi22_1
X_08330_ _09709_/Q _09693_/Q _08180_/B _08332_/A1 vdd vdd vss vss
+ gf180mcu_fd_sc_mcu7t5v0__nand3_1
X_05473_ _09528_/Q _05627_/A2 _05627_/B1 _09536_/Q _05475_/A1 vdd vdd
+ vss vss gf180mcu_fd_sc_mcu7t5v0__aoi22_1
X_08261_ _08311_/A1 _08260_/Z _08261_/Z vdd vdd vss vss gf180mcu_fd_sc_mcu7t5v0__xor2_1
X_07212_ _08633_/A1 _09638_/Q _09637_/Q _07216_/B2 vdd vdd vss vss
+ gf180mcu_fd_sc_mcu7t5v0__aoi21_1
X_08192_ _08192_/I _08274_/A1 vdd vdd vss vss gf180mcu_fd_sc_mcu7t5v0__clkinv_1
X_07143_ _07143_/A1 _07143_/A2 _07195_/A1 vdd vdd vss vss gf180mcu_fd_sc_mcu7t5v0__nor2_1
X_07074_ _07075_/A1 _07073_/Z _07121_/A1 vdd vdd vss vss gf180mcu_fd_sc_mcu7t5v0__nand2_1
X_06025_ _08430_/B _06016_/I _06026_/S vdd vdd vss vss gf180mcu_fd_sc_mcu7t5v0__or2_1
X_07976_ _07976_/A1 _07976_/A2 _07976_/B _07999_/A2 vdd vdd vss vss
+ gf180mcu_fd_sc_mcu7t5v0__aoi21_1
X_06927_ _06927_/A1 _06927_/A2 _06927_/B _06945_/A2 vdd vdd vss vss
+ gf180mcu_fd_sc_mcu7t5v0__oai21_1
X_09715_ _09715_/D clk _09715_/Q vdd vdd vss vss gf180mcu_fd_sc_mcu7t5v0__dffq_4
X_09646_ _09646_/D clk _09646_/Q vdd vdd vss vss gf180mcu_fd_sc_mcu7t5v0__dffq_1
X_06858_ _09618_/Q _06857_/Z _06858_/Z vdd vdd vss vss gf180mcu_fd_sc_mcu7t5v0__or2_1
X_09577_ _09577_/D clk _09577_/Q vdd vdd vss vss gf180mcu_fd_sc_mcu7t5v0__dffq_2
X_05809_ _05809_/A1 _05808_/B _05809_/Z vdd vdd vss vss gf180mcu_fd_sc_mcu7t5v0__xor2_1
XTAP_1016 vdd vss gf180mcu_fd_sc_mcu7t5v0__filltie
XTAP_1005 vdd vss gf180mcu_fd_sc_mcu7t5v0__filltie
XTAP_1027 vdd vss gf180mcu_fd_sc_mcu7t5v0__filltie
XTAP_1038 vdd vss gf180mcu_fd_sc_mcu7t5v0__filltie
X_06789_ _06790_/A1 _06755_/Z _06831_/A2 vdd vdd vss vss gf180mcu_fd_sc_mcu7t5v0__nand2_1
XTAP_1049 vdd vss gf180mcu_fd_sc_mcu7t5v0__filltie
X_08528_ _07494_/B _08389_/Z _08528_/B _08626_/A2 vdd vdd vss vss
+ gf180mcu_fd_sc_mcu7t5v0__oai21_4
X_08459_ _08460_/A1 _08460_/A3 _08490_/A2 vdd vdd vss vss gf180mcu_fd_sc_mcu7t5v0__nand2_1
XTAP_1550 vdd vss gf180mcu_fd_sc_mcu7t5v0__filltie
XPHY_90 vdd vss gf180mcu_fd_sc_mcu7t5v0__endcap
XTAP_1561 vdd vss gf180mcu_fd_sc_mcu7t5v0__filltie
XTAP_1583 vdd vss gf180mcu_fd_sc_mcu7t5v0__filltie
XTAP_1572 vdd vss gf180mcu_fd_sc_mcu7t5v0__filltie
XTAP_1594 vdd vss gf180mcu_fd_sc_mcu7t5v0__filltie
X_07830_ _07830_/I _07909_/A1 vdd vdd vss vss gf180mcu_fd_sc_mcu7t5v0__clkinv_1
X_07761_ _07761_/A1 _07781_/A2 _07909_/B _07762_/A2 vdd vdd vss vss
+ gf180mcu_fd_sc_mcu7t5v0__aoi21_1
X_04973_ _09421_/Q _05256_/B2 vdd vdd vss vss gf180mcu_fd_sc_mcu7t5v0__clkinv_1
X_09500_ _09500_/D clk _09500_/Q vdd vdd vss vss gf180mcu_fd_sc_mcu7t5v0__dffq_1
X_06712_ _06712_/A1 _06712_/A2 _09614_/D vdd vdd vss vss gf180mcu_fd_sc_mcu7t5v0__nor2_1
X_07692_ _08018_/A1 _07692_/A2 _08001_/A1 vdd vdd vss vss gf180mcu_fd_sc_mcu7t5v0__nor2_2
X_06643_ _09002_/A2 _09400_/A1 _06652_/A2 vdd vdd vss vss gf180mcu_fd_sc_mcu7t5v0__nand2_4
X_09431_ _09431_/D clk _09431_/Q vdd vdd vss vss gf180mcu_fd_sc_mcu7t5v0__dffq_1
X_06574_ _06575_/A1 _06521_/Z _06575_/B _06597_/B vdd vdd vss vss
+ gf180mcu_fd_sc_mcu7t5v0__nand3_1
X_09362_ _09395_/A1 _09366_/A2 _09362_/B _09399_/C _10001_/D vdd vdd vss
+ vss gf180mcu_fd_sc_mcu7t5v0__aoi211_1
X_05525_ _09494_/Q _05627_/A2 _05627_/B1 _09510_/Q _05527_/A1 vdd vdd
+ vss vss gf180mcu_fd_sc_mcu7t5v0__aoi22_1
X_08313_ _08354_/A2 _08355_/A1 _08313_/Z vdd vdd vss vss gf180mcu_fd_sc_mcu7t5v0__xor2_1
X_09293_ _09971_/Q _09298_/A2 _09294_/B vdd vdd vss vss gf180mcu_fd_sc_mcu7t5v0__nor2_1
X_08244_ _08232_/Z _08247_/A3 _08274_/A2 vdd vdd vss vss gf180mcu_fd_sc_mcu7t5v0__nor2_1
X_05456_ _09012_/A1 _05456_/A2 _05456_/B1 _08736_/A2 _05459_/A1 vdd vdd
+ vss vss gf180mcu_fd_sc_mcu7t5v0__aoi22_1
X_08175_ _08176_/A3 _08174_/Z _08225_/B vdd vdd vss vss gf180mcu_fd_sc_mcu7t5v0__nor2_1
X_05387_ _09407_/A1 _05389_/A2 _05389_/B1 _05387_/B2 _09539_/D vdd vdd
+ vss vss gf180mcu_fd_sc_mcu7t5v0__oai22_1
X_07126_ _07178_/B _07065_/Z _07126_/B _07127_/A2 vdd vdd vss vss
+ gf180mcu_fd_sc_mcu7t5v0__aoi21_1
X_07057_ _07289_/B _07057_/A2 _07057_/B _08706_/B _07058_/A2 vdd vdd vss
+ vss gf180mcu_fd_sc_mcu7t5v0__oai211_1
X_06008_ _06072_/C _06008_/A2 _06008_/B _08706_/B _06009_/C vdd vdd vss
+ vss gf180mcu_fd_sc_mcu7t5v0__oai211_1
X_07959_ _09674_/Q _07959_/A2 _07957_/B _07976_/A2 vdd vdd vss vss
+ gf180mcu_fd_sc_mcu7t5v0__xnor3_1
X_09629_ _09629_/D clk _09629_/Q vdd vdd vss vss gf180mcu_fd_sc_mcu7t5v0__dffq_4
XTAP_619 vdd vss gf180mcu_fd_sc_mcu7t5v0__filltie
XTAP_608 vdd vss gf180mcu_fd_sc_mcu7t5v0__filltie
XTAP_1380 vdd vss gf180mcu_fd_sc_mcu7t5v0__filltie
XTAP_1391 vdd vss gf180mcu_fd_sc_mcu7t5v0__filltie
X_06290_ _06290_/A1 _06287_/Z _06300_/A1 vdd vdd vss vss gf180mcu_fd_sc_mcu7t5v0__nand2_1
X_05310_ _09402_/A1 _05317_/A2 _05317_/B1 _05310_/B2 _09474_/D vdd vdd
+ vss vss gf180mcu_fd_sc_mcu7t5v0__oai22_1
X_05241_ _05918_/A1 _05217_/S _05242_/B vdd vdd vss vss gf180mcu_fd_sc_mcu7t5v0__nand2_1
X_05172_ _09755_/Q _09378_/A2 _05174_/A1 vdd vdd vss vss gf180mcu_fd_sc_mcu7t5v0__nand2_1
X_09980_ _09980_/D clk _09980_/Q vdd vdd vss vss gf180mcu_fd_sc_mcu7t5v0__dffq_1
X_08931_ _09811_/Q _09812_/Q _09813_/Q _08933_/A2 vdd vdd vss vss
+ gf180mcu_fd_sc_mcu7t5v0__aoi21_1
X_08862_ _09783_/Q _08860_/B _08862_/B _09257_/B _08863_/B vdd vdd vss
+ vss gf180mcu_fd_sc_mcu7t5v0__oai211_1
X_07813_ _09713_/Q _08012_/A2 _07813_/B _07814_/C vdd vdd vss vss
+ gf180mcu_fd_sc_mcu7t5v0__aoi21_1
X_08793_ _09751_/Q _08851_/A1 _09226_/B _08794_/B vdd vdd vss vss
+ gf180mcu_fd_sc_mcu7t5v0__oai21_1
X_07744_ _07753_/A1 _07781_/A3 _07744_/Z vdd vdd vss vss gf180mcu_fd_sc_mcu7t5v0__and2_1
X_04956_ _09437_/Q _05282_/B2 vdd vdd vss vss gf180mcu_fd_sc_mcu7t5v0__clkinv_1
X_07675_ _09408_/A1 _07676_/A2 _07676_/B1 _07675_/B2 _09666_/D vdd vdd
+ vss vss gf180mcu_fd_sc_mcu7t5v0__oai22_1
X_06626_ _06439_/B _06626_/A2 _06626_/B _06627_/A3 vdd vdd vss vss
+ gf180mcu_fd_sc_mcu7t5v0__aoi21_1
X_09414_ _09414_/D clk _09414_/Q vdd vdd vss vss gf180mcu_fd_sc_mcu7t5v0__dffq_1
X_04887_ _09860_/Q _09015_/B2 vdd vdd vss vss gf180mcu_fd_sc_mcu7t5v0__clkinv_1
X_06557_ _06447_/Z _06506_/Z _06598_/A2 vdd vdd vss vss gf180mcu_fd_sc_mcu7t5v0__nor2_1
X_09345_ _09389_/A2 _09311_/Z _09355_/A2 vdd vdd vss vss gf180mcu_fd_sc_mcu7t5v0__nor2_4
X_06488_ _06367_/B _06486_/Z _06534_/A2 _06494_/C vdd vdd vss vss
+ gf180mcu_fd_sc_mcu7t5v0__nand3_1
X_05508_ _09838_/Q _05627_/A2 _05627_/B1 _09806_/Q _05510_/A1 vdd vdd
+ vss vss gf180mcu_fd_sc_mcu7t5v0__aoi22_1
X_09276_ _09300_/A1 _09367_/A2 _09286_/A2 vdd vdd vss vss gf180mcu_fd_sc_mcu7t5v0__nor2_4
X_08227_ _08227_/I _08275_/A1 vdd vdd vss vss gf180mcu_fd_sc_mcu7t5v0__clkinv_1
X_05439_ _09543_/Q _05628_/A2 _05628_/B1 _09860_/Q _05440_/A2 vdd vdd
+ vss vss gf180mcu_fd_sc_mcu7t5v0__aoi22_1
X_08158_ _08159_/A1 _08159_/A2 _08159_/B _08161_/A1 vdd vdd vss vss
+ gf180mcu_fd_sc_mcu7t5v0__nand3_1
X_08089_ _09712_/Q _08061_/Z _08145_/A1 vdd vdd vss vss gf180mcu_fd_sc_mcu7t5v0__nand2_1
X_07109_ _09711_/Q _07106_/Z _07157_/A1 vdd vdd vss vss gf180mcu_fd_sc_mcu7t5v0__nand2_1
XTAP_405 vdd vss gf180mcu_fd_sc_mcu7t5v0__filltie
XTAP_416 vdd vss gf180mcu_fd_sc_mcu7t5v0__filltie
XTAP_438 vdd vss gf180mcu_fd_sc_mcu7t5v0__filltie
XTAP_427 vdd vss gf180mcu_fd_sc_mcu7t5v0__filltie
XTAP_449 vdd vss gf180mcu_fd_sc_mcu7t5v0__filltie
X_04810_ _09624_/Q _06969_/A1 vdd vdd vss vss gf180mcu_fd_sc_mcu7t5v0__clkinv_1
X_05790_ _05792_/A1 _05792_/A2 _05792_/B _09710_/Q _05795_/A3 vdd vdd
+ vss vss gf180mcu_fd_sc_mcu7t5v0__oai211_2
X_04741_ _09750_/Q _08776_/A1 vdd vdd vss vss gf180mcu_fd_sc_mcu7t5v0__clkinv_1
X_07460_ _07341_/B _07442_/Z _08565_/C _07461_/B2 vdd vdd vss vss
+ gf180mcu_fd_sc_mcu7t5v0__aoi21_1
X_06411_ _06591_/A1 _06510_/A1 _06411_/B1 _06411_/B2 _06412_/C vdd vdd
+ vss vss gf180mcu_fd_sc_mcu7t5v0__oai22_1
X_07391_ _07365_/Z _07388_/Z _07391_/Z vdd vdd vss vss gf180mcu_fd_sc_mcu7t5v0__xor2_1
X_06342_ _06329_/Z _06591_/A1 _06630_/A1 _06343_/B vdd vdd vss vss
+ gf180mcu_fd_sc_mcu7t5v0__nand3_1
X_09130_ _09399_/C _09130_/A2 _09912_/D vdd vdd vss vss gf180mcu_fd_sc_mcu7t5v0__nor2_1
X_09061_ _09061_/A1 _09073_/A2 _09061_/B _09884_/D vdd vdd vss vss
+ gf180mcu_fd_sc_mcu7t5v0__aoi21_1
X_06273_ _07611_/B _06016_/I _06276_/A2 vdd vdd vss vss gf180mcu_fd_sc_mcu7t5v0__nor2_1
X_08012_ _09717_/Q _08012_/A2 _07970_/C _08012_/B2 _08012_/C _08013_/B vdd vdd
+ vss vss gf180mcu_fd_sc_mcu7t5v0__aoi221_2
X_05224_ _09558_/Q _05217_/S _05224_/B _09402_/A1 vdd vdd vss vss
+ gf180mcu_fd_sc_mcu7t5v0__aoi21_4
X_05155_ _09226_/B _09732_/Q _05168_/A2 vdd vdd vss vss gf180mcu_fd_sc_mcu7t5v0__nand2_1
X_05086_ _09457_/Q _05306_/B2 vdd vdd vss vss gf180mcu_fd_sc_mcu7t5v0__clkinv_1
X_09963_ _09963_/D clk _09963_/Q vdd vdd vss vss gf180mcu_fd_sc_mcu7t5v0__dffq_1
X_08914_ _09462_/Q _09458_/Q _09472_/Q _09463_/Q _08915_/A2 vdd vdd vss
+ vss gf180mcu_fd_sc_mcu7t5v0__nor4_1
XTAP_950 vdd vss gf180mcu_fd_sc_mcu7t5v0__filltie
XTAP_961 vdd vss gf180mcu_fd_sc_mcu7t5v0__filltie
X_09894_ _09894_/D clk _09894_/Q vdd vdd vss vss gf180mcu_fd_sc_mcu7t5v0__dffq_1
XTAP_972 vdd vss gf180mcu_fd_sc_mcu7t5v0__filltie
XTAP_983 vdd vss gf180mcu_fd_sc_mcu7t5v0__filltie
XTAP_994 vdd vss gf180mcu_fd_sc_mcu7t5v0__filltie
X_08845_ _09776_/Q _08841_/Z _08845_/B _08846_/B vdd vdd vss vss gf180mcu_fd_sc_mcu7t5v0__oai21_1
X_08776_ _08776_/A1 _08782_/A2 _08776_/B _09750_/D vdd vdd vss vss
+ gf180mcu_fd_sc_mcu7t5v0__aoi21_1
X_05988_ _08291_/B _06101_/A1 _06005_/B vdd vdd vss vss gf180mcu_fd_sc_mcu7t5v0__nor2_2
X_07727_ _09710_/Q _07727_/A2 _07727_/A3 _07729_/A2 vdd vdd vss vss
+ gf180mcu_fd_sc_mcu7t5v0__nand3_1
X_04939_ _09607_/Q _06647_/B2 vdd vdd vss vss gf180mcu_fd_sc_mcu7t5v0__clkinv_1
X_07658_ _07658_/A1 _09073_/A2 _07658_/B _09655_/D vdd vdd vss vss
+ gf180mcu_fd_sc_mcu7t5v0__aoi21_1
X_06609_ _09711_/Q _06626_/A2 _06611_/A3 vdd vdd vss vss gf180mcu_fd_sc_mcu7t5v0__nand2_1
X_07589_ _07589_/A1 _07589_/A2 _07589_/Z vdd vdd vss vss gf180mcu_fd_sc_mcu7t5v0__xor2_1
X_09328_ _09986_/Q _09333_/A2 _09329_/B vdd vdd vss vss gf180mcu_fd_sc_mcu7t5v0__nor2_1
X_09259_ _09958_/Q _09467_/Q _09259_/B _09260_/B vdd vdd vss vss gf180mcu_fd_sc_mcu7t5v0__oai21_1
X_10034_ _10034_/ZN vdd vdd vss vss gf180mcu_fd_sc_mcu7t5v0__tiel
XPHY_260 vdd vss gf180mcu_fd_sc_mcu7t5v0__endcap
X_06960_ _06739_/C _06960_/A2 _08565_/C _06961_/B2 vdd vdd vss vss
+ gf180mcu_fd_sc_mcu7t5v0__aoi21_1
X_05911_ _05911_/A1 _05909_/Z _05911_/Z vdd vdd vss vss gf180mcu_fd_sc_mcu7t5v0__xor2_1
XTAP_279 vdd vss gf180mcu_fd_sc_mcu7t5v0__filltie
XTAP_268 vdd vss gf180mcu_fd_sc_mcu7t5v0__filltie
X_06891_ _09711_/Q _06890_/Z _06933_/A1 vdd vdd vss vss gf180mcu_fd_sc_mcu7t5v0__nand2_1
X_05842_ _05843_/A1 _05843_/A3 _05899_/A2 vdd vdd vss vss gf180mcu_fd_sc_mcu7t5v0__nand2_1
X_08630_ _08676_/B1 _08630_/A2 _08630_/A3 _08639_/C vdd vdd vss vss
+ gf180mcu_fd_sc_mcu7t5v0__xor3_1
X_08561_ _09714_/Q _08626_/A2 _08561_/B _08562_/A3 vdd vdd vss vss
+ gf180mcu_fd_sc_mcu7t5v0__aoi21_1
X_05773_ _09713_/Q _05965_/A2 _05773_/B1 _05773_/B2 _05903_/A1 _05773_/C2 _05774_/A2
+ vdd vdd vss vss gf180mcu_fd_sc_mcu7t5v0__aoi222_1
X_08492_ _09711_/Q _08678_/A2 _08495_/A2 vdd vdd vss vss gf180mcu_fd_sc_mcu7t5v0__nand2_1
X_04724_ _09890_/Q _09073_/A1 vdd vdd vss vss gf180mcu_fd_sc_mcu7t5v0__inv_1
X_07512_ _09651_/Q _08565_/C _07512_/B _07513_/A2 vdd vdd vss vss
+ gf180mcu_fd_sc_mcu7t5v0__aoi21_1
X_07443_ _07317_/Z _07349_/Z _07385_/Z _07443_/B _07444_/A2 vdd vdd vss
+ vss gf180mcu_fd_sc_mcu7t5v0__oai31_1
X_09113_ _09408_/A1 _09114_/A2 _09114_/B1 _09113_/B2 _09906_/D vdd vdd
+ vss vss gf180mcu_fd_sc_mcu7t5v0__oai22_1
X_07374_ _07396_/B _07374_/A2 _07373_/Z _07375_/A2 vdd vdd vss vss
+ gf180mcu_fd_sc_mcu7t5v0__nor3_1
X_06325_ _09647_/Q _09604_/Q _06640_/A1 _06362_/A1 vdd vdd vss vss
+ gf180mcu_fd_sc_mcu7t5v0__nor3_4
X_06256_ _06254_/Z _06291_/B _06257_/A2 vdd vdd vss vss gf180mcu_fd_sc_mcu7t5v0__nor2_1
X_09044_ _09878_/Q _09103_/A2 _09045_/A2 vdd vdd vss vss gf180mcu_fd_sc_mcu7t5v0__nand2_1
X_05207_ _09910_/Q _09893_/Q _05217_/S _05207_/Z vdd vdd vss vss gf180mcu_fd_sc_mcu7t5v0__mux2_4
X_06187_ _06188_/A1 _06188_/A2 _06212_/B vdd vdd vss vss gf180mcu_fd_sc_mcu7t5v0__nor2_1
X_05138_ _09909_/Q _09121_/A1 _05108_/Z _09077_/A3 _05175_/A2 vdd vdd
+ vss vss gf180mcu_fd_sc_mcu7t5v0__nor4_4
X_05069_ _09424_/Q _05259_/B2 vdd vdd vss vss gf180mcu_fd_sc_mcu7t5v0__clkinv_1
X_09946_ _09946_/D clk _09946_/Q vdd vdd vss vss gf180mcu_fd_sc_mcu7t5v0__dffq_1
XTAP_780 vdd vss gf180mcu_fd_sc_mcu7t5v0__filltie
XTAP_791 vdd vss gf180mcu_fd_sc_mcu7t5v0__filltie
X_09877_ _09877_/D clk _09877_/Q vdd vdd vss vss gf180mcu_fd_sc_mcu7t5v0__dffq_1
X_08828_ _08826_/Z _08828_/A2 _09770_/D vdd vdd vss vss gf180mcu_fd_sc_mcu7t5v0__nor2_1
X_08759_ _09743_/Q _08759_/A2 _08760_/I vdd vdd vss vss gf180mcu_fd_sc_mcu7t5v0__nand2_1
XTAP_1924 vdd vss gf180mcu_fd_sc_mcu7t5v0__filltie
XTAP_1913 vdd vss gf180mcu_fd_sc_mcu7t5v0__filltie
XTAP_1902 vdd vss gf180mcu_fd_sc_mcu7t5v0__filltie
XTAP_1968 vdd vss gf180mcu_fd_sc_mcu7t5v0__filltie
XTAP_1957 vdd vss gf180mcu_fd_sc_mcu7t5v0__filltie
XTAP_1935 vdd vss gf180mcu_fd_sc_mcu7t5v0__filltie
XTAP_1946 vdd vss gf180mcu_fd_sc_mcu7t5v0__filltie
XTAP_1979 vdd vss gf180mcu_fd_sc_mcu7t5v0__filltie
X_10017_ _10017_/D clk _10017_/Q vdd vdd vss vss gf180mcu_fd_sc_mcu7t5v0__dffq_1
X_06110_ _09713_/Q _06085_/Z _06224_/A1 vdd vdd vss vss gf180mcu_fd_sc_mcu7t5v0__nand2_1
X_07090_ _07286_/I1 _07208_/A1 _07287_/C _07092_/B1 vdd vdd vss vss
+ gf180mcu_fd_sc_mcu7t5v0__aoi21_1
X_06041_ _09572_/Q _08706_/B _08708_/B _06042_/B vdd vdd vss vss gf180mcu_fd_sc_mcu7t5v0__oai21_1
X_07992_ _07985_/Z _07989_/Z _07992_/A3 _07992_/Z vdd vdd vss vss
+ gf180mcu_fd_sc_mcu7t5v0__xor3_1
X_09800_ _09800_/D clk _09800_/Q vdd vdd vss vss gf180mcu_fd_sc_mcu7t5v0__dffq_1
X_06943_ _06943_/A1 _06938_/Z _06942_/Z _06943_/Z vdd vdd vss vss
+ gf180mcu_fd_sc_mcu7t5v0__xor3_1
X_09731_ _09731_/D clk _09731_/Q vdd vdd vss vss gf180mcu_fd_sc_mcu7t5v0__dffq_1
X_09662_ _09662_/D clk _09662_/Q vdd vdd vss vss gf180mcu_fd_sc_mcu7t5v0__dffq_1
X_06874_ _06739_/C _06860_/Z _06874_/B _08706_/B _06875_/A2 vdd vdd vss
+ vss gf180mcu_fd_sc_mcu7t5v0__oai211_1
X_05825_ _09562_/Q _08565_/C _05825_/B1 _05825_/B2 _05826_/A2 vdd vdd
+ vss vss gf180mcu_fd_sc_mcu7t5v0__aoi22_1
X_08613_ _08476_/C _08613_/A2 _08613_/B _08706_/B _08614_/A2 vdd vdd vss
+ vss gf180mcu_fd_sc_mcu7t5v0__oai211_1
X_09593_ _09593_/D clk _09593_/Q vdd vdd vss vss gf180mcu_fd_sc_mcu7t5v0__dffq_2
X_05756_ _05758_/A1 _05758_/A3 _05756_/Z vdd vdd vss vss gf180mcu_fd_sc_mcu7t5v0__xor2_1
X_08544_ _08505_/Z _08542_/Z _08550_/A2 vdd vdd vss vss gf180mcu_fd_sc_mcu7t5v0__xnor2_1
XTAP_1209 vdd vss gf180mcu_fd_sc_mcu7t5v0__filltie
X_04707_ _09919_/Q _09395_/A1 vdd vdd vss vss gf180mcu_fd_sc_mcu7t5v0__clkinv_8
X_05687_ _05645_/I _05722_/B _05692_/A3 vdd vdd vss vss gf180mcu_fd_sc_mcu7t5v0__nor2_1
X_08475_ _09712_/Q _08700_/A2 _08476_/B vdd vdd vss vss gf180mcu_fd_sc_mcu7t5v0__nand2_1
X_07426_ _09659_/Q _09658_/Q _07426_/Z vdd vdd vss vss gf180mcu_fd_sc_mcu7t5v0__or2_1
X_07357_ _07358_/A1 _07356_/Z _07357_/Z vdd vdd vss vss gf180mcu_fd_sc_mcu7t5v0__and2_1
X_06308_ _10011_/Q _09104_/A2 _09072_/B _06309_/B vdd vdd vss vss
+ gf180mcu_fd_sc_mcu7t5v0__oai21_1
X_09027_ _09405_/A1 _09031_/A2 _09031_/B1 _09027_/B2 _09870_/D vdd vdd
+ vss vss gf180mcu_fd_sc_mcu7t5v0__oai22_1
X_07288_ _07288_/A1 _07288_/A2 _07289_/A3 vdd vdd vss vss gf180mcu_fd_sc_mcu7t5v0__nor2_1
X_06239_ _06239_/A1 _06239_/A2 _06242_/A3 vdd vdd vss vss gf180mcu_fd_sc_mcu7t5v0__xnor2_1
X_09929_ _09929_/D clk _09929_/Q vdd vdd vss vss gf180mcu_fd_sc_mcu7t5v0__dffq_1
XTAP_1743 vdd vss gf180mcu_fd_sc_mcu7t5v0__filltie
XTAP_1721 vdd vss gf180mcu_fd_sc_mcu7t5v0__filltie
XTAP_1732 vdd vss gf180mcu_fd_sc_mcu7t5v0__filltie
XTAP_1710 vdd vss gf180mcu_fd_sc_mcu7t5v0__filltie
XTAP_1776 vdd vss gf180mcu_fd_sc_mcu7t5v0__filltie
XTAP_1765 vdd vss gf180mcu_fd_sc_mcu7t5v0__filltie
XTAP_1754 vdd vss gf180mcu_fd_sc_mcu7t5v0__filltie
XTAP_1798 vdd vss gf180mcu_fd_sc_mcu7t5v0__filltie
XTAP_1787 vdd vss gf180mcu_fd_sc_mcu7t5v0__filltie
X_05610_ _09521_/Q _05628_/A2 _05628_/B1 _09481_/Q _05611_/A2 vdd vdd
+ vss vss gf180mcu_fd_sc_mcu7t5v0__aoi22_1
X_06590_ _09716_/Q _06629_/A2 _06591_/A2 _06628_/B2 _06590_/C _06591_/B vdd
+ vdd vss vss gf180mcu_fd_sc_mcu7t5v0__aoi221_1
X_05541_ _09739_/Q _05627_/A2 _05627_/B1 _09871_/Q _05543_/A1 vdd vdd
+ vss vss gf180mcu_fd_sc_mcu7t5v0__aoi22_1
X_05472_ _05472_/A1 _05472_/A2 _05487_/A2 vdd vdd vss vss gf180mcu_fd_sc_mcu7t5v0__nand2_1
X_08260_ _09715_/Q _08260_/A2 _08260_/Z vdd vdd vss vss gf180mcu_fd_sc_mcu7t5v0__xor2_1
X_08191_ _08194_/A2 _08190_/Z _08192_/I vdd vdd vss vss gf180mcu_fd_sc_mcu7t5v0__nor2_1
X_07211_ _08308_/A1 _09638_/Q _07300_/A1 _07211_/B _07216_/B1 vdd vdd
+ vss vss gf180mcu_fd_sc_mcu7t5v0__oai31_2
X_07142_ _07142_/A1 _07122_/Z _07142_/B _07194_/A1 vdd vdd vss vss
+ gf180mcu_fd_sc_mcu7t5v0__aoi21_1
X_07073_ _07073_/A1 _07072_/Z _07073_/Z vdd vdd vss vss gf180mcu_fd_sc_mcu7t5v0__xor2_1
X_06024_ _06296_/A1 _06065_/A2 _06023_/Z _06035_/A2 vdd vdd vss vss
+ gf180mcu_fd_sc_mcu7t5v0__nand3_1
X_07975_ _07975_/A1 _07975_/A2 _08670_/B _09674_/D vdd vdd vss vss
+ gf180mcu_fd_sc_mcu7t5v0__aoi21_1
X_06926_ _06926_/A1 _06926_/A2 _06926_/B _06945_/A1 vdd vdd vss vss
+ gf180mcu_fd_sc_mcu7t5v0__oai21_1
X_09714_ _09714_/D clk _09714_/Q vdd vdd vss vss gf180mcu_fd_sc_mcu7t5v0__dffq_4
X_09645_ _09645_/D clk _09645_/Q vdd vdd vss vss gf180mcu_fd_sc_mcu7t5v0__dffq_1
X_06857_ _06877_/A1 _06877_/A2 _06857_/Z vdd vdd vss vss gf180mcu_fd_sc_mcu7t5v0__xor2_1
X_05808_ _05759_/Z _05808_/A2 _05808_/B _05828_/A2 vdd vdd vss vss
+ gf180mcu_fd_sc_mcu7t5v0__oai21_1
X_09576_ _09576_/D clk _09576_/Q vdd vdd vss vss gf180mcu_fd_sc_mcu7t5v0__dffq_2
XTAP_1017 vdd vss gf180mcu_fd_sc_mcu7t5v0__filltie
XTAP_1006 vdd vss gf180mcu_fd_sc_mcu7t5v0__filltie
XTAP_1028 vdd vss gf180mcu_fd_sc_mcu7t5v0__filltie
X_06788_ _06790_/A1 _06755_/Z _06831_/B vdd vdd vss vss gf180mcu_fd_sc_mcu7t5v0__nor2_1
X_05739_ _07452_/C _05645_/I _05754_/A2 vdd vdd vss vss gf180mcu_fd_sc_mcu7t5v0__nor2_1
XTAP_1039 vdd vss gf180mcu_fd_sc_mcu7t5v0__filltie
X_08527_ _09722_/Q _09721_/Q _09685_/Q _08528_/B vdd vdd vss vss gf180mcu_fd_sc_mcu7t5v0__nand3_2
X_08458_ _08460_/A1 _08460_/A3 _08490_/B vdd vdd vss vss gf180mcu_fd_sc_mcu7t5v0__nor2_1
X_07409_ _07649_/A1 _07409_/A2 _07409_/B _07410_/A2 vdd vdd vss vss
+ gf180mcu_fd_sc_mcu7t5v0__oai21_1
X_08389_ _09722_/Q _09721_/Q _08389_/Z vdd vdd vss vss gf180mcu_fd_sc_mcu7t5v0__or2_4
XTAP_1540 vdd vss gf180mcu_fd_sc_mcu7t5v0__filltie
XTAP_1551 vdd vss gf180mcu_fd_sc_mcu7t5v0__filltie
XPHY_80 vdd vss gf180mcu_fd_sc_mcu7t5v0__endcap
XPHY_91 vdd vss gf180mcu_fd_sc_mcu7t5v0__endcap
XTAP_1562 vdd vss gf180mcu_fd_sc_mcu7t5v0__filltie
XTAP_1584 vdd vss gf180mcu_fd_sc_mcu7t5v0__filltie
XTAP_1573 vdd vss gf180mcu_fd_sc_mcu7t5v0__filltie
XTAP_1595 vdd vss gf180mcu_fd_sc_mcu7t5v0__filltie
X_04972_ _09587_/Q _06319_/B2 vdd vdd vss vss gf180mcu_fd_sc_mcu7t5v0__clkinv_1
X_07760_ _07718_/Z _07720_/Z _07766_/A1 vdd vdd vss vss gf180mcu_fd_sc_mcu7t5v0__nor2_1
X_06711_ _09614_/Q _08706_/B _08708_/B _06712_/A2 vdd vdd vss vss
+ gf180mcu_fd_sc_mcu7t5v0__oai21_1
X_07691_ _07692_/A2 _08011_/A1 _07725_/A3 _07920_/A1 vdd vdd vss vss
+ gf180mcu_fd_sc_mcu7t5v0__nand3_2
X_09430_ _09430_/D clk _09430_/Q vdd vdd vss vss gf180mcu_fd_sc_mcu7t5v0__dffq_1
X_06642_ _06387_/B _09073_/A2 _06642_/B _09604_/D vdd vdd vss vss
+ gf180mcu_fd_sc_mcu7t5v0__aoi21_1
X_06573_ _06573_/A1 _06571_/Z _06575_/B vdd vdd vss vss gf180mcu_fd_sc_mcu7t5v0__xor2_1
X_09361_ _10001_/Q _09366_/A2 _09362_/B vdd vdd vss vss gf180mcu_fd_sc_mcu7t5v0__nor2_1
X_05524_ _05524_/A1 _05524_/A2 _05545_/A2 vdd vdd vss vss gf180mcu_fd_sc_mcu7t5v0__nand2_1
X_08312_ _08154_/B _08335_/A2 _08312_/B _08355_/A1 vdd vdd vss vss
+ gf180mcu_fd_sc_mcu7t5v0__aoi21_1
X_09292_ _09393_/A1 _09298_/A2 _09292_/B _09399_/C _09970_/D vdd vdd vss
+ vss gf180mcu_fd_sc_mcu7t5v0__aoi211_1
X_08243_ _08243_/A1 _08243_/A2 _08247_/A3 vdd vdd vss vss gf180mcu_fd_sc_mcu7t5v0__xnor2_1
X_05455_ _05455_/A1 _05455_/A2 _05458_/B1 vdd vdd vss vss gf180mcu_fd_sc_mcu7t5v0__nand2_1
X_08174_ _08128_/I _08225_/A2 _08174_/Z vdd vdd vss vss gf180mcu_fd_sc_mcu7t5v0__xor2_1
X_05386_ _09406_/A1 _05389_/A2 _05389_/B1 _05386_/B2 _09538_/D vdd vdd
+ vss vss gf180mcu_fd_sc_mcu7t5v0__oai22_1
X_07125_ _07278_/A1 _07121_/Z _07138_/A2 vdd vdd vss vss gf180mcu_fd_sc_mcu7t5v0__nand2_1
X_07056_ _07056_/A1 _07056_/A2 _07056_/A3 _07056_/A4 _07057_/B vdd vdd
+ vss vss gf180mcu_fd_sc_mcu7t5v0__nand4_1
X_06007_ _09710_/Q _05987_/I _06007_/B _06072_/C _06008_/B vdd vdd vss
+ vss gf180mcu_fd_sc_mcu7t5v0__oai211_1
X_07958_ _09674_/Q _07956_/Z _07977_/A2 _07976_/B vdd vdd vss vss
+ gf180mcu_fd_sc_mcu7t5v0__and3_1
X_07889_ _09880_/Q _07886_/Z _07982_/B1 _09618_/Q _07890_/A2 vdd vdd vss
+ vss gf180mcu_fd_sc_mcu7t5v0__aoi22_2
X_06909_ _06669_/I _06905_/Z _06921_/A2 vdd vdd vss vss gf180mcu_fd_sc_mcu7t5v0__nand2_1
X_09628_ _09628_/D clk _09628_/Q vdd vdd vss vss gf180mcu_fd_sc_mcu7t5v0__dffq_2
X_09559_ _09559_/D clk _09559_/Q vdd vdd vss vss gf180mcu_fd_sc_mcu7t5v0__dffq_2
XTAP_609 vdd vss gf180mcu_fd_sc_mcu7t5v0__filltie
XTAP_1370 vdd vss gf180mcu_fd_sc_mcu7t5v0__filltie
XTAP_1381 vdd vss gf180mcu_fd_sc_mcu7t5v0__filltie
XTAP_1392 vdd vss gf180mcu_fd_sc_mcu7t5v0__filltie
X_05240_ _05240_/A1 _05246_/A2 _09407_/A1 _05246_/B2 _09415_/D vdd vdd
+ vss vss gf180mcu_fd_sc_mcu7t5v0__oai22_1
X_05171_ _09226_/B _08851_/A1 _05171_/A3 _09731_/D vdd vdd vss vss
+ gf180mcu_fd_sc_mcu7t5v0__nand3_1
X_08930_ _08927_/I _08929_/Z _09812_/D vdd vdd vss vss gf180mcu_fd_sc_mcu7t5v0__nor2_1
X_08861_ _09257_/B _08862_/B _08865_/A1 vdd vdd vss vss gf180mcu_fd_sc_mcu7t5v0__nand2_1
X_07812_ _09713_/Q _07788_/Z _07811_/Z _07970_/C _07814_/B vdd vdd vss
+ vss gf180mcu_fd_sc_mcu7t5v0__oai22_1
X_08792_ _08792_/A1 _08851_/A1 _08792_/B _09758_/D vdd vdd vss vss
+ gf180mcu_fd_sc_mcu7t5v0__aoi21_1
X_07743_ _07753_/A1 _07781_/A3 _07820_/A1 vdd vdd vss vss gf180mcu_fd_sc_mcu7t5v0__nor2_2
X_04955_ _09429_/Q _05270_/B2 vdd vdd vss vss gf180mcu_fd_sc_mcu7t5v0__clkinv_1
X_04886_ _09836_/Q _08985_/B2 vdd vdd vss vss gf180mcu_fd_sc_mcu7t5v0__clkinv_1
X_07674_ _09407_/A1 _07676_/A2 _07676_/B1 _07674_/B2 _09665_/D vdd vdd
+ vss vss gf180mcu_fd_sc_mcu7t5v0__oai22_1
X_06625_ _09717_/Q _06625_/A2 _06625_/Z vdd vdd vss vss gf180mcu_fd_sc_mcu7t5v0__xor2_1
X_09413_ _09413_/D clk _09413_/Q vdd vdd vss vss gf180mcu_fd_sc_mcu7t5v0__dffq_1
X_06556_ _06447_/Z _06506_/Z _06598_/B vdd vdd vss vss gf180mcu_fd_sc_mcu7t5v0__nand2_1
X_09344_ _09399_/A1 _09344_/A2 _09344_/B _09399_/C _09993_/D vdd vdd vss
+ vss gf180mcu_fd_sc_mcu7t5v0__aoi211_1
X_06487_ _06487_/A1 _06487_/A2 _06487_/B _06534_/A2 vdd vdd vss vss
+ gf180mcu_fd_sc_mcu7t5v0__oai21_1
X_05507_ _05507_/A1 _05507_/A2 _05516_/C1 vdd vdd vss vss gf180mcu_fd_sc_mcu7t5v0__nand2_1
X_09275_ _05131_/Z _09262_/Z _09367_/A2 vdd vdd vss vss gf180mcu_fd_sc_mcu7t5v0__nand2_4
X_08226_ _09715_/Q _08030_/Z _08227_/I vdd vdd vss vss gf180mcu_fd_sc_mcu7t5v0__nand2_1
X_05438_ _09411_/Q _05627_/A2 _05627_/B1 _09844_/Q _05440_/A1 vdd vdd
+ vss vss gf180mcu_fd_sc_mcu7t5v0__aoi22_1
X_08157_ _07452_/C _08155_/Z _08159_/B vdd vdd vss vss gf180mcu_fd_sc_mcu7t5v0__xor2_1
X_05369_ _09409_/A1 _05369_/A2 _05369_/B1 _05369_/B2 _09521_/D vdd vdd
+ vss vss gf180mcu_fd_sc_mcu7t5v0__oai22_1
X_07108_ _07156_/A1 _07111_/A3 _07149_/A2 vdd vdd vss vss gf180mcu_fd_sc_mcu7t5v0__nand2_1
X_08088_ _09712_/Q _08088_/A2 _08088_/A3 _08129_/A3 vdd vdd vss vss
+ gf180mcu_fd_sc_mcu7t5v0__nand3_4
X_07039_ _07039_/A1 _07039_/A2 _07039_/Z vdd vdd vss vss gf180mcu_fd_sc_mcu7t5v0__xor2_1
XTAP_406 vdd vss gf180mcu_fd_sc_mcu7t5v0__filltie
XTAP_417 vdd vss gf180mcu_fd_sc_mcu7t5v0__filltie
XTAP_439 vdd vss gf180mcu_fd_sc_mcu7t5v0__filltie
XTAP_428 vdd vss gf180mcu_fd_sc_mcu7t5v0__filltie
X_04740_ _09758_/Q _08792_/A1 vdd vdd vss vss gf180mcu_fd_sc_mcu7t5v0__clkinv_1
X_06410_ _06628_/B2 _06510_/A1 _06590_/C _06411_/B1 vdd vdd vss vss
+ gf180mcu_fd_sc_mcu7t5v0__aoi21_1
X_07390_ _07390_/I _07515_/B2 vdd vdd vss vss gf180mcu_fd_sc_mcu7t5v0__clkinv_1
X_06341_ _09600_/Q _06413_/A1 _06630_/A1 vdd vdd vss vss gf180mcu_fd_sc_mcu7t5v0__nand2_1
X_06272_ _09717_/Q _05987_/I _06276_/A1 vdd vdd vss vss gf180mcu_fd_sc_mcu7t5v0__nand2_1
X_09060_ _09551_/Q _09073_/A2 _09072_/B _09061_/B vdd vdd vss vss
+ gf180mcu_fd_sc_mcu7t5v0__oai21_1
X_08011_ _08011_/A1 _08011_/A2 _08011_/B1 _08011_/B2 _08012_/C vdd vdd
+ vss vss gf180mcu_fd_sc_mcu7t5v0__oai22_1
X_05223_ _09391_/A1 _05217_/S _05224_/B vdd vdd vss vss gf180mcu_fd_sc_mcu7t5v0__nor2_1
X_05154_ _08801_/A1 _05153_/Z _05168_/A1 vdd vdd vss vss gf180mcu_fd_sc_mcu7t5v0__nand2_1
X_05085_ _09449_/Q _05296_/B2 vdd vdd vss vss gf180mcu_fd_sc_mcu7t5v0__clkinv_1
X_09962_ _09962_/D clk _09962_/Q vdd vdd vss vss gf180mcu_fd_sc_mcu7t5v0__dffq_1
X_08913_ _09409_/A1 _08913_/A2 _08913_/B1 _08913_/B2 _09801_/D vdd vdd
+ vss vss gf180mcu_fd_sc_mcu7t5v0__oai22_1
XTAP_940 vdd vss gf180mcu_fd_sc_mcu7t5v0__filltie
XTAP_951 vdd vss gf180mcu_fd_sc_mcu7t5v0__filltie
XTAP_962 vdd vss gf180mcu_fd_sc_mcu7t5v0__filltie
X_09893_ _09893_/D clk _09893_/Q vdd vdd vss vss gf180mcu_fd_sc_mcu7t5v0__dffq_1
XTAP_973 vdd vss gf180mcu_fd_sc_mcu7t5v0__filltie
XTAP_984 vdd vss gf180mcu_fd_sc_mcu7t5v0__filltie
XTAP_995 vdd vss gf180mcu_fd_sc_mcu7t5v0__filltie
X_08844_ _09776_/Q _08841_/Z _08847_/A2 vdd vdd vss vss gf180mcu_fd_sc_mcu7t5v0__nand2_1
X_05987_ _05987_/I _06101_/A1 vdd vdd vss vss gf180mcu_fd_sc_mcu7t5v0__inv_1
X_08775_ _09751_/Q _08782_/A2 _09226_/B _08776_/B vdd vdd vss vss
+ gf180mcu_fd_sc_mcu7t5v0__oai21_1
X_07726_ _09711_/Q _07677_/Z _07741_/A3 _07729_/A1 vdd vdd vss vss
+ gf180mcu_fd_sc_mcu7t5v0__nand3_1
X_04938_ _09641_/Q _07307_/B2 vdd vdd vss vss gf180mcu_fd_sc_mcu7t5v0__clkinv_1
X_04869_ _09482_/Q _05322_/B2 vdd vdd vss vss gf180mcu_fd_sc_mcu7t5v0__clkinv_1
X_07657_ _09989_/Q _09073_/A2 _08734_/B _07658_/B vdd vdd vss vss
+ gf180mcu_fd_sc_mcu7t5v0__oai21_1
X_06608_ _09717_/Q _06608_/A2 _06610_/A3 vdd vdd vss vss gf180mcu_fd_sc_mcu7t5v0__nand2_1
X_07588_ _07589_/A1 _07589_/A2 _07621_/B vdd vdd vss vss gf180mcu_fd_sc_mcu7t5v0__nor2_1
X_06539_ _06591_/A1 _06539_/A2 _06539_/B _06540_/B vdd vdd vss vss
+ gf180mcu_fd_sc_mcu7t5v0__oai21_1
X_09327_ _09393_/A1 _09333_/A2 _09327_/B _09399_/C _09985_/D vdd vdd vss
+ vss gf180mcu_fd_sc_mcu7t5v0__aoi211_1
X_09258_ _09467_/Q _09258_/A2 _09258_/B _09957_/D vdd vdd vss vss
+ gf180mcu_fd_sc_mcu7t5v0__aoi21_1
X_08209_ _09714_/Q _08207_/Z _08210_/B vdd vdd vss vss gf180mcu_fd_sc_mcu7t5v0__xor2_1
X_09189_ _09553_/Q _09209_/A2 _09189_/B1 _09209_/B2 _09252_/A2 vdd vdd
+ vss vss gf180mcu_fd_sc_mcu7t5v0__aoi22_4
X_10033_ uart_rx_PU vdd vdd vss vss gf180mcu_fd_sc_mcu7t5v0__tiel
XPHY_261 vdd vss gf180mcu_fd_sc_mcu7t5v0__endcap
XPHY_250 vdd vss gf180mcu_fd_sc_mcu7t5v0__endcap
X_05910_ _05911_/A1 _05909_/Z _05938_/A1 vdd vdd vss vss gf180mcu_fd_sc_mcu7t5v0__nand2_1
XTAP_269 vdd vss gf180mcu_fd_sc_mcu7t5v0__filltie
X_06890_ _09564_/Q _09632_/Q _09674_/Q _09881_/Q _09625_/Q _09624_/Q _06890_/Z vdd
+ vdd vss vss gf180mcu_fd_sc_mcu7t5v0__mux4_4
X_05841_ _05843_/A1 _05843_/A3 _05899_/B vdd vdd vss vss gf180mcu_fd_sc_mcu7t5v0__nor2_1
X_08560_ _07506_/B _08560_/A2 _08562_/A2 vdd vdd vss vss gf180mcu_fd_sc_mcu7t5v0__nor2_1
X_05772_ _09566_/Q _05964_/A2 _05903_/A1 _05928_/B _09568_/Q _05773_/B2 vdd
+ vdd vss vss gf180mcu_fd_sc_mcu7t5v0__oai32_1
X_08491_ _09710_/Q _08677_/A2 _08495_/A1 vdd vdd vss vss gf180mcu_fd_sc_mcu7t5v0__nand2_1
X_04723_ _09898_/Q _09032_/A2 vdd vdd vss vss gf180mcu_fd_sc_mcu7t5v0__clkinv_2
X_07511_ _07341_/B _07496_/Z _07511_/B _07512_/B vdd vdd vss vss gf180mcu_fd_sc_mcu7t5v0__aoi21_1
X_07442_ _09650_/Q _07414_/Z _07439_/Z _07442_/Z vdd vdd vss vss gf180mcu_fd_sc_mcu7t5v0__xor3_1
X_07373_ _09647_/Q _07336_/B _07372_/B _07373_/Z vdd vdd vss vss gf180mcu_fd_sc_mcu7t5v0__and3_1
X_09112_ _09407_/A1 _09114_/A2 _09114_/B1 _09112_/B2 _09905_/D vdd vdd
+ vss vss gf180mcu_fd_sc_mcu7t5v0__oai22_1
X_06324_ _09604_/Q _06640_/A1 _06605_/A2 vdd vdd vss vss gf180mcu_fd_sc_mcu7t5v0__nor2_4
X_06255_ _06255_/A1 _06255_/A2 _06255_/B _06291_/B vdd vdd vss vss
+ gf180mcu_fd_sc_mcu7t5v0__aoi21_1
X_09043_ _09553_/Q _09033_/I _09045_/A1 vdd vdd vss vss gf180mcu_fd_sc_mcu7t5v0__nand2_1
X_06186_ _06131_/Z _06213_/A1 _06183_/Z _06188_/A2 vdd vdd vss vss
+ gf180mcu_fd_sc_mcu7t5v0__xnor3_1
X_05206_ _09893_/Q _05217_/S _05206_/B _05413_/A1 vdd vdd vss vss
+ gf180mcu_fd_sc_mcu7t5v0__aoi21_4
X_05137_ _09915_/Q _05137_/A2 _09913_/Q _05137_/A4 _09077_/A3 vdd vdd
+ vss vss gf180mcu_fd_sc_mcu7t5v0__nand4_4
X_05068_ _09590_/Q _06322_/B2 vdd vdd vss vss gf180mcu_fd_sc_mcu7t5v0__clkinv_1
X_09945_ _09945_/D clk _09945_/Q vdd vdd vss vss gf180mcu_fd_sc_mcu7t5v0__dffq_1
XTAP_770 vdd vss gf180mcu_fd_sc_mcu7t5v0__filltie
X_09876_ _09876_/D clk _09876_/Q vdd vdd vss vss gf180mcu_fd_sc_mcu7t5v0__dffq_2
XTAP_781 vdd vss gf180mcu_fd_sc_mcu7t5v0__filltie
XTAP_792 vdd vss gf180mcu_fd_sc_mcu7t5v0__filltie
X_08827_ _09770_/Q _08822_/Z _08845_/B _08828_/A2 vdd vdd vss vss
+ gf180mcu_fd_sc_mcu7t5v0__oai21_1
X_08758_ _05153_/Z _08782_/A2 _08758_/B _08759_/A2 vdd vdd vss vss
+ gf180mcu_fd_sc_mcu7t5v0__oai21_1
XTAP_1925 vdd vss gf180mcu_fd_sc_mcu7t5v0__filltie
XTAP_1914 vdd vss gf180mcu_fd_sc_mcu7t5v0__filltie
XTAP_1903 vdd vss gf180mcu_fd_sc_mcu7t5v0__filltie
X_07709_ _09680_/Q _09614_/Q _07711_/A2 vdd vdd vss vss gf180mcu_fd_sc_mcu7t5v0__nor2_1
X_08689_ _09712_/Q _08689_/A2 _08690_/A3 vdd vdd vss vss gf180mcu_fd_sc_mcu7t5v0__nand2_1
XTAP_1958 vdd vss gf180mcu_fd_sc_mcu7t5v0__filltie
XTAP_1936 vdd vss gf180mcu_fd_sc_mcu7t5v0__filltie
XTAP_1947 vdd vss gf180mcu_fd_sc_mcu7t5v0__filltie
XTAP_1969 vdd vss gf180mcu_fd_sc_mcu7t5v0__filltie
X_10016_ _10016_/D clk _10016_/Q vdd vdd vss vss gf180mcu_fd_sc_mcu7t5v0__dffq_1
X_06040_ _06072_/C _06040_/A2 _06040_/B _06042_/A2 vdd vdd vss vss
+ gf180mcu_fd_sc_mcu7t5v0__oai21_1
X_07991_ _07991_/A1 _07991_/A2 _07991_/A3 _07992_/A3 vdd vdd vss vss
+ gf180mcu_fd_sc_mcu7t5v0__xnor3_1
X_09730_ _09730_/D clk _09730_/Q vdd vdd vss vss gf180mcu_fd_sc_mcu7t5v0__dffq_1
X_06942_ _06942_/A1 _06942_/A2 _06942_/A3 _06942_/Z vdd vdd vss vss
+ gf180mcu_fd_sc_mcu7t5v0__xor3_1
X_09661_ _09661_/D clk _09661_/Q vdd vdd vss vss gf180mcu_fd_sc_mcu7t5v0__dffq_1
X_06873_ _06739_/C _06873_/A2 _06873_/A3 _06873_/A4 _06874_/B vdd vdd
+ vss vss gf180mcu_fd_sc_mcu7t5v0__nand4_1
X_05824_ _05698_/C _05809_/Z _08565_/C _05825_/B2 vdd vdd vss vss
+ gf180mcu_fd_sc_mcu7t5v0__aoi21_1
X_08612_ _08612_/A1 _08612_/A2 _08612_/A3 _08612_/A4 _08613_/B vdd vdd
+ vss vss gf180mcu_fd_sc_mcu7t5v0__nand4_1
X_09592_ _09592_/D clk _09592_/Q vdd vdd vss vss gf180mcu_fd_sc_mcu7t5v0__dffq_2
X_05755_ _05780_/A2 _05780_/B _05758_/A3 vdd vdd vss vss gf180mcu_fd_sc_mcu7t5v0__xnor2_1
X_08543_ _08505_/Z _08542_/Z _08593_/A1 vdd vdd vss vss gf180mcu_fd_sc_mcu7t5v0__nor2_1
X_04706_ _09920_/Q _09397_/A1 vdd vdd vss vss gf180mcu_fd_sc_mcu7t5v0__clkinv_8
X_08474_ _09712_/Q _08678_/A2 _08473_/Z _08510_/B _08478_/B1 vdd vdd vss
+ vss gf180mcu_fd_sc_mcu7t5v0__oai22_1
X_05686_ _09566_/Q _05686_/A2 _05922_/B vdd vdd vss vss gf180mcu_fd_sc_mcu7t5v0__nand2_1
X_07425_ _09659_/Q _09658_/Q _07627_/B1 vdd vdd vss vss gf180mcu_fd_sc_mcu7t5v0__nor2_2
X_07356_ _08430_/B _07417_/A2 _07356_/A3 _07356_/Z vdd vdd vss vss
+ gf180mcu_fd_sc_mcu7t5v0__xor3_1
X_06307_ _06307_/A1 _09104_/A2 _06307_/B _09580_/D vdd vdd vss vss
+ gf180mcu_fd_sc_mcu7t5v0__aoi21_1
X_07287_ _09717_/Q _07287_/A2 _07287_/B _07287_/C _07288_/A2 vdd vdd vss
+ vss gf180mcu_fd_sc_mcu7t5v0__aoi211_1
X_06238_ _06238_/A1 _06238_/A2 _06239_/A2 _06269_/A1 vdd vdd vss vss
+ gf180mcu_fd_sc_mcu7t5v0__nor3_1
X_09026_ _09404_/A1 _09031_/A2 _09031_/B1 _09026_/B2 _09869_/D vdd vdd
+ vss vss gf180mcu_fd_sc_mcu7t5v0__oai22_1
X_06169_ _07506_/B _06016_/I _06169_/B _06214_/A2 vdd vdd vss vss
+ gf180mcu_fd_sc_mcu7t5v0__oai21_1
X_09928_ _09928_/D clk _09928_/Q vdd vdd vss vss gf180mcu_fd_sc_mcu7t5v0__dffq_1
X_09859_ _09859_/D clk _09859_/Q vdd vdd vss vss gf180mcu_fd_sc_mcu7t5v0__dffq_1
XTAP_1700 vdd vss gf180mcu_fd_sc_mcu7t5v0__filltie
XTAP_1722 vdd vss gf180mcu_fd_sc_mcu7t5v0__filltie
XTAP_1733 vdd vss gf180mcu_fd_sc_mcu7t5v0__filltie
XTAP_1711 vdd vss gf180mcu_fd_sc_mcu7t5v0__filltie
XTAP_1766 vdd vss gf180mcu_fd_sc_mcu7t5v0__filltie
XTAP_1755 vdd vss gf180mcu_fd_sc_mcu7t5v0__filltie
XTAP_1744 vdd vss gf180mcu_fd_sc_mcu7t5v0__filltie
XTAP_1799 vdd vss gf180mcu_fd_sc_mcu7t5v0__filltie
XTAP_1788 vdd vss gf180mcu_fd_sc_mcu7t5v0__filltie
XTAP_1777 vdd vss gf180mcu_fd_sc_mcu7t5v0__filltie
X_05540_ _05540_/A1 _05540_/A2 _05544_/C1 vdd vdd vss vss gf180mcu_fd_sc_mcu7t5v0__nand2_1
X_05471_ _09796_/Q _05628_/A2 _05628_/B1 _09902_/Q _05472_/A2 vdd vdd
+ vss vss gf180mcu_fd_sc_mcu7t5v0__aoi22_1
X_08190_ _08229_/A1 _08278_/A1 _08190_/A3 _08190_/Z vdd vdd vss vss
+ gf180mcu_fd_sc_mcu7t5v0__xor3_1
X_07210_ _09638_/Q _09637_/Q _09619_/Q _07211_/B vdd vdd vss vss gf180mcu_fd_sc_mcu7t5v0__nand3_1
X_07141_ _09631_/Q _08565_/C _07192_/A1 vdd vdd vss vss gf180mcu_fd_sc_mcu7t5v0__nand2_1
X_07072_ _07036_/Z _07099_/B _07072_/Z vdd vdd vss vss gf180mcu_fd_sc_mcu7t5v0__xor2_1
X_06023_ _06023_/A1 _06021_/Z _06023_/Z vdd vdd vss vss gf180mcu_fd_sc_mcu7t5v0__or2_1
X_07974_ _07771_/C _07960_/Z _07974_/B _08706_/B _07975_/A2 vdd vdd vss
+ vss gf180mcu_fd_sc_mcu7t5v0__oai211_1
X_06925_ _06925_/A1 _06925_/A2 _06925_/B _06946_/A2 vdd vdd vss vss
+ gf180mcu_fd_sc_mcu7t5v0__oai21_1
X_09713_ _09713_/D clk _09713_/Q vdd vdd vss vss gf180mcu_fd_sc_mcu7t5v0__dffq_4
X_09644_ _09644_/D clk _09644_/Q vdd vdd vss vss gf180mcu_fd_sc_mcu7t5v0__dffq_1
X_06856_ _06877_/B _06855_/Z _06877_/A2 vdd vdd vss vss gf180mcu_fd_sc_mcu7t5v0__nor2_1
X_05807_ _09562_/Q _05807_/A2 _05807_/A3 _05808_/B vdd vdd vss vss
+ gf180mcu_fd_sc_mcu7t5v0__xnor3_1
X_09575_ _09575_/D clk _09575_/Q vdd vdd vss vss gf180mcu_fd_sc_mcu7t5v0__dffq_2
XTAP_1018 vdd vss gf180mcu_fd_sc_mcu7t5v0__filltie
XTAP_1007 vdd vss gf180mcu_fd_sc_mcu7t5v0__filltie
XTAP_1029 vdd vss gf180mcu_fd_sc_mcu7t5v0__filltie
X_06787_ _07506_/B _06811_/A1 _06831_/A1 vdd vdd vss vss gf180mcu_fd_sc_mcu7t5v0__nor2_1
X_05738_ _05761_/A1 _05761_/A2 _05762_/A1 vdd vdd vss vss gf180mcu_fd_sc_mcu7t5v0__nand2_1
X_08526_ _08526_/I _08570_/A1 vdd vdd vss vss gf180mcu_fd_sc_mcu7t5v0__clkinv_1
X_08457_ _08436_/S _08502_/A2 _08460_/A3 vdd vdd vss vss gf180mcu_fd_sc_mcu7t5v0__xnor2_1
X_05669_ _09072_/B _09073_/A2 _08708_/B vdd vdd vss vss gf180mcu_fd_sc_mcu7t5v0__and2_4
X_07408_ _09712_/Q _07651_/A2 _07391_/Z _07653_/A1 _07408_/C _07409_/B vdd vdd
+ vss vss gf180mcu_fd_sc_mcu7t5v0__aoi221_1
X_08388_ _09722_/Q _09721_/Q _08423_/B1 vdd vdd vss vss gf180mcu_fd_sc_mcu7t5v0__nor2_2
X_07339_ _09710_/Q _07317_/Z _07651_/B _07339_/B2 _07340_/A2 vdd vdd vss
+ vss gf180mcu_fd_sc_mcu7t5v0__oai22_1
X_09009_ _09407_/A1 _09011_/A2 _09011_/B1 _09009_/B2 _09856_/D vdd vdd
+ vss vss gf180mcu_fd_sc_mcu7t5v0__oai22_1
XTAP_1530 vdd vss gf180mcu_fd_sc_mcu7t5v0__filltie
XTAP_1541 vdd vss gf180mcu_fd_sc_mcu7t5v0__filltie
XPHY_81 vdd vss gf180mcu_fd_sc_mcu7t5v0__endcap
XPHY_70 vdd vss gf180mcu_fd_sc_mcu7t5v0__endcap
XPHY_92 vdd vss gf180mcu_fd_sc_mcu7t5v0__endcap
XTAP_1552 vdd vss gf180mcu_fd_sc_mcu7t5v0__filltie
XTAP_1563 vdd vss gf180mcu_fd_sc_mcu7t5v0__filltie
XTAP_1585 vdd vss gf180mcu_fd_sc_mcu7t5v0__filltie
XTAP_1574 vdd vss gf180mcu_fd_sc_mcu7t5v0__filltie
XTAP_1596 vdd vss gf180mcu_fd_sc_mcu7t5v0__filltie
X_04971_ _09608_/Q _06648_/B2 vdd vdd vss vss gf180mcu_fd_sc_mcu7t5v0__clkinv_1
X_06710_ _06710_/A1 _06710_/A2 _08565_/C _06712_/A1 vdd vdd vss vss
+ gf180mcu_fd_sc_mcu7t5v0__aoi21_1
X_07690_ _07692_/A2 _08011_/A1 _07725_/A3 _07721_/B vdd vdd vss vss
+ gf180mcu_fd_sc_mcu7t5v0__and3_1
X_06641_ _10008_/Q _09073_/A2 _08734_/B _06642_/B vdd vdd vss vss
+ gf180mcu_fd_sc_mcu7t5v0__oai21_1
X_06572_ _06573_/A1 _06571_/Z _06617_/B vdd vdd vss vss gf180mcu_fd_sc_mcu7t5v0__nand2_1
X_09360_ _09393_/A1 _09366_/A2 _09360_/B _09399_/C _10000_/D vdd vdd vss
+ vss gf180mcu_fd_sc_mcu7t5v0__aoi211_1
X_05523_ _09664_/Q _05628_/A2 _05628_/B1 _09727_/Q _05524_/A2 vdd vdd
+ vss vss gf180mcu_fd_sc_mcu7t5v0__aoi22_1
X_08311_ _08311_/A1 _08260_/Z _08311_/B _08352_/A1 vdd vdd vss vss
+ gf180mcu_fd_sc_mcu7t5v0__aoi21_1
X_09291_ _09970_/Q _09298_/A2 _09292_/B vdd vdd vss vss gf180mcu_fd_sc_mcu7t5v0__nor2_1
X_05454_ _09483_/Q _05628_/A2 _05628_/B1 _09499_/Q _05455_/A2 vdd vdd
+ vss vss gf180mcu_fd_sc_mcu7t5v0__aoi22_1
X_08242_ _09710_/Q _08243_/A1 _08335_/A2 _08298_/A1 vdd vdd vss vss
+ gf180mcu_fd_sc_mcu7t5v0__nand3_1
X_08173_ _09714_/Q _08030_/Z _08176_/A3 vdd vdd vss vss gf180mcu_fd_sc_mcu7t5v0__nand2_1
X_05385_ _09405_/A1 _05389_/A2 _05389_/B1 _05385_/B2 _09537_/D vdd vdd
+ vss vss gf180mcu_fd_sc_mcu7t5v0__oai22_1
X_07124_ _09630_/Q _07142_/A1 _07121_/Z _07124_/Z vdd vdd vss vss
+ gf180mcu_fd_sc_mcu7t5v0__xor3_1
X_07055_ _09712_/Q _07287_/A2 _07052_/Z _07286_/I0 _07248_/B _07056_/A4 vdd
+ vdd vss vss gf180mcu_fd_sc_mcu7t5v0__aoi221_1
X_06006_ _06006_/A1 _06006_/A2 _06006_/A3 _06007_/B vdd vdd vss vss
+ gf180mcu_fd_sc_mcu7t5v0__nand3_1
X_07957_ _07957_/A1 _07901_/Z _07957_/B _07977_/A2 vdd vdd vss vss
+ gf180mcu_fd_sc_mcu7t5v0__oai21_1
X_06908_ _09619_/Q _06925_/A1 _06905_/Z _06908_/Z vdd vdd vss vss
+ gf180mcu_fd_sc_mcu7t5v0__xor3_1
X_07888_ _09680_/Q _09679_/Q _07982_/B1 vdd vdd vss vss gf180mcu_fd_sc_mcu7t5v0__nor2_2
X_06839_ _07452_/C _06839_/A2 _06882_/A1 vdd vdd vss vss gf180mcu_fd_sc_mcu7t5v0__nor2_1
X_09627_ _09627_/D clk _09627_/Q vdd vdd vss vss gf180mcu_fd_sc_mcu7t5v0__dffq_2
X_09558_ _09558_/D clk _09558_/Q vdd vdd vss vss gf180mcu_fd_sc_mcu7t5v0__dffq_2
X_08509_ _08509_/I _08516_/B1 vdd vdd vss vss gf180mcu_fd_sc_mcu7t5v0__clkinv_1
X_09489_ _09489_/D clk _09489_/Q vdd vdd vss vss gf180mcu_fd_sc_mcu7t5v0__dffq_1
XTAP_1360 vdd vss gf180mcu_fd_sc_mcu7t5v0__filltie
XTAP_1371 vdd vss gf180mcu_fd_sc_mcu7t5v0__filltie
XTAP_1382 vdd vss gf180mcu_fd_sc_mcu7t5v0__filltie
XTAP_1393 vdd vss gf180mcu_fd_sc_mcu7t5v0__filltie
X_05170_ _09780_/Q _09731_/Q _05171_/A3 vdd vdd vss vss gf180mcu_fd_sc_mcu7t5v0__nand2_1
X_08860_ _08859_/C _08866_/B2 _08860_/B _09399_/C _09782_/D vdd vdd vss
+ vss gf180mcu_fd_sc_mcu7t5v0__aoi211_1
X_07811_ _07970_/B2 _07938_/A1 _07811_/Z vdd vdd vss vss gf180mcu_fd_sc_mcu7t5v0__and2_1
X_08791_ _09750_/Q _08851_/A1 _08791_/B _08792_/B vdd vdd vss vss
+ gf180mcu_fd_sc_mcu7t5v0__oai21_1
X_04954_ _09413_/Q _05234_/A1 vdd vdd vss vss gf180mcu_fd_sc_mcu7t5v0__clkinv_1
X_07742_ _09712_/Q _07712_/Z _07794_/A1 vdd vdd vss vss gf180mcu_fd_sc_mcu7t5v0__nand2_1
X_04885_ _09828_/Q _08975_/B2 vdd vdd vss vss gf180mcu_fd_sc_mcu7t5v0__clkinv_1
X_07673_ _09406_/A1 _07676_/A2 _07676_/B1 _07673_/B2 _09664_/D vdd vdd
+ vss vss gf180mcu_fd_sc_mcu7t5v0__oai22_1
X_06624_ _06624_/A1 _06624_/A2 _06624_/B _06627_/A1 vdd vdd vss vss
+ gf180mcu_fd_sc_mcu7t5v0__oai21_1
X_09412_ _09412_/D clk _09412_/Q vdd vdd vss vss gf180mcu_fd_sc_mcu7t5v0__dffq_1
X_09343_ _09993_/Q _09344_/A2 _09344_/B vdd vdd vss vss gf180mcu_fd_sc_mcu7t5v0__nor2_1
X_06555_ _09713_/Q _06555_/A2 _06602_/A1 vdd vdd vss vss gf180mcu_fd_sc_mcu7t5v0__nand2_1
X_06486_ _06487_/A1 _06487_/A2 _06487_/B _06486_/Z vdd vdd vss vss
+ gf180mcu_fd_sc_mcu7t5v0__or3_1
X_05506_ _09545_/Q _05628_/A2 _05628_/B1 _09862_/Q _05507_/A2 vdd vdd
+ vss vss gf180mcu_fd_sc_mcu7t5v0__aoi22_1
X_09274_ _09274_/A1 _09274_/A2 _09274_/B _09278_/C _09963_/D vdd vdd vss
+ vss gf180mcu_fd_sc_mcu7t5v0__oai211_1
X_08225_ _08225_/A1 _08225_/A2 _08225_/B _08274_/B2 vdd vdd vss vss
+ gf180mcu_fd_sc_mcu7t5v0__aoi21_2
X_05437_ _05437_/A1 _05437_/A2 _05457_/A2 vdd vdd vss vss gf180mcu_fd_sc_mcu7t5v0__nand2_1
X_05368_ _09408_/A1 _05369_/A2 _05369_/B1 _05368_/B2 _09520_/D vdd vdd
+ vss vss gf180mcu_fd_sc_mcu7t5v0__oai22_1
X_08156_ _09713_/Q _08155_/Z _08156_/Z vdd vdd vss vss gf180mcu_fd_sc_mcu7t5v0__and2_1
X_07107_ _09710_/Q _07106_/Z _07111_/A3 vdd vdd vss vss gf180mcu_fd_sc_mcu7t5v0__nand2_1
X_08087_ _08087_/A1 _08565_/C _08087_/B1 _08087_/B2 _08670_/B _09682_/D vdd
+ vdd vss vss gf180mcu_fd_sc_mcu7t5v0__aoi221_1
X_05299_ _09402_/A1 _05306_/A2 _05306_/B1 _05299_/B2 _09450_/D vdd vdd
+ vss vss gf180mcu_fd_sc_mcu7t5v0__oai22_1
X_07038_ _07039_/A1 _07039_/A2 _07075_/A1 vdd vdd vss vss gf180mcu_fd_sc_mcu7t5v0__nor2_1
X_08989_ _09407_/A1 _08991_/A2 _08991_/B1 _08989_/B2 _09840_/D vdd vdd
+ vss vss gf180mcu_fd_sc_mcu7t5v0__oai22_1
XTAP_407 vdd vss gf180mcu_fd_sc_mcu7t5v0__filltie
XTAP_418 vdd vss gf180mcu_fd_sc_mcu7t5v0__filltie
XTAP_429 vdd vss gf180mcu_fd_sc_mcu7t5v0__filltie
X_06340_ _06634_/A1 _06448_/A2 _06580_/A1 vdd vdd vss vss gf180mcu_fd_sc_mcu7t5v0__nor2_2
XTAP_1190 vdd vss gf180mcu_fd_sc_mcu7t5v0__filltie
X_06271_ _06271_/I0 _09712_/Q _06271_/S _06271_/Z vdd vdd vss vss
+ gf180mcu_fd_sc_mcu7t5v0__mux2_1
X_08010_ _07721_/B _08010_/A2 _08013_/A2 vdd vdd vss vss gf180mcu_fd_sc_mcu7t5v0__nand2_1
X_05222_ _09013_/A1 _05246_/B2 _05246_/A2 vdd vdd vss vss gf180mcu_fd_sc_mcu7t5v0__nand2_2
X_05153_ _09745_/Q _09744_/Q _09743_/Q _05153_/Z vdd vdd vss vss gf180mcu_fd_sc_mcu7t5v0__and3_1
X_09961_ _09961_/D clk _09961_/Q vdd vdd vss vss gf180mcu_fd_sc_mcu7t5v0__dffq_1
X_05084_ _09441_/Q _05286_/B2 vdd vdd vss vss gf180mcu_fd_sc_mcu7t5v0__clkinv_1
Xrepeater1 _09104_/A2 _09073_/A2 vdd vdd vss vss gf180mcu_fd_sc_mcu7t5v0__buf_20
X_08912_ _09408_/A1 _08913_/A2 _08913_/B1 _08912_/B2 _09800_/D vdd vdd
+ vss vss gf180mcu_fd_sc_mcu7t5v0__oai22_1
XTAP_941 vdd vss gf180mcu_fd_sc_mcu7t5v0__filltie
XTAP_930 vdd vss gf180mcu_fd_sc_mcu7t5v0__filltie
XTAP_952 vdd vss gf180mcu_fd_sc_mcu7t5v0__filltie
X_09892_ _09892_/D clk _09892_/Q vdd vdd vss vss gf180mcu_fd_sc_mcu7t5v0__dffq_1
XTAP_963 vdd vss gf180mcu_fd_sc_mcu7t5v0__filltie
XTAP_974 vdd vss gf180mcu_fd_sc_mcu7t5v0__filltie
XTAP_985 vdd vss gf180mcu_fd_sc_mcu7t5v0__filltie
XTAP_996 vdd vss gf180mcu_fd_sc_mcu7t5v0__filltie
X_08843_ _08841_/Z _08843_/A2 _09775_/D vdd vdd vss vss gf180mcu_fd_sc_mcu7t5v0__nor2_1
X_08774_ _08774_/A1 _08782_/A2 _08774_/B _09749_/D vdd vdd vss vss
+ gf180mcu_fd_sc_mcu7t5v0__aoi21_1
X_05986_ _09883_/Q _09626_/Q _09592_/Q _09558_/Q _09582_/Q _09583_/Q _05987_/I vdd
+ vdd vss vss gf180mcu_fd_sc_mcu7t5v0__mux4_4
X_04937_ _09662_/Q _07671_/B2 vdd vdd vss vss gf180mcu_fd_sc_mcu7t5v0__clkinv_1
X_07725_ _08430_/B _08022_/A1 _07725_/A3 _07753_/A1 _08011_/A1 _07731_/A1 vdd
+ vdd vss vss gf180mcu_fd_sc_mcu7t5v0__oai32_1
X_04868_ _09506_/Q _05352_/B2 vdd vdd vss vss gf180mcu_fd_sc_mcu7t5v0__clkinv_1
X_07656_ _08682_/A1 _08565_/C _08670_/B _07656_/C _09654_/D vdd vdd vss
+ vss gf180mcu_fd_sc_mcu7t5v0__aoi211_1
X_06607_ _09710_/Q _06625_/A2 _06611_/A2 vdd vdd vss vss gf180mcu_fd_sc_mcu7t5v0__nand2_1
X_04799_ _09638_/Q _07302_/A1 vdd vdd vss vss gf180mcu_fd_sc_mcu7t5v0__clkinv_1
X_07587_ _07586_/C _07587_/A2 _07587_/A3 _07589_/A2 vdd vdd vss vss
+ gf180mcu_fd_sc_mcu7t5v0__xnor3_1
X_06538_ _09715_/Q _06629_/A2 _06539_/A2 _06628_/B2 _06590_/C _06539_/B vdd
+ vdd vss vss gf180mcu_fd_sc_mcu7t5v0__aoi221_1
X_09326_ _09985_/Q _09333_/A2 _09327_/B vdd vdd vss vss gf180mcu_fd_sc_mcu7t5v0__nor2_1
X_09257_ _09467_/Q _09957_/Q _09257_/B _09258_/B vdd vdd vss vss gf180mcu_fd_sc_mcu7t5v0__oai21_1
X_06469_ _06464_/B _06429_/Z _06469_/B _06499_/B vdd vdd vss vss gf180mcu_fd_sc_mcu7t5v0__aoi21_1
X_08208_ _09714_/Q _08207_/Z _08256_/A1 vdd vdd vss vss gf180mcu_fd_sc_mcu7t5v0__nand2_1
X_09188_ _09188_/I _09189_/B1 vdd vdd vss vss gf180mcu_fd_sc_mcu7t5v0__clkinv_1
X_08139_ _08139_/A1 _08139_/A2 _08331_/B1 _08139_/B2 _08338_/A2 vdd vdd
+ vss vss gf180mcu_fd_sc_mcu7t5v0__aoi22_4
X_10032_ uart_rx_PD vdd vdd vss vss gf180mcu_fd_sc_mcu7t5v0__tiel
XPHY_251 vdd vss gf180mcu_fd_sc_mcu7t5v0__endcap
XPHY_240 vdd vss gf180mcu_fd_sc_mcu7t5v0__endcap
XPHY_262 vdd vss gf180mcu_fd_sc_mcu7t5v0__endcap
X_05840_ _08715_/A1 _05901_/A2 _05903_/A2 vdd vdd vss vss gf180mcu_fd_sc_mcu7t5v0__nor2_1
X_07510_ _07341_/B _07510_/A2 _08706_/B _07511_/B vdd vdd vss vss
+ gf180mcu_fd_sc_mcu7t5v0__oai21_1
X_05771_ _07452_/C _05943_/A2 _05903_/A1 vdd vdd vss vss gf180mcu_fd_sc_mcu7t5v0__nor2_2
X_08490_ _08453_/Z _08490_/A2 _08490_/B _08506_/A1 vdd vdd vss vss
+ gf180mcu_fd_sc_mcu7t5v0__aoi21_1
X_04722_ _09899_/Q _05668_/A1 vdd vdd vss vss gf180mcu_fd_sc_mcu7t5v0__clkinv_1
X_07441_ _09650_/Q _07439_/Z _07463_/B vdd vdd vss vss gf180mcu_fd_sc_mcu7t5v0__nand2_1
X_07372_ _09647_/Q _07336_/B _07372_/B _07374_/A2 vdd vdd vss vss
+ gf180mcu_fd_sc_mcu7t5v0__aoi21_1
X_06323_ _09409_/A1 _06323_/A2 _06323_/B1 _06323_/B2 _09591_/D vdd vdd
+ vss vss gf180mcu_fd_sc_mcu7t5v0__oai22_1
X_09111_ _09406_/A1 _09114_/A2 _09114_/B1 _09111_/B2 _09904_/D vdd vdd
+ vss vss gf180mcu_fd_sc_mcu7t5v0__oai22_1
X_06254_ _06255_/A1 _06255_/A2 _06255_/B _06254_/Z vdd vdd vss vss
+ gf180mcu_fd_sc_mcu7t5v0__and3_1
X_09042_ _09042_/A1 _09042_/A2 _09399_/C _09877_/D vdd vdd vss vss
+ gf180mcu_fd_sc_mcu7t5v0__aoi21_1
X_06185_ _06131_/Z _06183_/Z _06185_/Z vdd vdd vss vss gf180mcu_fd_sc_mcu7t5v0__or2_1
X_05205_ _09311_/A2 _05217_/S _05206_/B vdd vdd vss vss gf180mcu_fd_sc_mcu7t5v0__nor2_1
X_05136_ _09899_/Q _09898_/Q _09897_/Q _05217_/S vdd vdd vss vss gf180mcu_fd_sc_mcu7t5v0__or3_4
X_09944_ _09944_/D clk _09944_/Q vdd vdd vss vss gf180mcu_fd_sc_mcu7t5v0__dffq_1
X_05067_ _09611_/Q _06651_/B2 vdd vdd vss vss gf180mcu_fd_sc_mcu7t5v0__clkinv_1
XTAP_760 vdd vss gf180mcu_fd_sc_mcu7t5v0__filltie
X_09875_ _09875_/D clk _09875_/Q vdd vdd vss vss gf180mcu_fd_sc_mcu7t5v0__dffq_2
XTAP_782 vdd vss gf180mcu_fd_sc_mcu7t5v0__filltie
XTAP_793 vdd vss gf180mcu_fd_sc_mcu7t5v0__filltie
XTAP_771 vdd vss gf180mcu_fd_sc_mcu7t5v0__filltie
X_08826_ _09770_/Q _08822_/Z _08826_/Z vdd vdd vss vss gf180mcu_fd_sc_mcu7t5v0__and2_1
X_08757_ _09732_/Q _08757_/A2 _08758_/B vdd vdd vss vss gf180mcu_fd_sc_mcu7t5v0__or2_1
X_05969_ _10014_/Q _09104_/A2 _09259_/B _05970_/B vdd vdd vss vss
+ gf180mcu_fd_sc_mcu7t5v0__oai21_1
XTAP_1915 vdd vss gf180mcu_fd_sc_mcu7t5v0__filltie
XTAP_1904 vdd vss gf180mcu_fd_sc_mcu7t5v0__filltie
X_07708_ _08087_/A1 _09680_/Q _08024_/A1 _07727_/A2 vdd vdd vss vss
+ gf180mcu_fd_sc_mcu7t5v0__nand3_4
X_08688_ _09716_/Q _08688_/A2 _08690_/A2 vdd vdd vss vss gf180mcu_fd_sc_mcu7t5v0__nand2_1
XTAP_1959 vdd vss gf180mcu_fd_sc_mcu7t5v0__filltie
XTAP_1937 vdd vss gf180mcu_fd_sc_mcu7t5v0__filltie
XTAP_1948 vdd vss gf180mcu_fd_sc_mcu7t5v0__filltie
XTAP_1926 vdd vss gf180mcu_fd_sc_mcu7t5v0__filltie
X_07639_ _07639_/A1 _07639_/A2 _07638_/Z _07639_/Z vdd vdd vss vss
+ gf180mcu_fd_sc_mcu7t5v0__xor3_1
X_09309_ _09978_/Q _09310_/A2 _09310_/B vdd vdd vss vss gf180mcu_fd_sc_mcu7t5v0__nor2_1
X_10015_ _10015_/D clk _10015_/Q vdd vdd vss vss gf180mcu_fd_sc_mcu7t5v0__dffq_1
X_07990_ _07990_/A1 _07995_/A1 _07937_/Z _07990_/B2 _07991_/A3 vdd vdd
+ vss vss gf180mcu_fd_sc_mcu7t5v0__oai22_1
X_06941_ _07611_/B _06941_/A2 _06942_/A3 vdd vdd vss vss gf180mcu_fd_sc_mcu7t5v0__nor2_1
X_09660_ _09660_/D clk _09660_/Q vdd vdd vss vss gf180mcu_fd_sc_mcu7t5v0__dffq_1
X_08611_ _09715_/Q _08700_/A2 _08611_/B1 _08699_/A2 _08667_/C _08612_/A4 vdd
+ vdd vss vss gf180mcu_fd_sc_mcu7t5v0__aoi221_1
X_06872_ _09715_/Q _06845_/Z _06872_/B _06873_/A4 vdd vdd vss vss
+ gf180mcu_fd_sc_mcu7t5v0__oai21_1
X_05823_ _05733_/C _05823_/A2 _05825_/B1 vdd vdd vss vss gf180mcu_fd_sc_mcu7t5v0__nand2_1
X_09591_ _09591_/D clk _09591_/Q vdd vdd vss vss gf180mcu_fd_sc_mcu7t5v0__dffq_1
X_05754_ _05742_/B _05754_/A2 _05752_/Z _05780_/B vdd vdd vss vss
+ gf180mcu_fd_sc_mcu7t5v0__xor3_1
X_08542_ _08569_/A1 _08542_/A2 _08542_/Z vdd vdd vss vss gf180mcu_fd_sc_mcu7t5v0__xor2_1
X_08473_ _08510_/A1 _08525_/A1 _08473_/Z vdd vdd vss vss gf180mcu_fd_sc_mcu7t5v0__and2_1
X_04705_ _09921_/Q _09399_/A1 vdd vdd vss vss gf180mcu_fd_sc_mcu7t5v0__inv_4
X_07424_ _09705_/Q _07664_/A1 _07472_/B _07452_/A2 vdd vdd vss vss
+ gf180mcu_fd_sc_mcu7t5v0__oai21_4
X_05685_ _09566_/Q _05686_/A2 _05722_/B vdd vdd vss vss gf180mcu_fd_sc_mcu7t5v0__and2_1
X_07355_ _09711_/Q _07354_/Z _07355_/Z vdd vdd vss vss gf180mcu_fd_sc_mcu7t5v0__and2_1
X_06306_ _10010_/Q _09104_/A2 _09072_/B _06307_/B vdd vdd vss vss
+ gf180mcu_fd_sc_mcu7t5v0__oai21_1
X_07286_ _07286_/I0 _07286_/I1 _07286_/S _07287_/B vdd vdd vss vss
+ gf180mcu_fd_sc_mcu7t5v0__mux2_1
X_06237_ _06224_/Z _06237_/A2 _06235_/B _06239_/A2 vdd vdd vss vss
+ gf180mcu_fd_sc_mcu7t5v0__xnor3_1
X_09025_ _09403_/A1 _09031_/A2 _09031_/B1 _09025_/B2 _09868_/D vdd vdd
+ vss vss gf180mcu_fd_sc_mcu7t5v0__oai22_1
X_06168_ _07506_/B _06016_/I _06169_/B _06214_/B vdd vdd vss vss gf180mcu_fd_sc_mcu7t5v0__nor3_1
X_05119_ _08929_/A1 _09815_/Q _09817_/Q _05120_/A3 vdd vdd vss vss
+ gf180mcu_fd_sc_mcu7t5v0__nand3_1
X_06099_ _09574_/Q _06097_/Z _06119_/B vdd vdd vss vss gf180mcu_fd_sc_mcu7t5v0__nand2_1
X_09927_ _09927_/D clk _09927_/Q vdd vdd vss vss gf180mcu_fd_sc_mcu7t5v0__dffq_1
XTAP_590 vdd vss gf180mcu_fd_sc_mcu7t5v0__filltie
X_09858_ _09858_/D clk _09858_/Q vdd vdd vss vss gf180mcu_fd_sc_mcu7t5v0__dffq_1
X_08809_ _09764_/Q _05157_/Z _09765_/Q _08812_/B vdd vdd vss vss gf180mcu_fd_sc_mcu7t5v0__aoi21_1
X_09789_ _09789_/D clk _09789_/Q vdd vdd vss vss gf180mcu_fd_sc_mcu7t5v0__dffq_1
XTAP_1723 vdd vss gf180mcu_fd_sc_mcu7t5v0__filltie
XTAP_1734 vdd vss gf180mcu_fd_sc_mcu7t5v0__filltie
XTAP_1712 vdd vss gf180mcu_fd_sc_mcu7t5v0__filltie
XTAP_1701 vdd vss gf180mcu_fd_sc_mcu7t5v0__filltie
XTAP_1767 vdd vss gf180mcu_fd_sc_mcu7t5v0__filltie
XTAP_1756 vdd vss gf180mcu_fd_sc_mcu7t5v0__filltie
XTAP_1745 vdd vss gf180mcu_fd_sc_mcu7t5v0__filltie
XTAP_1789 vdd vss gf180mcu_fd_sc_mcu7t5v0__filltie
XTAP_1778 vdd vss gf180mcu_fd_sc_mcu7t5v0__filltie
X_05470_ _09737_/Q _05627_/A2 _05627_/B1 _09869_/Q _05472_/A1 vdd vdd
+ vss vss gf180mcu_fd_sc_mcu7t5v0__aoi22_1
X_07140_ _07140_/A1 _07140_/A2 _08670_/B _09630_/D vdd vdd vss vss
+ gf180mcu_fd_sc_mcu7t5v0__aoi21_1
X_07071_ _07071_/A1 _07071_/A2 _07099_/B vdd vdd vss vss gf180mcu_fd_sc_mcu7t5v0__xnor2_1
X_06022_ _06023_/A1 _06021_/Z _06065_/A2 vdd vdd vss vss gf180mcu_fd_sc_mcu7t5v0__nand2_1
X_07973_ _07771_/C _07973_/A2 _07973_/A3 _07973_/A4 _07974_/B vdd vdd
+ vss vss gf180mcu_fd_sc_mcu7t5v0__nand4_1
X_09712_ _09712_/D clk _09712_/Q vdd vdd vss vss gf180mcu_fd_sc_mcu7t5v0__dffq_4
X_06924_ _08670_/B _06924_/A2 _09619_/D vdd vdd vss vss gf180mcu_fd_sc_mcu7t5v0__nor2_1
X_09643_ _09643_/D clk _09643_/Q vdd vdd vss vss gf180mcu_fd_sc_mcu7t5v0__dffq_1
X_06855_ _06855_/A1 _06855_/A2 _06854_/B _06855_/Z vdd vdd vss vss
+ gf180mcu_fd_sc_mcu7t5v0__and3_1
X_05806_ _09562_/Q _05822_/A2 _05828_/A1 vdd vdd vss vss gf180mcu_fd_sc_mcu7t5v0__nand2_1
X_09574_ _09574_/D clk _09574_/Q vdd vdd vss vss gf180mcu_fd_sc_mcu7t5v0__dffq_2
X_08525_ _08525_/A1 _08525_/A2 _08526_/I vdd vdd vss vss gf180mcu_fd_sc_mcu7t5v0__xnor2_1
XTAP_1019 vdd vss gf180mcu_fd_sc_mcu7t5v0__filltie
XTAP_1008 vdd vss gf180mcu_fd_sc_mcu7t5v0__filltie
X_06786_ _06696_/S _06786_/A2 _06760_/B _06786_/B _06805_/A1 vdd vdd vss
+ vss gf180mcu_fd_sc_mcu7t5v0__oai31_1
X_05737_ _05737_/A1 _05737_/A2 _08670_/B _09560_/D vdd vdd vss vss
+ gf180mcu_fd_sc_mcu7t5v0__aoi21_1
X_08456_ _09712_/Q _08688_/A2 _08501_/A4 vdd vdd vss vss gf180mcu_fd_sc_mcu7t5v0__nand2_1
X_05668_ _05668_/A1 _09898_/Q _09897_/Q _09104_/A2 vdd vdd vss vss
+ gf180mcu_fd_sc_mcu7t5v0__nand3_4
X_08387_ _09722_/Q _09721_/Q _09681_/Q _08391_/B vdd vdd vss vss gf180mcu_fd_sc_mcu7t5v0__nand3_2
X_07407_ _07650_/I0 _07521_/A1 _07407_/B1 _07407_/B2 _07408_/C vdd vdd
+ vss vss gf180mcu_fd_sc_mcu7t5v0__oai22_1
X_05599_ _09520_/Q _05628_/A2 _05628_/B1 _09480_/Q _05600_/A2 vdd vdd
+ vss vss gf180mcu_fd_sc_mcu7t5v0__aoi22_1
X_07338_ _09657_/Q _09656_/Q _07658_/A1 _07396_/B vdd vdd vss vss
+ gf180mcu_fd_sc_mcu7t5v0__nand3_4
X_07269_ _07269_/A1 _07269_/A2 _07207_/Z _07269_/B2 _07272_/A1 vdd vdd
+ vss vss gf180mcu_fd_sc_mcu7t5v0__oai22_1
X_09008_ _09406_/A1 _09011_/A2 _09011_/B1 _09008_/B2 _09855_/D vdd vdd
+ vss vss gf180mcu_fd_sc_mcu7t5v0__oai22_1
XTAP_1520 vdd vss gf180mcu_fd_sc_mcu7t5v0__filltie
XTAP_1531 vdd vss gf180mcu_fd_sc_mcu7t5v0__filltie
XTAP_1542 vdd vss gf180mcu_fd_sc_mcu7t5v0__filltie
XPHY_82 vdd vss gf180mcu_fd_sc_mcu7t5v0__endcap
XPHY_71 vdd vss gf180mcu_fd_sc_mcu7t5v0__endcap
XPHY_60 vdd vss gf180mcu_fd_sc_mcu7t5v0__endcap
XTAP_1553 vdd vss gf180mcu_fd_sc_mcu7t5v0__filltie
XTAP_1564 vdd vss gf180mcu_fd_sc_mcu7t5v0__filltie
XTAP_1575 vdd vss gf180mcu_fd_sc_mcu7t5v0__filltie
XPHY_93 vdd vss gf180mcu_fd_sc_mcu7t5v0__endcap
XTAP_1586 vdd vss gf180mcu_fd_sc_mcu7t5v0__filltie
XTAP_1597 vdd vss gf180mcu_fd_sc_mcu7t5v0__filltie
X_04970_ _09642_/Q _07308_/B2 vdd vdd vss vss gf180mcu_fd_sc_mcu7t5v0__clkinv_1
X_06640_ _06640_/A1 _09073_/A2 _06640_/B _09603_/D vdd vdd vss vss
+ gf180mcu_fd_sc_mcu7t5v0__aoi21_1
X_06571_ _06617_/A1 _06617_/A2 _06571_/Z vdd vdd vss vss gf180mcu_fd_sc_mcu7t5v0__xor2_1
X_08310_ _08351_/A1 _08305_/Z _08326_/A2 _08322_/A2 vdd vdd vss vss
+ gf180mcu_fd_sc_mcu7t5v0__nand3_1
X_05522_ _09643_/Q _05627_/A2 _05627_/B1 _09698_/Q _05524_/A1 vdd vdd
+ vss vss gf180mcu_fd_sc_mcu7t5v0__aoi22_1
X_09290_ _09391_/A1 _09298_/A2 _09290_/B _09399_/C _09969_/D vdd vdd vss
+ vss gf180mcu_fd_sc_mcu7t5v0__aoi211_1
X_05453_ _09491_/Q _05627_/A2 _05627_/B1 _09507_/Q _05455_/A1 vdd vdd
+ vss vss gf180mcu_fd_sc_mcu7t5v0__aoi22_1
X_08241_ _09710_/Q _08335_/A2 _08243_/A2 vdd vdd vss vss gf180mcu_fd_sc_mcu7t5v0__nand2_1
X_08172_ _08172_/A1 _08172_/A2 _08172_/B _08223_/A1 vdd vdd vss vss
+ gf180mcu_fd_sc_mcu7t5v0__oai21_2
X_05384_ _09404_/A1 _05389_/A2 _05389_/B1 _05384_/B2 _09536_/D vdd vdd
+ vss vss gf180mcu_fd_sc_mcu7t5v0__oai22_1
X_07123_ _09630_/Q _07121_/Z _07142_/B vdd vdd vss vss gf180mcu_fd_sc_mcu7t5v0__and2_1
X_07054_ _09712_/Q _07033_/Z _07054_/B1 _07287_/C _07056_/A3 vdd vdd vss
+ vss gf180mcu_fd_sc_mcu7t5v0__oai22_1
X_06005_ _06297_/I0 _06290_/A1 _06005_/B _06006_/A3 vdd vdd vss vss
+ gf180mcu_fd_sc_mcu7t5v0__oai21_1
X_07956_ _07957_/A1 _07901_/Z _07957_/B _07956_/Z vdd vdd vss vss
+ gf180mcu_fd_sc_mcu7t5v0__or3_1
X_06907_ _09619_/Q _06905_/Z _06925_/A2 vdd vdd vss vss gf180mcu_fd_sc_mcu7t5v0__nor2_1
X_07887_ _09686_/Q _09680_/Q _08024_/A1 _07890_/A1 vdd vdd vss vss
+ gf180mcu_fd_sc_mcu7t5v0__nand3_2
X_06838_ _06838_/A1 _06838_/A2 _06838_/A3 _06838_/Z vdd vdd vss vss
+ gf180mcu_fd_sc_mcu7t5v0__xor3_1
X_09626_ _09626_/D clk _09626_/Q vdd vdd vss vss gf180mcu_fd_sc_mcu7t5v0__dffq_2
X_09557_ _09557_/D clk _09557_/Q vdd vdd vss vss gf180mcu_fd_sc_mcu7t5v0__dffq_2
X_06769_ _06910_/B _06769_/A2 _06772_/A3 vdd vdd vss vss gf180mcu_fd_sc_mcu7t5v0__nand2_1
X_09488_ _09488_/D clk _09488_/Q vdd vdd vss vss gf180mcu_fd_sc_mcu7t5v0__dffq_1
X_08508_ _09713_/Q _08677_/A2 _08509_/I vdd vdd vss vss gf180mcu_fd_sc_mcu7t5v0__nand2_1
X_08439_ _08430_/B _08631_/A2 _08429_/B _08291_/B _08440_/A2 vdd vdd vss
+ vss gf180mcu_fd_sc_mcu7t5v0__oai22_1
XTAP_1350 vdd vss gf180mcu_fd_sc_mcu7t5v0__filltie
XTAP_1361 vdd vss gf180mcu_fd_sc_mcu7t5v0__filltie
XTAP_1372 vdd vss gf180mcu_fd_sc_mcu7t5v0__filltie
XTAP_1383 vdd vss gf180mcu_fd_sc_mcu7t5v0__filltie
XTAP_1394 vdd vss gf180mcu_fd_sc_mcu7t5v0__filltie
X_07810_ _09713_/Q _07784_/Z _07881_/A3 _07938_/A1 vdd vdd vss vss
+ gf180mcu_fd_sc_mcu7t5v0__nand3_2
X_08790_ _08790_/A1 _08851_/A1 _08790_/B _09757_/D vdd vdd vss vss
+ gf180mcu_fd_sc_mcu7t5v0__aoi21_1
X_07741_ _09712_/Q _07677_/Z _07741_/A3 _07781_/A3 vdd vdd vss vss
+ gf180mcu_fd_sc_mcu7t5v0__nand3_4
X_04953_ _09545_/Q _05395_/B2 vdd vdd vss vss gf180mcu_fd_sc_mcu7t5v0__clkinv_1
X_04884_ _09804_/Q _08919_/B2 vdd vdd vss vss gf180mcu_fd_sc_mcu7t5v0__clkinv_1
X_07672_ _09405_/A1 _07676_/A2 _07676_/B1 _07672_/B2 _09663_/D vdd vdd
+ vss vss gf180mcu_fd_sc_mcu7t5v0__oai22_1
X_06623_ _06623_/A1 _06623_/A2 _06623_/B _06628_/A2 vdd vdd vss vss
+ gf180mcu_fd_sc_mcu7t5v0__aoi21_1
X_09411_ _09411_/D clk _09411_/Q vdd vdd vss vss gf180mcu_fd_sc_mcu7t5v0__dffq_1
X_06554_ _09711_/Q _06613_/A2 _06598_/A1 vdd vdd vss vss gf180mcu_fd_sc_mcu7t5v0__nand2_1
X_09342_ _09397_/A1 _09344_/A2 _09342_/B _09399_/C _09992_/D vdd vdd vss
+ vss gf180mcu_fd_sc_mcu7t5v0__aoi211_1
X_05505_ _09413_/Q _05627_/A2 _05627_/B1 _09846_/Q _05507_/A1 vdd vdd
+ vss vss gf180mcu_fd_sc_mcu7t5v0__aoi22_1
X_06485_ _09714_/Q _06485_/A2 _06487_/B vdd vdd vss vss gf180mcu_fd_sc_mcu7t5v0__xor2_1
X_09273_ _09921_/Q _09274_/A2 _09274_/B vdd vdd vss vss gf180mcu_fd_sc_mcu7t5v0__nand2_1
X_08224_ _08224_/A1 _08224_/A2 _08224_/B _08250_/A1 vdd vdd vss vss
+ gf180mcu_fd_sc_mcu7t5v0__oai21_1
X_05436_ _09443_/Q _05628_/A2 _05628_/B1 _09427_/Q _05437_/A2 vdd vdd
+ vss vss gf180mcu_fd_sc_mcu7t5v0__aoi22_1
X_05367_ _09407_/A1 _05369_/A2 _05369_/B1 _05367_/B2 _09519_/D vdd vdd
+ vss vss gf180mcu_fd_sc_mcu7t5v0__oai22_1
X_08155_ _08338_/A2 _08155_/A2 _08155_/Z vdd vdd vss vss gf180mcu_fd_sc_mcu7t5v0__xor2_1
X_07106_ _09575_/Q _09651_/Q _09685_/Q _09617_/Q _09638_/Q _09637_/Q _07106_/Z vdd
+ vdd vss vss gf180mcu_fd_sc_mcu7t5v0__mux4_4
X_08086_ _08086_/A1 _08086_/A2 _08565_/C _08087_/B2 vdd vdd vss vss
+ gf180mcu_fd_sc_mcu7t5v0__aoi21_1
X_05298_ _08791_/B _05306_/A2 _05306_/B1 vdd vdd vss vss gf180mcu_fd_sc_mcu7t5v0__nand2_2
X_07037_ _07037_/A1 _07036_/Z _07039_/A2 vdd vdd vss vss gf180mcu_fd_sc_mcu7t5v0__nand2_1
X_08988_ _09406_/A1 _08991_/A2 _08991_/B1 _08988_/B2 _09839_/D vdd vdd
+ vss vss gf180mcu_fd_sc_mcu7t5v0__oai22_1
X_07939_ _09711_/Q _07988_/A2 _07947_/A2 vdd vdd vss vss gf180mcu_fd_sc_mcu7t5v0__nand2_1
X_09609_ _09609_/D clk _09609_/Q vdd vdd vss vss gf180mcu_fd_sc_mcu7t5v0__dffq_1
XTAP_408 vdd vss gf180mcu_fd_sc_mcu7t5v0__filltie
XTAP_419 vdd vss gf180mcu_fd_sc_mcu7t5v0__filltie
XTAP_1180 vdd vss gf180mcu_fd_sc_mcu7t5v0__filltie
XTAP_1191 vdd vss gf180mcu_fd_sc_mcu7t5v0__filltie
X_06270_ _09712_/Q _06178_/Z _06271_/I0 vdd vdd vss vss gf180mcu_fd_sc_mcu7t5v0__nand2_1
X_05221_ _09012_/A1 _09002_/A1 _05246_/B2 vdd vdd vss vss gf180mcu_fd_sc_mcu7t5v0__nand2_4
X_05152_ _09767_/Q _05161_/A1 _05152_/A3 _05152_/A4 _08801_/A1 vdd vdd
+ vss vss gf180mcu_fd_sc_mcu7t5v0__nor4_4
X_05083_ _09433_/Q _05274_/B2 vdd vdd vss vss gf180mcu_fd_sc_mcu7t5v0__clkinv_1
X_09960_ _09960_/D clk _09960_/Q vdd vdd vss vss gf180mcu_fd_sc_mcu7t5v0__dffq_1
Xrepeater2 _09257_/B _09259_/B vdd vdd vss vss gf180mcu_fd_sc_mcu7t5v0__buf_8
X_08911_ _09407_/A1 _08913_/A2 _08913_/B1 _08911_/B2 _09799_/D vdd vdd
+ vss vss gf180mcu_fd_sc_mcu7t5v0__oai22_1
XTAP_931 vdd vss gf180mcu_fd_sc_mcu7t5v0__filltie
XTAP_920 vdd vss gf180mcu_fd_sc_mcu7t5v0__filltie
XTAP_942 vdd vss gf180mcu_fd_sc_mcu7t5v0__filltie
XTAP_953 vdd vss gf180mcu_fd_sc_mcu7t5v0__filltie
X_09891_ _09891_/D clk _09891_/Q vdd vdd vss vss gf180mcu_fd_sc_mcu7t5v0__dffq_1
XTAP_964 vdd vss gf180mcu_fd_sc_mcu7t5v0__filltie
XTAP_975 vdd vss gf180mcu_fd_sc_mcu7t5v0__filltie
XTAP_986 vdd vss gf180mcu_fd_sc_mcu7t5v0__filltie
X_08842_ _09775_/Q _08838_/Z _08845_/B _08843_/A2 vdd vdd vss vss
+ gf180mcu_fd_sc_mcu7t5v0__oai21_1
XTAP_997 vdd vss gf180mcu_fd_sc_mcu7t5v0__filltie
X_08773_ _09750_/Q _08782_/A2 _08791_/B _08774_/B vdd vdd vss vss
+ gf180mcu_fd_sc_mcu7t5v0__oai21_1
X_05985_ _09583_/Q _09582_/Q _05985_/Z vdd vdd vss vss gf180mcu_fd_sc_mcu7t5v0__and2_1
X_07724_ _09711_/Q _07712_/Z _07723_/Z _07970_/C _07730_/C vdd vdd vss
+ vss gf180mcu_fd_sc_mcu7t5v0__oai22_1
X_04936_ _09696_/Q _08380_/B2 vdd vdd vss vss gf180mcu_fd_sc_mcu7t5v0__clkinv_1
X_07655_ _07341_/B _07641_/Z _07655_/B _07656_/C vdd vdd vss vss gf180mcu_fd_sc_mcu7t5v0__aoi21_1
X_06606_ _06623_/A1 _06623_/A2 _06625_/A2 vdd vdd vss vss gf180mcu_fd_sc_mcu7t5v0__nand2_1
X_04867_ _09498_/Q _05342_/B2 vdd vdd vss vss gf180mcu_fd_sc_mcu7t5v0__clkinv_1
X_04798_ _09647_/Q _08391_/A1 vdd vdd vss vss gf180mcu_fd_sc_mcu7t5v0__inv_1
X_07586_ _07634_/A2 _07634_/A3 _07586_/B _07586_/C _07625_/A1 vdd vdd
+ vss vss gf180mcu_fd_sc_mcu7t5v0__oai211_1
X_06537_ _09715_/Q _06613_/A2 _06539_/A2 vdd vdd vss vss gf180mcu_fd_sc_mcu7t5v0__nand2_1
X_09325_ _09391_/A1 _09333_/A2 _09325_/B _09399_/C _09984_/D vdd vdd vss
+ vss gf180mcu_fd_sc_mcu7t5v0__aoi211_1
X_06468_ _06510_/A1 _06468_/A2 _06559_/A1 _06469_/B vdd vdd vss vss
+ gf180mcu_fd_sc_mcu7t5v0__xor3_1
X_09256_ _09467_/Q _09256_/A2 _09256_/B _09956_/D vdd vdd vss vss
+ gf180mcu_fd_sc_mcu7t5v0__aoi21_1
X_05419_ _05419_/A1 _05419_/A2 _05429_/C1 vdd vdd vss vss gf180mcu_fd_sc_mcu7t5v0__nand2_1
X_08207_ _08257_/A1 _08207_/A2 _08207_/Z vdd vdd vss vss gf180mcu_fd_sc_mcu7t5v0__xor2_1
X_06399_ _09594_/Q _06417_/A1 _06412_/B1 _06399_/Z vdd vdd vss vss
+ gf180mcu_fd_sc_mcu7t5v0__xor3_1
X_09187_ _09788_/Q _09299_/A3 _09378_/A2 _09757_/Q _09188_/I vdd vdd vss
+ vss gf180mcu_fd_sc_mcu7t5v0__aoi22_1
X_08138_ _08139_/B2 _08331_/B1 _08234_/B vdd vdd vss vss gf180mcu_fd_sc_mcu7t5v0__nand2_2
X_08069_ _08070_/A1 _08067_/Z _08069_/B _08070_/B vdd vdd vss vss
+ gf180mcu_fd_sc_mcu7t5v0__oai21_1
X_10031_ _10031_/ZN vdd vdd vss vss gf180mcu_fd_sc_mcu7t5v0__tiel
XPHY_252 vdd vss gf180mcu_fd_sc_mcu7t5v0__endcap
XPHY_241 vdd vss gf180mcu_fd_sc_mcu7t5v0__endcap
XPHY_230 vdd vss gf180mcu_fd_sc_mcu7t5v0__endcap
XPHY_263 vdd vss gf180mcu_fd_sc_mcu7t5v0__endcap
X_05770_ _07452_/C _05943_/A2 _05773_/B1 vdd vdd vss vss gf180mcu_fd_sc_mcu7t5v0__nand2_1
X_04721_ _09908_/Q _09121_/A1 vdd vdd vss vss gf180mcu_fd_sc_mcu7t5v0__inv_2
X_07440_ _09650_/Q _07439_/Z _07463_/A2 vdd vdd vss vss gf180mcu_fd_sc_mcu7t5v0__nor2_1
X_07371_ _08424_/A1 _07371_/A2 _07372_/B vdd vdd vss vss gf180mcu_fd_sc_mcu7t5v0__xor2_1
X_06322_ _09408_/A1 _06323_/A2 _06323_/B1 _06322_/B2 _09590_/D vdd vdd
+ vss vss gf180mcu_fd_sc_mcu7t5v0__oai22_1
X_09110_ _09405_/A1 _09114_/A2 _09114_/B1 _09110_/B2 _09903_/D vdd vdd
+ vss vss gf180mcu_fd_sc_mcu7t5v0__oai22_1
X_09041_ _09877_/Q _09103_/A2 _09042_/A2 vdd vdd vss vss gf180mcu_fd_sc_mcu7t5v0__nand2_1
X_06253_ _07611_/B _06252_/Z _06255_/B vdd vdd vss vss gf180mcu_fd_sc_mcu7t5v0__xor2_1
X_06184_ _06131_/Z _06183_/Z _06213_/B vdd vdd vss vss gf180mcu_fd_sc_mcu7t5v0__and2_1
X_05204_ _09911_/Q _09894_/Q _05217_/S _05204_/Z vdd vdd vss vss gf180mcu_fd_sc_mcu7t5v0__mux2_4
X_05135_ _09899_/Q _09898_/Q _09897_/Q _09074_/B vdd vdd vss vss gf180mcu_fd_sc_mcu7t5v0__nor3_2
X_05066_ _09645_/Q _07311_/B2 vdd vdd vss vss gf180mcu_fd_sc_mcu7t5v0__clkinv_1
X_09943_ _09943_/D clk _09943_/Q vdd vdd vss vss gf180mcu_fd_sc_mcu7t5v0__dffq_1
XTAP_761 vdd vss gf180mcu_fd_sc_mcu7t5v0__filltie
XTAP_750 vdd vss gf180mcu_fd_sc_mcu7t5v0__filltie
X_09874_ _09874_/D clk _09874_/Q vdd vdd vss vss gf180mcu_fd_sc_mcu7t5v0__dffq_1
XTAP_783 vdd vss gf180mcu_fd_sc_mcu7t5v0__filltie
XTAP_794 vdd vss gf180mcu_fd_sc_mcu7t5v0__filltie
XTAP_772 vdd vss gf180mcu_fd_sc_mcu7t5v0__filltie
X_08825_ _08825_/A1 _08822_/Z _08824_/I _09769_/D vdd vdd vss vss
+ gf180mcu_fd_sc_mcu7t5v0__nor3_1
X_08756_ _09732_/Q _08801_/A1 _08782_/A2 vdd vdd vss vss gf180mcu_fd_sc_mcu7t5v0__nand2_4
X_05968_ _05968_/A1 _08565_/C _05968_/B1 _05968_/B2 _08670_/B _09565_/D vdd
+ vdd vss vss gf180mcu_fd_sc_mcu7t5v0__aoi221_1
XTAP_1916 vdd vss gf180mcu_fd_sc_mcu7t5v0__filltie
XTAP_1905 vdd vss gf180mcu_fd_sc_mcu7t5v0__filltie
X_05899_ _05837_/Z _05899_/A2 _05899_/B _05906_/A2 vdd vdd vss vss
+ gf180mcu_fd_sc_mcu7t5v0__aoi21_2
X_07707_ _08291_/B _07681_/Z _07721_/A1 vdd vdd vss vss gf180mcu_fd_sc_mcu7t5v0__nand2_1
X_04919_ _09861_/Q _09016_/B2 vdd vdd vss vss gf180mcu_fd_sc_mcu7t5v0__clkinv_1
X_08687_ _08679_/Z _08684_/Z _08686_/Z _08687_/Z vdd vdd vss vss gf180mcu_fd_sc_mcu7t5v0__xor3_1
XTAP_1938 vdd vss gf180mcu_fd_sc_mcu7t5v0__filltie
XTAP_1949 vdd vss gf180mcu_fd_sc_mcu7t5v0__filltie
XTAP_1927 vdd vss gf180mcu_fd_sc_mcu7t5v0__filltie
X_07638_ _07638_/A1 _07625_/Z _07637_/Z _07638_/Z vdd vdd vss vss
+ gf180mcu_fd_sc_mcu7t5v0__xor3_1
X_07569_ _09715_/Q _07349_/Z _07572_/A1 vdd vdd vss vss gf180mcu_fd_sc_mcu7t5v0__nand2_1
X_09308_ _09397_/A1 _09310_/A2 _09308_/B _09399_/C _09977_/D vdd vdd vss
+ vss gf180mcu_fd_sc_mcu7t5v0__aoi211_1
X_09239_ _09948_/Q _09244_/A2 _09259_/B _09240_/B vdd vdd vss vss
+ gf180mcu_fd_sc_mcu7t5v0__oai21_1
X_10014_ _10014_/D clk _10014_/Q vdd vdd vss vss gf180mcu_fd_sc_mcu7t5v0__dffq_1
X_06940_ _09717_/Q _06658_/I _06942_/A2 vdd vdd vss vss gf180mcu_fd_sc_mcu7t5v0__nand2_1
X_06871_ _06957_/A1 _06871_/A2 _06871_/B _06872_/B vdd vdd vss vss
+ gf180mcu_fd_sc_mcu7t5v0__oai21_1
X_08610_ _09715_/Q _08689_/A2 _08610_/B1 _08510_/B _08612_/A3 vdd vdd
+ vss vss gf180mcu_fd_sc_mcu7t5v0__oai22_1
X_05822_ _05862_/A1 _05822_/A2 _05817_/Z _05694_/B _05822_/C _05823_/A2 vdd
+ vdd vss vss gf180mcu_fd_sc_mcu7t5v0__aoi221_1
X_09590_ _09590_/D clk _09590_/Q vdd vdd vss vss gf180mcu_fd_sc_mcu7t5v0__dffq_1
X_05753_ _05741_/Z _05753_/A2 _05752_/Z _05829_/A2 vdd vdd vss vss
+ gf180mcu_fd_sc_mcu7t5v0__nand3_1
X_08541_ _08541_/A1 _08538_/Z _08542_/A2 vdd vdd vss vss gf180mcu_fd_sc_mcu7t5v0__xnor2_1
X_05684_ _08291_/B _05940_/A2 _05694_/A1 vdd vdd vss vss gf180mcu_fd_sc_mcu7t5v0__nand2_1
X_08472_ _09712_/Q _08678_/A2 _08525_/A1 vdd vdd vss vss gf180mcu_fd_sc_mcu7t5v0__nand2_1
X_07423_ _08521_/A1 _09658_/Q _09659_/Q _07526_/A2 vdd vdd vss vss
+ gf180mcu_fd_sc_mcu7t5v0__aoi21_2
X_07354_ _07349_/Z _07356_/A3 _07354_/Z vdd vdd vss vss gf180mcu_fd_sc_mcu7t5v0__xor2_1
X_06305_ _06305_/A1 _09104_/A2 _06305_/B _09579_/D vdd vdd vss vss
+ gf180mcu_fd_sc_mcu7t5v0__aoi21_1
X_07285_ _07279_/Z _07283_/Z _07285_/B _07289_/A2 vdd vdd vss vss
+ gf180mcu_fd_sc_mcu7t5v0__aoi21_1
X_06236_ _06224_/Z _06271_/S _06236_/A3 _06285_/A1 vdd vdd vss vss
+ gf180mcu_fd_sc_mcu7t5v0__nor3_1
X_09024_ _09402_/A1 _09031_/A2 _09031_/B1 _09024_/B2 _09867_/D vdd vdd
+ vss vss gf180mcu_fd_sc_mcu7t5v0__oai22_1
X_06167_ _06167_/A1 _06167_/A2 _06167_/B _06169_/B vdd vdd vss vss
+ gf180mcu_fd_sc_mcu7t5v0__aoi21_2
X_05118_ _09816_/Q _09818_/Q _09820_/Q _09821_/Q _05121_/A3 vdd vdd vss
+ vss gf180mcu_fd_sc_mcu7t5v0__nor4_1
X_06098_ _09574_/Q _06097_/Z _06119_/A2 vdd vdd vss vss gf180mcu_fd_sc_mcu7t5v0__nor2_1
X_05049_ _09548_/Q _05398_/B2 vdd vdd vss vss gf180mcu_fd_sc_mcu7t5v0__clkinv_1
X_09926_ _09926_/D clk _09926_/Q vdd vdd vss vss gf180mcu_fd_sc_mcu7t5v0__dffq_2
XTAP_591 vdd vss gf180mcu_fd_sc_mcu7t5v0__filltie
XTAP_580 vdd vss gf180mcu_fd_sc_mcu7t5v0__filltie
X_09857_ _09857_/D clk _09857_/Q vdd vdd vss vss gf180mcu_fd_sc_mcu7t5v0__dffq_1
X_08808_ _05165_/B _08812_/A2 _08817_/A2 vdd vdd vss vss gf180mcu_fd_sc_mcu7t5v0__nand2_1
X_09788_ _09788_/D clk _09788_/Q vdd vdd vss vss gf180mcu_fd_sc_mcu7t5v0__dffq_1
X_08739_ _09403_/A1 _08745_/A2 _08745_/B1 _08739_/B2 _09724_/D vdd vdd
+ vss vss gf180mcu_fd_sc_mcu7t5v0__oai22_1
XTAP_1713 vdd vss gf180mcu_fd_sc_mcu7t5v0__filltie
XTAP_1724 vdd vss gf180mcu_fd_sc_mcu7t5v0__filltie
XTAP_1702 vdd vss gf180mcu_fd_sc_mcu7t5v0__filltie
XTAP_1757 vdd vss gf180mcu_fd_sc_mcu7t5v0__filltie
XTAP_1746 vdd vss gf180mcu_fd_sc_mcu7t5v0__filltie
XTAP_1735 vdd vss gf180mcu_fd_sc_mcu7t5v0__filltie
XTAP_1779 vdd vss gf180mcu_fd_sc_mcu7t5v0__filltie
XTAP_1768 vdd vss gf180mcu_fd_sc_mcu7t5v0__filltie
X_07070_ _07071_/A1 _07071_/A2 _07116_/A1 vdd vdd vss vss gf180mcu_fd_sc_mcu7t5v0__nor2_1
X_06021_ _09711_/Q _06016_/I _06018_/Z _06021_/Z vdd vdd vss vss gf180mcu_fd_sc_mcu7t5v0__xor3_1
X_07972_ _09716_/Q _08005_/A2 _07972_/B _07973_/A4 vdd vdd vss vss
+ gf180mcu_fd_sc_mcu7t5v0__oai21_1
X_09711_ _09711_/D clk _09711_/Q vdd vdd vss vss gf180mcu_fd_sc_mcu7t5v0__dffq_4
X_06923_ _09619_/Q _08565_/C _06923_/B1 _06923_/B2 _06924_/A2 vdd vdd
+ vss vss gf180mcu_fd_sc_mcu7t5v0__aoi22_1
X_09642_ _09642_/D clk _09642_/Q vdd vdd vss vss gf180mcu_fd_sc_mcu7t5v0__dffq_1
X_06854_ _06855_/A1 _06855_/A2 _06854_/B _06877_/B vdd vdd vss vss
+ gf180mcu_fd_sc_mcu7t5v0__aoi21_1
X_05805_ _05807_/A2 _05807_/A3 _05822_/A2 vdd vdd vss vss gf180mcu_fd_sc_mcu7t5v0__xnor2_1
X_06785_ _06785_/A1 _06765_/Z _06785_/B _06829_/A1 vdd vdd vss vss
+ gf180mcu_fd_sc_mcu7t5v0__aoi21_1
X_09573_ _09573_/D clk _09573_/Q vdd vdd vss vss gf180mcu_fd_sc_mcu7t5v0__dffq_2
X_05736_ _05733_/C _05720_/Z _05736_/B1 _05736_/B2 _08706_/B _05737_/A2 vdd
+ vdd vss vss gf180mcu_fd_sc_mcu7t5v0__oai221_1
X_08524_ _08525_/A1 _08525_/A2 _08524_/Z vdd vdd vss vss gf180mcu_fd_sc_mcu7t5v0__or2_1
XTAP_1009 vdd vss gf180mcu_fd_sc_mcu7t5v0__filltie
X_08455_ _09712_/Q _08685_/A2 _08502_/A2 vdd vdd vss vss gf180mcu_fd_sc_mcu7t5v0__nand2_1
X_05667_ _05698_/C _05666_/Z _08565_/C _05667_/C _05672_/A1 vdd vdd vss
+ vss gf180mcu_fd_sc_mcu7t5v0__aoi211_1
X_05598_ _09532_/Q _05627_/A2 _05627_/B1 _09540_/Q _05600_/A1 vdd vdd
+ vss vss gf180mcu_fd_sc_mcu7t5v0__aoi22_1
X_08386_ _09722_/Q _09721_/Q _08386_/Z vdd vdd vss vss gf180mcu_fd_sc_mcu7t5v0__and2_2
X_07406_ _07556_/B2 _07521_/A1 _07651_/B _07407_/B1 vdd vdd vss vss
+ gf180mcu_fd_sc_mcu7t5v0__aoi21_1
X_07337_ _07662_/A1 _07337_/A2 _07341_/B vdd vdd vss vss gf180mcu_fd_sc_mcu7t5v0__nor2_4
X_07268_ _07268_/A1 _07267_/Z _07268_/Z vdd vdd vss vss gf180mcu_fd_sc_mcu7t5v0__xor2_1
X_06219_ _06218_/B _06220_/A3 _06219_/Z vdd vdd vss vss gf180mcu_fd_sc_mcu7t5v0__xor2_1
X_09007_ _09405_/A1 _09011_/A2 _09011_/B1 _09007_/B2 _09854_/D vdd vdd
+ vss vss gf180mcu_fd_sc_mcu7t5v0__oai22_1
X_07199_ _07199_/I _07255_/A1 vdd vdd vss vss gf180mcu_fd_sc_mcu7t5v0__clkinv_1
X_09909_ _09909_/D clk _09909_/Q vdd vdd vss vss gf180mcu_fd_sc_mcu7t5v0__dffq_4
XTAP_1521 vdd vss gf180mcu_fd_sc_mcu7t5v0__filltie
XTAP_1510 vdd vss gf180mcu_fd_sc_mcu7t5v0__filltie
XTAP_1532 vdd vss gf180mcu_fd_sc_mcu7t5v0__filltie
XPHY_83 vdd vss gf180mcu_fd_sc_mcu7t5v0__endcap
XPHY_72 vdd vss gf180mcu_fd_sc_mcu7t5v0__endcap
XPHY_61 vdd vss gf180mcu_fd_sc_mcu7t5v0__endcap
XPHY_50 vdd vss gf180mcu_fd_sc_mcu7t5v0__endcap
XTAP_1543 vdd vss gf180mcu_fd_sc_mcu7t5v0__filltie
XTAP_1554 vdd vss gf180mcu_fd_sc_mcu7t5v0__filltie
XTAP_1565 vdd vss gf180mcu_fd_sc_mcu7t5v0__filltie
XTAP_1576 vdd vss gf180mcu_fd_sc_mcu7t5v0__filltie
XPHY_94 vdd vss gf180mcu_fd_sc_mcu7t5v0__endcap
XTAP_1587 vdd vss gf180mcu_fd_sc_mcu7t5v0__filltie
XTAP_1598 vdd vss gf180mcu_fd_sc_mcu7t5v0__filltie
X_06570_ _06570_/A1 _06570_/A2 _06617_/A2 vdd vdd vss vss gf180mcu_fd_sc_mcu7t5v0__xnor2_1
X_05521_ _05521_/A1 _05521_/A2 _05544_/A2 vdd vdd vss vss gf180mcu_fd_sc_mcu7t5v0__nand2_1
X_05452_ _05452_/A1 _05452_/A2 _05458_/C1 vdd vdd vss vss gf180mcu_fd_sc_mcu7t5v0__nand2_1
X_08240_ _08287_/A1 _08287_/A2 _08335_/A2 vdd vdd vss vss gf180mcu_fd_sc_mcu7t5v0__nand2_2
X_08171_ _08125_/Z _08171_/A2 _08171_/B _08222_/A1 vdd vdd vss vss
+ gf180mcu_fd_sc_mcu7t5v0__oai21_1
X_05383_ _09403_/A1 _05389_/A2 _05389_/B1 _05383_/B2 _09535_/D vdd vdd
+ vss vss gf180mcu_fd_sc_mcu7t5v0__oai22_1
X_07122_ _09630_/Q _07121_/Z _07122_/Z vdd vdd vss vss gf180mcu_fd_sc_mcu7t5v0__or2_1
X_07053_ _09634_/Q _07053_/A2 _07052_/Z _07054_/B1 vdd vdd vss vss
+ gf180mcu_fd_sc_mcu7t5v0__nor3_1
X_06004_ _06297_/I1 _06296_/A1 _06004_/B _06006_/A2 vdd vdd vss vss
+ gf180mcu_fd_sc_mcu7t5v0__oai21_1
X_07955_ _07955_/A1 _07955_/A2 _07957_/B vdd vdd vss vss gf180mcu_fd_sc_mcu7t5v0__xor2_1
X_06906_ _09619_/Q _06905_/Z _06925_/B vdd vdd vss vss gf180mcu_fd_sc_mcu7t5v0__nand2_1
X_07886_ _09680_/Q _09679_/Q _07886_/Z vdd vdd vss vss gf180mcu_fd_sc_mcu7t5v0__and2_1
X_09625_ _09625_/D clk _09625_/Q vdd vdd vss vss gf180mcu_fd_sc_mcu7t5v0__dffq_4
X_06837_ _06838_/A1 _06836_/Z _06879_/A2 vdd vdd vss vss gf180mcu_fd_sc_mcu7t5v0__nor2_1
X_06768_ _06811_/A1 _06941_/A2 _06839_/A2 _06769_/A2 vdd vdd vss vss
+ gf180mcu_fd_sc_mcu7t5v0__nand3_1
X_09556_ _09556_/D clk _09556_/Q vdd vdd vss vss gf180mcu_fd_sc_mcu7t5v0__dffq_2
X_05719_ _05720_/A1 _05718_/Z _05761_/A2 vdd vdd vss vss gf180mcu_fd_sc_mcu7t5v0__nand2_1
X_09487_ _09487_/D clk _09487_/Q vdd vdd vss vss gf180mcu_fd_sc_mcu7t5v0__dffq_1
X_08507_ _09713_/Q _08677_/A2 _08517_/B1 vdd vdd vss vss gf180mcu_fd_sc_mcu7t5v0__nor2_1
X_06699_ _09711_/Q _06658_/I _06702_/A1 vdd vdd vss vss gf180mcu_fd_sc_mcu7t5v0__nand2_1
X_08438_ _09711_/Q _09710_/Q _08685_/A2 _08688_/A2 _08460_/A1 vdd vdd
+ vss vss gf180mcu_fd_sc_mcu7t5v0__nand4_2
X_08369_ _08369_/A1 _09073_/A2 _08369_/B _09690_/D vdd vdd vss vss
+ gf180mcu_fd_sc_mcu7t5v0__aoi21_1
XTAP_2030 vdd vss gf180mcu_fd_sc_mcu7t5v0__filltie
XTAP_1340 vdd vss gf180mcu_fd_sc_mcu7t5v0__filltie
XTAP_1362 vdd vss gf180mcu_fd_sc_mcu7t5v0__filltie
XTAP_1351 vdd vss gf180mcu_fd_sc_mcu7t5v0__filltie
XTAP_1373 vdd vss gf180mcu_fd_sc_mcu7t5v0__filltie
XTAP_1384 vdd vss gf180mcu_fd_sc_mcu7t5v0__filltie
XTAP_1395 vdd vss gf180mcu_fd_sc_mcu7t5v0__filltie
X_04952_ _09846_/Q _08997_/B2 vdd vdd vss vss gf180mcu_fd_sc_mcu7t5v0__clkinv_1
X_07740_ _07740_/A1 _07735_/Z _07740_/Z vdd vdd vss vss gf180mcu_fd_sc_mcu7t5v0__or2_1
X_04883_ _10020_/Q _09403_/B2 vdd vdd vss vss gf180mcu_fd_sc_mcu7t5v0__clkinv_1
X_07671_ _09404_/A1 _07676_/A2 _07676_/B1 _07671_/B2 _09662_/D vdd vdd
+ vss vss gf180mcu_fd_sc_mcu7t5v0__oai22_1
X_06622_ _06623_/B _06623_/A1 _06623_/A2 _06629_/B2 vdd vdd vss vss
+ gf180mcu_fd_sc_mcu7t5v0__nand3_1
X_09410_ _09410_/D clk _09410_/Q vdd vdd vss vss gf180mcu_fd_sc_mcu7t5v0__dffq_1
X_06553_ _06553_/A1 _06517_/Z _06553_/B _06570_/A1 vdd vdd vss vss
+ gf180mcu_fd_sc_mcu7t5v0__aoi21_1
X_09341_ _09992_/Q _09344_/A2 _09342_/B vdd vdd vss vss gf180mcu_fd_sc_mcu7t5v0__nor2_1
X_05504_ _05504_/A1 _05504_/A2 _05516_/B1 vdd vdd vss vss gf180mcu_fd_sc_mcu7t5v0__nand2_1
X_06484_ _09714_/Q _06485_/A2 _06534_/A1 vdd vdd vss vss gf180mcu_fd_sc_mcu7t5v0__nand2_1
X_09272_ _09397_/A1 _09274_/A2 _09272_/B _09399_/C _09962_/D vdd vdd vss
+ vss gf180mcu_fd_sc_mcu7t5v0__aoi211_1
X_08223_ _08223_/A1 _08223_/A2 _08196_/Z _08198_/Z _08223_/B2 _08223_/B3 _08252_/A1
+ vdd vdd vss vss gf180mcu_fd_sc_mcu7t5v0__oai33_2
X_05435_ _09451_/Q _05627_/A2 _05627_/B1 _09435_/Q _05437_/A1 vdd vdd
+ vss vss gf180mcu_fd_sc_mcu7t5v0__aoi22_1
X_05366_ _09406_/A1 _05369_/A2 _05369_/B1 _05366_/B2 _09518_/D vdd vdd
+ vss vss gf180mcu_fd_sc_mcu7t5v0__oai22_1
X_08154_ _08030_/Z _08061_/Z _08096_/Z _08154_/B _08155_/A2 vdd vdd vss
+ vss gf180mcu_fd_sc_mcu7t5v0__oai31_1
X_08085_ _08107_/B _08106_/A2 _08086_/A2 vdd vdd vss vss gf180mcu_fd_sc_mcu7t5v0__nor2_1
X_07105_ _07113_/A1 _07113_/A2 _07145_/A2 vdd vdd vss vss gf180mcu_fd_sc_mcu7t5v0__nor2_1
X_05297_ _09002_/A1 _05631_/B2 _05306_/A2 vdd vdd vss vss gf180mcu_fd_sc_mcu7t5v0__nand2_4
X_07036_ _07073_/A1 _07032_/Z _07035_/B _07036_/Z vdd vdd vss vss
+ gf180mcu_fd_sc_mcu7t5v0__or3_1
X_08987_ _09405_/A1 _08991_/A2 _08991_/B1 _08987_/B2 _09838_/D vdd vdd
+ vss vss gf180mcu_fd_sc_mcu7t5v0__oai22_1
X_07938_ _07938_/A1 _07938_/A2 _07934_/Z _07947_/A1 vdd vdd vss vss
+ gf180mcu_fd_sc_mcu7t5v0__xnor3_1
X_07869_ _07869_/A1 _07869_/A2 _07841_/Z _07843_/Z _07869_/B2 _07869_/B3 _07902_/A1
+ vdd vdd vss vss gf180mcu_fd_sc_mcu7t5v0__oai33_2
X_09608_ _09608_/D clk _09608_/Q vdd vdd vss vss gf180mcu_fd_sc_mcu7t5v0__dffq_1
X_09539_ _09539_/D clk _09539_/Q vdd vdd vss vss gf180mcu_fd_sc_mcu7t5v0__dffq_1
XTAP_409 vdd vss gf180mcu_fd_sc_mcu7t5v0__filltie
XTAP_1170 vdd vss gf180mcu_fd_sc_mcu7t5v0__filltie
XTAP_1181 vdd vss gf180mcu_fd_sc_mcu7t5v0__filltie
XTAP_1192 vdd vss gf180mcu_fd_sc_mcu7t5v0__filltie
X_05220_ _05276_/A1 _05250_/A2 _05276_/A3 _09002_/A1 vdd vdd vss vss
+ gf180mcu_fd_sc_mcu7t5v0__nor3_4
X_05151_ _09766_/Q _05158_/A3 _05152_/A4 vdd vdd vss vss gf180mcu_fd_sc_mcu7t5v0__nand2_1
X_05082_ _09417_/Q _05246_/A1 vdd vdd vss vss gf180mcu_fd_sc_mcu7t5v0__clkinv_1
Xrepeater3 _09226_/B _09257_/B vdd vdd vss vss gf180mcu_fd_sc_mcu7t5v0__buf_8
XTAP_910 vdd vss gf180mcu_fd_sc_mcu7t5v0__filltie
X_08910_ _09406_/A1 _08913_/A2 _08913_/B1 _08910_/B2 _09798_/D vdd vdd
+ vss vss gf180mcu_fd_sc_mcu7t5v0__oai22_1
X_09890_ _09890_/D clk _09890_/Q vdd vdd vss vss gf180mcu_fd_sc_mcu7t5v0__dffq_1
XTAP_932 vdd vss gf180mcu_fd_sc_mcu7t5v0__filltie
XTAP_921 vdd vss gf180mcu_fd_sc_mcu7t5v0__filltie
XTAP_943 vdd vss gf180mcu_fd_sc_mcu7t5v0__filltie
X_08841_ _09775_/Q _08838_/Z _08841_/Z vdd vdd vss vss gf180mcu_fd_sc_mcu7t5v0__and2_1
XTAP_954 vdd vss gf180mcu_fd_sc_mcu7t5v0__filltie
XTAP_965 vdd vss gf180mcu_fd_sc_mcu7t5v0__filltie
XTAP_976 vdd vss gf180mcu_fd_sc_mcu7t5v0__filltie
XTAP_987 vdd vss gf180mcu_fd_sc_mcu7t5v0__filltie
XTAP_998 vdd vss gf180mcu_fd_sc_mcu7t5v0__filltie
X_08772_ _08772_/A1 _08782_/A2 _08772_/B _09748_/D vdd vdd vss vss
+ gf180mcu_fd_sc_mcu7t5v0__aoi21_1
X_05984_ _06313_/A1 _06280_/B _06231_/B1 vdd vdd vss vss gf180mcu_fd_sc_mcu7t5v0__nand2_2
X_07723_ _07970_/B2 _07753_/A1 _07723_/Z vdd vdd vss vss gf180mcu_fd_sc_mcu7t5v0__and2_1
X_04935_ _09725_/Q _08740_/B2 vdd vdd vss vss gf180mcu_fd_sc_mcu7t5v0__clkinv_1
X_07654_ _07341_/B _07654_/A2 _08706_/B _07655_/B vdd vdd vss vss
+ gf180mcu_fd_sc_mcu7t5v0__oai21_1
X_04866_ _09526_/Q _05372_/B2 vdd vdd vss vss gf180mcu_fd_sc_mcu7t5v0__clkinv_1
X_06605_ _09654_/Q _06605_/A2 _06605_/B1 _09890_/Q _06623_/A2 vdd vdd
+ vss vss gf180mcu_fd_sc_mcu7t5v0__aoi22_2
X_04797_ _09648_/Q _08424_/A1 vdd vdd vss vss gf180mcu_fd_sc_mcu7t5v0__clkinv_3
X_07585_ _07587_/A2 _07587_/A3 _07586_/B vdd vdd vss vss gf180mcu_fd_sc_mcu7t5v0__nand2_1
X_06536_ _06581_/B _06536_/A2 _06536_/Z vdd vdd vss vss gf180mcu_fd_sc_mcu7t5v0__or2_1
X_09324_ _09984_/Q _09333_/A2 _09325_/B vdd vdd vss vss gf180mcu_fd_sc_mcu7t5v0__nor2_1
X_06467_ _09714_/Q _06562_/A2 _06515_/A1 vdd vdd vss vss gf180mcu_fd_sc_mcu7t5v0__nand2_1
X_09255_ _09467_/Q _09956_/Q _09259_/B _09256_/B vdd vdd vss vss gf180mcu_fd_sc_mcu7t5v0__oai21_1
X_05418_ _09542_/Q _05628_/A2 _05628_/B1 _09859_/Q _05419_/A2 vdd vdd
+ vss vss gf180mcu_fd_sc_mcu7t5v0__aoi22_1
X_08206_ _08257_/B _08257_/A2 _08207_/A2 vdd vdd vss vss gf180mcu_fd_sc_mcu7t5v0__nor2_1
X_06398_ _09594_/Q _06412_/B1 _06417_/B vdd vdd vss vss gf180mcu_fd_sc_mcu7t5v0__nand2_1
X_09186_ _09173_/B _09250_/A2 _09186_/B _09929_/D vdd vdd vss vss
+ gf180mcu_fd_sc_mcu7t5v0__aoi21_1
X_05349_ _09409_/A1 _05349_/A2 _05349_/B1 _05349_/B2 _09505_/D vdd vdd
+ vss vss gf180mcu_fd_sc_mcu7t5v0__oai22_1
X_08137_ _09693_/Q _09692_/Q _08331_/B1 vdd vdd vss vss gf180mcu_fd_sc_mcu7t5v0__nor2_4
X_08068_ _08070_/A1 _08067_/Z _08108_/B vdd vdd vss vss gf180mcu_fd_sc_mcu7t5v0__nand2_1
X_07019_ _09626_/Q _06993_/B _07020_/B _07042_/A2 vdd vdd vss vss
+ gf180mcu_fd_sc_mcu7t5v0__nand3_1
X_10030_ _10030_/ZN vdd vdd vss vss gf180mcu_fd_sc_mcu7t5v0__tiel
XPHY_242 vdd vss gf180mcu_fd_sc_mcu7t5v0__endcap
XPHY_231 vdd vss gf180mcu_fd_sc_mcu7t5v0__endcap
XPHY_220 vdd vss gf180mcu_fd_sc_mcu7t5v0__endcap
XPHY_264 vdd vss gf180mcu_fd_sc_mcu7t5v0__endcap
XPHY_253 vdd vss gf180mcu_fd_sc_mcu7t5v0__endcap
X_04720_ _09910_/Q _09311_/A2 vdd vdd vss vss gf180mcu_fd_sc_mcu7t5v0__clkinv_2
X_07370_ _08424_/A1 _07371_/A2 _07395_/A1 vdd vdd vss vss gf180mcu_fd_sc_mcu7t5v0__nor2_1
X_06321_ _09407_/A1 _06323_/A2 _06323_/B1 _06321_/B2 _09589_/D vdd vdd
+ vss vss gf180mcu_fd_sc_mcu7t5v0__oai22_1
X_06252_ _06261_/A2 _06293_/B2 _06252_/Z vdd vdd vss vss gf180mcu_fd_sc_mcu7t5v0__xor2_1
X_09040_ _09552_/Q _09033_/I _09042_/A1 vdd vdd vss vss gf180mcu_fd_sc_mcu7t5v0__nand2_1
X_05203_ _05203_/I _05318_/A1 vdd vdd vss vss gf180mcu_fd_sc_mcu7t5v0__clkinv_1
X_06183_ _06170_/Z _06181_/Z _06183_/Z vdd vdd vss vss gf180mcu_fd_sc_mcu7t5v0__xor2_1
X_05134_ _05134_/I _05140_/A2 vdd vdd vss vss gf180mcu_fd_sc_mcu7t5v0__inv_1
X_05065_ _09666_/Q _07675_/B2 vdd vdd vss vss gf180mcu_fd_sc_mcu7t5v0__clkinv_1
X_09942_ _09942_/D clk _09942_/Q vdd vdd vss vss gf180mcu_fd_sc_mcu7t5v0__dffq_1
XTAP_751 vdd vss gf180mcu_fd_sc_mcu7t5v0__filltie
XTAP_740 vdd vss gf180mcu_fd_sc_mcu7t5v0__filltie
X_09873_ _09873_/D clk _09873_/Q vdd vdd vss vss gf180mcu_fd_sc_mcu7t5v0__dffq_1
XTAP_784 vdd vss gf180mcu_fd_sc_mcu7t5v0__filltie
XTAP_795 vdd vss gf180mcu_fd_sc_mcu7t5v0__filltie
XTAP_773 vdd vss gf180mcu_fd_sc_mcu7t5v0__filltie
XTAP_762 vdd vss gf180mcu_fd_sc_mcu7t5v0__filltie
X_08824_ _08824_/I _08845_/B vdd vdd vss vss gf180mcu_fd_sc_mcu7t5v0__clkinv_2
X_08755_ _09409_/A1 _08755_/A2 _08755_/B1 _08755_/B2 _09742_/D vdd vdd
+ vss vss gf180mcu_fd_sc_mcu7t5v0__oai22_1
X_07706_ _08029_/A2 _08565_/C _08670_/B _07706_/C _09668_/D vdd vdd vss
+ vss gf180mcu_fd_sc_mcu7t5v0__aoi211_1
X_05967_ _05733_/C _05967_/A2 _08565_/C _05968_/B2 vdd vdd vss vss
+ gf180mcu_fd_sc_mcu7t5v0__aoi21_1
XTAP_1906 vdd vss gf180mcu_fd_sc_mcu7t5v0__filltie
X_05898_ _05898_/I _05941_/A1 vdd vdd vss vss gf180mcu_fd_sc_mcu7t5v0__clkinv_1
X_04918_ _09837_/Q _08986_/B2 vdd vdd vss vss gf180mcu_fd_sc_mcu7t5v0__clkinv_1
X_08686_ _09717_/Q _08686_/I1 _08686_/S _08686_/Z vdd vdd vss vss
+ gf180mcu_fd_sc_mcu7t5v0__mux2_1
XTAP_1939 vdd vss gf180mcu_fd_sc_mcu7t5v0__filltie
XTAP_1928 vdd vss gf180mcu_fd_sc_mcu7t5v0__filltie
XTAP_1917 vdd vss gf180mcu_fd_sc_mcu7t5v0__filltie
X_04849_ _09769_/Q _05158_/A3 vdd vdd vss vss gf180mcu_fd_sc_mcu7t5v0__clkinv_1
X_07637_ _07630_/Z _07637_/A2 _07637_/A3 _07637_/Z vdd vdd vss vss
+ gf180mcu_fd_sc_mcu7t5v0__xor3_1
X_07568_ _09716_/Q _07317_/Z _07590_/A1 vdd vdd vss vss gf180mcu_fd_sc_mcu7t5v0__nand2_1
X_06519_ _06520_/A1 _06520_/A2 _06546_/B vdd vdd vss vss gf180mcu_fd_sc_mcu7t5v0__or2_1
X_09307_ _09977_/Q _09310_/A2 _09308_/B vdd vdd vss vss gf180mcu_fd_sc_mcu7t5v0__nor2_1
X_07499_ _07548_/B _07548_/A2 _07500_/A2 vdd vdd vss vss gf180mcu_fd_sc_mcu7t5v0__nor2_1
X_09238_ _09254_/A2 _09244_/A2 _09238_/B _09947_/D vdd vdd vss vss
+ gf180mcu_fd_sc_mcu7t5v0__aoi21_1
X_09169_ _09137_/Z _09169_/A2 _09170_/C vdd vdd vss vss gf180mcu_fd_sc_mcu7t5v0__nor2_1
X_10013_ _10013_/D clk _10013_/Q vdd vdd vss vss gf180mcu_fd_sc_mcu7t5v0__dffq_1
X_06870_ _09715_/Q _06672_/B _06955_/A1 _06871_/A2 _06918_/C _06871_/B vdd vdd
+ vss vss gf180mcu_fd_sc_mcu7t5v0__aoi221_1
X_05821_ _07506_/B _05901_/A2 _05821_/B _05822_/C vdd vdd vss vss
+ gf180mcu_fd_sc_mcu7t5v0__aoi21_1
X_05752_ _05752_/A1 _05793_/A1 _05752_/Z vdd vdd vss vss gf180mcu_fd_sc_mcu7t5v0__xor2_1
X_08540_ _08541_/A1 _08538_/Z _08569_/A2 vdd vdd vss vss gf180mcu_fd_sc_mcu7t5v0__nand2_1
X_05683_ _09710_/Q _05645_/I _05721_/A1 vdd vdd vss vss gf180mcu_fd_sc_mcu7t5v0__nor2_1
X_08471_ _08715_/A1 _08481_/A1 _08468_/Z _08471_/Z vdd vdd vss vss
+ gf180mcu_fd_sc_mcu7t5v0__xor3_1
X_07422_ _09629_/Q _07420_/Z _07452_/A1 vdd vdd vss vss gf180mcu_fd_sc_mcu7t5v0__nand2_2
X_07353_ _07377_/A2 _07377_/A3 _07443_/B _07356_/A3 vdd vdd vss vss
+ gf180mcu_fd_sc_mcu7t5v0__nand3_1
X_06304_ _10009_/Q _09104_/A2 _09072_/B _06305_/B vdd vdd vss vss
+ gf180mcu_fd_sc_mcu7t5v0__oai21_1
X_07284_ _07240_/Z _07242_/Z _07283_/Z _07284_/B _07285_/B vdd vdd vss
+ vss gf180mcu_fd_sc_mcu7t5v0__oai31_1
X_06235_ _09711_/Q _06178_/Z _06235_/B _06236_/A3 vdd vdd vss vss
+ gf180mcu_fd_sc_mcu7t5v0__aoi21_1
X_09023_ _09023_/A1 _09031_/A2 _09031_/B1 vdd vdd vss vss gf180mcu_fd_sc_mcu7t5v0__nand2_2
X_06166_ _07506_/B _06016_/I _06170_/A2 vdd vdd vss vss gf180mcu_fd_sc_mcu7t5v0__nor2_1
X_06097_ _06120_/A1 _06055_/I _06097_/A3 _06097_/Z vdd vdd vss vss
+ gf180mcu_fd_sc_mcu7t5v0__xor3_2
X_05117_ _09822_/Q _09824_/Q _05116_/Z _05121_/A2 vdd vdd vss vss
+ gf180mcu_fd_sc_mcu7t5v0__nor3_1
X_05048_ _09849_/Q _09000_/B2 vdd vdd vss vss gf180mcu_fd_sc_mcu7t5v0__clkinv_1
X_09925_ _09925_/D clk _09925_/Q vdd vdd vss vss gf180mcu_fd_sc_mcu7t5v0__dffq_1
X_09856_ _09856_/D clk _09856_/Q vdd vdd vss vss gf180mcu_fd_sc_mcu7t5v0__dffq_1
XTAP_570 vdd vss gf180mcu_fd_sc_mcu7t5v0__filltie
XTAP_592 vdd vss gf180mcu_fd_sc_mcu7t5v0__filltie
XTAP_581 vdd vss gf180mcu_fd_sc_mcu7t5v0__filltie
X_08807_ _09764_/Q _05157_/Z _05165_/B _08801_/Z _08807_/C _09764_/D vdd vdd
+ vss vss gf180mcu_fd_sc_mcu7t5v0__aoi221_1
X_06999_ _08291_/B _07003_/B _07008_/A1 vdd vdd vss vss gf180mcu_fd_sc_mcu7t5v0__nand2_1
X_09787_ _09787_/D clk _09787_/Q vdd vdd vss vss gf180mcu_fd_sc_mcu7t5v0__dffq_1
X_08738_ _09402_/A1 _08745_/A2 _08745_/B1 _08738_/B2 _09723_/D vdd vdd
+ vss vss gf180mcu_fd_sc_mcu7t5v0__oai22_1
XTAP_1714 vdd vss gf180mcu_fd_sc_mcu7t5v0__filltie
XTAP_1725 vdd vss gf180mcu_fd_sc_mcu7t5v0__filltie
XTAP_1703 vdd vss gf180mcu_fd_sc_mcu7t5v0__filltie
X_08669_ _08476_/C _08655_/Z _08669_/B _08706_/B _08670_/A2 vdd vdd vss
+ vss gf180mcu_fd_sc_mcu7t5v0__oai211_1
XTAP_1758 vdd vss gf180mcu_fd_sc_mcu7t5v0__filltie
XTAP_1747 vdd vss gf180mcu_fd_sc_mcu7t5v0__filltie
XTAP_1736 vdd vss gf180mcu_fd_sc_mcu7t5v0__filltie
XTAP_1769 vdd vss gf180mcu_fd_sc_mcu7t5v0__filltie
X_06020_ _09711_/Q _06019_/Z _06065_/A1 vdd vdd vss vss gf180mcu_fd_sc_mcu7t5v0__nand2_1
X_07971_ _08011_/A1 _07971_/A2 _07971_/B _07972_/B vdd vdd vss vss
+ gf180mcu_fd_sc_mcu7t5v0__oai21_1
X_06922_ _06781_/C _06908_/Z _08565_/C _06923_/B2 vdd vdd vss vss
+ gf180mcu_fd_sc_mcu7t5v0__aoi21_1
X_09710_ _09710_/D clk _09710_/Q vdd vdd vss vss gf180mcu_fd_sc_mcu7t5v0__dffq_4
X_09641_ _09641_/D clk _09641_/Q vdd vdd vss vss gf180mcu_fd_sc_mcu7t5v0__dffq_1
X_06853_ _06853_/A1 _06878_/A1 _06850_/Z _06854_/B vdd vdd vss vss
+ gf180mcu_fd_sc_mcu7t5v0__xor3_1
X_05804_ _05804_/A1 _05756_/Z _05807_/A3 _05857_/A2 vdd vdd vss vss
+ gf180mcu_fd_sc_mcu7t5v0__nor3_1
X_06784_ _06784_/A1 _06784_/A2 _08670_/B _09616_/D vdd vdd vss vss
+ gf180mcu_fd_sc_mcu7t5v0__aoi21_1
X_09572_ _09572_/D clk _09572_/Q vdd vdd vss vss gf180mcu_fd_sc_mcu7t5v0__dffq_2
X_05735_ _05735_/A1 _05735_/A2 _05735_/B _05736_/B2 vdd vdd vss vss
+ gf180mcu_fd_sc_mcu7t5v0__oai21_1
X_08523_ _09712_/Q _08677_/A2 _08587_/A1 vdd vdd vss vss gf180mcu_fd_sc_mcu7t5v0__nand2_1
X_08454_ _09710_/Q _08678_/A2 _08494_/A1 vdd vdd vss vss gf180mcu_fd_sc_mcu7t5v0__nand2_1
X_05666_ _09558_/Q _05666_/A2 _05666_/Z vdd vdd vss vss gf180mcu_fd_sc_mcu7t5v0__xor2_1
X_05597_ _05597_/A1 _05597_/A2 _05602_/C2 vdd vdd vss vss gf180mcu_fd_sc_mcu7t5v0__nand2_1
X_08385_ _09409_/A1 _08385_/A2 _08385_/B1 _08385_/B2 _09701_/D vdd vdd
+ vss vss gf180mcu_fd_sc_mcu7t5v0__oai22_1
X_07405_ _09712_/Q _07385_/Z _07521_/A1 vdd vdd vss vss gf180mcu_fd_sc_mcu7t5v0__nand2_2
X_07336_ _07612_/B _07649_/A1 _07336_/B _07339_/B2 vdd vdd vss vss
+ gf180mcu_fd_sc_mcu7t5v0__aoi21_1
X_09006_ _09404_/A1 _09011_/A2 _09011_/B1 _09006_/B2 _09853_/D vdd vdd
+ vss vss gf180mcu_fd_sc_mcu7t5v0__oai22_1
X_07267_ _07267_/I0 _09712_/Q _07267_/S _07267_/Z vdd vdd vss vss
+ gf180mcu_fd_sc_mcu7t5v0__mux2_1
X_06218_ _06218_/A1 _06218_/A2 _06218_/B _06268_/B vdd vdd vss vss
+ gf180mcu_fd_sc_mcu7t5v0__oai21_1
X_07198_ _09716_/Q _07003_/B _07199_/I vdd vdd vss vss gf180mcu_fd_sc_mcu7t5v0__nand2_1
X_06149_ _07506_/B _06147_/Z _06150_/B vdd vdd vss vss gf180mcu_fd_sc_mcu7t5v0__xor2_1
X_09908_ _09908_/D clk _09908_/Q vdd vdd vss vss gf180mcu_fd_sc_mcu7t5v0__dffq_2
X_09839_ _09839_/D clk _09839_/Q vdd vdd vss vss gf180mcu_fd_sc_mcu7t5v0__dffq_1
XPHY_40 vdd vss gf180mcu_fd_sc_mcu7t5v0__endcap
XTAP_1500 vdd vss gf180mcu_fd_sc_mcu7t5v0__filltie
XTAP_1522 vdd vss gf180mcu_fd_sc_mcu7t5v0__filltie
XTAP_1511 vdd vss gf180mcu_fd_sc_mcu7t5v0__filltie
XTAP_1533 vdd vss gf180mcu_fd_sc_mcu7t5v0__filltie
XPHY_73 vdd vss gf180mcu_fd_sc_mcu7t5v0__endcap
XPHY_62 vdd vss gf180mcu_fd_sc_mcu7t5v0__endcap
XPHY_51 vdd vss gf180mcu_fd_sc_mcu7t5v0__endcap
XTAP_1544 vdd vss gf180mcu_fd_sc_mcu7t5v0__filltie
XTAP_1555 vdd vss gf180mcu_fd_sc_mcu7t5v0__filltie
XTAP_1566 vdd vss gf180mcu_fd_sc_mcu7t5v0__filltie
XPHY_84 vdd vss gf180mcu_fd_sc_mcu7t5v0__endcap
XPHY_95 vdd vss gf180mcu_fd_sc_mcu7t5v0__endcap
XTAP_1588 vdd vss gf180mcu_fd_sc_mcu7t5v0__filltie
XTAP_1577 vdd vss gf180mcu_fd_sc_mcu7t5v0__filltie
XTAP_1599 vdd vss gf180mcu_fd_sc_mcu7t5v0__filltie
X_05520_ _09518_/Q _05628_/A2 _05628_/B1 _09478_/Q _05521_/A2 vdd vdd
+ vss vss gf180mcu_fd_sc_mcu7t5v0__aoi22_1
X_05451_ _09419_/Q _05628_/A2 _05628_/B1 _09606_/Q _05452_/A2 vdd vdd
+ vss vss gf180mcu_fd_sc_mcu7t5v0__aoi22_1
X_08170_ _08170_/A1 _08170_/A2 _08670_/B _09684_/D vdd vdd vss vss
+ gf180mcu_fd_sc_mcu7t5v0__aoi21_1
X_05382_ _09402_/A1 _05389_/A2 _05389_/B1 _05382_/B2 _09534_/D vdd vdd
+ vss vss gf180mcu_fd_sc_mcu7t5v0__oai22_1
X_07121_ _07121_/A1 _07119_/Z _07121_/Z vdd vdd vss vss gf180mcu_fd_sc_mcu7t5v0__xor2_1
X_07052_ _09712_/Q _07033_/Z _07052_/Z vdd vdd vss vss gf180mcu_fd_sc_mcu7t5v0__and2_1
X_06003_ _05996_/B _06297_/I0 _06152_/A3 _06296_/A1 vdd vdd vss vss
+ gf180mcu_fd_sc_mcu7t5v0__nor3_4
X_07954_ _07955_/A1 _07955_/A2 _07977_/A1 vdd vdd vss vss gf180mcu_fd_sc_mcu7t5v0__nand2_1
X_07885_ _07885_/A1 _07885_/A2 _07990_/A1 _07893_/A1 vdd vdd vss vss
+ gf180mcu_fd_sc_mcu7t5v0__xnor3_1
X_06905_ _06926_/A1 _06926_/A2 _06905_/Z vdd vdd vss vss gf180mcu_fd_sc_mcu7t5v0__xor2_2
X_06836_ _06838_/A2 _06838_/A3 _06836_/Z vdd vdd vss vss gf180mcu_fd_sc_mcu7t5v0__xor2_1
X_09624_ _09624_/D clk _09624_/Q vdd vdd vss vss gf180mcu_fd_sc_mcu7t5v0__dffq_4
X_06767_ _09616_/Q _06785_/A1 _06764_/Z _06767_/Z vdd vdd vss vss
+ gf180mcu_fd_sc_mcu7t5v0__xor3_1
X_09555_ _09555_/D clk _09555_/Q vdd vdd vss vss gf180mcu_fd_sc_mcu7t5v0__dffq_2
X_05718_ _09560_/Q _05716_/Z _05718_/Z vdd vdd vss vss gf180mcu_fd_sc_mcu7t5v0__xor2_1
X_09486_ _09486_/D clk _09486_/Q vdd vdd vss vss gf180mcu_fd_sc_mcu7t5v0__dffq_1
X_08506_ _08506_/A1 _08504_/Z _08517_/A2 vdd vdd vss vss gf180mcu_fd_sc_mcu7t5v0__xnor2_1
X_06698_ _08430_/B _06941_/A2 _06698_/B _06703_/B vdd vdd vss vss
+ gf180mcu_fd_sc_mcu7t5v0__aoi21_1
X_08437_ _09711_/Q _08700_/A2 _08510_/B _08437_/C _08442_/A2 vdd vdd vss
+ vss gf180mcu_fd_sc_mcu7t5v0__aoi211_1
X_05649_ _09567_/Q _05970_/A1 _05660_/A2 vdd vdd vss vss gf180mcu_fd_sc_mcu7t5v0__nand2_1
X_08368_ _09980_/Q _09073_/A2 _08734_/B _08369_/B vdd vdd vss vss
+ gf180mcu_fd_sc_mcu7t5v0__oai21_1
X_08299_ _08299_/A1 _08299_/A2 _08298_/Z _08302_/A3 vdd vdd vss vss
+ gf180mcu_fd_sc_mcu7t5v0__xnor3_1
X_07319_ _08291_/B _07465_/A2 _07336_/B vdd vdd vss vss gf180mcu_fd_sc_mcu7t5v0__nor2_2
XTAP_2031 vdd vss gf180mcu_fd_sc_mcu7t5v0__filltie
XTAP_2020 vdd vss gf180mcu_fd_sc_mcu7t5v0__filltie
XTAP_1330 vdd vss gf180mcu_fd_sc_mcu7t5v0__filltie
XTAP_1341 vdd vss gf180mcu_fd_sc_mcu7t5v0__filltie
XTAP_1363 vdd vss gf180mcu_fd_sc_mcu7t5v0__filltie
XTAP_1352 vdd vss gf180mcu_fd_sc_mcu7t5v0__filltie
XTAP_1374 vdd vss gf180mcu_fd_sc_mcu7t5v0__filltie
XTAP_1385 vdd vss gf180mcu_fd_sc_mcu7t5v0__filltie
XTAP_1396 vdd vss gf180mcu_fd_sc_mcu7t5v0__filltie
X_04951_ _09862_/Q _09017_/B2 vdd vdd vss vss gf180mcu_fd_sc_mcu7t5v0__clkinv_1
X_07670_ _09403_/A1 _07676_/A2 _07676_/B1 _07670_/B2 _09661_/D vdd vdd
+ vss vss gf180mcu_fd_sc_mcu7t5v0__oai22_1
X_04882_ _09735_/Q _08748_/B2 vdd vdd vss vss gf180mcu_fd_sc_mcu7t5v0__clkinv_1
X_06621_ _06450_/C _06620_/Z _06632_/B1 vdd vdd vss vss gf180mcu_fd_sc_mcu7t5v0__nand2_1
X_06552_ _06552_/A1 _06552_/A2 _06617_/A1 vdd vdd vss vss gf180mcu_fd_sc_mcu7t5v0__xnor2_1
X_09340_ _09395_/A1 _09344_/A2 _09340_/B _09399_/C _09991_/D vdd vdd vss
+ vss gf180mcu_fd_sc_mcu7t5v0__aoi211_1
X_05503_ _09797_/Q _05628_/A2 _05628_/B1 _09903_/Q _05504_/A2 vdd vdd
+ vss vss gf180mcu_fd_sc_mcu7t5v0__aoi22_1
X_09271_ _09962_/Q _09274_/A2 _09272_/B vdd vdd vss vss gf180mcu_fd_sc_mcu7t5v0__nor2_1
X_06483_ _06555_/A2 _06530_/B _06485_/A2 vdd vdd vss vss gf180mcu_fd_sc_mcu7t5v0__xnor2_1
X_08222_ _08222_/A1 _08222_/A2 _08222_/B _08272_/A1 vdd vdd vss vss
+ gf180mcu_fd_sc_mcu7t5v0__aoi21_1
X_05434_ _05434_/A1 _05434_/A2 _05458_/A2 vdd vdd vss vss gf180mcu_fd_sc_mcu7t5v0__nand2_1
X_08153_ _08167_/C _08152_/Z _08169_/A2 vdd vdd vss vss gf180mcu_fd_sc_mcu7t5v0__nand2_1
X_05365_ _09405_/A1 _05369_/A2 _05369_/B1 _05365_/B2 _09517_/D vdd vdd
+ vss vss gf180mcu_fd_sc_mcu7t5v0__oai22_1
X_08084_ _08084_/A1 _08084_/A2 _08084_/A3 _08107_/B _08087_/B1 vdd vdd
+ vss vss gf180mcu_fd_sc_mcu7t5v0__oai31_1
X_07104_ _07113_/A1 _07113_/A2 _07104_/Z vdd vdd vss vss gf180mcu_fd_sc_mcu7t5v0__and2_1
X_05296_ _09409_/A1 _05296_/A2 _05296_/B1 _05296_/B2 _09449_/D vdd vdd
+ vss vss gf180mcu_fd_sc_mcu7t5v0__oai22_1
X_07035_ _07073_/A1 _07032_/Z _07035_/B _07037_/A1 vdd vdd vss vss
+ gf180mcu_fd_sc_mcu7t5v0__oai21_1
X_08986_ _09404_/A1 _08991_/A2 _08991_/B1 _08986_/B2 _09837_/D vdd vdd
+ vss vss gf180mcu_fd_sc_mcu7t5v0__oai22_1
X_07937_ _07938_/A1 _07938_/A2 _07937_/Z vdd vdd vss vss gf180mcu_fd_sc_mcu7t5v0__and2_1
X_07868_ _07868_/A1 _07868_/A2 _07868_/B _07924_/A1 vdd vdd vss vss
+ gf180mcu_fd_sc_mcu7t5v0__aoi21_1
X_09607_ _09607_/D clk _09607_/Q vdd vdd vss vss gf180mcu_fd_sc_mcu7t5v0__dffq_1
X_07799_ _09671_/Q _07798_/Z _07819_/A2 vdd vdd vss vss gf180mcu_fd_sc_mcu7t5v0__nor2_1
X_06819_ _06958_/A1 _06819_/A2 _06824_/A3 vdd vdd vss vss gf180mcu_fd_sc_mcu7t5v0__nand2_1
X_09538_ _09538_/D clk _09538_/Q vdd vdd vss vss gf180mcu_fd_sc_mcu7t5v0__dffq_1
X_09469_ _09469_/D clk _09469_/Q vdd vdd vss vss gf180mcu_fd_sc_mcu7t5v0__dffq_1
XTAP_1160 vdd vss gf180mcu_fd_sc_mcu7t5v0__filltie
XTAP_1171 vdd vss gf180mcu_fd_sc_mcu7t5v0__filltie
XTAP_1182 vdd vss gf180mcu_fd_sc_mcu7t5v0__filltie
XTAP_1193 vdd vss gf180mcu_fd_sc_mcu7t5v0__filltie
X_05150_ _09763_/Q _09764_/Q _09768_/Q _05150_/A4 _05152_/A3 vdd vdd vss
+ vss gf180mcu_fd_sc_mcu7t5v0__nand4_2
X_05081_ _09549_/Q _05399_/B2 vdd vdd vss vss gf180mcu_fd_sc_mcu7t5v0__clkinv_1
Xrepeater4 _08806_/B _09226_/B vdd vdd vss vss gf180mcu_fd_sc_mcu7t5v0__buf_8
XTAP_900 vdd vss gf180mcu_fd_sc_mcu7t5v0__filltie
XTAP_911 vdd vss gf180mcu_fd_sc_mcu7t5v0__filltie
XTAP_933 vdd vss gf180mcu_fd_sc_mcu7t5v0__filltie
XTAP_922 vdd vss gf180mcu_fd_sc_mcu7t5v0__filltie
XTAP_944 vdd vss gf180mcu_fd_sc_mcu7t5v0__filltie
X_08840_ _08838_/Z _08840_/A2 _09774_/D vdd vdd vss vss gf180mcu_fd_sc_mcu7t5v0__nor2_1
XTAP_955 vdd vss gf180mcu_fd_sc_mcu7t5v0__filltie
XTAP_966 vdd vss gf180mcu_fd_sc_mcu7t5v0__filltie
XTAP_977 vdd vss gf180mcu_fd_sc_mcu7t5v0__filltie
XTAP_988 vdd vss gf180mcu_fd_sc_mcu7t5v0__filltie
XTAP_999 vdd vss gf180mcu_fd_sc_mcu7t5v0__filltie
X_08771_ _09749_/Q _08782_/A2 _08791_/B _08772_/B vdd vdd vss vss
+ gf180mcu_fd_sc_mcu7t5v0__oai21_1
X_05983_ _09583_/Q _09582_/Q _06282_/A2 vdd vdd vss vss gf180mcu_fd_sc_mcu7t5v0__nor2_4
X_04934_ _09492_/Q _05334_/B2 vdd vdd vss vss gf180mcu_fd_sc_mcu7t5v0__clkinv_1
X_07722_ _09711_/Q _07727_/A2 _07727_/A3 _07753_/A1 vdd vdd vss vss
+ gf180mcu_fd_sc_mcu7t5v0__nand3_2
X_04865_ _09514_/Q _05362_/B2 vdd vdd vss vss gf180mcu_fd_sc_mcu7t5v0__clkinv_1
X_07653_ _07653_/A1 _07640_/Z _07653_/B1 _07653_/B2 _07653_/C _07654_/A2 vdd
+ vdd vss vss gf180mcu_fd_sc_mcu7t5v0__aoi221_1
X_06604_ _09604_/Q _09603_/Q _09578_/Q _06623_/A1 vdd vdd vss vss
+ gf180mcu_fd_sc_mcu7t5v0__nand3_2
X_09323_ _09367_/A2 _09311_/Z _09333_/A2 vdd vdd vss vss gf180mcu_fd_sc_mcu7t5v0__nor2_4
X_07584_ _09711_/Q _07644_/A2 _07634_/A3 vdd vdd vss vss gf180mcu_fd_sc_mcu7t5v0__nand2_1
X_04796_ _09649_/Q _08452_/A1 vdd vdd vss vss gf180mcu_fd_sc_mcu7t5v0__inv_2
X_06535_ _06367_/B _06535_/A2 _06536_/A2 vdd vdd vss vss gf180mcu_fd_sc_mcu7t5v0__nand2_1
X_06466_ _09714_/Q _06608_/A2 _06562_/A2 _09713_/Q _06510_/A2 vdd vdd
+ vss vss gf180mcu_fd_sc_mcu7t5v0__aoi22_1
X_09254_ _09467_/Q _09254_/A2 _09254_/B _09955_/D vdd vdd vss vss
+ gf180mcu_fd_sc_mcu7t5v0__aoi21_1
X_09185_ _09929_/Q _09173_/B _09257_/B _09186_/B vdd vdd vss vss gf180mcu_fd_sc_mcu7t5v0__oai21_1
X_05417_ _09410_/Q _05627_/A2 _05627_/B1 _09843_/Q _05419_/A1 vdd vdd
+ vss vss gf180mcu_fd_sc_mcu7t5v0__aoi22_1
X_08205_ _08030_/Z _08061_/Z _08096_/Z _08338_/A2 _08257_/A2 vdd vdd vss
+ vss gf180mcu_fd_sc_mcu7t5v0__nor4_2
X_06397_ _09594_/Q _06412_/B1 _06417_/A2 vdd vdd vss vss gf180mcu_fd_sc_mcu7t5v0__nor2_1
X_08136_ _09705_/Q _08375_/A1 _08180_/B _08139_/A2 vdd vdd vss vss
+ gf180mcu_fd_sc_mcu7t5v0__oai21_2
X_05348_ _09408_/A1 _05349_/A2 _05349_/B1 _05348_/B2 _09504_/D vdd vdd
+ vss vss gf180mcu_fd_sc_mcu7t5v0__oai22_1
X_08067_ _08430_/B _08129_/A2 _08067_/A3 _08067_/Z vdd vdd vss vss
+ gf180mcu_fd_sc_mcu7t5v0__xor3_1
X_05279_ _09402_/A1 _05286_/A2 _05286_/B1 _05279_/B2 _09434_/D vdd vdd
+ vss vss gf180mcu_fd_sc_mcu7t5v0__oai22_1
X_07018_ _09627_/Q _07021_/C1 _07020_/B vdd vdd vss vss gf180mcu_fd_sc_mcu7t5v0__xor2_1
X_08969_ _09825_/Q _08964_/Z _08969_/B _09825_/D vdd vdd vss vss
+ gf180mcu_fd_sc_mcu7t5v0__aoi21_1
XPHY_210 vdd vss gf180mcu_fd_sc_mcu7t5v0__endcap
XPHY_243 vdd vss gf180mcu_fd_sc_mcu7t5v0__endcap
XPHY_232 vdd vss gf180mcu_fd_sc_mcu7t5v0__endcap
XPHY_221 vdd vss gf180mcu_fd_sc_mcu7t5v0__endcap
XPHY_265 vdd vss gf180mcu_fd_sc_mcu7t5v0__endcap
XPHY_254 vdd vss gf180mcu_fd_sc_mcu7t5v0__endcap
X_06320_ _09406_/A1 _06323_/A2 _06323_/B1 _06320_/B2 _09588_/D vdd vdd
+ vss vss gf180mcu_fd_sc_mcu7t5v0__oai22_1
X_06251_ _06146_/B _06178_/Z _06251_/B _06293_/B2 vdd vdd vss vss
+ gf180mcu_fd_sc_mcu7t5v0__aoi21_1
X_05202_ _09912_/Q _09895_/Q _05217_/S _05203_/I vdd vdd vss vss gf180mcu_fd_sc_mcu7t5v0__mux2_2
X_06182_ _06170_/Z _06181_/Z _06267_/A1 vdd vdd vss vss gf180mcu_fd_sc_mcu7t5v0__nand2_1
X_05133_ _09785_/Q _09299_/A3 _09378_/A2 _09754_/Q _05131_/Z _09793_/Q _05134_/I vdd
+ vdd vss vss gf180mcu_fd_sc_mcu7t5v0__aoi222_1
X_05064_ _09700_/Q _08384_/B2 vdd vdd vss vss gf180mcu_fd_sc_mcu7t5v0__clkinv_1
X_09941_ _09941_/D clk _09941_/Q vdd vdd vss vss gf180mcu_fd_sc_mcu7t5v0__dffq_1
XTAP_752 vdd vss gf180mcu_fd_sc_mcu7t5v0__filltie
XTAP_741 vdd vss gf180mcu_fd_sc_mcu7t5v0__filltie
XTAP_730 vdd vss gf180mcu_fd_sc_mcu7t5v0__filltie
X_09872_ _09872_/D clk _09872_/Q vdd vdd vss vss gf180mcu_fd_sc_mcu7t5v0__dffq_1
XTAP_785 vdd vss gf180mcu_fd_sc_mcu7t5v0__filltie
XTAP_774 vdd vss gf180mcu_fd_sc_mcu7t5v0__filltie
XTAP_763 vdd vss gf180mcu_fd_sc_mcu7t5v0__filltie
X_08823_ _09732_/Q _09733_/Q _09734_/Q _09226_/B _08824_/I vdd vdd vss
+ vss gf180mcu_fd_sc_mcu7t5v0__oai31_2
XTAP_796 vdd vss gf180mcu_fd_sc_mcu7t5v0__filltie
X_08754_ _09408_/A1 _08755_/A2 _08755_/B1 _08754_/B2 _09741_/D vdd vdd
+ vss vss gf180mcu_fd_sc_mcu7t5v0__oai22_1
X_05966_ _05966_/A1 _05966_/A2 _05963_/Z _05769_/B _05966_/C _05967_/A2 vdd
+ vdd vss vss gf180mcu_fd_sc_mcu7t5v0__oai221_1
X_04917_ _09829_/Q _08976_/B2 vdd vdd vss vss gf180mcu_fd_sc_mcu7t5v0__clkinv_1
X_07705_ _07771_/C _07705_/A2 _07705_/B _08565_/C _07706_/C vdd vdd vss
+ vss gf180mcu_fd_sc_mcu7t5v0__aoi211_1
XTAP_1907 vdd vss gf180mcu_fd_sc_mcu7t5v0__filltie
X_05897_ _05897_/A1 _05897_/A2 _05898_/I vdd vdd vss vss gf180mcu_fd_sc_mcu7t5v0__xor2_1
X_08685_ _09717_/Q _08685_/A2 _08686_/I1 vdd vdd vss vss gf180mcu_fd_sc_mcu7t5v0__nand2_1
XTAP_1929 vdd vss gf180mcu_fd_sc_mcu7t5v0__filltie
XTAP_1918 vdd vss gf180mcu_fd_sc_mcu7t5v0__filltie
X_04848_ _09766_/Q _08813_/A1 vdd vdd vss vss gf180mcu_fd_sc_mcu7t5v0__clkinv_1
X_07636_ _07636_/A1 _07636_/A2 _07636_/A3 _07637_/A3 vdd vdd vss vss
+ gf180mcu_fd_sc_mcu7t5v0__xnor3_1
X_04779_ _09679_/Q _08024_/A1 vdd vdd vss vss gf180mcu_fd_sc_mcu7t5v0__inv_2
X_07567_ _07567_/A1 _07567_/A2 _07567_/B _07619_/A1 vdd vdd vss vss
+ gf180mcu_fd_sc_mcu7t5v0__aoi21_1
X_06518_ _06553_/A1 _06517_/Z _06520_/A2 vdd vdd vss vss gf180mcu_fd_sc_mcu7t5v0__xnor2_1
X_09306_ _09395_/A1 _09310_/A2 _09306_/B _09399_/C _09976_/D vdd vdd vss
+ vss gf180mcu_fd_sc_mcu7t5v0__aoi211_1
X_09237_ _09947_/Q _09244_/A2 _09259_/B _09238_/B vdd vdd vss vss
+ gf180mcu_fd_sc_mcu7t5v0__oai21_1
X_07498_ _07317_/Z _07349_/Z _07385_/Z _07623_/A2 _07548_/A2 vdd vdd vss
+ vss gf180mcu_fd_sc_mcu7t5v0__nor4_2
X_06449_ _09713_/Q _06601_/A2 _06449_/B1 _06590_/C _06451_/A1 vdd vdd
+ vss vss gf180mcu_fd_sc_mcu7t5v0__oai22_1
X_09168_ _09958_/Q _09461_/Q _09169_/A2 vdd vdd vss vss gf180mcu_fd_sc_mcu7t5v0__nand2_1
X_08119_ _08358_/I0 _08229_/A1 _08119_/B1 _08119_/B2 _08119_/C _08120_/C vdd
+ vdd vss vss gf180mcu_fd_sc_mcu7t5v0__oai221_2
X_09099_ _09896_/Q _09077_/Z _09100_/A2 vdd vdd vss vss gf180mcu_fd_sc_mcu7t5v0__nand2_1
X_10012_ _10012_/D clk _10012_/Q vdd vdd vss vss gf180mcu_fd_sc_mcu7t5v0__dffq_1
X_05820_ _09714_/Q _05820_/A2 _05819_/Z _05930_/B2 _05930_/C _05821_/B vdd vdd
+ vss vss gf180mcu_fd_sc_mcu7t5v0__aoi221_1
X_05751_ _05751_/A1 _05795_/A2 _05798_/A1 vdd vdd vss vss gf180mcu_fd_sc_mcu7t5v0__nor2_1
X_08470_ _09712_/Q _08468_/Z _08481_/A2 vdd vdd vss vss gf180mcu_fd_sc_mcu7t5v0__nor2_1
X_05682_ _09559_/Q _05704_/A1 _05698_/B1 _05700_/A2 vdd vdd vss vss
+ gf180mcu_fd_sc_mcu7t5v0__xnor3_1
X_07421_ _09629_/Q _07420_/Z _07421_/Z vdd vdd vss vss gf180mcu_fd_sc_mcu7t5v0__and2_1
X_07352_ _09655_/Q _07352_/A2 _07443_/B vdd vdd vss vss gf180mcu_fd_sc_mcu7t5v0__nand2_2
X_06303_ _06303_/A1 _06303_/A2 _09578_/D vdd vdd vss vss gf180mcu_fd_sc_mcu7t5v0__nor2_1
X_07283_ _06623_/B _07283_/A2 _07283_/A3 _07283_/Z vdd vdd vss vss
+ gf180mcu_fd_sc_mcu7t5v0__xor3_1
X_06234_ _06238_/A2 _06284_/A1 _06271_/S vdd vdd vss vss gf180mcu_fd_sc_mcu7t5v0__nor2_1
X_09022_ _09022_/A1 _09105_/A2 _09031_/A2 vdd vdd vss vss gf180mcu_fd_sc_mcu7t5v0__nand2_4
X_06165_ _06165_/I _06214_/A1 vdd vdd vss vss gf180mcu_fd_sc_mcu7t5v0__clkinv_1
X_05116_ _09819_/Q _09823_/Q _09826_/Q _09825_/Q _05116_/Z vdd vdd vss
+ vss gf180mcu_fd_sc_mcu7t5v0__or4_1
X_06096_ _06120_/A1 _06097_/A3 _06096_/Z vdd vdd vss vss gf180mcu_fd_sc_mcu7t5v0__xor2_1
X_05047_ _09865_/Q _09020_/B2 vdd vdd vss vss gf180mcu_fd_sc_mcu7t5v0__clkinv_1
X_09924_ _09924_/D clk _09924_/Q vdd vdd vss vss gf180mcu_fd_sc_mcu7t5v0__dffq_2
X_09855_ _09855_/D clk _09855_/Q vdd vdd vss vss gf180mcu_fd_sc_mcu7t5v0__dffq_1
XTAP_560 vdd vss gf180mcu_fd_sc_mcu7t5v0__filltie
XTAP_593 vdd vss gf180mcu_fd_sc_mcu7t5v0__filltie
XTAP_571 vdd vss gf180mcu_fd_sc_mcu7t5v0__filltie
XTAP_582 vdd vss gf180mcu_fd_sc_mcu7t5v0__filltie
X_08806_ _09764_/Q _05157_/Z _08806_/B _08807_/C vdd vdd vss vss gf180mcu_fd_sc_mcu7t5v0__oai21_1
X_09786_ _09786_/D clk _09786_/Q vdd vdd vss vss gf180mcu_fd_sc_mcu7t5v0__dffq_1
X_06998_ _07316_/A2 _08565_/C _06998_/B1 _06998_/B2 _08670_/B _09626_/D vdd
+ vdd vss vss gf180mcu_fd_sc_mcu7t5v0__aoi221_1
X_08737_ _09089_/B _08745_/A2 _08745_/B1 vdd vdd vss vss gf180mcu_fd_sc_mcu7t5v0__nand2_2
X_05949_ _09715_/Q _05711_/I _05951_/A2 vdd vdd vss vss gf180mcu_fd_sc_mcu7t5v0__nand2_1
XTAP_1715 vdd vss gf180mcu_fd_sc_mcu7t5v0__filltie
XTAP_1704 vdd vss gf180mcu_fd_sc_mcu7t5v0__filltie
X_08668_ _08668_/A1 _08668_/A2 _08668_/A3 _08668_/A4 _08669_/B vdd vdd
+ vss vss gf180mcu_fd_sc_mcu7t5v0__nand4_1
XTAP_1748 vdd vss gf180mcu_fd_sc_mcu7t5v0__filltie
XTAP_1737 vdd vss gf180mcu_fd_sc_mcu7t5v0__filltie
XTAP_1726 vdd vss gf180mcu_fd_sc_mcu7t5v0__filltie
X_07619_ _07619_/A1 _07619_/A2 _07619_/B _07639_/A1 vdd vdd vss vss
+ gf180mcu_fd_sc_mcu7t5v0__oai21_1
XTAP_1759 vdd vss gf180mcu_fd_sc_mcu7t5v0__filltie
X_08599_ _08656_/A1 _08599_/A2 _08612_/A1 vdd vdd vss vss gf180mcu_fd_sc_mcu7t5v0__nand2_1
X_07970_ _09716_/Q _08012_/A2 _07971_/A2 _07970_/B2 _07970_/C _07971_/B vdd
+ vdd vss vss gf180mcu_fd_sc_mcu7t5v0__aoi221_1
X_06921_ _06739_/C _06921_/A2 _06921_/A3 _06921_/A4 _06923_/B1 vdd vdd
+ vss vss gf180mcu_fd_sc_mcu7t5v0__nand4_1
X_09640_ _09640_/D clk _09640_/Q vdd vdd vss vss gf180mcu_fd_sc_mcu7t5v0__dffq_1
X_06852_ _06853_/A1 _06850_/Z _06878_/A2 vdd vdd vss vss gf180mcu_fd_sc_mcu7t5v0__nor2_1
X_05803_ _05741_/Z _05803_/A2 _05803_/A3 _05807_/A3 vdd vdd vss vss
+ gf180mcu_fd_sc_mcu7t5v0__xnor3_1
X_06783_ _06739_/C _06767_/Z _06783_/B _08706_/B _06784_/A2 vdd vdd vss
+ vss gf180mcu_fd_sc_mcu7t5v0__oai211_1
X_09571_ _09571_/D clk _09571_/Q vdd vdd vss vss gf180mcu_fd_sc_mcu7t5v0__dffq_2
X_05734_ _05862_/A1 _05716_/Z _05734_/B _05735_/B vdd vdd vss vss
+ gf180mcu_fd_sc_mcu7t5v0__aoi21_1
X_08522_ _08495_/Z _08522_/A2 _08522_/B _08541_/A1 vdd vdd vss vss
+ gf180mcu_fd_sc_mcu7t5v0__aoi21_2
X_08453_ _09710_/Q _08678_/A2 _08453_/Z vdd vdd vss vss gf180mcu_fd_sc_mcu7t5v0__and2_1
X_05665_ _09558_/Q _05666_/A2 _05704_/A1 vdd vdd vss vss gf180mcu_fd_sc_mcu7t5v0__nand2_1
X_07404_ _09712_/Q _07385_/Z _07407_/B2 vdd vdd vss vss gf180mcu_fd_sc_mcu7t5v0__nor2_1
X_05596_ _09424_/Q _05628_/A2 _05628_/B1 _09611_/Q _05597_/A2 vdd vdd
+ vss vss gf180mcu_fd_sc_mcu7t5v0__aoi22_1
X_08384_ _09408_/A1 _08385_/A2 _08385_/B1 _08384_/B2 _09700_/D vdd vdd
+ vss vss gf180mcu_fd_sc_mcu7t5v0__oai22_1
X_07335_ _07336_/B _07335_/A2 _07651_/A2 _09710_/Q _07340_/A1 vdd vdd
+ vss vss gf180mcu_fd_sc_mcu7t5v0__aoi22_1
X_07266_ _09712_/Q _07160_/Z _07267_/I0 vdd vdd vss vss gf180mcu_fd_sc_mcu7t5v0__nand2_1
X_06217_ _06218_/A1 _06218_/A2 _06220_/A3 vdd vdd vss vss gf180mcu_fd_sc_mcu7t5v0__nor2_1
X_09005_ _09403_/A1 _09011_/A2 _09011_/B1 _09005_/B2 _09852_/D vdd vdd
+ vss vss gf180mcu_fd_sc_mcu7t5v0__oai22_1
X_07197_ _07197_/A1 _07197_/A2 _07197_/B _07254_/A1 vdd vdd vss vss
+ gf180mcu_fd_sc_mcu7t5v0__aoi21_1
X_06148_ _09714_/Q _06147_/Z _06148_/Z vdd vdd vss vss gf180mcu_fd_sc_mcu7t5v0__and2_1
X_06079_ _09713_/Q _05987_/I _06083_/B vdd vdd vss vss gf180mcu_fd_sc_mcu7t5v0__nand2_1
X_09907_ _09907_/D clk _09907_/Q vdd vdd vss vss gf180mcu_fd_sc_mcu7t5v0__dffq_1
X_09838_ _09838_/D clk _09838_/Q vdd vdd vss vss gf180mcu_fd_sc_mcu7t5v0__dffq_1
XTAP_390 vdd vss gf180mcu_fd_sc_mcu7t5v0__filltie
X_09769_ _09769_/D clk _09769_/Q vdd vdd vss vss gf180mcu_fd_sc_mcu7t5v0__dffq_1
XPHY_30 vdd vss gf180mcu_fd_sc_mcu7t5v0__endcap
XTAP_1501 vdd vss gf180mcu_fd_sc_mcu7t5v0__filltie
XTAP_1523 vdd vss gf180mcu_fd_sc_mcu7t5v0__filltie
XTAP_1512 vdd vss gf180mcu_fd_sc_mcu7t5v0__filltie
XPHY_74 vdd vss gf180mcu_fd_sc_mcu7t5v0__endcap
XPHY_63 vdd vss gf180mcu_fd_sc_mcu7t5v0__endcap
XPHY_52 vdd vss gf180mcu_fd_sc_mcu7t5v0__endcap
XPHY_41 vdd vss gf180mcu_fd_sc_mcu7t5v0__endcap
XTAP_1534 vdd vss gf180mcu_fd_sc_mcu7t5v0__filltie
XTAP_1545 vdd vss gf180mcu_fd_sc_mcu7t5v0__filltie
XTAP_1556 vdd vss gf180mcu_fd_sc_mcu7t5v0__filltie
XTAP_1567 vdd vss gf180mcu_fd_sc_mcu7t5v0__filltie
XPHY_85 vdd vss gf180mcu_fd_sc_mcu7t5v0__endcap
XPHY_96 vdd vss gf180mcu_fd_sc_mcu7t5v0__endcap
XTAP_1589 vdd vss gf180mcu_fd_sc_mcu7t5v0__filltie
XTAP_1578 vdd vss gf180mcu_fd_sc_mcu7t5v0__filltie
X_05450_ _09852_/Q _05627_/A2 _05627_/B1 _09585_/Q _05452_/A1 vdd vdd
+ vss vss gf180mcu_fd_sc_mcu7t5v0__aoi22_1
X_05381_ _09401_/A1 _05389_/A2 _05389_/B1 vdd vdd vss vss gf180mcu_fd_sc_mcu7t5v0__nand2_2
X_07120_ _07121_/A1 _07119_/Z _07143_/A2 vdd vdd vss vss gf180mcu_fd_sc_mcu7t5v0__nor2_1
X_07051_ _07278_/A1 _07039_/Z _07056_/A2 vdd vdd vss vss gf180mcu_fd_sc_mcu7t5v0__nand2_1
X_06002_ _09581_/Q _09580_/Q _06293_/A2 vdd vdd vss vss gf180mcu_fd_sc_mcu7t5v0__nor2_2
X_07953_ _07895_/Z _07978_/A1 _07953_/A3 _07955_/A2 vdd vdd vss vss
+ gf180mcu_fd_sc_mcu7t5v0__xnor3_1
X_07884_ _07885_/A1 _07990_/A1 _07930_/A2 vdd vdd vss vss gf180mcu_fd_sc_mcu7t5v0__nand2_1
X_06904_ _06904_/A1 _06902_/Z _06926_/A2 vdd vdd vss vss gf180mcu_fd_sc_mcu7t5v0__xnor2_1
X_06835_ _07506_/B _06941_/A2 _06838_/A3 _06879_/A1 vdd vdd vss vss
+ gf180mcu_fd_sc_mcu7t5v0__nor3_1
X_09623_ _09623_/D clk _09623_/Q vdd vdd vss vss gf180mcu_fd_sc_mcu7t5v0__dffq_4
X_09554_ _09554_/D clk _09554_/Q vdd vdd vss vss gf180mcu_fd_sc_mcu7t5v0__dffq_2
X_06766_ _09616_/Q _06764_/Z _06785_/B vdd vdd vss vss gf180mcu_fd_sc_mcu7t5v0__and2_1
X_05717_ _09560_/Q _05716_/Z _05761_/A1 vdd vdd vss vss gf180mcu_fd_sc_mcu7t5v0__nand2_1
X_09485_ _09485_/D clk _09485_/Q vdd vdd vss vss gf180mcu_fd_sc_mcu7t5v0__dffq_1
X_08505_ _08506_/A1 _08504_/Z _08505_/Z vdd vdd vss vss gf180mcu_fd_sc_mcu7t5v0__or2_1
X_06697_ _09711_/Q _06956_/A2 _06697_/B _06918_/C _06698_/B vdd vdd vss
+ vss gf180mcu_fd_sc_mcu7t5v0__aoi211_1
X_08436_ _08699_/A2 _08510_/A1 _08436_/S _08437_/C vdd vdd vss vss
+ gf180mcu_fd_sc_mcu7t5v0__mux2_1
X_05648_ _09566_/Q _05964_/A2 _05930_/B2 vdd vdd vss vss gf180mcu_fd_sc_mcu7t5v0__nor2_2
X_08367_ _08367_/A1 _09073_/A2 _08367_/B _09689_/D vdd vdd vss vss
+ gf180mcu_fd_sc_mcu7t5v0__aoi21_1
X_05579_ _05579_/A1 _05579_/A2 _05603_/A2 vdd vdd vss vss gf180mcu_fd_sc_mcu7t5v0__nand2_1
X_07318_ _07377_/A2 _07377_/A3 _07465_/A2 vdd vdd vss vss gf180mcu_fd_sc_mcu7t5v0__nand2_2
X_08298_ _08298_/A1 _08298_/A2 _08298_/Z vdd vdd vss vss gf180mcu_fd_sc_mcu7t5v0__xor2_1
X_07249_ _07242_/Z _07249_/A2 _07249_/B _07249_/C _07250_/B vdd vdd vss
+ vss gf180mcu_fd_sc_mcu7t5v0__oai211_1
XTAP_2010 vdd vss gf180mcu_fd_sc_mcu7t5v0__filltie
XTAP_2032 vdd vss gf180mcu_fd_sc_mcu7t5v0__filltie
XTAP_2021 vdd vss gf180mcu_fd_sc_mcu7t5v0__filltie
XTAP_1320 vdd vss gf180mcu_fd_sc_mcu7t5v0__filltie
XTAP_1331 vdd vss gf180mcu_fd_sc_mcu7t5v0__filltie
XTAP_1342 vdd vss gf180mcu_fd_sc_mcu7t5v0__filltie
XTAP_1364 vdd vss gf180mcu_fd_sc_mcu7t5v0__filltie
XTAP_1353 vdd vss gf180mcu_fd_sc_mcu7t5v0__filltie
XTAP_1375 vdd vss gf180mcu_fd_sc_mcu7t5v0__filltie
XTAP_1386 vdd vss gf180mcu_fd_sc_mcu7t5v0__filltie
XTAP_1397 vdd vss gf180mcu_fd_sc_mcu7t5v0__filltie
X_04950_ _09838_/Q _08987_/B2 vdd vdd vss vss gf180mcu_fd_sc_mcu7t5v0__clkinv_1
X_06620_ _06632_/A1 _06620_/A2 _06630_/A2 _06620_/Z vdd vdd vss vss
+ gf180mcu_fd_sc_mcu7t5v0__xor3_1
X_04881_ _09794_/Q _08906_/B2 vdd vdd vss vss gf180mcu_fd_sc_mcu7t5v0__clkinv_1
X_06551_ _06552_/A1 _06552_/A2 _06616_/A1 vdd vdd vss vss gf180mcu_fd_sc_mcu7t5v0__nor2_1
X_06482_ _06482_/A1 _06482_/A2 _06530_/B vdd vdd vss vss gf180mcu_fd_sc_mcu7t5v0__nand2_1
X_05502_ _09738_/Q _05627_/A2 _05627_/B1 _09870_/Q _05504_/A1 vdd vdd
+ vss vss gf180mcu_fd_sc_mcu7t5v0__aoi22_1
X_09270_ _09395_/A1 _09274_/A2 _09270_/B _09399_/C _09961_/D vdd vdd vss
+ vss gf180mcu_fd_sc_mcu7t5v0__aoi211_1
X_08221_ _08670_/B _08221_/A2 _09685_/D vdd vdd vss vss gf180mcu_fd_sc_mcu7t5v0__nor2_1
X_05433_ _09515_/Q _05628_/A2 _05628_/B1 _09475_/Q _05434_/A2 vdd vdd
+ vss vss gf180mcu_fd_sc_mcu7t5v0__aoi22_1
X_08152_ _09684_/Q _08125_/Z _08149_/Z _08152_/Z vdd vdd vss vss gf180mcu_fd_sc_mcu7t5v0__xor3_1
X_05364_ _09404_/A1 _05369_/A2 _05369_/B1 _05364_/B2 _09516_/D vdd vdd
+ vss vss gf180mcu_fd_sc_mcu7t5v0__oai22_1
X_08083_ _08358_/I0 _08099_/A1 _08083_/B1 _08217_/A1 _08083_/C _08084_/A3 vdd
+ vdd vss vss gf180mcu_fd_sc_mcu7t5v0__oai221_1
X_05295_ _09408_/A1 _05296_/A2 _05296_/B1 _05295_/B2 _09448_/D vdd vdd
+ vss vss gf180mcu_fd_sc_mcu7t5v0__oai22_1
X_07103_ _07103_/A1 _07103_/A2 _07113_/A2 vdd vdd vss vss gf180mcu_fd_sc_mcu7t5v0__xnor2_1
X_07034_ _09710_/Q _07033_/Z _07035_/B vdd vdd vss vss gf180mcu_fd_sc_mcu7t5v0__nand2_1
X_08985_ _09403_/A1 _08991_/A2 _08991_/B1 _08985_/B2 _09836_/D vdd vdd
+ vss vss gf180mcu_fd_sc_mcu7t5v0__oai22_1
X_07936_ _09713_/Q _07830_/I _07995_/A1 vdd vdd vss vss gf180mcu_fd_sc_mcu7t5v0__nand2_1
X_07867_ _09673_/Q _08565_/C _07922_/A1 vdd vdd vss vss gf180mcu_fd_sc_mcu7t5v0__nand2_1
X_09606_ _09606_/D clk _09606_/Q vdd vdd vss vss gf180mcu_fd_sc_mcu7t5v0__dffq_1
X_07798_ _07820_/A1 _07755_/I _07795_/Z _07798_/Z vdd vdd vss vss
+ gf180mcu_fd_sc_mcu7t5v0__xor3_2
X_06818_ _06816_/Z _06867_/A2 _06819_/A2 vdd vdd vss vss gf180mcu_fd_sc_mcu7t5v0__nor2_1
X_09537_ _09537_/D clk _09537_/Q vdd vdd vss vss gf180mcu_fd_sc_mcu7t5v0__dffq_1
X_06749_ _06758_/A1 _06758_/A2 _06749_/Z vdd vdd vss vss gf180mcu_fd_sc_mcu7t5v0__xor2_1
X_09468_ _09468_/D clk _09468_/Q vdd vdd vss vss gf180mcu_fd_sc_mcu7t5v0__dffq_1
X_08419_ _09702_/Q _08706_/B _08708_/B _08419_/C _08420_/I vdd vdd vss
+ vss gf180mcu_fd_sc_mcu7t5v0__oai211_1
X_09399_ _09399_/A1 _09399_/A2 _09399_/B _09399_/C _10018_/D vdd vdd vss
+ vss gf180mcu_fd_sc_mcu7t5v0__aoi211_1
XTAP_1150 vdd vss gf180mcu_fd_sc_mcu7t5v0__filltie
XTAP_1161 vdd vss gf180mcu_fd_sc_mcu7t5v0__filltie
XTAP_1172 vdd vss gf180mcu_fd_sc_mcu7t5v0__filltie
XTAP_1183 vdd vss gf180mcu_fd_sc_mcu7t5v0__filltie
XTAP_1194 vdd vss gf180mcu_fd_sc_mcu7t5v0__filltie
X_05080_ _09850_/Q _09001_/B2 vdd vdd vss vss gf180mcu_fd_sc_mcu7t5v0__clkinv_1
Xrepeater5 _09278_/C _08734_/B vdd vdd vss vss gf180mcu_fd_sc_mcu7t5v0__buf_8
XTAP_901 vdd vss gf180mcu_fd_sc_mcu7t5v0__filltie
XTAP_912 vdd vss gf180mcu_fd_sc_mcu7t5v0__filltie
XTAP_934 vdd vss gf180mcu_fd_sc_mcu7t5v0__filltie
XTAP_923 vdd vss gf180mcu_fd_sc_mcu7t5v0__filltie
XTAP_945 vdd vss gf180mcu_fd_sc_mcu7t5v0__filltie
XTAP_956 vdd vss gf180mcu_fd_sc_mcu7t5v0__filltie
XTAP_967 vdd vss gf180mcu_fd_sc_mcu7t5v0__filltie
XTAP_978 vdd vss gf180mcu_fd_sc_mcu7t5v0__filltie
X_05982_ _09581_/Q _05998_/A2 _06072_/C vdd vdd vss vss gf180mcu_fd_sc_mcu7t5v0__nand2_4
XTAP_989 vdd vss gf180mcu_fd_sc_mcu7t5v0__filltie
X_08770_ _08770_/A1 _08782_/A2 _08770_/B _09747_/D vdd vdd vss vss
+ gf180mcu_fd_sc_mcu7t5v0__aoi21_1
X_04933_ _09484_/Q _05324_/B2 vdd vdd vss vss gf180mcu_fd_sc_mcu7t5v0__clkinv_1
X_07721_ _07721_/A1 _07719_/Z _07721_/B _07730_/A2 vdd vdd vss vss
+ gf180mcu_fd_sc_mcu7t5v0__oai21_1
X_04864_ _09534_/Q _05382_/B2 vdd vdd vss vss gf180mcu_fd_sc_mcu7t5v0__clkinv_1
X_07652_ _07650_/Z _07652_/A2 _07652_/B _07653_/C vdd vdd vss vss
+ gf180mcu_fd_sc_mcu7t5v0__aoi21_1
X_06603_ _09715_/Q _06603_/A2 _06611_/A1 vdd vdd vss vss gf180mcu_fd_sc_mcu7t5v0__nand2_1
X_07583_ _09710_/Q _07644_/A2 _07587_/A3 vdd vdd vss vss gf180mcu_fd_sc_mcu7t5v0__nand2_1
X_06534_ _06534_/A1 _06534_/A2 _06533_/B _06535_/A2 vdd vdd vss vss
+ gf180mcu_fd_sc_mcu7t5v0__nand3_1
X_09322_ _09399_/A1 _09322_/A2 _09322_/B _09399_/C _09983_/D vdd vdd vss
+ vss gf180mcu_fd_sc_mcu7t5v0__aoi211_1
X_04795_ _09650_/Q _08483_/A1 vdd vdd vss vss gf180mcu_fd_sc_mcu7t5v0__inv_2
X_06465_ _09714_/Q _06608_/A2 _06559_/A1 vdd vdd vss vss gf180mcu_fd_sc_mcu7t5v0__nand2_1
X_09253_ _09467_/Q _09955_/Q _09259_/B _09254_/B vdd vdd vss vss gf180mcu_fd_sc_mcu7t5v0__oai21_1
X_06396_ _06396_/A1 _06396_/A2 _06412_/B1 vdd vdd vss vss gf180mcu_fd_sc_mcu7t5v0__xnor2_1
X_08204_ _09685_/Q _08222_/A1 _08201_/Z _08204_/Z vdd vdd vss vss
+ gf180mcu_fd_sc_mcu7t5v0__xor3_1
X_05416_ _05416_/A1 _05416_/A2 _05429_/B2 vdd vdd vss vss gf180mcu_fd_sc_mcu7t5v0__nand2_1
X_09184_ _09552_/Q _09209_/A2 _09184_/B1 _09209_/B2 _09250_/A2 vdd vdd
+ vss vss gf180mcu_fd_sc_mcu7t5v0__aoi22_4
X_05347_ _09407_/A1 _05349_/A2 _05349_/B1 _05347_/B2 _09503_/D vdd vdd
+ vss vss gf180mcu_fd_sc_mcu7t5v0__oai22_1
X_08135_ _08521_/A1 _09693_/Q _09692_/Q _08234_/A2 vdd vdd vss vss
+ gf180mcu_fd_sc_mcu7t5v0__aoi21_4
X_08066_ _08129_/A2 _08067_/A3 _08066_/Z vdd vdd vss vss gf180mcu_fd_sc_mcu7t5v0__xor2_1
X_05278_ _08791_/B _05286_/A2 _05286_/B1 vdd vdd vss vss gf180mcu_fd_sc_mcu7t5v0__nand2_2
X_07017_ _09627_/Q _07021_/C1 _07042_/A1 vdd vdd vss vss gf180mcu_fd_sc_mcu7t5v0__nand2_1
X_08968_ _09825_/Q _08964_/Z _08968_/B _08969_/B vdd vdd vss vss gf180mcu_fd_sc_mcu7t5v0__oai21_1
X_07919_ _09715_/Q _07988_/A2 _07919_/B _07920_/B vdd vdd vss vss
+ gf180mcu_fd_sc_mcu7t5v0__oai21_1
X_08899_ _09792_/Q _08899_/A2 _08899_/B _08900_/I vdd vdd vss vss
+ gf180mcu_fd_sc_mcu7t5v0__oai21_1
XPHY_200 vdd vss gf180mcu_fd_sc_mcu7t5v0__endcap
XPHY_233 vdd vss gf180mcu_fd_sc_mcu7t5v0__endcap
XPHY_222 vdd vss gf180mcu_fd_sc_mcu7t5v0__endcap
XPHY_211 vdd vss gf180mcu_fd_sc_mcu7t5v0__endcap
XPHY_266 vdd vss gf180mcu_fd_sc_mcu7t5v0__endcap
XPHY_255 vdd vss gf180mcu_fd_sc_mcu7t5v0__endcap
XPHY_244 vdd vss gf180mcu_fd_sc_mcu7t5v0__endcap
X_06250_ _06290_/A1 _06246_/Z _06262_/A2 vdd vdd vss vss gf180mcu_fd_sc_mcu7t5v0__nand2_1
X_05201_ _09257_/B _09468_/Q _09464_/D vdd vdd vss vss gf180mcu_fd_sc_mcu7t5v0__and2_1
X_06181_ _06238_/A1 _06238_/A2 _06181_/Z vdd vdd vss vss gf180mcu_fd_sc_mcu7t5v0__xor2_1
X_05132_ _09909_/Q _09121_/A1 _09378_/A2 vdd vdd vss vss gf180mcu_fd_sc_mcu7t5v0__nor2_4
X_05063_ _09729_/Q _08744_/B2 vdd vdd vss vss gf180mcu_fd_sc_mcu7t5v0__clkinv_1
X_09940_ _09940_/D clk _09940_/Q vdd vdd vss vss gf180mcu_fd_sc_mcu7t5v0__dffq_1
XTAP_742 vdd vss gf180mcu_fd_sc_mcu7t5v0__filltie
XTAP_720 vdd vss gf180mcu_fd_sc_mcu7t5v0__filltie
XTAP_731 vdd vss gf180mcu_fd_sc_mcu7t5v0__filltie
X_09871_ _09871_/D clk _09871_/Q vdd vdd vss vss gf180mcu_fd_sc_mcu7t5v0__dffq_1
XTAP_786 vdd vss gf180mcu_fd_sc_mcu7t5v0__filltie
XTAP_775 vdd vss gf180mcu_fd_sc_mcu7t5v0__filltie
XTAP_764 vdd vss gf180mcu_fd_sc_mcu7t5v0__filltie
XTAP_753 vdd vss gf180mcu_fd_sc_mcu7t5v0__filltie
X_08822_ _09769_/Q _08818_/Z _08822_/Z vdd vdd vss vss gf180mcu_fd_sc_mcu7t5v0__and2_1
XTAP_797 vdd vss gf180mcu_fd_sc_mcu7t5v0__filltie
X_08753_ _09407_/A1 _08755_/A2 _08755_/B1 _08753_/B2 _09740_/D vdd vdd
+ vss vss gf180mcu_fd_sc_mcu7t5v0__oai22_1
X_05965_ _09717_/Q _05965_/A2 _05959_/Z _05930_/C _05965_/C _05966_/C vdd vdd
+ vss vss gf180mcu_fd_sc_mcu7t5v0__aoi221_1
X_04916_ _09805_/Q _08920_/B2 vdd vdd vss vss gf180mcu_fd_sc_mcu7t5v0__clkinv_1
X_07704_ _09668_/Q _07698_/B _07704_/B _07705_/B vdd vdd vss vss gf180mcu_fd_sc_mcu7t5v0__aoi21_1
X_05896_ _08291_/B _05897_/A1 _05894_/I _05952_/A2 vdd vdd vss vss
+ gf180mcu_fd_sc_mcu7t5v0__nor3_1
X_08684_ _08684_/A1 _08684_/A2 _08684_/Z vdd vdd vss vss gf180mcu_fd_sc_mcu7t5v0__xor2_1
XTAP_1919 vdd vss gf180mcu_fd_sc_mcu7t5v0__filltie
XTAP_1908 vdd vss gf180mcu_fd_sc_mcu7t5v0__filltie
X_04847_ _09523_/Q _08897_/A2 vdd vdd vss vss gf180mcu_fd_sc_mcu7t5v0__inv_2
X_07635_ _07635_/A1 _07635_/A2 _07635_/B1 _07635_/B2 _07636_/A3 vdd vdd
+ vss vss gf180mcu_fd_sc_mcu7t5v0__oai22_1
X_04778_ _09680_/Q _08026_/A1 vdd vdd vss vss gf180mcu_fd_sc_mcu7t5v0__clkinv_2
X_07566_ _07566_/A1 _07566_/A2 _07536_/Z _07566_/B1 _07566_/B2 _07595_/A1 vdd
+ vdd vss vss gf180mcu_fd_sc_mcu7t5v0__oai32_1
X_06517_ _06517_/A1 _06517_/A2 _06517_/Z vdd vdd vss vss gf180mcu_fd_sc_mcu7t5v0__xor2_1
X_09305_ _09976_/Q _09310_/A2 _09306_/B vdd vdd vss vss gf180mcu_fd_sc_mcu7t5v0__nor2_1
X_09236_ _09252_/A2 _09244_/A2 _09236_/B _09946_/D vdd vdd vss vss
+ gf180mcu_fd_sc_mcu7t5v0__aoi21_1
X_07497_ _07503_/A1 _07503_/A2 _07504_/A1 vdd vdd vss vss gf180mcu_fd_sc_mcu7t5v0__nor2_1
X_06448_ _09600_/Q _06448_/A2 _06447_/Z _06449_/B1 vdd vdd vss vss
+ gf180mcu_fd_sc_mcu7t5v0__nor3_1
X_06379_ _09593_/Q _06376_/Z _06386_/B vdd vdd vss vss gf180mcu_fd_sc_mcu7t5v0__and2_1
X_09167_ _09399_/C _09167_/A2 _09923_/D vdd vdd vss vss gf180mcu_fd_sc_mcu7t5v0__nor2_1
X_08118_ _09712_/Q _08359_/A2 _08119_/C vdd vdd vss vss gf180mcu_fd_sc_mcu7t5v0__nand2_1
X_09098_ _09098_/A1 _09098_/A2 _09098_/B _09895_/D vdd vdd vss vss
+ gf180mcu_fd_sc_mcu7t5v0__aoi21_1
X_08049_ _09710_/Q _08030_/Z _08359_/B _08049_/B2 _08050_/A2 vdd vdd vss
+ vss gf180mcu_fd_sc_mcu7t5v0__oai22_1
X_10011_ _10011_/D clk _10011_/Q vdd vdd vss vss gf180mcu_fd_sc_mcu7t5v0__dffq_1
X_05750_ _05839_/A1 _05839_/A2 _05839_/B _09711_/Q _05795_/A2 vdd vdd
+ vss vss gf180mcu_fd_sc_mcu7t5v0__oai211_2
X_05681_ _09559_/Q _05698_/B1 _05704_/A2 vdd vdd vss vss gf180mcu_fd_sc_mcu7t5v0__nor2_1
X_07420_ _09659_/Q _09658_/Q _07420_/Z vdd vdd vss vss gf180mcu_fd_sc_mcu7t5v0__and2_1
X_07351_ _09655_/Q _07352_/A2 _07548_/B vdd vdd vss vss gf180mcu_fd_sc_mcu7t5v0__and2_1
X_06302_ _09578_/Q _08706_/B _08708_/B _06303_/A2 vdd vdd vss vss
+ gf180mcu_fd_sc_mcu7t5v0__oai21_1
X_07282_ _07001_/Z _07282_/A2 _07282_/B _07283_/A3 vdd vdd vss vss
+ gf180mcu_fd_sc_mcu7t5v0__oai21_1
X_06233_ _09711_/Q _06261_/A2 _06284_/A1 vdd vdd vss vss gf180mcu_fd_sc_mcu7t5v0__nand2_1
X_09021_ _09409_/A1 _09021_/A2 _09021_/B1 _09021_/B2 _09866_/D vdd vdd
+ vss vss gf180mcu_fd_sc_mcu7t5v0__oai22_1
X_06164_ _09715_/Q _05987_/I _06165_/I vdd vdd vss vss gf180mcu_fd_sc_mcu7t5v0__nand2_1
X_05115_ _09522_/Q _08903_/A1 _05124_/A2 vdd vdd vss vss gf180mcu_fd_sc_mcu7t5v0__nand2_1
X_06095_ _06047_/Z _06097_/A3 _06095_/Z vdd vdd vss vss gf180mcu_fd_sc_mcu7t5v0__xor2_1
X_05046_ _09841_/Q _08990_/B2 vdd vdd vss vss gf180mcu_fd_sc_mcu7t5v0__clkinv_1
X_09923_ _09923_/D clk _09923_/Q vdd vdd vss vss gf180mcu_fd_sc_mcu7t5v0__dffq_2
X_09854_ _09854_/D clk _09854_/Q vdd vdd vss vss gf180mcu_fd_sc_mcu7t5v0__dffq_1
XTAP_561 vdd vss gf180mcu_fd_sc_mcu7t5v0__filltie
XTAP_550 vdd vss gf180mcu_fd_sc_mcu7t5v0__filltie
XTAP_594 vdd vss gf180mcu_fd_sc_mcu7t5v0__filltie
XTAP_572 vdd vss gf180mcu_fd_sc_mcu7t5v0__filltie
XTAP_583 vdd vss gf180mcu_fd_sc_mcu7t5v0__filltie
X_08805_ _05157_/Z _08820_/A1 _08805_/A3 _09763_/D vdd vdd vss vss
+ gf180mcu_fd_sc_mcu7t5v0__nor3_1
X_06997_ _07248_/B _06980_/Z _08565_/C _06998_/B2 vdd vdd vss vss
+ gf180mcu_fd_sc_mcu7t5v0__aoi21_1
X_09785_ _09785_/D clk _09785_/Q vdd vdd vss vss gf180mcu_fd_sc_mcu7t5v0__dffq_1
X_08736_ _09400_/A1 _08736_/A2 _08745_/A2 vdd vdd vss vss gf180mcu_fd_sc_mcu7t5v0__nand2_4
X_05948_ _05950_/A2 _05948_/A2 _05947_/Z _05948_/Z vdd vdd vss vss
+ gf180mcu_fd_sc_mcu7t5v0__xor3_1
XTAP_1705 vdd vss gf180mcu_fd_sc_mcu7t5v0__filltie
X_08667_ _09716_/Q _08700_/A2 _08667_/B1 _08699_/A2 _08667_/C _08668_/A4 vdd
+ vdd vss vss gf180mcu_fd_sc_mcu7t5v0__aoi221_1
X_05879_ _09564_/Q _08565_/C _05935_/A1 vdd vdd vss vss gf180mcu_fd_sc_mcu7t5v0__nand2_1
XTAP_1749 vdd vss gf180mcu_fd_sc_mcu7t5v0__filltie
XTAP_1738 vdd vss gf180mcu_fd_sc_mcu7t5v0__filltie
XTAP_1716 vdd vss gf180mcu_fd_sc_mcu7t5v0__filltie
XTAP_1727 vdd vss gf180mcu_fd_sc_mcu7t5v0__filltie
X_07618_ _07618_/A1 _07618_/A2 _07640_/A1 vdd vdd vss vss gf180mcu_fd_sc_mcu7t5v0__nand2_1
X_08598_ _08654_/A2 _08597_/Z _08613_/A2 vdd vdd vss vss gf180mcu_fd_sc_mcu7t5v0__nor2_1
X_07549_ _07633_/B _07602_/B _07551_/A2 vdd vdd vss vss gf180mcu_fd_sc_mcu7t5v0__xnor2_1
X_09219_ _09176_/B _09252_/A2 _09219_/B _09938_/D vdd vdd vss vss
+ gf180mcu_fd_sc_mcu7t5v0__aoi21_1
X_06920_ _09716_/Q _06890_/Z _06920_/B _06921_/A4 vdd vdd vss vss
+ gf180mcu_fd_sc_mcu7t5v0__oai21_1
X_06851_ _06853_/A1 _06850_/Z _06878_/B vdd vdd vss vss gf180mcu_fd_sc_mcu7t5v0__nand2_1
X_05802_ _05803_/A2 _05801_/Z _05802_/Z vdd vdd vss vss gf180mcu_fd_sc_mcu7t5v0__and2_1
X_06782_ _06782_/A1 _06782_/A2 _06782_/B _06783_/B vdd vdd vss vss
+ gf180mcu_fd_sc_mcu7t5v0__oai21_1
X_09570_ _09570_/D clk _09570_/Q vdd vdd vss vss gf180mcu_fd_sc_mcu7t5v0__dffq_4
X_08521_ _08521_/A1 _08565_/C _08521_/B _09705_/D vdd vdd vss vss
+ gf180mcu_fd_sc_mcu7t5v0__aoi21_1
X_05733_ _05964_/B2 _05795_/A1 _05733_/B _05733_/C _05734_/B vdd vdd vss
+ vss gf180mcu_fd_sc_mcu7t5v0__oai211_1
X_08452_ _08452_/A1 _08389_/Z _08452_/B _08678_/A2 vdd vdd vss vss
+ gf180mcu_fd_sc_mcu7t5v0__oai21_4
X_05664_ _09897_/Q _09104_/A1 _08565_/C vdd vdd vss vss gf180mcu_fd_sc_mcu7t5v0__or2_4
X_07403_ _07449_/A2 _07402_/Z _07409_/A2 vdd vdd vss vss gf180mcu_fd_sc_mcu7t5v0__nand2_1
X_05595_ _09857_/Q _05627_/A2 _05627_/B1 _09590_/Q _05597_/A1 vdd vdd
+ vss vss gf180mcu_fd_sc_mcu7t5v0__aoi22_1
X_08383_ _09407_/A1 _08385_/A2 _08385_/B1 _08383_/B2 _09699_/D vdd vdd
+ vss vss gf180mcu_fd_sc_mcu7t5v0__oai22_1
X_07334_ _09657_/Q _07611_/A1 _07651_/B vdd vdd vss vss gf180mcu_fd_sc_mcu7t5v0__nor2_4
X_07265_ _09715_/Q _07033_/Z _07268_/A1 vdd vdd vss vss gf180mcu_fd_sc_mcu7t5v0__nand2_1
X_06216_ _08721_/A1 _06016_/I _06218_/B vdd vdd vss vss gf180mcu_fd_sc_mcu7t5v0__nor2_1
X_09004_ _09402_/A1 _09011_/A2 _09011_/B1 _09004_/B2 _09851_/D vdd vdd
+ vss vss gf180mcu_fd_sc_mcu7t5v0__oai22_1
X_07196_ _07196_/A1 _07196_/A2 _07196_/B _07232_/A2 vdd vdd vss vss
+ gf180mcu_fd_sc_mcu7t5v0__aoi21_2
X_06147_ _06125_/Z _06195_/A1 _06147_/Z vdd vdd vss vss gf180mcu_fd_sc_mcu7t5v0__xor2_1
X_06078_ _06078_/A1 _06057_/Z _06078_/B _06119_/A1 vdd vdd vss vss
+ gf180mcu_fd_sc_mcu7t5v0__aoi21_1
X_05029_ _09487_/Q _05327_/B2 vdd vdd vss vss gf180mcu_fd_sc_mcu7t5v0__clkinv_1
X_09906_ _09906_/D clk _09906_/Q vdd vdd vss vss gf180mcu_fd_sc_mcu7t5v0__dffq_1
X_09837_ _09837_/D clk _09837_/Q vdd vdd vss vss gf180mcu_fd_sc_mcu7t5v0__dffq_1
XTAP_380 vdd vss gf180mcu_fd_sc_mcu7t5v0__filltie
XTAP_391 vdd vss gf180mcu_fd_sc_mcu7t5v0__filltie
X_09768_ _09768_/D clk _09768_/Q vdd vdd vss vss gf180mcu_fd_sc_mcu7t5v0__dffq_1
X_08719_ _07506_/B _09073_/A2 _08719_/B _09714_/D vdd vdd vss vss
+ gf180mcu_fd_sc_mcu7t5v0__aoi21_1
XPHY_20 vdd vss gf180mcu_fd_sc_mcu7t5v0__endcap
XPHY_31 vdd vss gf180mcu_fd_sc_mcu7t5v0__endcap
X_09699_ _09699_/D clk _09699_/Q vdd vdd vss vss gf180mcu_fd_sc_mcu7t5v0__dffq_1
XTAP_1502 vdd vss gf180mcu_fd_sc_mcu7t5v0__filltie
XTAP_1524 vdd vss gf180mcu_fd_sc_mcu7t5v0__filltie
XTAP_1513 vdd vss gf180mcu_fd_sc_mcu7t5v0__filltie
XPHY_64 vdd vss gf180mcu_fd_sc_mcu7t5v0__endcap
XPHY_53 vdd vss gf180mcu_fd_sc_mcu7t5v0__endcap
XPHY_42 vdd vss gf180mcu_fd_sc_mcu7t5v0__endcap
XTAP_1535 vdd vss gf180mcu_fd_sc_mcu7t5v0__filltie
XTAP_1546 vdd vss gf180mcu_fd_sc_mcu7t5v0__filltie
XTAP_1557 vdd vss gf180mcu_fd_sc_mcu7t5v0__filltie
XPHY_75 vdd vss gf180mcu_fd_sc_mcu7t5v0__endcap
XPHY_86 vdd vss gf180mcu_fd_sc_mcu7t5v0__endcap
XPHY_97 vdd vss gf180mcu_fd_sc_mcu7t5v0__endcap
XTAP_1568 vdd vss gf180mcu_fd_sc_mcu7t5v0__filltie
XTAP_1579 vdd vss gf180mcu_fd_sc_mcu7t5v0__filltie
X_05380_ _09022_/A1 _05631_/C1 _05389_/A2 vdd vdd vss vss gf180mcu_fd_sc_mcu7t5v0__nand2_4
X_07050_ _07284_/B _07049_/Z _07056_/A1 vdd vdd vss vss gf180mcu_fd_sc_mcu7t5v0__nand2_1
X_06001_ _06309_/A1 _09580_/Q _09579_/Q _06297_/I1 vdd vdd vss vss
+ gf180mcu_fd_sc_mcu7t5v0__nor3_4
X_07952_ _07895_/Z _07953_/A3 _07978_/A2 vdd vdd vss vss gf180mcu_fd_sc_mcu7t5v0__nor2_1
X_07883_ _07885_/A1 _07990_/A1 _07930_/B vdd vdd vss vss gf180mcu_fd_sc_mcu7t5v0__nor2_1
X_06903_ _06904_/A1 _06902_/Z _06926_/B vdd vdd vss vss gf180mcu_fd_sc_mcu7t5v0__nand2_1
X_06834_ _06834_/A1 _06834_/A2 _06834_/B _06838_/A3 vdd vdd vss vss
+ gf180mcu_fd_sc_mcu7t5v0__aoi21_2
X_09622_ _09622_/D clk _09622_/Q vdd vdd vss vss gf180mcu_fd_sc_mcu7t5v0__dffq_2
X_09553_ _09553_/D clk _09553_/Q vdd vdd vss vss gf180mcu_fd_sc_mcu7t5v0__dffq_2
X_08504_ _08495_/Z _08504_/A2 _08504_/Z vdd vdd vss vss gf180mcu_fd_sc_mcu7t5v0__xor2_1
X_06765_ _09616_/Q _06764_/Z _06765_/Z vdd vdd vss vss gf180mcu_fd_sc_mcu7t5v0__or2_1
X_05716_ _05716_/A1 _05714_/Z _05716_/Z vdd vdd vss vss gf180mcu_fd_sc_mcu7t5v0__xor2_1
X_09484_ _09484_/D clk _09484_/Q vdd vdd vss vss gf180mcu_fd_sc_mcu7t5v0__dffq_1
X_06696_ _06672_/C _06955_/A1 _06696_/S _06697_/B vdd vdd vss vss
+ gf180mcu_fd_sc_mcu7t5v0__mux2_1
X_08435_ _09711_/Q _08688_/A2 _08436_/S vdd vdd vss vss gf180mcu_fd_sc_mcu7t5v0__nand2_2
X_05647_ _09568_/Q _05972_/A1 _05964_/A2 vdd vdd vss vss gf180mcu_fd_sc_mcu7t5v0__nand2_2
X_08366_ _09979_/Q _09073_/A2 _08734_/B _08367_/B vdd vdd vss vss
+ gf180mcu_fd_sc_mcu7t5v0__oai21_1
X_05578_ _09548_/Q _05628_/A2 _05628_/B1 _09865_/Q _05579_/A2 vdd vdd
+ vss vss gf180mcu_fd_sc_mcu7t5v0__aoi22_1
X_07317_ _07377_/A2 _07377_/A3 _07317_/Z vdd vdd vss vss gf180mcu_fd_sc_mcu7t5v0__and2_2
X_08297_ _08298_/A1 _08298_/A2 _08329_/B vdd vdd vss vss gf180mcu_fd_sc_mcu7t5v0__nor2_1
X_07248_ _07248_/A1 _07248_/A2 _07248_/B _07249_/B vdd vdd vss vss
+ gf180mcu_fd_sc_mcu7t5v0__aoi21_1
X_07179_ _07179_/I _07238_/B vdd vdd vss vss gf180mcu_fd_sc_mcu7t5v0__clkinv_1
XTAP_2000 vdd vss gf180mcu_fd_sc_mcu7t5v0__filltie
XTAP_2033 vdd vss gf180mcu_fd_sc_mcu7t5v0__filltie
XTAP_2022 vdd vss gf180mcu_fd_sc_mcu7t5v0__filltie
XTAP_2011 vdd vss gf180mcu_fd_sc_mcu7t5v0__filltie
XTAP_1310 vdd vss gf180mcu_fd_sc_mcu7t5v0__filltie
XTAP_1321 vdd vss gf180mcu_fd_sc_mcu7t5v0__filltie
XTAP_1332 vdd vss gf180mcu_fd_sc_mcu7t5v0__filltie
XTAP_1343 vdd vss gf180mcu_fd_sc_mcu7t5v0__filltie
XTAP_1365 vdd vss gf180mcu_fd_sc_mcu7t5v0__filltie
XTAP_1354 vdd vss gf180mcu_fd_sc_mcu7t5v0__filltie
XTAP_1376 vdd vss gf180mcu_fd_sc_mcu7t5v0__filltie
XTAP_1387 vdd vss gf180mcu_fd_sc_mcu7t5v0__filltie
XTAP_1398 vdd vss gf180mcu_fd_sc_mcu7t5v0__filltie
X_04880_ _09867_/Q _09024_/B2 vdd vdd vss vss gf180mcu_fd_sc_mcu7t5v0__clkinv_1
X_06550_ _06460_/Z _06505_/Z _06550_/B _06552_/A2 vdd vdd vss vss
+ gf180mcu_fd_sc_mcu7t5v0__aoi21_1
X_06481_ _06439_/B _06601_/A2 _06482_/A2 vdd vdd vss vss gf180mcu_fd_sc_mcu7t5v0__nand2_1
X_05501_ _05501_/A1 _05501_/A2 _05515_/A2 vdd vdd vss vss gf180mcu_fd_sc_mcu7t5v0__nand2_1
X_08220_ _09685_/Q _08565_/C _08220_/B _08221_/A2 vdd vdd vss vss
+ gf180mcu_fd_sc_mcu7t5v0__aoi21_1
X_05432_ _09527_/Q _05627_/A2 _05627_/B1 _09535_/Q _05434_/A1 vdd vdd
+ vss vss gf180mcu_fd_sc_mcu7t5v0__aoi22_1
X_08151_ _09684_/Q _08149_/Z _08171_/B vdd vdd vss vss gf180mcu_fd_sc_mcu7t5v0__nand2_1
X_05363_ _09403_/A1 _05369_/A2 _05369_/B1 _05363_/B2 _09515_/D vdd vdd
+ vss vss gf180mcu_fd_sc_mcu7t5v0__oai22_1
X_08082_ _08430_/B _08129_/A2 _08082_/B _08084_/A2 vdd vdd vss vss
+ gf180mcu_fd_sc_mcu7t5v0__aoi21_1
X_05294_ _09407_/A1 _05296_/A2 _05296_/B1 _05294_/B2 _09447_/D vdd vdd
+ vss vss gf180mcu_fd_sc_mcu7t5v0__oai22_1
X_07102_ _07103_/A1 _07103_/A2 _07145_/A1 vdd vdd vss vss gf180mcu_fd_sc_mcu7t5v0__nor2_1
X_07033_ _09573_/Q _09649_/Q _09683_/Q _09615_/Q _09638_/Q _09637_/Q _07033_/Z vdd
+ vdd vss vss gf180mcu_fd_sc_mcu7t5v0__mux4_4
X_08984_ _09402_/A1 _08991_/A2 _08991_/B1 _08984_/B2 _09835_/D vdd vdd
+ vss vss gf180mcu_fd_sc_mcu7t5v0__oai22_1
X_07935_ _09714_/Q _07749_/Z _07990_/B2 vdd vdd vss vss gf180mcu_fd_sc_mcu7t5v0__nand2_1
X_09605_ _09605_/D clk _09605_/Q vdd vdd vss vss gf180mcu_fd_sc_mcu7t5v0__dffq_1
X_07866_ _08670_/B _07866_/A2 _09672_/D vdd vdd vss vss gf180mcu_fd_sc_mcu7t5v0__nor2_1
X_07797_ _07820_/A1 _07795_/Z _07869_/B3 vdd vdd vss vss gf180mcu_fd_sc_mcu7t5v0__xnor2_1
X_06817_ _06817_/A1 _06817_/A2 _06817_/B _06867_/A2 vdd vdd vss vss
+ gf180mcu_fd_sc_mcu7t5v0__aoi21_1
X_09536_ _09536_/D clk _09536_/Q vdd vdd vss vss gf180mcu_fd_sc_mcu7t5v0__dffq_1
X_06748_ _06786_/A2 _06790_/A1 _06803_/A1 vdd vdd vss vss gf180mcu_fd_sc_mcu7t5v0__nor2_1
X_09467_ _09467_/D clk _09467_/Q vdd vdd vss vss gf180mcu_fd_sc_mcu7t5v0__dffq_4
X_08418_ _08418_/A1 _08418_/A2 _08706_/B _08418_/C _08419_/C vdd vdd vss
+ vss gf180mcu_fd_sc_mcu7t5v0__oai211_1
X_06679_ _06679_/A1 _08565_/C _06679_/B1 _06679_/B2 _08670_/B _09613_/D vdd
+ vdd vss vss gf180mcu_fd_sc_mcu7t5v0__aoi221_1
X_09398_ _10018_/Q _09399_/A2 _09399_/B vdd vdd vss vss gf180mcu_fd_sc_mcu7t5v0__nor2_1
X_08349_ _09688_/Q _08349_/A2 _08348_/Z _08349_/Z vdd vdd vss vss
+ gf180mcu_fd_sc_mcu7t5v0__xor3_1
XTAP_1140 vdd vss gf180mcu_fd_sc_mcu7t5v0__filltie
XTAP_1162 vdd vss gf180mcu_fd_sc_mcu7t5v0__filltie
XTAP_1151 vdd vss gf180mcu_fd_sc_mcu7t5v0__filltie
XTAP_1173 vdd vss gf180mcu_fd_sc_mcu7t5v0__filltie
XTAP_1184 vdd vss gf180mcu_fd_sc_mcu7t5v0__filltie
XTAP_1195 vdd vss gf180mcu_fd_sc_mcu7t5v0__filltie
Xrepeater6 _09278_/C _09072_/B vdd vdd vss vss gf180mcu_fd_sc_mcu7t5v0__buf_8
XTAP_902 vdd vss gf180mcu_fd_sc_mcu7t5v0__filltie
XTAP_913 vdd vss gf180mcu_fd_sc_mcu7t5v0__filltie
XTAP_935 vdd vss gf180mcu_fd_sc_mcu7t5v0__filltie
XTAP_924 vdd vss gf180mcu_fd_sc_mcu7t5v0__filltie
XTAP_946 vdd vss gf180mcu_fd_sc_mcu7t5v0__filltie
XTAP_957 vdd vss gf180mcu_fd_sc_mcu7t5v0__filltie
XTAP_968 vdd vss gf180mcu_fd_sc_mcu7t5v0__filltie
X_05981_ _06309_/A1 _05997_/A2 _06207_/A1 vdd vdd vss vss gf180mcu_fd_sc_mcu7t5v0__nor2_1
X_07720_ _07721_/A1 _07719_/Z _07720_/Z vdd vdd vss vss gf180mcu_fd_sc_mcu7t5v0__and2_1
XTAP_979 vdd vss gf180mcu_fd_sc_mcu7t5v0__filltie
X_04932_ _09508_/Q _05354_/B2 vdd vdd vss vss gf180mcu_fd_sc_mcu7t5v0__clkinv_1
X_04863_ _09474_/Q _05310_/B2 vdd vdd vss vss gf180mcu_fd_sc_mcu7t5v0__clkinv_1
X_07651_ _09717_/Q _07651_/A2 _07651_/B _07652_/A2 vdd vdd vss vss
+ gf180mcu_fd_sc_mcu7t5v0__aoi21_1
X_06602_ _06602_/A1 _06602_/A2 _06602_/Z vdd vdd vss vss gf180mcu_fd_sc_mcu7t5v0__xor2_1
X_07582_ _07582_/A1 _07582_/A2 _07644_/A2 vdd vdd vss vss gf180mcu_fd_sc_mcu7t5v0__nand2_2
X_06533_ _06534_/A1 _06534_/A2 _06533_/B _06581_/B vdd vdd vss vss
+ gf180mcu_fd_sc_mcu7t5v0__aoi21_1
X_09321_ _09983_/Q _09322_/A2 _09322_/B vdd vdd vss vss gf180mcu_fd_sc_mcu7t5v0__nor2_1
X_04794_ _09651_/Q _07494_/B vdd vdd vss vss gf180mcu_fd_sc_mcu7t5v0__clkinv_3
X_06464_ _06464_/A1 _06464_/A2 _06464_/B _06470_/A1 vdd vdd vss vss
+ gf180mcu_fd_sc_mcu7t5v0__oai21_1
X_09252_ _09467_/Q _09252_/A2 _09252_/B _09954_/D vdd vdd vss vss
+ gf180mcu_fd_sc_mcu7t5v0__aoi21_1
X_06395_ _06372_/Z _06373_/Z _06396_/A2 _06474_/A1 vdd vdd vss vss
+ gf180mcu_fd_sc_mcu7t5v0__nand3_2
X_08203_ _08202_/B _08203_/A2 _08203_/A3 _08222_/B vdd vdd vss vss
+ gf180mcu_fd_sc_mcu7t5v0__nor3_1
X_05415_ _09794_/Q _05628_/A2 _05628_/B1 _09900_/Q _05416_/A2 vdd vdd
+ vss vss gf180mcu_fd_sc_mcu7t5v0__aoi22_1
X_09183_ _09183_/I _09184_/B1 vdd vdd vss vss gf180mcu_fd_sc_mcu7t5v0__clkinv_1
X_05346_ _09406_/A1 _05349_/A2 _05349_/B1 _05346_/B2 _09502_/D vdd vdd
+ vss vss gf180mcu_fd_sc_mcu7t5v0__oai22_1
X_08134_ _09671_/Q _08132_/Z _08139_/A1 vdd vdd vss vss gf180mcu_fd_sc_mcu7t5v0__nand2_1
X_08065_ _08088_/A2 _08088_/A3 _08154_/B _08067_/A3 vdd vdd vss vss
+ gf180mcu_fd_sc_mcu7t5v0__nand3_1
X_05277_ _05631_/B2 _09022_/A1 _05286_/A2 vdd vdd vss vss gf180mcu_fd_sc_mcu7t5v0__nand2_4
X_07016_ _06993_/B _07011_/Z _07016_/B _07021_/C1 vdd vdd vss vss
+ gf180mcu_fd_sc_mcu7t5v0__aoi21_2
X_08967_ _09825_/Q _08964_/Z _08970_/A2 vdd vdd vss vss gf180mcu_fd_sc_mcu7t5v0__nand2_1
X_07918_ _08011_/A1 _07918_/A2 _07918_/B _07919_/B vdd vdd vss vss
+ gf180mcu_fd_sc_mcu7t5v0__oai21_1
X_08898_ _08899_/A2 _08898_/A2 _09399_/C _08899_/B vdd vdd vss vss
+ gf180mcu_fd_sc_mcu7t5v0__aoi21_1
X_07849_ _09672_/Q _07868_/A1 _07846_/Z _07849_/Z vdd vdd vss vss
+ gf180mcu_fd_sc_mcu7t5v0__xor3_1
X_09519_ _09519_/D clk _09519_/Q vdd vdd vss vss gf180mcu_fd_sc_mcu7t5v0__dffq_1
XPHY_201 vdd vss gf180mcu_fd_sc_mcu7t5v0__endcap
XPHY_234 vdd vss gf180mcu_fd_sc_mcu7t5v0__endcap
XPHY_223 vdd vss gf180mcu_fd_sc_mcu7t5v0__endcap
XPHY_212 vdd vss gf180mcu_fd_sc_mcu7t5v0__endcap
XPHY_267 vdd vss gf180mcu_fd_sc_mcu7t5v0__endcap
XPHY_256 vdd vss gf180mcu_fd_sc_mcu7t5v0__endcap
XPHY_245 vdd vss gf180mcu_fd_sc_mcu7t5v0__endcap
X_05200_ _05200_/A1 _05200_/A2 _05200_/A3 _09465_/D vdd vdd vss vss
+ gf180mcu_fd_sc_mcu7t5v0__nor3_1
X_06180_ _06238_/A1 _06238_/A2 _06239_/A1 vdd vdd vss vss gf180mcu_fd_sc_mcu7t5v0__nor2_1
X_05131_ _09909_/Q _09121_/A1 _05131_/Z vdd vdd vss vss gf180mcu_fd_sc_mcu7t5v0__and2_1
X_05062_ _09496_/Q _05338_/B2 vdd vdd vss vss gf180mcu_fd_sc_mcu7t5v0__clkinv_1
XTAP_710 vdd vss gf180mcu_fd_sc_mcu7t5v0__filltie
X_09870_ _09870_/D clk _09870_/Q vdd vdd vss vss gf180mcu_fd_sc_mcu7t5v0__dffq_1
XTAP_743 vdd vss gf180mcu_fd_sc_mcu7t5v0__filltie
XTAP_721 vdd vss gf180mcu_fd_sc_mcu7t5v0__filltie
XTAP_732 vdd vss gf180mcu_fd_sc_mcu7t5v0__filltie
X_08821_ _09769_/Q _08818_/Z _08825_/A1 vdd vdd vss vss gf180mcu_fd_sc_mcu7t5v0__nor2_1
XTAP_776 vdd vss gf180mcu_fd_sc_mcu7t5v0__filltie
XTAP_765 vdd vss gf180mcu_fd_sc_mcu7t5v0__filltie
XTAP_754 vdd vss gf180mcu_fd_sc_mcu7t5v0__filltie
XTAP_787 vdd vss gf180mcu_fd_sc_mcu7t5v0__filltie
XTAP_798 vdd vss gf180mcu_fd_sc_mcu7t5v0__filltie
X_08752_ _09406_/A1 _08755_/A2 _08755_/B1 _08752_/B2 _09739_/D vdd vdd
+ vss vss gf180mcu_fd_sc_mcu7t5v0__oai22_1
X_05964_ _09566_/Q _05964_/A2 _05964_/A3 _05964_/B1 _05964_/B2 _05965_/C vdd
+ vdd vss vss gf180mcu_fd_sc_mcu7t5v0__oai32_1
X_04915_ _10021_/Q _09404_/B2 vdd vdd vss vss gf180mcu_fd_sc_mcu7t5v0__clkinv_1
X_07703_ _09668_/Q _07698_/B _07813_/B _07704_/B vdd vdd vss vss gf180mcu_fd_sc_mcu7t5v0__oai21_1
X_08683_ _09710_/Q _08699_/A3 _08684_/A2 vdd vdd vss vss gf180mcu_fd_sc_mcu7t5v0__nand2_1
X_05895_ _08291_/B _05894_/I _05897_/A2 vdd vdd vss vss gf180mcu_fd_sc_mcu7t5v0__nor2_1
X_07634_ _09712_/Q _07634_/A2 _07634_/A3 _07634_/B _07637_/A2 vdd vdd
+ vss vss gf180mcu_fd_sc_mcu7t5v0__oai31_1
XTAP_1909 vdd vss gf180mcu_fd_sc_mcu7t5v0__filltie
X_04846_ _09522_/Q _08901_/A2 vdd vdd vss vss gf180mcu_fd_sc_mcu7t5v0__clkinv_1
X_04777_ _09682_/Q _08087_/A1 vdd vdd vss vss gf180mcu_fd_sc_mcu7t5v0__inv_1
X_07565_ _07596_/A1 _07542_/Z _07598_/A2 vdd vdd vss vss gf180mcu_fd_sc_mcu7t5v0__nor2_2
X_06516_ _06517_/A1 _06517_/A2 _06553_/B vdd vdd vss vss gf180mcu_fd_sc_mcu7t5v0__and2_1
X_09304_ _09393_/A1 _09310_/A2 _09304_/B _09399_/C _09975_/D vdd vdd vss
+ vss gf180mcu_fd_sc_mcu7t5v0__aoi211_1
X_07496_ _09651_/Q _07514_/A1 _07493_/Z _07496_/Z vdd vdd vss vss
+ gf180mcu_fd_sc_mcu7t5v0__xor3_1
X_06447_ _09713_/Q _06601_/A2 _06447_/Z vdd vdd vss vss gf180mcu_fd_sc_mcu7t5v0__and2_1
X_09235_ _09946_/Q _09244_/A2 _09259_/B _09236_/B vdd vdd vss vss
+ gf180mcu_fd_sc_mcu7t5v0__oai21_1
X_06378_ _06366_/Z _06378_/A2 _06378_/B1 _06378_/B2 _06378_/C _06382_/B vdd
+ vdd vss vss gf180mcu_fd_sc_mcu7t5v0__oai221_1
X_09166_ _09949_/Q _09137_/Z _09170_/B1 _09923_/Q _09166_/C _09167_/A2 vdd vdd
+ vss vss gf180mcu_fd_sc_mcu7t5v0__aoi221_1
X_05329_ _09409_/A1 _05329_/A2 _05329_/B1 _05329_/B2 _09489_/D vdd vdd
+ vss vss gf180mcu_fd_sc_mcu7t5v0__oai22_1
X_08117_ _08319_/B2 _08229_/A1 _08359_/B _08119_/B1 vdd vdd vss vss
+ gf180mcu_fd_sc_mcu7t5v0__aoi21_1
X_09097_ _09895_/Q _09098_/A1 _09278_/C _09098_/B vdd vdd vss vss
+ gf180mcu_fd_sc_mcu7t5v0__oai21_1
X_08048_ _09691_/Q _09690_/Q _08367_/A1 _08107_/B vdd vdd vss vss
+ gf180mcu_fd_sc_mcu7t5v0__nand3_4
X_10010_ _10010_/D clk _10010_/Q vdd vdd vss vss gf180mcu_fd_sc_mcu7t5v0__dffq_1
X_09999_ _09999_/D clk _09999_/Q vdd vdd vss vss gf180mcu_fd_sc_mcu7t5v0__dffq_1
X_05680_ _09559_/Q _05698_/B1 _05704_/B vdd vdd vss vss gf180mcu_fd_sc_mcu7t5v0__nand2_1
X_07350_ _07364_/A2 _07364_/A3 _07417_/A2 vdd vdd vss vss gf180mcu_fd_sc_mcu7t5v0__nand2_2
X_06301_ _06072_/C _06301_/A2 _06301_/B _08565_/C _06303_/A1 vdd vdd vss
+ vss gf180mcu_fd_sc_mcu7t5v0__aoi211_1
X_09020_ _09408_/A1 _09021_/A2 _09021_/B1 _09020_/B2 _09865_/D vdd vdd
+ vss vss gf180mcu_fd_sc_mcu7t5v0__oai22_1
X_07281_ _09717_/Q _07283_/A2 _07286_/S vdd vdd vss vss gf180mcu_fd_sc_mcu7t5v0__nand2_1
X_06232_ _08291_/B _06293_/B1 _06235_/B vdd vdd vss vss gf180mcu_fd_sc_mcu7t5v0__nor2_1
X_06163_ _06163_/A1 _06163_/A2 _06163_/B _06213_/A1 vdd vdd vss vss
+ gf180mcu_fd_sc_mcu7t5v0__oai21_1
X_05114_ _05114_/A1 _09916_/Q _09299_/A3 _09209_/B2 _08903_/A1 vdd vdd
+ vss vss gf180mcu_fd_sc_mcu7t5v0__nand4_4
X_06094_ _06052_/Z _06120_/B _06097_/A3 vdd vdd vss vss gf180mcu_fd_sc_mcu7t5v0__xnor2_1
X_05045_ _09833_/Q _08980_/B2 vdd vdd vss vss gf180mcu_fd_sc_mcu7t5v0__clkinv_1
X_09922_ _09922_/D clk _09922_/Q vdd vdd vss vss gf180mcu_fd_sc_mcu7t5v0__dffq_1
X_09853_ _09853_/D clk _09853_/Q vdd vdd vss vss gf180mcu_fd_sc_mcu7t5v0__dffq_1
XTAP_551 vdd vss gf180mcu_fd_sc_mcu7t5v0__filltie
XTAP_540 vdd vss gf180mcu_fd_sc_mcu7t5v0__filltie
XTAP_573 vdd vss gf180mcu_fd_sc_mcu7t5v0__filltie
XTAP_584 vdd vss gf180mcu_fd_sc_mcu7t5v0__filltie
XTAP_562 vdd vss gf180mcu_fd_sc_mcu7t5v0__filltie
X_08804_ _09763_/Q _09762_/Q _08805_/A3 vdd vdd vss vss gf180mcu_fd_sc_mcu7t5v0__nor2_1
X_09784_ _09784_/D clk _09784_/Q vdd vdd vss vss gf180mcu_fd_sc_mcu7t5v0__dffq_1
XTAP_595 vdd vss gf180mcu_fd_sc_mcu7t5v0__filltie
X_08735_ _08735_/A1 _09073_/A2 _08735_/B _09722_/D vdd vdd vss vss
+ gf180mcu_fd_sc_mcu7t5v0__aoi21_1
X_06996_ _09710_/Q _07003_/B _06996_/B _07289_/B _06998_/B1 vdd vdd vss
+ vss gf180mcu_fd_sc_mcu7t5v0__oai211_1
X_05947_ _05947_/A1 _05947_/A2 _05947_/A3 _05947_/Z vdd vdd vss vss
+ gf180mcu_fd_sc_mcu7t5v0__xor3_1
XTAP_1706 vdd vss gf180mcu_fd_sc_mcu7t5v0__filltie
X_08666_ _09716_/Q _08703_/A1 _08666_/B1 _08510_/B _08668_/A3 vdd vdd
+ vss vss gf180mcu_fd_sc_mcu7t5v0__oai22_1
X_05878_ _05878_/A1 _05878_/A2 _08670_/B _09563_/D vdd vdd vss vss
+ gf180mcu_fd_sc_mcu7t5v0__aoi21_1
XTAP_1739 vdd vss gf180mcu_fd_sc_mcu7t5v0__filltie
XTAP_1717 vdd vss gf180mcu_fd_sc_mcu7t5v0__filltie
XTAP_1728 vdd vss gf180mcu_fd_sc_mcu7t5v0__filltie
X_04829_ _09581_/Q _06309_/A1 vdd vdd vss vss gf180mcu_fd_sc_mcu7t5v0__inv_3
X_08597_ _08545_/Z _08597_/A2 _08596_/B _08597_/Z vdd vdd vss vss
+ gf180mcu_fd_sc_mcu7t5v0__and3_1
X_07617_ _09653_/Q _07617_/A2 _07617_/B _07641_/A2 vdd vdd vss vss
+ gf180mcu_fd_sc_mcu7t5v0__aoi21_1
X_07548_ _07548_/A1 _07548_/A2 _07548_/B _07602_/B vdd vdd vss vss
+ gf180mcu_fd_sc_mcu7t5v0__aoi21_1
X_07479_ _07480_/A1 _07529_/A1 _07481_/A3 vdd vdd vss vss gf180mcu_fd_sc_mcu7t5v0__nor2_1
X_09218_ _09938_/Q _09176_/B _09278_/C _09219_/B vdd vdd vss vss gf180mcu_fd_sc_mcu7t5v0__oai21_1
X_09149_ _09137_/Z _09149_/A2 _09150_/C vdd vdd vss vss gf180mcu_fd_sc_mcu7t5v0__nor2_1
X_06850_ _06838_/Z _06848_/Z _06850_/Z vdd vdd vss vss gf180mcu_fd_sc_mcu7t5v0__xor2_1
X_05801_ _05741_/Z _05803_/A3 _05801_/Z vdd vdd vss vss gf180mcu_fd_sc_mcu7t5v0__xor2_1
X_06781_ _06669_/I _06764_/Z _06781_/B _06781_/C _06782_/B vdd vdd vss
+ vss gf180mcu_fd_sc_mcu7t5v0__aoi211_1
X_08520_ _08565_/C _08520_/A2 _08708_/B _08521_/B vdd vdd vss vss
+ gf180mcu_fd_sc_mcu7t5v0__oai21_1
X_05732_ _09712_/Q _05965_/A2 _05733_/B vdd vdd vss vss gf180mcu_fd_sc_mcu7t5v0__nand2_1
X_08451_ _09722_/Q _09721_/Q _09683_/Q _08452_/B vdd vdd vss vss gf180mcu_fd_sc_mcu7t5v0__nand3_2
X_05663_ _09897_/Q _09104_/A1 _08706_/B vdd vdd vss vss gf180mcu_fd_sc_mcu7t5v0__nor2_4
X_07402_ _07355_/Z _07357_/Z _07401_/B _07402_/Z vdd vdd vss vss gf180mcu_fd_sc_mcu7t5v0__or3_1
X_05594_ _05594_/A1 _05594_/A2 _05603_/C1 vdd vdd vss vss gf180mcu_fd_sc_mcu7t5v0__nand2_1
X_08382_ _09406_/A1 _08385_/A2 _08385_/B1 _08382_/B2 _09698_/D vdd vdd
+ vss vss gf180mcu_fd_sc_mcu7t5v0__oai22_1
X_07333_ _07662_/A1 _07611_/A1 _07651_/A2 vdd vdd vss vss gf180mcu_fd_sc_mcu7t5v0__nor2_2
X_07264_ _07264_/A1 _07258_/Z _07264_/A3 _07274_/A1 vdd vdd vss vss
+ gf180mcu_fd_sc_mcu7t5v0__xnor3_1
X_06215_ _09716_/Q _05987_/I _06268_/A1 vdd vdd vss vss gf180mcu_fd_sc_mcu7t5v0__nand2_1
X_09003_ _09013_/A1 _09011_/A2 _09011_/B1 vdd vdd vss vss gf180mcu_fd_sc_mcu7t5v0__nand2_2
X_07195_ _07195_/A1 _07195_/A2 _07195_/B _07253_/A1 vdd vdd vss vss
+ gf180mcu_fd_sc_mcu7t5v0__oai21_1
X_06146_ _06085_/Z _06146_/A2 _06146_/B _06195_/A1 vdd vdd vss vss
+ gf180mcu_fd_sc_mcu7t5v0__oai21_1
X_06077_ _09574_/Q _08565_/C _06117_/A1 vdd vdd vss vss gf180mcu_fd_sc_mcu7t5v0__nand2_1
X_05028_ _09511_/Q _05357_/B2 vdd vdd vss vss gf180mcu_fd_sc_mcu7t5v0__clkinv_1
X_09905_ _09905_/D clk _09905_/Q vdd vdd vss vss gf180mcu_fd_sc_mcu7t5v0__dffq_1
X_09836_ _09836_/D clk _09836_/Q vdd vdd vss vss gf180mcu_fd_sc_mcu7t5v0__dffq_1
XTAP_370 vdd vss gf180mcu_fd_sc_mcu7t5v0__filltie
XTAP_381 vdd vss gf180mcu_fd_sc_mcu7t5v0__filltie
XTAP_392 vdd vss gf180mcu_fd_sc_mcu7t5v0__filltie
X_06979_ _09710_/Q _07003_/B _06993_/B vdd vdd vss vss gf180mcu_fd_sc_mcu7t5v0__and2_2
X_09767_ _09767_/D clk _09767_/Q vdd vdd vss vss gf180mcu_fd_sc_mcu7t5v0__dffq_2
X_09698_ _09698_/D clk _09698_/Q vdd vdd vss vss gf180mcu_fd_sc_mcu7t5v0__dffq_1
X_08718_ _09879_/Q _09073_/A2 _08734_/B _08719_/B vdd vdd vss vss
+ gf180mcu_fd_sc_mcu7t5v0__oai21_1
XPHY_10 vdd vss gf180mcu_fd_sc_mcu7t5v0__endcap
XPHY_21 vdd vss gf180mcu_fd_sc_mcu7t5v0__endcap
X_08649_ _08649_/A1 _08648_/B _08672_/A2 vdd vdd vss vss gf180mcu_fd_sc_mcu7t5v0__xnor2_1
XTAP_1503 vdd vss gf180mcu_fd_sc_mcu7t5v0__filltie
XTAP_1514 vdd vss gf180mcu_fd_sc_mcu7t5v0__filltie
XPHY_65 vdd vss gf180mcu_fd_sc_mcu7t5v0__endcap
XPHY_54 vdd vss gf180mcu_fd_sc_mcu7t5v0__endcap
XPHY_43 vdd vss gf180mcu_fd_sc_mcu7t5v0__endcap
XPHY_32 vdd vss gf180mcu_fd_sc_mcu7t5v0__endcap
XTAP_1525 vdd vss gf180mcu_fd_sc_mcu7t5v0__filltie
XTAP_1536 vdd vss gf180mcu_fd_sc_mcu7t5v0__filltie
XTAP_1547 vdd vss gf180mcu_fd_sc_mcu7t5v0__filltie
XPHY_76 vdd vss gf180mcu_fd_sc_mcu7t5v0__endcap
XPHY_87 vdd vss gf180mcu_fd_sc_mcu7t5v0__endcap
XPHY_98 vdd vss gf180mcu_fd_sc_mcu7t5v0__endcap
XTAP_1558 vdd vss gf180mcu_fd_sc_mcu7t5v0__filltie
XTAP_1569 vdd vss gf180mcu_fd_sc_mcu7t5v0__filltie
X_06000_ _06309_/A1 _09580_/Q _06305_/A1 _06290_/A1 vdd vdd vss vss
+ gf180mcu_fd_sc_mcu7t5v0__nor3_4
X_07951_ _07895_/Z _07953_/A3 _07978_/B vdd vdd vss vss gf180mcu_fd_sc_mcu7t5v0__nand2_1
X_06902_ _06902_/A1 _06927_/A1 _06901_/B _06902_/Z vdd vdd vss vss
+ gf180mcu_fd_sc_mcu7t5v0__xor3_1
X_07882_ _09712_/Q _07882_/A2 _07882_/A3 _07938_/A2 vdd vdd vss vss
+ gf180mcu_fd_sc_mcu7t5v0__nand3_1
X_06833_ _07506_/B _06941_/A2 _06838_/A2 vdd vdd vss vss gf180mcu_fd_sc_mcu7t5v0__nor2_1
X_09621_ _09621_/D clk _09621_/Q vdd vdd vss vss gf180mcu_fd_sc_mcu7t5v0__dffq_2
X_09552_ _09552_/D clk _09552_/Q vdd vdd vss vss gf180mcu_fd_sc_mcu7t5v0__dffq_2
X_06764_ _06830_/A1 _06762_/Z _06764_/Z vdd vdd vss vss gf180mcu_fd_sc_mcu7t5v0__xor2_1
X_05715_ _05716_/A1 _05714_/Z _05804_/A1 vdd vdd vss vss gf180mcu_fd_sc_mcu7t5v0__nand2_1
X_08503_ _08501_/Z _08522_/A2 _08504_/A2 vdd vdd vss vss gf180mcu_fd_sc_mcu7t5v0__nand2_1
X_09483_ _09483_/D clk _09483_/Q vdd vdd vss vss gf180mcu_fd_sc_mcu7t5v0__dffq_1
X_06695_ _06747_/A1 _06747_/A2 _09711_/Q _06747_/C _06696_/S vdd vdd vss
+ vss gf180mcu_fd_sc_mcu7t5v0__oai211_4
X_08434_ _09711_/Q _08688_/A2 _08442_/A1 vdd vdd vss vss gf180mcu_fd_sc_mcu7t5v0__nor2_1
X_05646_ _08291_/B _05645_/I _05666_/A2 vdd vdd vss vss gf180mcu_fd_sc_mcu7t5v0__nor2_2
X_05577_ _09416_/Q _05627_/A2 _05627_/B1 _09849_/Q _05579_/A1 vdd vdd
+ vss vss gf180mcu_fd_sc_mcu7t5v0__aoi22_1
X_08365_ _08365_/A1 _08365_/A2 _09688_/D vdd vdd vss vss gf180mcu_fd_sc_mcu7t5v0__nor2_1
X_07316_ _07664_/A1 _07316_/A2 _07316_/B1 _09659_/Q _07377_/A3 vdd vdd
+ vss vss gf180mcu_fd_sc_mcu7t5v0__oai22_4
X_08296_ _08296_/A1 _08294_/Z _08298_/A2 vdd vdd vss vss gf180mcu_fd_sc_mcu7t5v0__xnor2_1
X_07247_ _07247_/A1 _07247_/A2 _07247_/B _07248_/A2 vdd vdd vss vss
+ gf180mcu_fd_sc_mcu7t5v0__oai21_1
X_07178_ _07065_/Z _07126_/B _07106_/Z _07178_/B _07179_/I vdd vdd vss
+ vss gf180mcu_fd_sc_mcu7t5v0__oai31_1
X_06129_ _06129_/A1 _06175_/A1 _06167_/B vdd vdd vss vss gf180mcu_fd_sc_mcu7t5v0__nor2_1
X_09819_ _09819_/D clk _09819_/Q vdd vdd vss vss gf180mcu_fd_sc_mcu7t5v0__dffq_1
XTAP_2001 vdd vss gf180mcu_fd_sc_mcu7t5v0__filltie
XTAP_2034 vdd vss gf180mcu_fd_sc_mcu7t5v0__filltie
XTAP_2023 vdd vss gf180mcu_fd_sc_mcu7t5v0__filltie
XTAP_2012 vdd vss gf180mcu_fd_sc_mcu7t5v0__filltie
XTAP_1300 vdd vss gf180mcu_fd_sc_mcu7t5v0__filltie
XTAP_1311 vdd vss gf180mcu_fd_sc_mcu7t5v0__filltie
XTAP_1322 vdd vss gf180mcu_fd_sc_mcu7t5v0__filltie
XTAP_1333 vdd vss gf180mcu_fd_sc_mcu7t5v0__filltie
XTAP_1344 vdd vss gf180mcu_fd_sc_mcu7t5v0__filltie
XTAP_1366 vdd vss gf180mcu_fd_sc_mcu7t5v0__filltie
XTAP_1355 vdd vss gf180mcu_fd_sc_mcu7t5v0__filltie
XTAP_1377 vdd vss gf180mcu_fd_sc_mcu7t5v0__filltie
XTAP_1388 vdd vss gf180mcu_fd_sc_mcu7t5v0__filltie
XTAP_1399 vdd vss gf180mcu_fd_sc_mcu7t5v0__filltie
X_06480_ _06580_/A1 _06480_/A2 _06494_/B vdd vdd vss vss gf180mcu_fd_sc_mcu7t5v0__nand2_1
X_05500_ _09421_/Q _05628_/A2 _05628_/B1 _09608_/Q _05501_/A2 vdd vdd
+ vss vss gf180mcu_fd_sc_mcu7t5v0__aoi22_1
X_05431_ _08791_/B _05431_/A2 _09550_/D vdd vdd vss vss gf180mcu_fd_sc_mcu7t5v0__and2_1
X_08150_ _09684_/Q _08149_/Z _08171_/A2 vdd vdd vss vss gf180mcu_fd_sc_mcu7t5v0__nor2_1
X_05362_ _09402_/A1 _05369_/A2 _05369_/B1 _05362_/B2 _09514_/D vdd vdd
+ vss vss gf180mcu_fd_sc_mcu7t5v0__oai22_1
X_07101_ _09714_/Q _07003_/B _07113_/A1 vdd vdd vss vss gf180mcu_fd_sc_mcu7t5v0__nand2_1
X_08081_ _08081_/A1 _08079_/Z _08086_/A1 vdd vdd vss vss gf180mcu_fd_sc_mcu7t5v0__nand2_1
X_05293_ _09406_/A1 _05296_/A2 _05296_/B1 _05293_/B2 _09446_/D vdd vdd
+ vss vss gf180mcu_fd_sc_mcu7t5v0__oai22_1
X_07032_ _07032_/A1 _07062_/A1 _07032_/Z vdd vdd vss vss gf180mcu_fd_sc_mcu7t5v0__and2_1
X_08983_ _09401_/A1 _08991_/A2 _08991_/B1 vdd vdd vss vss gf180mcu_fd_sc_mcu7t5v0__nand2_2
X_07934_ _09714_/Q _07745_/Z _07934_/A3 _07934_/Z vdd vdd vss vss
+ gf180mcu_fd_sc_mcu7t5v0__and3_1
X_07865_ _09672_/Q _08565_/C _07863_/Z _07865_/B2 _07866_/A2 vdd vdd vss
+ vss gf180mcu_fd_sc_mcu7t5v0__aoi22_1
X_09604_ _09604_/D clk _09604_/Q vdd vdd vss vss gf180mcu_fd_sc_mcu7t5v0__dffq_4
X_07796_ _07820_/A1 _07795_/Z _07796_/Z vdd vdd vss vss gf180mcu_fd_sc_mcu7t5v0__xor2_1
X_06816_ _06817_/A1 _06817_/A2 _06817_/B _06816_/Z vdd vdd vss vss
+ gf180mcu_fd_sc_mcu7t5v0__and3_1
X_09535_ _09535_/D clk _09535_/Q vdd vdd vss vss gf180mcu_fd_sc_mcu7t5v0__dffq_1
X_06747_ _06747_/A1 _06747_/A2 _09713_/Q _06747_/C _06790_/A1 vdd vdd
+ vss vss gf180mcu_fd_sc_mcu7t5v0__oai211_4
X_06678_ _06781_/C _06661_/Z _08565_/C _06679_/B2 vdd vdd vss vss
+ gf180mcu_fd_sc_mcu7t5v0__aoi21_1
X_09466_ _09466_/D clk _09466_/Q vdd vdd vss vss gf180mcu_fd_sc_mcu7t5v0__dffq_1
X_05629_ _05629_/A1 _05629_/A2 _05632_/C1 vdd vdd vss vss gf180mcu_fd_sc_mcu7t5v0__nand2_1
X_08417_ _08667_/C _08446_/A1 _08418_/A2 vdd vdd vss vss gf180mcu_fd_sc_mcu7t5v0__nand2_1
X_09397_ _09397_/A1 _09399_/A2 _09397_/B _09399_/C _10017_/D vdd vdd vss
+ vss gf180mcu_fd_sc_mcu7t5v0__aoi211_1
X_08348_ _08348_/A1 _08347_/Z _08348_/Z vdd vdd vss vss gf180mcu_fd_sc_mcu7t5v0__xor2_1
X_08279_ _09715_/Q _08061_/Z _08280_/A2 _08328_/A1 vdd vdd vss vss
+ gf180mcu_fd_sc_mcu7t5v0__nand3_1
XTAP_1130 vdd vss gf180mcu_fd_sc_mcu7t5v0__filltie
XTAP_1141 vdd vss gf180mcu_fd_sc_mcu7t5v0__filltie
XTAP_1152 vdd vss gf180mcu_fd_sc_mcu7t5v0__filltie
XTAP_1163 vdd vss gf180mcu_fd_sc_mcu7t5v0__filltie
XTAP_1174 vdd vss gf180mcu_fd_sc_mcu7t5v0__filltie
XTAP_1185 vdd vss gf180mcu_fd_sc_mcu7t5v0__filltie
XTAP_1196 vdd vss gf180mcu_fd_sc_mcu7t5v0__filltie
Xrepeater7 _09278_/C _09089_/B vdd vdd vss vss gf180mcu_fd_sc_mcu7t5v0__buf_8
XTAP_903 vdd vss gf180mcu_fd_sc_mcu7t5v0__filltie
XTAP_914 vdd vss gf180mcu_fd_sc_mcu7t5v0__filltie
XTAP_925 vdd vss gf180mcu_fd_sc_mcu7t5v0__filltie
X_05980_ _09580_/Q _06305_/A1 _05997_/A2 vdd vdd vss vss gf180mcu_fd_sc_mcu7t5v0__nand2_1
XTAP_936 vdd vss gf180mcu_fd_sc_mcu7t5v0__filltie
XTAP_947 vdd vss gf180mcu_fd_sc_mcu7t5v0__filltie
XTAP_958 vdd vss gf180mcu_fd_sc_mcu7t5v0__filltie
X_04931_ _09500_/Q _05344_/B2 vdd vdd vss vss gf180mcu_fd_sc_mcu7t5v0__clkinv_1
XTAP_969 vdd vss gf180mcu_fd_sc_mcu7t5v0__filltie
X_04862_ _09450_/Q _05299_/B2 vdd vdd vss vss gf180mcu_fd_sc_mcu7t5v0__clkinv_1
X_07650_ _07650_/I0 _07612_/B _07650_/S _07650_/Z vdd vdd vss vss
+ gf180mcu_fd_sc_mcu7t5v0__mux2_1
X_06601_ _09714_/Q _06601_/A2 _06602_/A2 vdd vdd vss vss gf180mcu_fd_sc_mcu7t5v0__nand2_1
X_04793_ _09652_/Q _08578_/A1 vdd vdd vss vss gf180mcu_fd_sc_mcu7t5v0__clkinv_1
X_07581_ _09632_/Q _07420_/Z _07627_/B1 _09598_/Q _07582_/A2 vdd vdd vss
+ vss gf180mcu_fd_sc_mcu7t5v0__aoi22_1
X_06532_ _08721_/A1 _06531_/Z _06533_/B vdd vdd vss vss gf180mcu_fd_sc_mcu7t5v0__xor2_1
X_09320_ _09397_/A1 _09322_/A2 _09320_/B _09399_/C _09982_/D vdd vdd
+ vss vss gf180mcu_fd_sc_mcu7t5v0__aoi211_1
X_09251_ _09467_/Q _09954_/Q _09257_/B _09252_/B vdd vdd vss vss gf180mcu_fd_sc_mcu7t5v0__oai21_1
X_06463_ _06463_/A1 _06460_/Z _06463_/B _06499_/A1 vdd vdd vss vss
+ gf180mcu_fd_sc_mcu7t5v0__aoi21_1
X_08202_ _08203_/A2 _08203_/A3 _08202_/B _08222_/A2 vdd vdd vss vss
+ gf180mcu_fd_sc_mcu7t5v0__oai21_1
X_06394_ _06394_/A1 _06422_/B2 _06394_/A3 _06396_/A2 vdd vdd vss vss
+ gf180mcu_fd_sc_mcu7t5v0__xnor3_1
X_05414_ _09735_/Q _05627_/A2 _05627_/B1 _09867_/Q _05416_/A1 vdd vdd
+ vss vss gf180mcu_fd_sc_mcu7t5v0__aoi22_1
X_09182_ _09787_/Q _09299_/A3 _09378_/A2 _09756_/Q _09183_/I vdd vdd vss
+ vss gf180mcu_fd_sc_mcu7t5v0__aoi22_1
X_05345_ _09405_/A1 _05349_/A2 _05349_/B1 _05345_/B2 _09501_/D vdd vdd
+ vss vss gf180mcu_fd_sc_mcu7t5v0__oai22_1
X_08133_ _09671_/Q _08132_/Z _08133_/Z vdd vdd vss vss gf180mcu_fd_sc_mcu7t5v0__and2_2
X_08064_ _09689_/Q _08064_/A2 _08154_/B vdd vdd vss vss gf180mcu_fd_sc_mcu7t5v0__nand2_2
X_05276_ _05276_/A1 _05216_/I _05276_/A3 _09022_/A1 vdd vdd vss vss
+ gf180mcu_fd_sc_mcu7t5v0__nor3_4
X_07015_ _09711_/Q _07003_/B _07000_/Z _09710_/Q _07016_/B vdd vdd vss
+ vss gf180mcu_fd_sc_mcu7t5v0__aoi22_1
X_08966_ _08964_/Z _08966_/A2 _09824_/D vdd vdd vss vss gf180mcu_fd_sc_mcu7t5v0__nor2_1
X_07917_ _09715_/Q _08012_/A2 _07918_/A2 _07970_/B2 _07970_/C _07918_/B vdd
+ vdd vss vss gf180mcu_fd_sc_mcu7t5v0__aoi221_1
X_08897_ _09924_/Q _08897_/A2 _08898_/A2 vdd vdd vss vss gf180mcu_fd_sc_mcu7t5v0__nand2_1
X_07848_ _07847_/B _07848_/A2 _07848_/A3 _07868_/B vdd vdd vss vss
+ gf180mcu_fd_sc_mcu7t5v0__nor3_1
X_07779_ _09713_/Q _07712_/Z _07780_/I vdd vdd vss vss gf180mcu_fd_sc_mcu7t5v0__nand2_1
X_09518_ _09518_/D clk _09518_/Q vdd vdd vss vss gf180mcu_fd_sc_mcu7t5v0__dffq_1
XPHY_224 vdd vss gf180mcu_fd_sc_mcu7t5v0__endcap
XPHY_213 vdd vss gf180mcu_fd_sc_mcu7t5v0__endcap
XPHY_202 vdd vss gf180mcu_fd_sc_mcu7t5v0__endcap
XPHY_257 vdd vss gf180mcu_fd_sc_mcu7t5v0__endcap
XPHY_246 vdd vss gf180mcu_fd_sc_mcu7t5v0__endcap
XPHY_235 vdd vss gf180mcu_fd_sc_mcu7t5v0__endcap
X_09449_ _09449_/D clk _09449_/Q vdd vdd vss vss gf180mcu_fd_sc_mcu7t5v0__dffq_1
X_05130_ _09399_/C _08901_/A2 _08903_/A1 _05130_/B _09524_/D vdd vdd vss
+ vss gf180mcu_fd_sc_mcu7t5v0__oai31_1
X_05061_ _09488_/Q _05328_/B2 vdd vdd vss vss gf180mcu_fd_sc_mcu7t5v0__clkinv_1
XTAP_700 vdd vss gf180mcu_fd_sc_mcu7t5v0__filltie
XTAP_722 vdd vss gf180mcu_fd_sc_mcu7t5v0__filltie
XTAP_733 vdd vss gf180mcu_fd_sc_mcu7t5v0__filltie
XTAP_711 vdd vss gf180mcu_fd_sc_mcu7t5v0__filltie
X_08820_ _08820_/A1 _08818_/Z _08820_/A3 _09768_/D vdd vdd vss vss
+ gf180mcu_fd_sc_mcu7t5v0__nor3_1
XTAP_777 vdd vss gf180mcu_fd_sc_mcu7t5v0__filltie
XTAP_766 vdd vss gf180mcu_fd_sc_mcu7t5v0__filltie
XTAP_755 vdd vss gf180mcu_fd_sc_mcu7t5v0__filltie
XTAP_744 vdd vss gf180mcu_fd_sc_mcu7t5v0__filltie
XTAP_799 vdd vss gf180mcu_fd_sc_mcu7t5v0__filltie
XTAP_788 vdd vss gf180mcu_fd_sc_mcu7t5v0__filltie
X_08751_ _09405_/A1 _08755_/A2 _08755_/B1 _08751_/B2 _09738_/D vdd vdd
+ vss vss gf180mcu_fd_sc_mcu7t5v0__oai22_1
X_05963_ _05963_/A1 _05964_/A3 _05963_/A3 _05963_/Z vdd vdd vss vss
+ gf180mcu_fd_sc_mcu7t5v0__xor3_1
X_07702_ _07702_/A1 _07702_/A2 _07705_/A2 vdd vdd vss vss gf180mcu_fd_sc_mcu7t5v0__nand2_1
X_04914_ _09736_/Q _08749_/B2 vdd vdd vss vss gf180mcu_fd_sc_mcu7t5v0__clkinv_1
X_08682_ _08682_/A1 _08389_/Z _08682_/B _08699_/A3 vdd vdd vss vss
+ gf180mcu_fd_sc_mcu7t5v0__oai21_2
X_05894_ _05894_/I _05932_/A2 vdd vdd vss vss gf180mcu_fd_sc_mcu7t5v0__clkinv_1
X_07633_ _08291_/B _07634_/A3 _07633_/B _09712_/Q _07634_/B vdd vdd vss
+ vss gf180mcu_fd_sc_mcu7t5v0__oai211_1
X_04845_ _09813_/Q _05120_/A2 vdd vdd vss vss gf180mcu_fd_sc_mcu7t5v0__clkinv_1
X_04776_ _09685_/Q _08202_/B vdd vdd vss vss gf180mcu_fd_sc_mcu7t5v0__inv_1
X_07564_ _07564_/A1 _07564_/A2 _07564_/B _07600_/A1 vdd vdd vss vss
+ gf180mcu_fd_sc_mcu7t5v0__oai21_1
X_06515_ _06515_/A1 _06559_/B2 _06614_/A1 _06517_/A2 vdd vdd vss vss
+ gf180mcu_fd_sc_mcu7t5v0__xnor3_1
X_09303_ _09975_/Q _09310_/A2 _09304_/B vdd vdd vss vss gf180mcu_fd_sc_mcu7t5v0__nor2_1
X_07495_ _07494_/B _07495_/A2 _07495_/A3 _07514_/B vdd vdd vss vss
+ gf180mcu_fd_sc_mcu7t5v0__nor3_1
X_06446_ _06367_/B _06446_/A2 _06453_/A2 vdd vdd vss vss gf180mcu_fd_sc_mcu7t5v0__nand2_1
X_09234_ _09250_/A2 _09244_/A2 _09234_/B _09945_/D vdd vdd vss vss
+ gf180mcu_fd_sc_mcu7t5v0__aoi21_1
X_09165_ _09137_/Z _09165_/A2 _09166_/C vdd vdd vss vss gf180mcu_fd_sc_mcu7t5v0__nor2_1
X_06377_ _09711_/Q _06629_/A2 _06376_/Z _06580_/A1 _06450_/C _06378_/C vdd vdd
+ vss vss gf180mcu_fd_sc_mcu7t5v0__aoi221_1
X_08116_ _09712_/Q _08096_/Z _08229_/A1 vdd vdd vss vss gf180mcu_fd_sc_mcu7t5v0__nand2_2
X_05328_ _09408_/A1 _05329_/A2 _05329_/B1 _05328_/B2 _09488_/D vdd vdd
+ vss vss gf180mcu_fd_sc_mcu7t5v0__oai22_1
X_09096_ _09963_/Q _08706_/B _09096_/B1 _09973_/Q _09096_/C _09098_/A2 vdd vdd
+ vss vss gf180mcu_fd_sc_mcu7t5v0__aoi221_2
X_05259_ _09408_/A1 _05260_/A2 _05260_/B1 _05259_/B2 _09424_/D vdd vdd
+ vss vss gf180mcu_fd_sc_mcu7t5v0__oai22_1
X_08047_ _08371_/A1 _08369_/A1 _09689_/Q _08167_/C vdd vdd vss vss
+ gf180mcu_fd_sc_mcu7t5v0__nor3_4
X_09998_ _09998_/D clk _09998_/Q vdd vdd vss vss gf180mcu_fd_sc_mcu7t5v0__dffq_1
X_08949_ _09819_/Q _08946_/Z _08949_/Z vdd vdd vss vss gf180mcu_fd_sc_mcu7t5v0__and2_1
X_06300_ _06300_/A1 _06300_/A2 _06300_/A3 _06301_/A2 vdd vdd vss vss
+ gf180mcu_fd_sc_mcu7t5v0__nand3_1
X_07280_ _09717_/Q _07283_/A2 _07288_/A1 vdd vdd vss vss gf180mcu_fd_sc_mcu7t5v0__nor2_1
X_06231_ _06226_/Z _06227_/Z _06231_/A3 _06231_/B1 _09889_/Q _06293_/B1 vdd
+ vdd vss vss gf180mcu_fd_sc_mcu7t5v0__oai32_2
X_06162_ _06162_/A1 _06092_/Z _06162_/B _06188_/A1 vdd vdd vss vss
+ gf180mcu_fd_sc_mcu7t5v0__oai21_1
X_06093_ _06093_/A1 _06083_/B _06091_/I _06120_/B vdd vdd vss vss
+ gf180mcu_fd_sc_mcu7t5v0__xor3_1
X_05113_ _09913_/Q _09912_/Q _05108_/Z _05113_/A4 _09209_/B2 vdd vdd vss
+ vss gf180mcu_fd_sc_mcu7t5v0__nor4_4
X_05044_ _09809_/Q _08924_/B2 vdd vdd vss vss gf180mcu_fd_sc_mcu7t5v0__clkinv_1
X_09921_ _09921_/D clk _09921_/Q vdd vdd vss vss gf180mcu_fd_sc_mcu7t5v0__dffq_1
X_09852_ _09852_/D clk _09852_/Q vdd vdd vss vss gf180mcu_fd_sc_mcu7t5v0__dffq_1
XTAP_552 vdd vss gf180mcu_fd_sc_mcu7t5v0__filltie
XTAP_541 vdd vss gf180mcu_fd_sc_mcu7t5v0__filltie
XTAP_530 vdd vss gf180mcu_fd_sc_mcu7t5v0__filltie
XTAP_574 vdd vss gf180mcu_fd_sc_mcu7t5v0__filltie
XTAP_585 vdd vss gf180mcu_fd_sc_mcu7t5v0__filltie
XTAP_563 vdd vss gf180mcu_fd_sc_mcu7t5v0__filltie
X_08803_ _09762_/Q _08820_/A1 _09762_/D vdd vdd vss vss gf180mcu_fd_sc_mcu7t5v0__nor2_1
X_09783_ _09783_/D clk _09783_/Q vdd vdd vss vss gf180mcu_fd_sc_mcu7t5v0__dffq_1
XTAP_596 vdd vss gf180mcu_fd_sc_mcu7t5v0__filltie
X_08734_ _09978_/Q _09073_/A2 _08734_/B _08735_/B vdd vdd vss vss
+ gf180mcu_fd_sc_mcu7t5v0__oai21_1
X_06995_ _06993_/B _06995_/A2 _06995_/B _06995_/C _06996_/B vdd vdd vss
+ vss gf180mcu_fd_sc_mcu7t5v0__oai211_1
X_05946_ _09710_/Q _05945_/Z _05947_/A3 vdd vdd vss vss gf180mcu_fd_sc_mcu7t5v0__nand2_1
X_08665_ _08561_/B _08667_/B1 _08666_/B1 vdd vdd vss vss gf180mcu_fd_sc_mcu7t5v0__nor2_1
X_05877_ _05862_/Z _05877_/A2 _05877_/A3 _05877_/B _05878_/A2 vdd vdd
+ vss vss gf180mcu_fd_sc_mcu7t5v0__oai31_1
XTAP_1718 vdd vss gf180mcu_fd_sc_mcu7t5v0__filltie
XTAP_1729 vdd vss gf180mcu_fd_sc_mcu7t5v0__filltie
XTAP_1707 vdd vss gf180mcu_fd_sc_mcu7t5v0__filltie
X_08596_ _08545_/Z _08597_/A2 _08596_/B _08654_/A2 vdd vdd vss vss
+ gf180mcu_fd_sc_mcu7t5v0__aoi21_1
X_04828_ _09582_/Q _06280_/B vdd vdd vss vss gf180mcu_fd_sc_mcu7t5v0__inv_1
X_07616_ _07616_/A1 _07616_/A2 _08670_/B _09653_/D vdd vdd vss vss
+ gf180mcu_fd_sc_mcu7t5v0__aoi21_1
X_04759_ _09714_/Q _07506_/B vdd vdd vss vss gf180mcu_fd_sc_mcu7t5v0__inv_8
X_07547_ _07653_/A1 _07543_/Z _07559_/A2 vdd vdd vss vss gf180mcu_fd_sc_mcu7t5v0__nand2_1
X_07478_ _07469_/Z _07527_/A2 _07527_/B _09711_/Q _07529_/A1 vdd vdd vss
+ vss gf180mcu_fd_sc_mcu7t5v0__oai211_2
X_06429_ _06464_/A1 _06426_/Z _06464_/A2 _06429_/Z vdd vdd vss vss
+ gf180mcu_fd_sc_mcu7t5v0__or3_1
X_09217_ _09176_/B _09250_/A2 _09217_/B _09937_/D vdd vdd vss vss
+ gf180mcu_fd_sc_mcu7t5v0__aoi21_1
X_09148_ _09953_/Q _09461_/Q _09149_/A2 vdd vdd vss vss gf180mcu_fd_sc_mcu7t5v0__nand2_1
X_09079_ _09278_/A1 _09899_/Q _09103_/A1 _09080_/C vdd vdd vss vss
+ gf180mcu_fd_sc_mcu7t5v0__nor3_1
X_05800_ _05829_/A2 _05830_/A1 _05798_/Z _05803_/A3 vdd vdd vss vss
+ gf180mcu_fd_sc_mcu7t5v0__xnor3_1
X_06780_ _06957_/A1 _06889_/A1 _06780_/B1 _06780_/B2 _06780_/C _06781_/B vdd
+ vdd vss vss gf180mcu_fd_sc_mcu7t5v0__oai221_1
X_05731_ _08715_/A1 _05835_/A2 _05731_/B _05736_/B1 vdd vdd vss vss
+ gf180mcu_fd_sc_mcu7t5v0__aoi21_1
X_08450_ _08450_/A1 _08450_/A2 _08465_/A1 vdd vdd vss vss gf180mcu_fd_sc_mcu7t5v0__nand2_1
X_05662_ _08291_/B _05645_/I _05662_/B1 _05662_/B2 _05698_/C _05667_/C vdd vdd
+ vss vss gf180mcu_fd_sc_mcu7t5v0__aoi221_1
X_08381_ _09405_/A1 _08385_/A2 _08385_/B1 _08381_/B2 _09697_/D vdd vdd
+ vss vss gf180mcu_fd_sc_mcu7t5v0__oai22_1
X_07401_ _07355_/Z _07357_/Z _07401_/B _07449_/A2 vdd vdd vss vss
+ gf180mcu_fd_sc_mcu7t5v0__oai21_2
X_05593_ _09488_/Q _05628_/A2 _05628_/B1 _09504_/Q _05594_/A2 vdd vdd
+ vss vss gf180mcu_fd_sc_mcu7t5v0__aoi22_1
X_07332_ _07650_/I0 _07509_/A1 _07335_/A2 vdd vdd vss vss gf180mcu_fd_sc_mcu7t5v0__nand2_1
X_07263_ _09710_/Q _07283_/A2 _07264_/A3 vdd vdd vss vss gf180mcu_fd_sc_mcu7t5v0__nand2_1
X_06214_ _06214_/A1 _06214_/A2 _06214_/B _06267_/B2 vdd vdd vss vss
+ gf180mcu_fd_sc_mcu7t5v0__aoi21_1
X_09002_ _09002_/A1 _09002_/A2 _09011_/A2 vdd vdd vss vss gf180mcu_fd_sc_mcu7t5v0__nand2_4
X_07194_ _07194_/A1 _07175_/Z _07194_/B _07252_/A1 vdd vdd vss vss
+ gf180mcu_fd_sc_mcu7t5v0__oai21_1
X_06145_ _06150_/A1 _06150_/A2 _06151_/A1 vdd vdd vss vss gf180mcu_fd_sc_mcu7t5v0__nand2_1
X_06076_ _08670_/B _06076_/A2 _09573_/D vdd vdd vss vss gf180mcu_fd_sc_mcu7t5v0__nor2_1
X_05027_ _09503_/Q _05347_/B2 vdd vdd vss vss gf180mcu_fd_sc_mcu7t5v0__clkinv_1
X_09904_ _09904_/D clk _09904_/Q vdd vdd vss vss gf180mcu_fd_sc_mcu7t5v0__dffq_1
XTAP_360 vdd vss gf180mcu_fd_sc_mcu7t5v0__filltie
X_09835_ _09835_/D clk _09835_/Q vdd vdd vss vss gf180mcu_fd_sc_mcu7t5v0__dffq_1
XTAP_371 vdd vss gf180mcu_fd_sc_mcu7t5v0__filltie
XTAP_382 vdd vss gf180mcu_fd_sc_mcu7t5v0__filltie
XTAP_393 vdd vss gf180mcu_fd_sc_mcu7t5v0__filltie
X_09766_ _09766_/D clk _09766_/Q vdd vdd vss vss gf180mcu_fd_sc_mcu7t5v0__dffq_1
X_06978_ _09571_/Q _09647_/Q _09681_/Q _09613_/Q _09638_/Q _09637_/Q _07003_/B vdd
+ vdd vss vss gf180mcu_fd_sc_mcu7t5v0__mux4_4
X_09697_ _09697_/D clk _09697_/Q vdd vdd vss vss gf180mcu_fd_sc_mcu7t5v0__dffq_1
X_08717_ _07452_/C _09104_/A2 _08717_/B _09713_/D vdd vdd vss vss
+ gf180mcu_fd_sc_mcu7t5v0__aoi21_1
X_05929_ _09716_/Q _05932_/A2 _05930_/B1 vdd vdd vss vss gf180mcu_fd_sc_mcu7t5v0__nand2_1
XPHY_11 vdd vss gf180mcu_fd_sc_mcu7t5v0__endcap
XPHY_22 vdd vss gf180mcu_fd_sc_mcu7t5v0__endcap
X_08648_ _08617_/B _08590_/Z _08648_/B _08672_/B vdd vdd vss vss gf180mcu_fd_sc_mcu7t5v0__aoi21_1
XTAP_1504 vdd vss gf180mcu_fd_sc_mcu7t5v0__filltie
XTAP_1515 vdd vss gf180mcu_fd_sc_mcu7t5v0__filltie
XPHY_55 vdd vss gf180mcu_fd_sc_mcu7t5v0__endcap
XPHY_44 vdd vss gf180mcu_fd_sc_mcu7t5v0__endcap
XPHY_33 vdd vss gf180mcu_fd_sc_mcu7t5v0__endcap
XTAP_1526 vdd vss gf180mcu_fd_sc_mcu7t5v0__filltie
XTAP_1537 vdd vss gf180mcu_fd_sc_mcu7t5v0__filltie
XTAP_1548 vdd vss gf180mcu_fd_sc_mcu7t5v0__filltie
XPHY_77 vdd vss gf180mcu_fd_sc_mcu7t5v0__endcap
XPHY_66 vdd vss gf180mcu_fd_sc_mcu7t5v0__endcap
XPHY_88 vdd vss gf180mcu_fd_sc_mcu7t5v0__endcap
X_08579_ _09710_/Q _08689_/A2 _08582_/A3 vdd vdd vss vss gf180mcu_fd_sc_mcu7t5v0__nand2_1
XTAP_1559 vdd vss gf180mcu_fd_sc_mcu7t5v0__filltie
XPHY_99 vdd vss gf180mcu_fd_sc_mcu7t5v0__endcap
X_07950_ _07950_/A1 _07931_/Z _07949_/Z _07953_/A3 vdd vdd vss vss
+ gf180mcu_fd_sc_mcu7t5v0__xnor3_1
X_06901_ _06838_/Z _06848_/Z _06901_/B _06927_/A2 vdd vdd vss vss
+ gf180mcu_fd_sc_mcu7t5v0__aoi21_1
X_07881_ _09712_/Q _07784_/Z _07881_/A3 _07990_/A1 vdd vdd vss vss
+ gf180mcu_fd_sc_mcu7t5v0__nand3_2
X_06832_ _09715_/Q _06658_/I _06838_/A1 vdd vdd vss vss gf180mcu_fd_sc_mcu7t5v0__nand2_1
X_09620_ _09620_/D clk _09620_/Q vdd vdd vss vss gf180mcu_fd_sc_mcu7t5v0__dffq_2
X_09551_ _09551_/D clk _09551_/Q vdd vdd vss vss gf180mcu_fd_sc_mcu7t5v0__dffq_2
X_06763_ _06830_/A1 _06762_/Z _06763_/Z vdd vdd vss vss gf180mcu_fd_sc_mcu7t5v0__or2_1
X_05714_ _05709_/B _05714_/A2 _05751_/A1 _05714_/Z vdd vdd vss vss
+ gf180mcu_fd_sc_mcu7t5v0__xor3_1
X_08502_ _08436_/S _08502_/A2 _08502_/B1 _08502_/B2 _08522_/A2 vdd vdd
+ vss vss gf180mcu_fd_sc_mcu7t5v0__oai22_2
X_09482_ _09482_/D clk _09482_/Q vdd vdd vss vss gf180mcu_fd_sc_mcu7t5v0__dffq_1
X_06694_ _08430_/B _06941_/A2 _06722_/A2 vdd vdd vss vss gf180mcu_fd_sc_mcu7t5v0__nor2_1
X_05645_ _05645_/I _05940_/A2 vdd vdd vss vss gf180mcu_fd_sc_mcu7t5v0__inv_1
X_08433_ _08466_/A1 _08431_/Z _08433_/B _08447_/A1 vdd vdd vss vss
+ gf180mcu_fd_sc_mcu7t5v0__aoi21_1
X_08364_ _09688_/Q _08706_/B _08708_/B _08365_/A2 vdd vdd vss vss
+ gf180mcu_fd_sc_mcu7t5v0__oai21_1
X_05576_ _08791_/B _05576_/A2 _09555_/D vdd vdd vss vss gf180mcu_fd_sc_mcu7t5v0__and2_1
X_07315_ _09658_/Q _09592_/Q _07316_/B1 vdd vdd vss vss gf180mcu_fd_sc_mcu7t5v0__nor2_1
X_08295_ _08296_/A1 _08294_/Z _08345_/A1 vdd vdd vss vss gf180mcu_fd_sc_mcu7t5v0__nand2_1
X_07246_ _09716_/Q _06984_/B _07286_/I1 _07247_/A2 _07287_/C _07247_/B vdd vdd
+ vss vss gf180mcu_fd_sc_mcu7t5v0__aoi221_1
X_07177_ _07278_/A1 _07173_/Z _07190_/A2 vdd vdd vss vss gf180mcu_fd_sc_mcu7t5v0__nand2_1
X_06128_ _09711_/Q _06125_/Z _06175_/A1 vdd vdd vss vss gf180mcu_fd_sc_mcu7t5v0__nand2_1
X_06059_ _09573_/Q _06078_/A1 _06056_/Z _06074_/A2 vdd vdd vss vss
+ gf180mcu_fd_sc_mcu7t5v0__xnor3_1
X_09818_ _09818_/D clk _09818_/Q vdd vdd vss vss gf180mcu_fd_sc_mcu7t5v0__dffq_1
X_09749_ _09749_/D clk _09749_/Q vdd vdd vss vss gf180mcu_fd_sc_mcu7t5v0__dffq_1
XTAP_2024 vdd vss gf180mcu_fd_sc_mcu7t5v0__filltie
XTAP_2002 vdd vss gf180mcu_fd_sc_mcu7t5v0__filltie
XTAP_2013 vdd vss gf180mcu_fd_sc_mcu7t5v0__filltie
XTAP_2035 vdd vss gf180mcu_fd_sc_mcu7t5v0__filltie
XTAP_1301 vdd vss gf180mcu_fd_sc_mcu7t5v0__filltie
XTAP_1312 vdd vss gf180mcu_fd_sc_mcu7t5v0__filltie
XTAP_1323 vdd vss gf180mcu_fd_sc_mcu7t5v0__filltie
XTAP_1334 vdd vss gf180mcu_fd_sc_mcu7t5v0__filltie
XTAP_1345 vdd vss gf180mcu_fd_sc_mcu7t5v0__filltie
XTAP_1356 vdd vss gf180mcu_fd_sc_mcu7t5v0__filltie
XTAP_1367 vdd vss gf180mcu_fd_sc_mcu7t5v0__filltie
XTAP_1378 vdd vss gf180mcu_fd_sc_mcu7t5v0__filltie
XTAP_1389 vdd vss gf180mcu_fd_sc_mcu7t5v0__filltie
X_05430_ _05430_/A1 _05430_/A2 _05430_/A3 _05431_/A2 vdd vdd vss vss
+ gf180mcu_fd_sc_mcu7t5v0__nand3_1
XTAP_1890 vdd vss gf180mcu_fd_sc_mcu7t5v0__filltie
X_05361_ _09401_/A1 _05369_/A2 _05369_/B1 vdd vdd vss vss gf180mcu_fd_sc_mcu7t5v0__nand2_2
X_07100_ _07100_/I _07118_/A1 vdd vdd vss vss gf180mcu_fd_sc_mcu7t5v0__clkinv_1
X_08080_ _08081_/A1 _08079_/Z _08106_/A2 vdd vdd vss vss gf180mcu_fd_sc_mcu7t5v0__nor2_1
X_05292_ _09405_/A1 _05296_/A2 _05296_/B1 _05292_/B2 _09445_/D vdd vdd
+ vss vss gf180mcu_fd_sc_mcu7t5v0__oai22_1
X_07031_ _09712_/Q _07003_/B _07011_/Z _07099_/A1 vdd vdd vss vss
+ gf180mcu_fd_sc_mcu7t5v0__nand3_1
X_08982_ _09002_/A1 _09400_/A2 _08991_/A2 vdd vdd vss vss gf180mcu_fd_sc_mcu7t5v0__nand2_4
X_07933_ _07950_/A1 _07931_/Z _07980_/A1 vdd vdd vss vss gf180mcu_fd_sc_mcu7t5v0__xnor2_1
X_07864_ _07813_/B _07849_/Z _08565_/C _07865_/B2 vdd vdd vss vss
+ gf180mcu_fd_sc_mcu7t5v0__aoi21_1
X_06815_ _07506_/B _06813_/Z _06817_/B vdd vdd vss vss gf180mcu_fd_sc_mcu7t5v0__xor2_1
X_09603_ _09603_/D clk _09603_/Q vdd vdd vss vss gf180mcu_fd_sc_mcu7t5v0__dffq_4
X_07795_ _07820_/A2 _07820_/B _07795_/Z vdd vdd vss vss gf180mcu_fd_sc_mcu7t5v0__xor2_1
X_09534_ _09534_/D clk _09534_/Q vdd vdd vss vss gf180mcu_fd_sc_mcu7t5v0__dffq_1
X_06746_ _09713_/Q _06658_/I _06758_/A2 vdd vdd vss vss gf180mcu_fd_sc_mcu7t5v0__nand2_1
X_06677_ _09710_/Q _06658_/I _06677_/B _06739_/C _06679_/B1 vdd vdd vss
+ vss gf180mcu_fd_sc_mcu7t5v0__oai211_1
X_09465_ _09465_/D clk _09465_/Q vdd vdd vss vss gf180mcu_fd_sc_mcu7t5v0__dffq_2
X_05628_ _09489_/Q _05628_/A2 _05628_/B1 _09505_/Q _05629_/A2 vdd vdd
+ vss vss gf180mcu_fd_sc_mcu7t5v0__aoi22_1
X_08416_ _09702_/Q _08639_/A1 _08446_/A1 vdd vdd vss vss gf180mcu_fd_sc_mcu7t5v0__nand2_1
X_09396_ _10017_/Q _09399_/A2 _09397_/B vdd vdd vss vss gf180mcu_fd_sc_mcu7t5v0__nor2_1
X_08347_ _08347_/A1 _08347_/A2 _08346_/Z _08347_/Z vdd vdd vss vss
+ gf180mcu_fd_sc_mcu7t5v0__xor3_1
X_05559_ _05559_/A1 _05559_/A2 _05573_/B1 vdd vdd vss vss gf180mcu_fd_sc_mcu7t5v0__nand2_1
X_08278_ _08278_/A1 _08286_/A2 _08236_/Z _08278_/B2 _08280_/A2 vdd vdd
+ vss vss gf180mcu_fd_sc_mcu7t5v0__oai22_2
X_07229_ _07229_/I _07232_/A3 vdd vdd vss vss gf180mcu_fd_sc_mcu7t5v0__clkinv_1
XTAP_1120 vdd vss gf180mcu_fd_sc_mcu7t5v0__filltie
XTAP_1131 vdd vss gf180mcu_fd_sc_mcu7t5v0__filltie
XTAP_1153 vdd vss gf180mcu_fd_sc_mcu7t5v0__filltie
XTAP_1142 vdd vss gf180mcu_fd_sc_mcu7t5v0__filltie
XTAP_1164 vdd vss gf180mcu_fd_sc_mcu7t5v0__filltie
XTAP_1175 vdd vss gf180mcu_fd_sc_mcu7t5v0__filltie
XTAP_1186 vdd vss gf180mcu_fd_sc_mcu7t5v0__filltie
XTAP_1197 vdd vss gf180mcu_fd_sc_mcu7t5v0__filltie
Xrepeater8 _08791_/B _09278_/C vdd vdd vss vss gf180mcu_fd_sc_mcu7t5v0__buf_8
XTAP_904 vdd vss gf180mcu_fd_sc_mcu7t5v0__filltie
XTAP_915 vdd vss gf180mcu_fd_sc_mcu7t5v0__filltie
XTAP_926 vdd vss gf180mcu_fd_sc_mcu7t5v0__filltie
XTAP_937 vdd vss gf180mcu_fd_sc_mcu7t5v0__filltie
XTAP_948 vdd vss gf180mcu_fd_sc_mcu7t5v0__filltie
XTAP_959 vdd vss gf180mcu_fd_sc_mcu7t5v0__filltie
X_04930_ _09528_/Q _05374_/B2 vdd vdd vss vss gf180mcu_fd_sc_mcu7t5v0__clkinv_1
X_04861_ _09442_/Q _05289_/B2 vdd vdd vss vss gf180mcu_fd_sc_mcu7t5v0__clkinv_1
X_06600_ _06600_/A1 _06600_/A2 _06600_/Z vdd vdd vss vss gf180mcu_fd_sc_mcu7t5v0__xor2_1
X_07580_ _09708_/Q _07472_/B _09658_/Q _07582_/A1 vdd vdd vss vss
+ gf180mcu_fd_sc_mcu7t5v0__nand3_1
X_04792_ _09653_/Q _08633_/A1 vdd vdd vss vss gf180mcu_fd_sc_mcu7t5v0__clkinv_2
X_06531_ _06613_/A2 _06583_/A1 _06531_/Z vdd vdd vss vss gf180mcu_fd_sc_mcu7t5v0__xor2_1
X_09250_ _09467_/Q _09250_/A2 _09250_/B _09953_/D vdd vdd vss vss
+ gf180mcu_fd_sc_mcu7t5v0__aoi21_1
X_06462_ _09711_/Q _06601_/A2 _06555_/A2 _09710_/Q _06463_/B vdd vdd vss
+ vss gf180mcu_fd_sc_mcu7t5v0__aoi22_1
X_08201_ _08203_/A2 _08203_/A3 _08201_/Z vdd vdd vss vss gf180mcu_fd_sc_mcu7t5v0__or2_1
X_06393_ _09712_/Q _06608_/A2 _06562_/A2 _09711_/Q _06422_/B1 vdd vdd
+ vss vss gf180mcu_fd_sc_mcu7t5v0__aoi22_1
X_09181_ _09248_/A2 _09173_/B _09181_/B _09928_/D vdd vdd vss vss
+ gf180mcu_fd_sc_mcu7t5v0__aoi21_1
X_05413_ _05413_/A1 _05413_/A2 _09105_/A2 vdd vdd vss vss gf180mcu_fd_sc_mcu7t5v0__nor2_4
X_05344_ _09404_/A1 _05349_/A2 _05349_/B1 _05344_/B2 _09500_/D vdd vdd
+ vss vss gf180mcu_fd_sc_mcu7t5v0__oai22_1
X_08132_ _09693_/Q _09692_/Q _08132_/Z vdd vdd vss vss gf180mcu_fd_sc_mcu7t5v0__and2_2
X_08063_ _09689_/Q _08064_/A2 _08257_/B vdd vdd vss vss gf180mcu_fd_sc_mcu7t5v0__and2_1
X_05275_ _05216_/I _05276_/A3 _05627_/B1 vdd vdd vss vss gf180mcu_fd_sc_mcu7t5v0__nor2_4
X_07014_ _06993_/B _07011_/Z _07039_/A1 vdd vdd vss vss gf180mcu_fd_sc_mcu7t5v0__nand2_1
X_08965_ _09824_/Q _08961_/Z _08968_/B _08966_/A2 vdd vdd vss vss
+ gf180mcu_fd_sc_mcu7t5v0__oai21_1
X_07916_ _09715_/Q _07988_/A2 _07918_/A2 vdd vdd vss vss gf180mcu_fd_sc_mcu7t5v0__nand2_1
X_08896_ _08896_/A1 _08896_/A2 _09791_/D vdd vdd vss vss gf180mcu_fd_sc_mcu7t5v0__nor2_1
X_07847_ _07848_/A2 _07848_/A3 _07847_/B _07868_/A2 vdd vdd vss vss
+ gf180mcu_fd_sc_mcu7t5v0__oai21_1
X_07778_ _09713_/Q _07681_/Z _07794_/A2 vdd vdd vss vss gf180mcu_fd_sc_mcu7t5v0__nand2_1
X_09517_ _09517_/D clk _09517_/Q vdd vdd vss vss gf180mcu_fd_sc_mcu7t5v0__dffq_1
X_06729_ _06719_/I _06731_/A3 _06729_/Z vdd vdd vss vss gf180mcu_fd_sc_mcu7t5v0__xor2_1
XPHY_225 vdd vss gf180mcu_fd_sc_mcu7t5v0__endcap
XPHY_214 vdd vss gf180mcu_fd_sc_mcu7t5v0__endcap
XPHY_203 vdd vss gf180mcu_fd_sc_mcu7t5v0__endcap
XPHY_258 vdd vss gf180mcu_fd_sc_mcu7t5v0__endcap
XPHY_247 vdd vss gf180mcu_fd_sc_mcu7t5v0__endcap
XPHY_236 vdd vss gf180mcu_fd_sc_mcu7t5v0__endcap
X_09448_ _09448_/D clk _09448_/Q vdd vdd vss vss gf180mcu_fd_sc_mcu7t5v0__dffq_1
X_09379_ _10009_/Q _09378_/Z _09380_/B vdd vdd vss vss gf180mcu_fd_sc_mcu7t5v0__nor2_1
X_05060_ _09512_/Q _05358_/B2 vdd vdd vss vss gf180mcu_fd_sc_mcu7t5v0__clkinv_1
XTAP_701 vdd vss gf180mcu_fd_sc_mcu7t5v0__filltie
XTAP_734 vdd vss gf180mcu_fd_sc_mcu7t5v0__filltie
XTAP_712 vdd vss gf180mcu_fd_sc_mcu7t5v0__filltie
XTAP_723 vdd vss gf180mcu_fd_sc_mcu7t5v0__filltie
XTAP_767 vdd vss gf180mcu_fd_sc_mcu7t5v0__filltie
XTAP_756 vdd vss gf180mcu_fd_sc_mcu7t5v0__filltie
XTAP_745 vdd vss gf180mcu_fd_sc_mcu7t5v0__filltie
XTAP_778 vdd vss gf180mcu_fd_sc_mcu7t5v0__filltie
XTAP_789 vdd vss gf180mcu_fd_sc_mcu7t5v0__filltie
X_08750_ _09404_/A1 _08755_/A2 _08755_/B1 _08750_/B2 _09737_/D vdd vdd
+ vss vss gf180mcu_fd_sc_mcu7t5v0__oai22_1
X_05962_ _05722_/B _05894_/I _05962_/B _05963_/A3 vdd vdd vss vss
+ gf180mcu_fd_sc_mcu7t5v0__oai21_1
X_07701_ _09710_/Q _07681_/Z _07970_/C _07701_/B2 _07702_/A2 vdd vdd vss
+ vss gf180mcu_fd_sc_mcu7t5v0__oai22_1
X_04913_ _09795_/Q _08907_/B2 vdd vdd vss vss gf180mcu_fd_sc_mcu7t5v0__clkinv_1
X_08681_ _09688_/Q _08386_/Z _08682_/B vdd vdd vss vss gf180mcu_fd_sc_mcu7t5v0__nand2_1
X_05893_ _05890_/Z _05893_/A2 _05893_/A3 _05639_/Z _09889_/Q _05894_/I vdd vdd
+ vss vss gf180mcu_fd_sc_mcu7t5v0__oai32_4
X_04844_ _08806_/B _09399_/C vdd vdd vss vss gf180mcu_fd_sc_mcu7t5v0__inv_20
X_07632_ _09716_/Q _07349_/Z _07636_/A2 vdd vdd vss vss gf180mcu_fd_sc_mcu7t5v0__nand2_1
X_04775_ _09687_/Q _08308_/A1 vdd vdd vss vss gf180mcu_fd_sc_mcu7t5v0__clkinv_3
X_09302_ _09391_/A1 _09310_/A2 _09302_/B _09399_/C _09974_/D vdd vdd vss
+ vss gf180mcu_fd_sc_mcu7t5v0__aoi211_1
X_07563_ _09653_/Q _08565_/C _07616_/A1 vdd vdd vss vss gf180mcu_fd_sc_mcu7t5v0__nand2_1
X_06514_ _09715_/Q _06608_/A2 _06562_/A2 _09714_/Q _06559_/B1 vdd vdd
+ vss vss gf180mcu_fd_sc_mcu7t5v0__aoi22_1
X_07494_ _07495_/A2 _07495_/A3 _07494_/B _07514_/A2 vdd vdd vss vss
+ gf180mcu_fd_sc_mcu7t5v0__oai21_1
X_06445_ _06445_/A1 _06445_/A2 _06444_/B _06446_/A2 vdd vdd vss vss
+ gf180mcu_fd_sc_mcu7t5v0__nand3_1
X_09233_ _09945_/Q _09244_/A2 _09259_/B _09234_/B vdd vdd vss vss
+ gf180mcu_fd_sc_mcu7t5v0__oai21_1
X_09164_ _09957_/Q _09461_/Q _09165_/A2 vdd vdd vss vss gf180mcu_fd_sc_mcu7t5v0__nand2_1
X_06376_ _06372_/Z _06373_/Z _06376_/Z vdd vdd vss vss gf180mcu_fd_sc_mcu7t5v0__xor2_1
X_08115_ _09712_/Q _08096_/Z _08119_/B2 vdd vdd vss vss gf180mcu_fd_sc_mcu7t5v0__nor2_1
X_05327_ _09407_/A1 _05329_/A2 _05329_/B1 _05327_/B2 _09487_/D vdd vdd
+ vss vss gf180mcu_fd_sc_mcu7t5v0__oai22_1
X_09095_ _09968_/Q _09095_/A2 _09096_/C vdd vdd vss vss gf180mcu_fd_sc_mcu7t5v0__and2_1
X_05258_ _09407_/A1 _05260_/A2 _05260_/B1 _05258_/B2 _09423_/D vdd vdd
+ vss vss gf180mcu_fd_sc_mcu7t5v0__oai22_1
X_08046_ _08358_/I1 _08362_/A1 _08046_/B _08049_/B2 vdd vdd vss vss
+ gf180mcu_fd_sc_mcu7t5v0__aoi21_1
X_05189_ _09259_/B _09471_/Q _09246_/A2 _09461_/D vdd vdd vss vss
+ gf180mcu_fd_sc_mcu7t5v0__and3_1
X_09997_ _09997_/D clk _09997_/Q vdd vdd vss vss gf180mcu_fd_sc_mcu7t5v0__dffq_1
X_08948_ _08927_/I _08946_/Z _08948_/A3 _09818_/D vdd vdd vss vss
+ gf180mcu_fd_sc_mcu7t5v0__nor3_1
X_08879_ _09397_/A1 _09523_/Q _08880_/B vdd vdd vss vss gf180mcu_fd_sc_mcu7t5v0__nor2_1
X_06230_ _09071_/A1 _06282_/A2 _06230_/B _06261_/A2 vdd vdd vss vss
+ gf180mcu_fd_sc_mcu7t5v0__aoi21_4
X_06161_ _06161_/A1 _06134_/Z _06161_/A3 _06137_/Z _06055_/I _06096_/Z _06212_/A1
+ vdd vdd vss vss gf180mcu_fd_sc_mcu7t5v0__oai33_2
X_06092_ _06082_/Z _06092_/A2 _06092_/A3 _06092_/Z vdd vdd vss vss
+ gf180mcu_fd_sc_mcu7t5v0__and3_1
X_05112_ _09913_/Q _05113_/A4 _09299_/A4 vdd vdd vss vss gf180mcu_fd_sc_mcu7t5v0__nor2_2
X_05043_ _10025_/Q _09408_/B2 vdd vdd vss vss gf180mcu_fd_sc_mcu7t5v0__clkinv_1
X_09920_ _09920_/D clk _09920_/Q vdd vdd vss vss gf180mcu_fd_sc_mcu7t5v0__dffq_2
XTAP_542 vdd vss gf180mcu_fd_sc_mcu7t5v0__filltie
XTAP_520 vdd vss gf180mcu_fd_sc_mcu7t5v0__filltie
XTAP_531 vdd vss gf180mcu_fd_sc_mcu7t5v0__filltie
X_09851_ _09851_/D clk _09851_/Q vdd vdd vss vss gf180mcu_fd_sc_mcu7t5v0__dffq_1
XTAP_575 vdd vss gf180mcu_fd_sc_mcu7t5v0__filltie
XTAP_564 vdd vss gf180mcu_fd_sc_mcu7t5v0__filltie
XTAP_553 vdd vss gf180mcu_fd_sc_mcu7t5v0__filltie
X_08802_ _09733_/Q _08802_/A2 _08806_/B _08820_/A1 vdd vdd vss vss
+ gf180mcu_fd_sc_mcu7t5v0__oai21_2
X_06994_ _07298_/A1 _06994_/A2 _07287_/A2 vdd vdd vss vss gf180mcu_fd_sc_mcu7t5v0__nor2_2
X_09782_ _09782_/D clk _09782_/Q vdd vdd vss vss gf180mcu_fd_sc_mcu7t5v0__dffq_1
XTAP_597 vdd vss gf180mcu_fd_sc_mcu7t5v0__filltie
XTAP_586 vdd vss gf180mcu_fd_sc_mcu7t5v0__filltie
X_08733_ _08733_/A1 _09073_/A2 _08733_/B _09721_/D vdd vdd vss vss
+ gf180mcu_fd_sc_mcu7t5v0__aoi21_1
X_05945_ _09890_/Q _09620_/Q _09578_/Q _09882_/Q _09569_/Q _09570_/Q _05945_/Z vdd
+ vdd vss vss gf180mcu_fd_sc_mcu7t5v0__mux4_2
X_08664_ _08702_/A1 _08662_/Z _08664_/B _08668_/A2 vdd vdd vss vss
+ gf180mcu_fd_sc_mcu7t5v0__oai21_1
X_05876_ _05698_/C _05861_/Z _08565_/C _05877_/B vdd vdd vss vss gf180mcu_fd_sc_mcu7t5v0__aoi21_1
XTAP_1719 vdd vss gf180mcu_fd_sc_mcu7t5v0__filltie
XTAP_1708 vdd vss gf180mcu_fd_sc_mcu7t5v0__filltie
X_08595_ _08595_/A1 _08599_/A2 _08596_/B vdd vdd vss vss gf180mcu_fd_sc_mcu7t5v0__xor2_1
X_04827_ _09583_/Q _06313_/A1 vdd vdd vss vss gf180mcu_fd_sc_mcu7t5v0__clkinv_2
X_07615_ _07396_/B _07600_/Z _07615_/B _08706_/B _07616_/A2 vdd vdd vss
+ vss gf180mcu_fd_sc_mcu7t5v0__oai211_1
X_04758_ _09715_/Q _08721_/A1 vdd vdd vss vss gf180mcu_fd_sc_mcu7t5v0__clkinv_8
X_07546_ _09652_/Q _07564_/A1 _07543_/Z _07546_/Z vdd vdd vss vss
+ gf180mcu_fd_sc_mcu7t5v0__xor3_1
X_09216_ _09937_/Q _09176_/B _09278_/C _09217_/B vdd vdd vss vss gf180mcu_fd_sc_mcu7t5v0__oai21_1
X_07477_ _09711_/Q _07623_/A2 _07475_/I _09710_/Q _07521_/A2 vdd vdd vss
+ vss gf180mcu_fd_sc_mcu7t5v0__aoi22_1
X_06428_ _09713_/Q _06608_/A2 _06562_/A2 _09712_/Q _06464_/A2 vdd vdd
+ vss vss gf180mcu_fd_sc_mcu7t5v0__aoi22_1
X_06359_ _08424_/A1 _06605_/A2 _06359_/B1 _06359_/B2 _06562_/A2 vdd vdd
+ vss vss gf180mcu_fd_sc_mcu7t5v0__aoi22_4
X_09147_ _09399_/C _09147_/A2 _09918_/D vdd vdd vss vss gf180mcu_fd_sc_mcu7t5v0__nor2_1
X_09078_ _09096_/B1 _09077_/Z _09098_/A1 vdd vdd vss vss gf180mcu_fd_sc_mcu7t5v0__nand2_4
X_08029_ _08375_/A1 _08029_/A2 _08029_/B1 _09692_/Q _08088_/A3 vdd vdd
+ vss vss gf180mcu_fd_sc_mcu7t5v0__oai22_4
X_05730_ _05930_/B2 _05795_/A1 _05930_/C _05731_/B vdd vdd vss vss
+ gf180mcu_fd_sc_mcu7t5v0__aoi21_1
X_05661_ _09568_/Q _09567_/Q _05970_/A1 _05733_/C vdd vdd vss vss
+ gf180mcu_fd_sc_mcu7t5v0__nand3_4
X_08380_ _09404_/A1 _08385_/A2 _08385_/B1 _08380_/B2 _09696_/D vdd vdd
+ vss vss gf180mcu_fd_sc_mcu7t5v0__oai22_1
X_07400_ _08715_/A1 _07385_/Z _07400_/A3 _07401_/B vdd vdd vss vss
+ gf180mcu_fd_sc_mcu7t5v0__xor3_1
X_05592_ _09496_/Q _05627_/A2 _05627_/B1 _09512_/Q _05594_/A1 vdd vdd
+ vss vss gf180mcu_fd_sc_mcu7t5v0__aoi22_1
X_07331_ _09655_/Q _07331_/A2 _07509_/A1 vdd vdd vss vss gf180mcu_fd_sc_mcu7t5v0__nand2_1
X_07262_ _07262_/A1 _07262_/A2 _07283_/A2 vdd vdd vss vss gf180mcu_fd_sc_mcu7t5v0__nor2_2
X_06213_ _06213_/A1 _06185_/Z _06213_/B _06266_/A1 vdd vdd vss vss
+ gf180mcu_fd_sc_mcu7t5v0__aoi21_1
X_09001_ _09409_/A1 _09001_/A2 _09001_/B1 _09001_/B2 _09850_/D vdd vdd
+ vss vss gf180mcu_fd_sc_mcu7t5v0__oai22_1
X_07193_ _09632_/Q _08565_/C _07251_/A1 vdd vdd vss vss gf180mcu_fd_sc_mcu7t5v0__nand2_1
X_06144_ _06290_/A1 _06144_/A2 _06157_/A2 vdd vdd vss vss gf180mcu_fd_sc_mcu7t5v0__nand2_1
X_06075_ _09573_/Q _08565_/C _06075_/B _06076_/A2 vdd vdd vss vss
+ gf180mcu_fd_sc_mcu7t5v0__aoi21_1
X_05026_ _09531_/Q _05377_/B2 vdd vdd vss vss gf180mcu_fd_sc_mcu7t5v0__clkinv_1
X_09903_ _09903_/D clk _09903_/Q vdd vdd vss vss gf180mcu_fd_sc_mcu7t5v0__dffq_1
X_09834_ _09834_/D clk _09834_/Q vdd vdd vss vss gf180mcu_fd_sc_mcu7t5v0__dffq_1
XTAP_350 vdd vss gf180mcu_fd_sc_mcu7t5v0__filltie
XTAP_361 vdd vss gf180mcu_fd_sc_mcu7t5v0__filltie
XTAP_372 vdd vss gf180mcu_fd_sc_mcu7t5v0__filltie
XTAP_383 vdd vss gf180mcu_fd_sc_mcu7t5v0__filltie
XTAP_394 vdd vss gf180mcu_fd_sc_mcu7t5v0__filltie
X_09765_ _09765_/D clk _09765_/Q vdd vdd vss vss gf180mcu_fd_sc_mcu7t5v0__dffq_1
X_06977_ _09638_/Q _07300_/A1 _07260_/B1 vdd vdd vss vss gf180mcu_fd_sc_mcu7t5v0__nor2_1
X_09696_ _09696_/D clk _09696_/Q vdd vdd vss vss gf180mcu_fd_sc_mcu7t5v0__dffq_1
X_08716_ _09878_/Q _09104_/A2 _09072_/B _08717_/B vdd vdd vss vss
+ gf180mcu_fd_sc_mcu7t5v0__oai21_1
X_05928_ _05964_/B2 _05894_/I _05928_/B _05930_/A2 vdd vdd vss vss
+ gf180mcu_fd_sc_mcu7t5v0__oai21_1
XPHY_12 vdd vss gf180mcu_fd_sc_mcu7t5v0__endcap
X_08647_ _08673_/A1 _08646_/I _08648_/B vdd vdd vss vss gf180mcu_fd_sc_mcu7t5v0__xor2_1
XTAP_1505 vdd vss gf180mcu_fd_sc_mcu7t5v0__filltie
X_05859_ _09563_/Q _05858_/Z _05880_/A2 vdd vdd vss vss gf180mcu_fd_sc_mcu7t5v0__nor2_1
XPHY_56 vdd vss gf180mcu_fd_sc_mcu7t5v0__endcap
XPHY_45 vdd vss gf180mcu_fd_sc_mcu7t5v0__endcap
XPHY_23 vdd vss gf180mcu_fd_sc_mcu7t5v0__endcap
XPHY_34 vdd vss gf180mcu_fd_sc_mcu7t5v0__endcap
XTAP_1516 vdd vss gf180mcu_fd_sc_mcu7t5v0__filltie
XTAP_1527 vdd vss gf180mcu_fd_sc_mcu7t5v0__filltie
XTAP_1538 vdd vss gf180mcu_fd_sc_mcu7t5v0__filltie
XPHY_78 vdd vss gf180mcu_fd_sc_mcu7t5v0__endcap
XPHY_67 vdd vss gf180mcu_fd_sc_mcu7t5v0__endcap
XPHY_89 vdd vss gf180mcu_fd_sc_mcu7t5v0__endcap
X_08578_ _08578_/A1 _08389_/Z _08578_/B _08689_/A2 vdd vdd vss vss
+ gf180mcu_fd_sc_mcu7t5v0__oai21_4
XTAP_1549 vdd vss gf180mcu_fd_sc_mcu7t5v0__filltie
X_07529_ _07529_/A1 _07570_/B2 _07635_/A1 _07534_/A1 vdd vdd vss vss
+ gf180mcu_fd_sc_mcu7t5v0__xnor3_1
X_06900_ _06838_/Z _06848_/Z _06901_/B _06927_/B vdd vdd vss vss gf180mcu_fd_sc_mcu7t5v0__nand3_1
X_07880_ _09713_/Q _07745_/Z _07934_/A3 _07885_/A2 vdd vdd vss vss
+ gf180mcu_fd_sc_mcu7t5v0__nand3_1
X_06831_ _06831_/A1 _06831_/A2 _06831_/B _06878_/A1 vdd vdd vss vss
+ gf180mcu_fd_sc_mcu7t5v0__aoi21_1
X_09550_ _09550_/D clk _09550_/Q vdd vdd vss vss gf180mcu_fd_sc_mcu7t5v0__dffq_2
X_06762_ _06762_/A1 _06762_/A2 _06762_/Z vdd vdd vss vss gf180mcu_fd_sc_mcu7t5v0__xor2_1
X_05713_ _09710_/Q _05708_/Z _05713_/A3 _05711_/I _05780_/A2 vdd vdd vss
+ vss gf180mcu_fd_sc_mcu7t5v0__nand4_2
X_08501_ _09713_/Q _08430_/B _08631_/A2 _08501_/A4 _08501_/Z vdd vdd vss
+ vss gf180mcu_fd_sc_mcu7t5v0__or4_1
X_09481_ _09481_/D clk _09481_/Q vdd vdd vss vss gf180mcu_fd_sc_mcu7t5v0__dffq_1
X_08432_ _08466_/A1 _08431_/Z _08432_/B _08433_/B vdd vdd vss vss
+ gf180mcu_fd_sc_mcu7t5v0__oai21_1
X_06693_ _06958_/A1 _06732_/A2 _06704_/A2 vdd vdd vss vss gf180mcu_fd_sc_mcu7t5v0__nand2_1
X_05644_ _05644_/A1 _05644_/A2 _05644_/A3 _05639_/Z _09883_/Q _05645_/I vdd
+ vdd vss vss gf180mcu_fd_sc_mcu7t5v0__oai32_4
X_05575_ _05575_/A1 _05575_/A2 _05575_/A3 _05576_/A2 vdd vdd vss vss
+ gf180mcu_fd_sc_mcu7t5v0__nand3_1
X_08363_ _08107_/B _08363_/A2 _08363_/B _08565_/C _08365_/A1 vdd vdd vss
+ vss gf180mcu_fd_sc_mcu7t5v0__aoi211_1
X_08294_ _08294_/A1 _08294_/A2 _08294_/Z vdd vdd vss vss gf180mcu_fd_sc_mcu7t5v0__xor2_1
X_07314_ _08027_/A1 _07472_/B _09658_/Q _07377_/A2 vdd vdd vss vss
+ gf180mcu_fd_sc_mcu7t5v0__nand3_4
X_07245_ _09716_/Q _07245_/A2 _07247_/A2 vdd vdd vss vss gf180mcu_fd_sc_mcu7t5v0__nand2_1
X_07176_ _07194_/A1 _07175_/Z _07176_/Z vdd vdd vss vss gf180mcu_fd_sc_mcu7t5v0__xor2_1
X_06127_ _06174_/A1 _06130_/A3 _06167_/A2 vdd vdd vss vss gf180mcu_fd_sc_mcu7t5v0__nand2_1
X_06058_ _09573_/Q _06056_/Z _06078_/B vdd vdd vss vss gf180mcu_fd_sc_mcu7t5v0__and2_1
X_05009_ _09798_/Q _08910_/B2 vdd vdd vss vss gf180mcu_fd_sc_mcu7t5v0__clkinv_1
X_09817_ _09817_/D clk _09817_/Q vdd vdd vss vss gf180mcu_fd_sc_mcu7t5v0__dffq_1
X_09748_ _09748_/D clk _09748_/Q vdd vdd vss vss gf180mcu_fd_sc_mcu7t5v0__dffq_1
XTAP_2025 vdd vss gf180mcu_fd_sc_mcu7t5v0__filltie
XTAP_2003 vdd vss gf180mcu_fd_sc_mcu7t5v0__filltie
XTAP_2014 vdd vss gf180mcu_fd_sc_mcu7t5v0__filltie
X_09679_ _09679_/D clk _09679_/Q vdd vdd vss vss gf180mcu_fd_sc_mcu7t5v0__dffq_4
XTAP_1302 vdd vss gf180mcu_fd_sc_mcu7t5v0__filltie
XTAP_1313 vdd vss gf180mcu_fd_sc_mcu7t5v0__filltie
XTAP_1324 vdd vss gf180mcu_fd_sc_mcu7t5v0__filltie
XTAP_1335 vdd vss gf180mcu_fd_sc_mcu7t5v0__filltie
XTAP_1346 vdd vss gf180mcu_fd_sc_mcu7t5v0__filltie
XTAP_1357 vdd vss gf180mcu_fd_sc_mcu7t5v0__filltie
XTAP_1368 vdd vss gf180mcu_fd_sc_mcu7t5v0__filltie
XTAP_1379 vdd vss gf180mcu_fd_sc_mcu7t5v0__filltie
XTAP_1891 vdd vss gf180mcu_fd_sc_mcu7t5v0__filltie
XTAP_1880 vdd vss gf180mcu_fd_sc_mcu7t5v0__filltie
X_05360_ _08972_/A1 _05631_/C1 _05369_/A2 vdd vdd vss vss gf180mcu_fd_sc_mcu7t5v0__nand2_4
X_05291_ _09404_/A1 _05296_/A2 _05296_/B1 _05291_/B2 _09444_/D vdd vdd
+ vss vss gf180mcu_fd_sc_mcu7t5v0__oai22_1
X_07030_ _07032_/A1 _07062_/A1 _07073_/A1 vdd vdd vss vss gf180mcu_fd_sc_mcu7t5v0__nor2_1
X_08981_ _09409_/A1 _08981_/A2 _08981_/B1 _08981_/B2 _09834_/D vdd vdd
+ vss vss gf180mcu_fd_sc_mcu7t5v0__oai22_1
X_07932_ _09716_/Q _07681_/Z _07931_/Z _07979_/B vdd vdd vss vss gf180mcu_fd_sc_mcu7t5v0__nand3_1
X_07863_ _07813_/B _07863_/A2 _07863_/Z vdd vdd vss vss gf180mcu_fd_sc_mcu7t5v0__or2_1
X_09602_ _09602_/D clk _09602_/Q vdd vdd vss vss gf180mcu_fd_sc_mcu7t5v0__dffq_2
X_06814_ _09714_/Q _06813_/Z _06814_/Z vdd vdd vss vss gf180mcu_fd_sc_mcu7t5v0__and2_1
X_07794_ _07794_/A1 _07794_/A2 _07794_/A3 _07820_/B vdd vdd vss vss
+ gf180mcu_fd_sc_mcu7t5v0__xnor3_1
X_09533_ _09533_/D clk _09533_/Q vdd vdd vss vss gf180mcu_fd_sc_mcu7t5v0__dffq_1
X_06745_ _06713_/Z _06745_/A2 _06745_/B _06785_/A1 vdd vdd vss vss
+ gf180mcu_fd_sc_mcu7t5v0__oai21_1
X_06676_ _06674_/B _06676_/A2 _06676_/B _06676_/C _06677_/B vdd vdd vss
+ vss gf180mcu_fd_sc_mcu7t5v0__oai211_1
X_09464_ _09464_/D clk _09464_/Q vdd vdd vss vss gf180mcu_fd_sc_mcu7t5v0__dffq_1
X_05627_ _09497_/Q _05627_/A2 _05627_/B1 _09513_/Q _05629_/A1 vdd vdd
+ vss vss gf180mcu_fd_sc_mcu7t5v0__aoi22_1
X_08415_ _09702_/Q _08639_/A1 _08418_/A1 vdd vdd vss vss gf180mcu_fd_sc_mcu7t5v0__nor2_1
X_09395_ _09395_/A1 _09399_/A2 _09395_/B _09399_/C _10016_/D vdd vdd vss
+ vss gf180mcu_fd_sc_mcu7t5v0__aoi211_1
X_08346_ _08346_/A1 _08340_/Z _08345_/Z _08346_/Z vdd vdd vss vss
+ gf180mcu_fd_sc_mcu7t5v0__xor3_1
X_05558_ _09487_/Q _05628_/A2 _05628_/B1 _09503_/Q _05559_/A2 vdd vdd
+ vss vss gf180mcu_fd_sc_mcu7t5v0__aoi22_1
X_08277_ _09715_/Q _08061_/Z _08280_/A1 vdd vdd vss vss gf180mcu_fd_sc_mcu7t5v0__nand2_1
X_05489_ _08791_/B _05489_/A2 _09552_/D vdd vdd vss vss gf180mcu_fd_sc_mcu7t5v0__and2_1
X_07228_ _07166_/I _07254_/A1 _07225_/Z _07229_/I vdd vdd vss vss
+ gf180mcu_fd_sc_mcu7t5v0__xor3_1
X_07159_ _07159_/A1 _07159_/A2 _07163_/A1 vdd vdd vss vss gf180mcu_fd_sc_mcu7t5v0__xnor2_1
XTAP_1110 vdd vss gf180mcu_fd_sc_mcu7t5v0__filltie
XTAP_1121 vdd vss gf180mcu_fd_sc_mcu7t5v0__filltie
XTAP_1132 vdd vss gf180mcu_fd_sc_mcu7t5v0__filltie
XTAP_1154 vdd vss gf180mcu_fd_sc_mcu7t5v0__filltie
XTAP_1143 vdd vss gf180mcu_fd_sc_mcu7t5v0__filltie
XTAP_1165 vdd vss gf180mcu_fd_sc_mcu7t5v0__filltie
XTAP_1176 vdd vss gf180mcu_fd_sc_mcu7t5v0__filltie
XTAP_1187 vdd vss gf180mcu_fd_sc_mcu7t5v0__filltie
XTAP_1198 vdd vss gf180mcu_fd_sc_mcu7t5v0__filltie
Xrepeater9 _08806_/B _08791_/B vdd vdd vss vss gf180mcu_fd_sc_mcu7t5v0__buf_8
XTAP_905 vdd vss gf180mcu_fd_sc_mcu7t5v0__filltie
XTAP_916 vdd vss gf180mcu_fd_sc_mcu7t5v0__filltie
XTAP_938 vdd vss gf180mcu_fd_sc_mcu7t5v0__filltie
XTAP_927 vdd vss gf180mcu_fd_sc_mcu7t5v0__filltie
XTAP_949 vdd vss gf180mcu_fd_sc_mcu7t5v0__filltie
X_04860_ _09434_/Q _05279_/B2 vdd vdd vss vss gf180mcu_fd_sc_mcu7t5v0__clkinv_1
X_04791_ _09654_/Q _08682_/A1 vdd vdd vss vss gf180mcu_fd_sc_mcu7t5v0__clkinv_2
X_06530_ _06439_/B _06555_/A2 _06530_/B _06583_/A1 vdd vdd vss vss
+ gf180mcu_fd_sc_mcu7t5v0__aoi21_1
X_06461_ _06463_/A1 _06460_/Z _06546_/A1 vdd vdd vss vss gf180mcu_fd_sc_mcu7t5v0__nand2_1
X_08200_ _08101_/I _08147_/Z _08200_/B _08203_/A3 vdd vdd vss vss
+ gf180mcu_fd_sc_mcu7t5v0__aoi21_1
X_05412_ _05412_/A1 _05412_/A2 _05428_/B1 vdd vdd vss vss gf180mcu_fd_sc_mcu7t5v0__nand2_1
X_06392_ _09712_/Q _06562_/A2 _06430_/A1 vdd vdd vss vss gf180mcu_fd_sc_mcu7t5v0__nand2_1
X_09180_ _09928_/Q _09173_/B _09257_/B _09181_/B vdd vdd vss vss gf180mcu_fd_sc_mcu7t5v0__oai21_1
X_05343_ _09403_/A1 _05349_/A2 _05349_/B1 _05343_/B2 _09499_/D vdd vdd
+ vss vss gf180mcu_fd_sc_mcu7t5v0__oai22_1
X_08131_ _09711_/Q _08283_/A2 _08283_/A3 _08143_/A1 vdd vdd vss vss
+ gf180mcu_fd_sc_mcu7t5v0__nand3_2
X_08062_ _08074_/A2 _08074_/A3 _08129_/A2 vdd vdd vss vss gf180mcu_fd_sc_mcu7t5v0__nand2_2
X_05274_ _09409_/A1 _05274_/A2 _05274_/B1 _05274_/B2 _09433_/D vdd vdd
+ vss vss gf180mcu_fd_sc_mcu7t5v0__oai22_1
X_07013_ _07286_/I1 _07032_/A1 _07287_/C _07022_/A2 vdd vdd vss vss
+ gf180mcu_fd_sc_mcu7t5v0__aoi21_1
X_08964_ _09824_/Q _08961_/Z _08964_/Z vdd vdd vss vss gf180mcu_fd_sc_mcu7t5v0__and2_1
X_07915_ _07915_/A1 _07914_/B _07915_/Z vdd vdd vss vss gf180mcu_fd_sc_mcu7t5v0__xor2_1
X_08895_ _09923_/Q _08897_/A2 _08895_/B _08896_/A2 vdd vdd vss vss
+ gf180mcu_fd_sc_mcu7t5v0__aoi21_1
X_07846_ _07848_/A2 _07848_/A3 _07846_/Z vdd vdd vss vss gf180mcu_fd_sc_mcu7t5v0__or2_1
X_07777_ _07740_/Z _07757_/Z _07777_/B _07819_/A1 vdd vdd vss vss
+ gf180mcu_fd_sc_mcu7t5v0__aoi21_1
X_04989_ _09446_/Q _05293_/B2 vdd vdd vss vss gf180mcu_fd_sc_mcu7t5v0__clkinv_1
X_09516_ _09516_/D clk _09516_/Q vdd vdd vss vss gf180mcu_fd_sc_mcu7t5v0__dffq_1
X_06728_ _09621_/Q _06728_/A2 _06941_/A2 _06811_/A1 _06731_/A3 vdd vdd
+ vss vss gf180mcu_fd_sc_mcu7t5v0__aoi22_2
XPHY_215 vdd vss gf180mcu_fd_sc_mcu7t5v0__endcap
X_09447_ _09447_/D clk _09447_/Q vdd vdd vss vss gf180mcu_fd_sc_mcu7t5v0__dffq_1
XPHY_204 vdd vss gf180mcu_fd_sc_mcu7t5v0__endcap
XPHY_259 vdd vss gf180mcu_fd_sc_mcu7t5v0__endcap
XPHY_248 vdd vss gf180mcu_fd_sc_mcu7t5v0__endcap
XPHY_237 vdd vss gf180mcu_fd_sc_mcu7t5v0__endcap
XPHY_226 vdd vss gf180mcu_fd_sc_mcu7t5v0__endcap
X_06659_ _08291_/B _06811_/A1 _06674_/B vdd vdd vss vss gf180mcu_fd_sc_mcu7t5v0__nor2_4
X_09378_ _09378_/A1 _09378_/A2 _09262_/Z _09378_/Z vdd vdd vss vss
+ gf180mcu_fd_sc_mcu7t5v0__and3_2
X_08329_ _08329_/A1 _08298_/Z _08329_/B _08346_/A1 vdd vdd vss vss
+ gf180mcu_fd_sc_mcu7t5v0__aoi21_1
XTAP_713 vdd vss gf180mcu_fd_sc_mcu7t5v0__filltie
XTAP_724 vdd vss gf180mcu_fd_sc_mcu7t5v0__filltie
XTAP_702 vdd vss gf180mcu_fd_sc_mcu7t5v0__filltie
XTAP_768 vdd vss gf180mcu_fd_sc_mcu7t5v0__filltie
XTAP_757 vdd vss gf180mcu_fd_sc_mcu7t5v0__filltie
XTAP_746 vdd vss gf180mcu_fd_sc_mcu7t5v0__filltie
XTAP_735 vdd vss gf180mcu_fd_sc_mcu7t5v0__filltie
XTAP_779 vdd vss gf180mcu_fd_sc_mcu7t5v0__filltie
X_07700_ _09678_/Q _09677_/Q _08018_/A1 _07771_/C vdd vdd vss vss
+ gf180mcu_fd_sc_mcu7t5v0__nand3_4
X_05961_ _05959_/Z _05964_/B1 _05964_/A3 vdd vdd vss vss gf180mcu_fd_sc_mcu7t5v0__nand2_1
X_04912_ _09868_/Q _09025_/B2 vdd vdd vss vss gf180mcu_fd_sc_mcu7t5v0__clkinv_1
X_08680_ _09711_/Q _08703_/A1 _08684_/A1 vdd vdd vss vss gf180mcu_fd_sc_mcu7t5v0__nand2_1
X_05892_ _05892_/A1 _09569_/Q _09570_/Q _05893_/A3 vdd vdd vss vss
+ gf180mcu_fd_sc_mcu7t5v0__aoi21_2
X_07631_ _09717_/Q _07317_/Z _07636_/A1 vdd vdd vss vss gf180mcu_fd_sc_mcu7t5v0__nand2_1
X_04843_ _09811_/Q _08929_/A1 vdd vdd vss vss gf180mcu_fd_sc_mcu7t5v0__clkinv_1
X_07562_ _08670_/B _07562_/A2 _09652_/D vdd vdd vss vss gf180mcu_fd_sc_mcu7t5v0__nor2_1
X_06513_ _09715_/Q _06562_/A2 _06564_/A1 vdd vdd vss vss gf180mcu_fd_sc_mcu7t5v0__nand2_1
X_04774_ _09689_/Q _08367_/A1 vdd vdd vss vss gf180mcu_fd_sc_mcu7t5v0__inv_3
X_09301_ _09974_/Q _09310_/A2 _09302_/B vdd vdd vss vss gf180mcu_fd_sc_mcu7t5v0__nor2_1
X_07493_ _07495_/A2 _07495_/A3 _07493_/Z vdd vdd vss vss gf180mcu_fd_sc_mcu7t5v0__or2_1
X_06444_ _06445_/A1 _06445_/A2 _06444_/B _06487_/A2 vdd vdd vss vss
+ gf180mcu_fd_sc_mcu7t5v0__aoi21_2
X_09232_ _09248_/A2 _09244_/A2 _09232_/B _09944_/D vdd vdd vss vss
+ gf180mcu_fd_sc_mcu7t5v0__aoi21_1
X_06375_ _06372_/Z _06373_/Z _06396_/A1 vdd vdd vss vss gf180mcu_fd_sc_mcu7t5v0__nand2_1
X_09163_ _09399_/C _09163_/A2 _09922_/D vdd vdd vss vss gf180mcu_fd_sc_mcu7t5v0__nor2_1
X_08114_ _08114_/A1 _08112_/Z _08114_/Z vdd vdd vss vss gf180mcu_fd_sc_mcu7t5v0__xor2_1
X_05326_ _09406_/A1 _05329_/A2 _05329_/B1 _05326_/B2 _09486_/D vdd vdd
+ vss vss gf180mcu_fd_sc_mcu7t5v0__oai22_1
X_09094_ _09098_/A1 _09094_/A2 _09094_/B _09894_/D vdd vdd vss vss
+ gf180mcu_fd_sc_mcu7t5v0__aoi21_1
X_05257_ _09406_/A1 _05260_/A2 _05260_/B1 _05257_/B2 _09422_/D vdd vdd
+ vss vss gf180mcu_fd_sc_mcu7t5v0__oai22_1
X_08045_ _08046_/B _08045_/A2 _08359_/A2 _09710_/Q _08050_/A1 vdd vdd
+ vss vss gf180mcu_fd_sc_mcu7t5v0__aoi22_1
X_05188_ _09248_/A2 _05188_/A2 _09462_/D vdd vdd vss vss gf180mcu_fd_sc_mcu7t5v0__nor2_1
X_09996_ _09996_/D clk _09996_/Q vdd vdd vss vss gf180mcu_fd_sc_mcu7t5v0__dffq_1
X_08947_ _09818_/Q _08944_/Z _08948_/A3 vdd vdd vss vss gf180mcu_fd_sc_mcu7t5v0__nor2_1
X_08878_ _08899_/A2 _08878_/A2 _08878_/B _09787_/D vdd vdd vss vss
+ gf180mcu_fd_sc_mcu7t5v0__aoi21_1
X_07829_ _07882_/A2 _07882_/A3 _07830_/I vdd vdd vss vss gf180mcu_fd_sc_mcu7t5v0__and2_2
X_06160_ _06160_/A1 _06160_/A2 _06160_/B _06211_/A1 vdd vdd vss vss
+ gf180mcu_fd_sc_mcu7t5v0__aoi21_1
X_06091_ _06091_/I _06092_/A3 vdd vdd vss vss gf180mcu_fd_sc_mcu7t5v0__clkinv_1
X_05111_ _09915_/Q _05137_/A2 _05113_/A4 vdd vdd vss vss gf180mcu_fd_sc_mcu7t5v0__nand2_1
X_05042_ _09740_/Q _08753_/B2 vdd vdd vss vss gf180mcu_fd_sc_mcu7t5v0__clkinv_1
X_09850_ _09850_/D clk _09850_/Q vdd vdd vss vss gf180mcu_fd_sc_mcu7t5v0__dffq_1
XTAP_543 vdd vss gf180mcu_fd_sc_mcu7t5v0__filltie
XTAP_510 vdd vss gf180mcu_fd_sc_mcu7t5v0__filltie
XTAP_521 vdd vss gf180mcu_fd_sc_mcu7t5v0__filltie
XTAP_532 vdd vss gf180mcu_fd_sc_mcu7t5v0__filltie
XTAP_576 vdd vss gf180mcu_fd_sc_mcu7t5v0__filltie
XTAP_565 vdd vss gf180mcu_fd_sc_mcu7t5v0__filltie
XTAP_554 vdd vss gf180mcu_fd_sc_mcu7t5v0__filltie
X_08801_ _08801_/A1 _08812_/A2 _08801_/Z vdd vdd vss vss gf180mcu_fd_sc_mcu7t5v0__or2_1
X_06993_ _07286_/I0 _07278_/A1 _06993_/B _06995_/B vdd vdd vss vss
+ gf180mcu_fd_sc_mcu7t5v0__oai21_1
X_09781_ _09781_/D clk _09781_/Q vdd vdd vss vss gf180mcu_fd_sc_mcu7t5v0__dffq_2
XTAP_598 vdd vss gf180mcu_fd_sc_mcu7t5v0__filltie
XTAP_587 vdd vss gf180mcu_fd_sc_mcu7t5v0__filltie
X_08732_ _09977_/Q _09073_/A2 _08734_/B _08733_/B vdd vdd vss vss
+ gf180mcu_fd_sc_mcu7t5v0__oai21_1
X_05944_ _08430_/B _05894_/I _05947_/A2 vdd vdd vss vss gf180mcu_fd_sc_mcu7t5v0__nor2_1
X_08663_ _08702_/A1 _08662_/Z _08663_/B _08664_/B vdd vdd vss vss
+ gf180mcu_fd_sc_mcu7t5v0__aoi21_1
X_05875_ _05733_/C _05875_/A2 _05877_/A3 vdd vdd vss vss gf180mcu_fd_sc_mcu7t5v0__nand2_1
X_04826_ _09596_/Q _07474_/A1 vdd vdd vss vss gf180mcu_fd_sc_mcu7t5v0__clkinv_2
XTAP_1709 vdd vss gf180mcu_fd_sc_mcu7t5v0__filltie
X_08594_ _09707_/Q _08599_/A2 _08594_/Z vdd vdd vss vss gf180mcu_fd_sc_mcu7t5v0__and2_1
X_07614_ _07396_/B _07614_/A2 _07614_/A3 _07614_/A4 _07615_/B vdd vdd
+ vss vss gf180mcu_fd_sc_mcu7t5v0__nand4_1
X_04757_ _09716_/Q _07611_/B vdd vdd vss vss gf180mcu_fd_sc_mcu7t5v0__inv_4
X_07545_ _09652_/Q _07543_/Z _07564_/B vdd vdd vss vss gf180mcu_fd_sc_mcu7t5v0__nand2_1
X_07476_ _09710_/Q _07475_/I _07482_/A3 vdd vdd vss vss gf180mcu_fd_sc_mcu7t5v0__nand2_1
X_06427_ _09713_/Q _09712_/Q _06608_/A2 _06562_/A2 _06464_/B vdd vdd vss
+ vss gf180mcu_fd_sc_mcu7t5v0__nand4_1
X_09215_ _09248_/A2 _09176_/B _09215_/B _09936_/D vdd vdd vss vss
+ gf180mcu_fd_sc_mcu7t5v0__aoi21_1
X_06358_ _06387_/B _09572_/Q _09603_/Q _06359_/B2 vdd vdd vss vss
+ gf180mcu_fd_sc_mcu7t5v0__oai21_2
X_09146_ _09944_/Q _09137_/Z _09170_/B1 _09918_/Q _09146_/C _09147_/A2 vdd vdd
+ vss vss gf180mcu_fd_sc_mcu7t5v0__aoi221_1
X_06289_ _06072_/C _06288_/Z _06301_/B vdd vdd vss vss gf180mcu_fd_sc_mcu7t5v0__nor2_1
X_05309_ _09401_/A1 _05317_/A2 _05317_/B1 vdd vdd vss vss gf180mcu_fd_sc_mcu7t5v0__nand2_2
X_09077_ _09077_/A1 _05217_/S _09077_/A3 _09077_/Z vdd vdd vss vss
+ gf180mcu_fd_sc_mcu7t5v0__or3_1
X_08028_ _09693_/Q _09626_/Q _08029_/B1 vdd vdd vss vss gf180mcu_fd_sc_mcu7t5v0__nor2_1
X_09979_ _09979_/D clk _09979_/Q vdd vdd vss vss gf180mcu_fd_sc_mcu7t5v0__dffq_1
X_05660_ _05974_/A1 _05660_/A2 _05698_/C vdd vdd vss vss gf180mcu_fd_sc_mcu7t5v0__nor2_4
X_05591_ _05591_/A1 _05591_/A2 _05603_/B1 vdd vdd vss vss gf180mcu_fd_sc_mcu7t5v0__nand2_1
X_07330_ _07658_/A1 _07330_/A2 _07653_/A1 vdd vdd vss vss gf180mcu_fd_sc_mcu7t5v0__nor2_2
X_09000_ _09408_/A1 _09001_/A2 _09001_/B1 _09000_/B2 _09849_/D vdd vdd
+ vss vss gf180mcu_fd_sc_mcu7t5v0__oai22_1
X_07261_ _09638_/Q _09637_/Q _09578_/Q _07262_/A2 vdd vdd vss vss
+ gf180mcu_fd_sc_mcu7t5v0__nor3_1
X_06212_ _06212_/A1 _06188_/Z _06212_/B _06246_/A1 vdd vdd vss vss
+ gf180mcu_fd_sc_mcu7t5v0__aoi21_1
X_07192_ _07192_/A1 _07192_/A2 _08670_/B _09631_/D vdd vdd vss vss
+ gf180mcu_fd_sc_mcu7t5v0__aoi21_1
X_06143_ _09575_/Q _06160_/A1 _06144_/A2 _06143_/Z vdd vdd vss vss
+ gf180mcu_fd_sc_mcu7t5v0__xor3_1
X_06074_ _06207_/A1 _06074_/A2 _06074_/B1 _06074_/B2 _08565_/C _06075_/B vdd
+ vdd vss vss gf180mcu_fd_sc_mcu7t5v0__aoi221_1
X_05025_ _09519_/Q _05367_/B2 vdd vdd vss vss gf180mcu_fd_sc_mcu7t5v0__clkinv_1
X_09902_ _09902_/D clk _09902_/Q vdd vdd vss vss gf180mcu_fd_sc_mcu7t5v0__dffq_1
XTAP_340 vdd vss gf180mcu_fd_sc_mcu7t5v0__filltie
XTAP_351 vdd vss gf180mcu_fd_sc_mcu7t5v0__filltie
X_09833_ _09833_/D clk _09833_/Q vdd vdd vss vss gf180mcu_fd_sc_mcu7t5v0__dffq_1
XTAP_362 vdd vss gf180mcu_fd_sc_mcu7t5v0__filltie
XTAP_373 vdd vss gf180mcu_fd_sc_mcu7t5v0__filltie
XTAP_384 vdd vss gf180mcu_fd_sc_mcu7t5v0__filltie
XTAP_395 vdd vss gf180mcu_fd_sc_mcu7t5v0__filltie
X_09764_ _09764_/D clk _09764_/Q vdd vdd vss vss gf180mcu_fd_sc_mcu7t5v0__dffq_2
X_06976_ _07302_/A1 _07300_/A1 _07260_/A2 vdd vdd vss vss gf180mcu_fd_sc_mcu7t5v0__nor2_1
X_09695_ _09695_/D clk _09695_/Q vdd vdd vss vss gf180mcu_fd_sc_mcu7t5v0__dffq_1
X_08715_ _08715_/A1 _09073_/A2 _08715_/B _09712_/D vdd vdd vss vss
+ gf180mcu_fd_sc_mcu7t5v0__aoi21_1
X_05927_ _05927_/A1 _05926_/B _05927_/Z vdd vdd vss vss gf180mcu_fd_sc_mcu7t5v0__xor2_1
X_05858_ _05856_/Z _05915_/A2 _05858_/Z vdd vdd vss vss gf180mcu_fd_sc_mcu7t5v0__and2_1
XPHY_13 vdd vss gf180mcu_fd_sc_mcu7t5v0__endcap
X_08646_ _08646_/I _08673_/A2 vdd vdd vss vss gf180mcu_fd_sc_mcu7t5v0__clkinv_1
XTAP_1506 vdd vss gf180mcu_fd_sc_mcu7t5v0__filltie
XPHY_46 vdd vss gf180mcu_fd_sc_mcu7t5v0__endcap
XPHY_24 vdd vss gf180mcu_fd_sc_mcu7t5v0__endcap
XPHY_35 vdd vss gf180mcu_fd_sc_mcu7t5v0__endcap
X_04809_ _09625_/Q _06971_/A1 vdd vdd vss vss gf180mcu_fd_sc_mcu7t5v0__inv_1
XTAP_1517 vdd vss gf180mcu_fd_sc_mcu7t5v0__filltie
XTAP_1528 vdd vss gf180mcu_fd_sc_mcu7t5v0__filltie
XTAP_1539 vdd vss gf180mcu_fd_sc_mcu7t5v0__filltie
XPHY_79 vdd vss gf180mcu_fd_sc_mcu7t5v0__endcap
XPHY_68 vdd vss gf180mcu_fd_sc_mcu7t5v0__endcap
XPHY_57 vdd vss gf180mcu_fd_sc_mcu7t5v0__endcap
X_08577_ _09722_/Q _09721_/Q _09686_/Q _08578_/B vdd vdd vss vss gf180mcu_fd_sc_mcu7t5v0__nand3_2
X_05789_ _05792_/A1 _05792_/A2 _05792_/B _05901_/A2 vdd vdd vss vss
+ gf180mcu_fd_sc_mcu7t5v0__oai21_4
X_07528_ _07529_/A1 _07635_/A1 _07528_/Z vdd vdd vss vss gf180mcu_fd_sc_mcu7t5v0__and2_1
X_07459_ _07459_/A1 _07459_/A2 _07461_/B1 vdd vdd vss vss gf180mcu_fd_sc_mcu7t5v0__nand2_1
X_09129_ _09939_/Q _09116_/I _09136_/A2 _09912_/Q _09130_/A2 vdd vdd vss
+ vss gf180mcu_fd_sc_mcu7t5v0__aoi22_1
X_06830_ _06830_/A1 _06762_/Z _06830_/A3 _06830_/B _06877_/A1 vdd vdd
+ vss vss gf180mcu_fd_sc_mcu7t5v0__oai31_1
X_06761_ _06786_/B _06761_/A2 _06762_/A2 vdd vdd vss vss gf180mcu_fd_sc_mcu7t5v0__nand2_1
X_05712_ _09710_/Q _05711_/I _05751_/A1 vdd vdd vss vss gf180mcu_fd_sc_mcu7t5v0__nand2_1
X_08500_ _09713_/Q _08430_/B _08631_/A2 _08501_/A4 _08522_/B vdd vdd vss
+ vss gf180mcu_fd_sc_mcu7t5v0__nor4_2
X_09480_ _09480_/D clk _09480_/Q vdd vdd vss vss gf180mcu_fd_sc_mcu7t5v0__dffq_1
X_06692_ _06692_/A1 _06690_/Z _06704_/A1 vdd vdd vss vss gf180mcu_fd_sc_mcu7t5v0__nor2_1
X_08431_ _09711_/Q _08688_/A2 _08431_/A3 _08431_/Z vdd vdd vss vss
+ gf180mcu_fd_sc_mcu7t5v0__xor3_1
X_05643_ _05639_/Z _05643_/A2 _05644_/A3 vdd vdd vss vss gf180mcu_fd_sc_mcu7t5v0__nand2_1
X_08362_ _08362_/A1 _08357_/Z _08362_/B _08362_/C _08363_/A2 vdd vdd vss
+ vss gf180mcu_fd_sc_mcu7t5v0__oai211_1
X_05574_ _05631_/B2 _05574_/A2 _05574_/B1 _08736_/A2 _05574_/C1 _09105_/A2 _05575_/A3
+ vdd vdd vss vss gf180mcu_fd_sc_mcu7t5v0__aoi222_2
X_08293_ _08294_/A1 _08294_/A2 _08336_/S vdd vdd vss vss gf180mcu_fd_sc_mcu7t5v0__nand2_1
X_07313_ _09659_/Q _07664_/A1 _07626_/A2 vdd vdd vss vss gf180mcu_fd_sc_mcu7t5v0__nor2_2
X_07244_ _07611_/B _07282_/A2 _07248_/A1 vdd vdd vss vss gf180mcu_fd_sc_mcu7t5v0__nand2_1
X_07175_ _07531_/A2 _07173_/Z _07175_/Z vdd vdd vss vss gf180mcu_fd_sc_mcu7t5v0__xor2_1
X_06126_ _09710_/Q _06125_/Z _06130_/A3 vdd vdd vss vss gf180mcu_fd_sc_mcu7t5v0__nand2_1
X_06057_ _09573_/Q _06056_/Z _06057_/Z vdd vdd vss vss gf180mcu_fd_sc_mcu7t5v0__or2_1
X_05008_ _09871_/Q _09028_/B2 vdd vdd vss vss gf180mcu_fd_sc_mcu7t5v0__clkinv_1
X_09816_ _09816_/D clk _09816_/Q vdd vdd vss vss gf180mcu_fd_sc_mcu7t5v0__dffq_1
X_06959_ _06959_/A1 _06945_/Z _06959_/B _06960_/A2 vdd vdd vss vss
+ gf180mcu_fd_sc_mcu7t5v0__oai21_1
X_09747_ _09747_/D clk _09747_/Q vdd vdd vss vss gf180mcu_fd_sc_mcu7t5v0__dffq_1
XTAP_2004 vdd vss gf180mcu_fd_sc_mcu7t5v0__filltie
XTAP_2015 vdd vss gf180mcu_fd_sc_mcu7t5v0__filltie
XTAP_2026 vdd vss gf180mcu_fd_sc_mcu7t5v0__filltie
X_09678_ _09678_/D clk _09678_/Q vdd vdd vss vss gf180mcu_fd_sc_mcu7t5v0__dffq_4
XTAP_1303 vdd vss gf180mcu_fd_sc_mcu7t5v0__filltie
XTAP_1314 vdd vss gf180mcu_fd_sc_mcu7t5v0__filltie
X_08629_ _08630_/A2 _08630_/A3 _08629_/Z vdd vdd vss vss gf180mcu_fd_sc_mcu7t5v0__and2_1
XTAP_1325 vdd vss gf180mcu_fd_sc_mcu7t5v0__filltie
XTAP_1336 vdd vss gf180mcu_fd_sc_mcu7t5v0__filltie
XTAP_1347 vdd vss gf180mcu_fd_sc_mcu7t5v0__filltie
XTAP_1369 vdd vss gf180mcu_fd_sc_mcu7t5v0__filltie
XTAP_1358 vdd vss gf180mcu_fd_sc_mcu7t5v0__filltie
XTAP_1870 vdd vss gf180mcu_fd_sc_mcu7t5v0__filltie
XTAP_1892 vdd vss gf180mcu_fd_sc_mcu7t5v0__filltie
XTAP_1881 vdd vss gf180mcu_fd_sc_mcu7t5v0__filltie
X_05290_ _09403_/A1 _05296_/A2 _05296_/B1 _05290_/B2 _09443_/D vdd vdd
+ vss vss gf180mcu_fd_sc_mcu7t5v0__oai22_1
X_08980_ _09408_/A1 _08981_/A2 _08981_/B1 _08980_/B2 _09833_/D vdd vdd
+ vss vss gf180mcu_fd_sc_mcu7t5v0__oai22_1
X_07931_ _07979_/A1 _07979_/A2 _07931_/Z vdd vdd vss vss gf180mcu_fd_sc_mcu7t5v0__xor2_1
X_07862_ _07862_/A1 _07846_/Z _07862_/B1 _07862_/B2 _07862_/C _07863_/A2 vdd
+ vdd vss vss gf180mcu_fd_sc_mcu7t5v0__oai221_1
X_06813_ _06792_/Z _06813_/A2 _06813_/Z vdd vdd vss vss gf180mcu_fd_sc_mcu7t5v0__xor2_1
X_09601_ _09601_/D clk _09601_/Q vdd vdd vss vss gf180mcu_fd_sc_mcu7t5v0__dffq_2
X_07793_ _07870_/A1 _07793_/A2 _07794_/A3 _07870_/A2 vdd vdd vss vss
+ gf180mcu_fd_sc_mcu7t5v0__nor3_1
X_09532_ _09532_/D clk _09532_/Q vdd vdd vss vss gf180mcu_fd_sc_mcu7t5v0__dffq_1
X_06744_ _09616_/Q _08565_/C _06784_/A1 vdd vdd vss vss gf180mcu_fd_sc_mcu7t5v0__nand2_1
X_06675_ _06967_/A1 _06675_/A2 _06956_/A2 vdd vdd vss vss gf180mcu_fd_sc_mcu7t5v0__nor2_2
X_09463_ _09463_/D clk _09463_/Q vdd vdd vss vss gf180mcu_fd_sc_mcu7t5v0__dffq_1
X_05626_ _05626_/A1 _05626_/A2 _05631_/B1 vdd vdd vss vss gf180mcu_fd_sc_mcu7t5v0__nand2_1
X_08414_ _09710_/Q _08685_/A2 _08414_/B _08476_/C _08418_/C vdd vdd vss
+ vss gf180mcu_fd_sc_mcu7t5v0__oai211_1
X_09394_ _10016_/Q _09399_/A2 _09395_/B vdd vdd vss vss gf180mcu_fd_sc_mcu7t5v0__nor2_1
X_05557_ _09495_/Q _05627_/A2 _05627_/B1 _09511_/Q _05559_/A1 vdd vdd
+ vss vss gf180mcu_fd_sc_mcu7t5v0__aoi22_1
X_08345_ _08345_/A1 _08345_/A2 _08344_/Z _08345_/Z vdd vdd vss vss
+ gf180mcu_fd_sc_mcu7t5v0__xor3_1
X_08276_ _09716_/Q _08030_/Z _08299_/A1 vdd vdd vss vss gf180mcu_fd_sc_mcu7t5v0__nand2_1
X_05488_ _05488_/A1 _05488_/A2 _05488_/A3 _05489_/A2 vdd vdd vss vss
+ gf180mcu_fd_sc_mcu7t5v0__nand3_1
X_07227_ _07227_/A1 _07225_/Z _07254_/A2 vdd vdd vss vss gf180mcu_fd_sc_mcu7t5v0__nor2_1
X_07158_ _07159_/A1 _07159_/A2 _07201_/A2 vdd vdd vss vss gf180mcu_fd_sc_mcu7t5v0__nor2_1
X_06109_ _09713_/Q _06085_/Z _06113_/B2 vdd vdd vss vss gf180mcu_fd_sc_mcu7t5v0__nor2_1
X_07089_ _09713_/Q _07065_/Z _07208_/A1 vdd vdd vss vss gf180mcu_fd_sc_mcu7t5v0__nand2_1
XTAP_1100 vdd vss gf180mcu_fd_sc_mcu7t5v0__filltie
XTAP_1111 vdd vss gf180mcu_fd_sc_mcu7t5v0__filltie
XTAP_1122 vdd vss gf180mcu_fd_sc_mcu7t5v0__filltie
XTAP_1133 vdd vss gf180mcu_fd_sc_mcu7t5v0__filltie
XTAP_1155 vdd vss gf180mcu_fd_sc_mcu7t5v0__filltie
XTAP_1144 vdd vss gf180mcu_fd_sc_mcu7t5v0__filltie
XTAP_1166 vdd vss gf180mcu_fd_sc_mcu7t5v0__filltie
XTAP_1177 vdd vss gf180mcu_fd_sc_mcu7t5v0__filltie
XTAP_1188 vdd vss gf180mcu_fd_sc_mcu7t5v0__filltie
XTAP_1199 vdd vss gf180mcu_fd_sc_mcu7t5v0__filltie
XTAP_906 vdd vss gf180mcu_fd_sc_mcu7t5v0__filltie
XTAP_917 vdd vss gf180mcu_fd_sc_mcu7t5v0__filltie
XTAP_939 vdd vss gf180mcu_fd_sc_mcu7t5v0__filltie
XTAP_928 vdd vss gf180mcu_fd_sc_mcu7t5v0__filltie
X_04790_ _09655_/Q _07658_/A1 vdd vdd vss vss gf180mcu_fd_sc_mcu7t5v0__inv_3
X_06460_ _09711_/Q _06555_/A2 _06460_/Z vdd vdd vss vss gf180mcu_fd_sc_mcu7t5v0__and2_1
X_05411_ _09442_/Q _05628_/A2 _05628_/B1 _09426_/Q _05412_/A2 vdd vdd
+ vss vss gf180mcu_fd_sc_mcu7t5v0__aoi22_1
X_06391_ _09712_/Q _06608_/A2 _06394_/A3 vdd vdd vss vss gf180mcu_fd_sc_mcu7t5v0__nand2_1
X_08130_ _09713_/Q _08030_/Z _08061_/Z _09712_/Q _08144_/A2 vdd vdd vss
+ vss gf180mcu_fd_sc_mcu7t5v0__aoi22_1
X_05342_ _09402_/A1 _05349_/A2 _05349_/B1 _05342_/B2 _09498_/D vdd vdd
+ vss vss gf180mcu_fd_sc_mcu7t5v0__oai22_1
X_08061_ _08074_/A2 _08074_/A3 _08061_/Z vdd vdd vss vss gf180mcu_fd_sc_mcu7t5v0__and2_2
X_05273_ _09408_/A1 _05274_/A2 _05274_/B1 _05273_/B2 _09432_/D vdd vdd
+ vss vss gf180mcu_fd_sc_mcu7t5v0__oai22_1
X_07012_ _09711_/Q _07000_/Z _07032_/A1 vdd vdd vss vss gf180mcu_fd_sc_mcu7t5v0__nand2_1
X_08963_ _08961_/Z _08963_/A2 _09823_/D vdd vdd vss vss gf180mcu_fd_sc_mcu7t5v0__nor2_1
X_07914_ _07914_/A1 _07914_/A2 _07914_/B _07967_/A2 vdd vdd vss vss
+ gf180mcu_fd_sc_mcu7t5v0__aoi21_1
X_08894_ _08899_/A2 _08894_/A2 _08895_/B vdd vdd vss vss gf180mcu_fd_sc_mcu7t5v0__nand2_1
X_07845_ _07755_/I _07796_/Z _07845_/B _07848_/A3 vdd vdd vss vss
+ gf180mcu_fd_sc_mcu7t5v0__aoi21_2
X_07776_ _09671_/Q _08565_/C _07818_/A1 vdd vdd vss vss gf180mcu_fd_sc_mcu7t5v0__nand2_1
X_04988_ _09438_/Q _05283_/B2 vdd vdd vss vss gf180mcu_fd_sc_mcu7t5v0__clkinv_1
X_09515_ _09515_/D clk _09515_/Q vdd vdd vss vss gf180mcu_fd_sc_mcu7t5v0__dffq_1
X_06727_ _06732_/A1 _06732_/A2 _06733_/A1 vdd vdd vss vss gf180mcu_fd_sc_mcu7t5v0__nand2_1
XPHY_216 vdd vss gf180mcu_fd_sc_mcu7t5v0__endcap
X_09446_ _09446_/D clk _09446_/Q vdd vdd vss vss gf180mcu_fd_sc_mcu7t5v0__dffq_1
XPHY_205 vdd vss gf180mcu_fd_sc_mcu7t5v0__endcap
XPHY_249 vdd vss gf180mcu_fd_sc_mcu7t5v0__endcap
XPHY_238 vdd vss gf180mcu_fd_sc_mcu7t5v0__endcap
XPHY_227 vdd vss gf180mcu_fd_sc_mcu7t5v0__endcap
X_06658_ _06658_/I _06811_/A1 vdd vdd vss vss gf180mcu_fd_sc_mcu7t5v0__clkinv_3
X_06589_ _09716_/Q _06626_/A2 _06591_/A2 vdd vdd vss vss gf180mcu_fd_sc_mcu7t5v0__nand2_1
X_05609_ _09533_/Q _05627_/A2 _05627_/B1 _09541_/Q _05611_/A1 vdd vdd
+ vss vss gf180mcu_fd_sc_mcu7t5v0__aoi22_1
X_09377_ _09399_/A1 _09377_/A2 _09377_/B _09399_/C _10008_/D vdd vdd vss
+ vss gf180mcu_fd_sc_mcu7t5v0__aoi211_1
X_08328_ _08328_/A1 _08328_/A2 _08347_/A2 vdd vdd vss vss gf180mcu_fd_sc_mcu7t5v0__nand2_1
X_08259_ _09715_/Q _08260_/A2 _08311_/B vdd vdd vss vss gf180mcu_fd_sc_mcu7t5v0__and2_1
XTAP_714 vdd vss gf180mcu_fd_sc_mcu7t5v0__filltie
XTAP_725 vdd vss gf180mcu_fd_sc_mcu7t5v0__filltie
XTAP_703 vdd vss gf180mcu_fd_sc_mcu7t5v0__filltie
XTAP_758 vdd vss gf180mcu_fd_sc_mcu7t5v0__filltie
XTAP_747 vdd vss gf180mcu_fd_sc_mcu7t5v0__filltie
XTAP_736 vdd vss gf180mcu_fd_sc_mcu7t5v0__filltie
XTAP_769 vdd vss gf180mcu_fd_sc_mcu7t5v0__filltie
X_05960_ _09717_/Q _05945_/Z _05964_/B1 vdd vdd vss vss gf180mcu_fd_sc_mcu7t5v0__nand2_1
X_04911_ _09901_/Q _09108_/B2 vdd vdd vss vss gf180mcu_fd_sc_mcu7t5v0__clkinv_1
X_05891_ _06548_/A3 _09569_/Q _05893_/A2 vdd vdd vss vss gf180mcu_fd_sc_mcu7t5v0__nor2_1
X_04842_ _09564_/Q _05918_/A1 vdd vdd vss vss gf180mcu_fd_sc_mcu7t5v0__clkinv_1
X_07630_ _07634_/A3 _07630_/A2 _07630_/Z vdd vdd vss vss gf180mcu_fd_sc_mcu7t5v0__xor2_1
X_04773_ _09690_/Q _08369_/A1 vdd vdd vss vss gf180mcu_fd_sc_mcu7t5v0__inv_2
X_07561_ _09652_/Q _08565_/C _07561_/B1 _07561_/B2 _07562_/A2 vdd vdd
+ vss vss gf180mcu_fd_sc_mcu7t5v0__aoi22_1
X_06512_ _09715_/Q _06608_/A2 _06614_/A1 vdd vdd vss vss gf180mcu_fd_sc_mcu7t5v0__nand2_1
X_09300_ _09300_/A1 _09389_/A2 _09310_/A2 vdd vdd vss vss gf180mcu_fd_sc_mcu7t5v0__nor2_4
X_07492_ _07390_/I _07437_/Z _07492_/B _07495_/A3 vdd vdd vss vss
+ gf180mcu_fd_sc_mcu7t5v0__aoi21_2
X_06443_ _07452_/C _06440_/Z _06444_/B vdd vdd vss vss gf180mcu_fd_sc_mcu7t5v0__xor2_1
X_09231_ _09944_/Q _09244_/A2 _09257_/B _09232_/B vdd vdd vss vss
+ gf180mcu_fd_sc_mcu7t5v0__oai21_1
X_06374_ _09711_/Q _06608_/A2 _06422_/A1 vdd vdd vss vss gf180mcu_fd_sc_mcu7t5v0__nand2_1
X_09162_ _09948_/Q _09137_/Z _09170_/B1 _09922_/Q _09162_/C _09163_/A2 vdd vdd
+ vss vss gf180mcu_fd_sc_mcu7t5v0__aoi221_1
X_05325_ _09405_/A1 _05329_/A2 _05329_/B1 _05325_/B2 _09485_/D vdd vdd
+ vss vss gf180mcu_fd_sc_mcu7t5v0__oai22_1
X_08113_ _08114_/A1 _08112_/Z _08159_/A2 vdd vdd vss vss gf180mcu_fd_sc_mcu7t5v0__nand2_1
X_09093_ _09894_/Q _09098_/A1 _09278_/C _09094_/B vdd vdd vss vss
+ gf180mcu_fd_sc_mcu7t5v0__oai21_1
X_05256_ _09405_/A1 _05260_/A2 _05260_/B1 _05256_/B2 _09421_/D vdd vdd
+ vss vss gf180mcu_fd_sc_mcu7t5v0__oai22_1
X_08044_ _09691_/Q _08044_/A2 _08359_/B vdd vdd vss vss gf180mcu_fd_sc_mcu7t5v0__nor2_2
X_05187_ _09259_/B _09466_/Q _05188_/A2 vdd vdd vss vss gf180mcu_fd_sc_mcu7t5v0__nand2_1
X_09995_ _09995_/D clk _09995_/Q vdd vdd vss vss gf180mcu_fd_sc_mcu7t5v0__dffq_1
X_08946_ _09818_/Q _08944_/Z _08946_/Z vdd vdd vss vss gf180mcu_fd_sc_mcu7t5v0__and2_1
X_08877_ _09787_/Q _08899_/A2 _09226_/B _08878_/B vdd vdd vss vss
+ gf180mcu_fd_sc_mcu7t5v0__oai21_1
X_07828_ _09679_/Q _07828_/A2 _07828_/B _07882_/A3 vdd vdd vss vss
+ gf180mcu_fd_sc_mcu7t5v0__oai21_2
X_07759_ _09670_/Q _07740_/Z _07756_/Z _07759_/Z vdd vdd vss vss gf180mcu_fd_sc_mcu7t5v0__xor3_1
X_09429_ _09429_/D clk _09429_/Q vdd vdd vss vss gf180mcu_fd_sc_mcu7t5v0__dffq_1
X_05110_ _09916_/Q _09378_/A1 _09299_/A3 _09077_/A1 vdd vdd vss vss
+ gf180mcu_fd_sc_mcu7t5v0__nand3_1
X_06090_ _06090_/A1 _06129_/A1 _06091_/I vdd vdd vss vss gf180mcu_fd_sc_mcu7t5v0__xnor2_1
X_05041_ _09799_/Q _08911_/B2 vdd vdd vss vss gf180mcu_fd_sc_mcu7t5v0__clkinv_1
XTAP_500 vdd vss gf180mcu_fd_sc_mcu7t5v0__filltie
XTAP_511 vdd vss gf180mcu_fd_sc_mcu7t5v0__filltie
XTAP_522 vdd vss gf180mcu_fd_sc_mcu7t5v0__filltie
XTAP_533 vdd vss gf180mcu_fd_sc_mcu7t5v0__filltie
X_08800_ _08801_/A1 _08812_/A2 _08802_/A2 vdd vdd vss vss gf180mcu_fd_sc_mcu7t5v0__nor2_1
XTAP_566 vdd vss gf180mcu_fd_sc_mcu7t5v0__filltie
XTAP_555 vdd vss gf180mcu_fd_sc_mcu7t5v0__filltie
XTAP_544 vdd vss gf180mcu_fd_sc_mcu7t5v0__filltie
X_06992_ _07286_/I1 _07284_/B _06995_/A2 vdd vdd vss vss gf180mcu_fd_sc_mcu7t5v0__nor2_1
X_09780_ _09780_/D clk _09780_/Q vdd vdd vss vss gf180mcu_fd_sc_mcu7t5v0__dffq_1
XTAP_599 vdd vss gf180mcu_fd_sc_mcu7t5v0__filltie
XTAP_577 vdd vss gf180mcu_fd_sc_mcu7t5v0__filltie
XTAP_588 vdd vss gf180mcu_fd_sc_mcu7t5v0__filltie
X_08731_ _08731_/A1 _09073_/A2 _08731_/B _09720_/D vdd vdd vss vss
+ gf180mcu_fd_sc_mcu7t5v0__aoi21_1
X_05943_ _07506_/B _05943_/A2 _05948_/A2 vdd vdd vss vss gf180mcu_fd_sc_mcu7t5v0__nor2_1
X_08662_ _09716_/Q _08662_/A2 _08662_/Z vdd vdd vss vss gf180mcu_fd_sc_mcu7t5v0__xor2_1
X_07613_ _07651_/B _07613_/A2 _07613_/A3 _07644_/A2 _09716_/Q _07614_/A4 vdd
+ vdd vss vss gf180mcu_fd_sc_mcu7t5v0__oai32_1
X_05874_ _09715_/Q _05836_/Z _05874_/B _05875_/A2 vdd vdd vss vss
+ gf180mcu_fd_sc_mcu7t5v0__oai21_1
X_08593_ _08593_/A1 _08592_/Z _08599_/A2 vdd vdd vss vss gf180mcu_fd_sc_mcu7t5v0__xnor2_1
X_04825_ _09598_/Q _06579_/A1 vdd vdd vss vss gf180mcu_fd_sc_mcu7t5v0__inv_1
X_04756_ _09717_/Q _06623_/B vdd vdd vss vss gf180mcu_fd_sc_mcu7t5v0__clkinv_3
X_07544_ _09652_/Q _07543_/Z _07564_/A2 vdd vdd vss vss gf180mcu_fd_sc_mcu7t5v0__nor2_1
X_07475_ _07475_/I _07548_/A1 vdd vdd vss vss gf180mcu_fd_sc_mcu7t5v0__clkinv_1
X_06426_ _09713_/Q _09712_/Q _06608_/A2 _06562_/A2 _06426_/Z vdd vdd vss
+ vss gf180mcu_fd_sc_mcu7t5v0__and4_1
X_09214_ _09936_/Q _09176_/B _09226_/B _09215_/B vdd vdd vss vss gf180mcu_fd_sc_mcu7t5v0__oai21_1
X_09145_ _09137_/Z _09145_/A2 _09146_/C vdd vdd vss vss gf180mcu_fd_sc_mcu7t5v0__nor2_1
X_06357_ _09884_/Q _06387_/B _06359_/B1 vdd vdd vss vss gf180mcu_fd_sc_mcu7t5v0__nand2_1
X_06288_ _09578_/Q _06288_/A2 _06287_/Z _06288_/Z vdd vdd vss vss
+ gf180mcu_fd_sc_mcu7t5v0__xor3_1
X_05308_ _09400_/A1 _05631_/C1 _05317_/A2 vdd vdd vss vss gf180mcu_fd_sc_mcu7t5v0__nand2_4
X_09076_ _08706_/B _09095_/A2 _09096_/B1 vdd vdd vss vss gf180mcu_fd_sc_mcu7t5v0__nor2_4
X_08027_ _08027_/A1 _09693_/Q _08180_/B _08088_/A2 vdd vdd vss vss
+ gf180mcu_fd_sc_mcu7t5v0__nand3_4
X_05239_ _09563_/Q _05217_/S _05239_/B _09407_/A1 vdd vdd vss vss
+ gf180mcu_fd_sc_mcu7t5v0__aoi21_4
X_09978_ _09978_/D clk _09978_/Q vdd vdd vss vss gf180mcu_fd_sc_mcu7t5v0__dffq_1
X_08929_ _08929_/A1 _09812_/Q _08929_/Z vdd vdd vss vss gf180mcu_fd_sc_mcu7t5v0__xor2_1
X_05590_ _09800_/Q _05628_/A2 _05628_/B1 _09906_/Q _05591_/A2 vdd vdd
+ vss vss gf180mcu_fd_sc_mcu7t5v0__aoi22_1
X_07260_ _09620_/Q _07260_/A2 _07260_/B1 _09688_/Q _07260_/C _07262_/A1 vdd
+ vdd vss vss gf180mcu_fd_sc_mcu7t5v0__aoi221_2
X_06211_ _06211_/A1 _06211_/A2 _06211_/B _06265_/A1 vdd vdd vss vss
+ gf180mcu_fd_sc_mcu7t5v0__oai21_1
X_07191_ _07289_/B _07176_/Z _07191_/B _08706_/B _07192_/A2 vdd vdd vss
+ vss gf180mcu_fd_sc_mcu7t5v0__oai211_1
X_06142_ _06141_/B _06142_/A2 _06142_/A3 _06160_/B vdd vdd vss vss
+ gf180mcu_fd_sc_mcu7t5v0__nor3_1
X_06073_ _06290_/A1 _06056_/Z _06073_/B1 _06296_/A1 _06073_/C _06074_/B2 vdd
+ vdd vss vss gf180mcu_fd_sc_mcu7t5v0__aoi221_1
X_05024_ _09539_/Q _05387_/B2 vdd vdd vss vss gf180mcu_fd_sc_mcu7t5v0__clkinv_1
X_09901_ _09901_/D clk _09901_/Q vdd vdd vss vss gf180mcu_fd_sc_mcu7t5v0__dffq_1
XTAP_341 vdd vss gf180mcu_fd_sc_mcu7t5v0__filltie
XTAP_330 vdd vss gf180mcu_fd_sc_mcu7t5v0__filltie
X_09832_ _09832_/D clk _09832_/Q vdd vdd vss vss gf180mcu_fd_sc_mcu7t5v0__dffq_1
XTAP_363 vdd vss gf180mcu_fd_sc_mcu7t5v0__filltie
XTAP_352 vdd vss gf180mcu_fd_sc_mcu7t5v0__filltie
XTAP_374 vdd vss gf180mcu_fd_sc_mcu7t5v0__filltie
XTAP_385 vdd vss gf180mcu_fd_sc_mcu7t5v0__filltie
X_09763_ _09763_/D clk _09763_/Q vdd vdd vss vss gf180mcu_fd_sc_mcu7t5v0__dffq_1
XTAP_396 vdd vss gf180mcu_fd_sc_mcu7t5v0__filltie
X_06975_ _09636_/Q _06986_/A2 _07289_/B vdd vdd vss vss gf180mcu_fd_sc_mcu7t5v0__nand2_4
X_08714_ _09877_/Q _09073_/A2 _09072_/B _08715_/B vdd vdd vss vss
+ gf180mcu_fd_sc_mcu7t5v0__oai21_1
X_09694_ _09694_/D clk _09694_/Q vdd vdd vss vss gf180mcu_fd_sc_mcu7t5v0__dffq_1
X_05926_ _05926_/A1 _05868_/Z _05926_/B _05958_/B vdd vdd vss vss
+ gf180mcu_fd_sc_mcu7t5v0__aoi21_1
X_05857_ _05802_/Z _05857_/A2 _05857_/B _05915_/A2 vdd vdd vss vss
+ gf180mcu_fd_sc_mcu7t5v0__oai21_1
X_08645_ _08645_/A1 _08643_/Z _08646_/I vdd vdd vss vss gf180mcu_fd_sc_mcu7t5v0__xor2_1
XPHY_47 vdd vss gf180mcu_fd_sc_mcu7t5v0__endcap
XPHY_14 vdd vss gf180mcu_fd_sc_mcu7t5v0__endcap
XPHY_25 vdd vss gf180mcu_fd_sc_mcu7t5v0__endcap
XPHY_36 vdd vss gf180mcu_fd_sc_mcu7t5v0__endcap
X_08576_ _09714_/Q _08688_/A2 _08582_/A2 vdd vdd vss vss gf180mcu_fd_sc_mcu7t5v0__nand2_1
X_04808_ _09626_/Q _07316_/A2 vdd vdd vss vss gf180mcu_fd_sc_mcu7t5v0__inv_1
XTAP_1518 vdd vss gf180mcu_fd_sc_mcu7t5v0__filltie
XTAP_1507 vdd vss gf180mcu_fd_sc_mcu7t5v0__filltie
XTAP_1529 vdd vss gf180mcu_fd_sc_mcu7t5v0__filltie
XPHY_69 vdd vss gf180mcu_fd_sc_mcu7t5v0__endcap
XPHY_58 vdd vss gf180mcu_fd_sc_mcu7t5v0__endcap
X_07527_ _07469_/Z _07527_/A2 _07527_/B _09712_/Q _07578_/A2 vdd vdd vss
+ vss gf180mcu_fd_sc_mcu7t5v0__oai211_2
X_05788_ _09067_/A1 _05978_/A1 _05976_/A1 _05792_/B vdd vdd vss vss
+ gf180mcu_fd_sc_mcu7t5v0__nand3_4
X_04739_ _09751_/Q _08778_/A1 vdd vdd vss vss gf180mcu_fd_sc_mcu7t5v0__clkinv_1
X_07458_ _07458_/A1 _07458_/A2 _07458_/B _07459_/A2 vdd vdd vss vss
+ gf180mcu_fd_sc_mcu7t5v0__aoi21_1
X_06409_ _09712_/Q _06603_/A2 _06510_/A1 vdd vdd vss vss gf180mcu_fd_sc_mcu7t5v0__nand2_2
X_07389_ _07365_/Z _07388_/Z _07390_/I vdd vdd vss vss gf180mcu_fd_sc_mcu7t5v0__nor2_2
X_09128_ _09399_/C _09128_/A2 _09911_/D vdd vdd vss vss gf180mcu_fd_sc_mcu7t5v0__nor2_1
X_09059_ _09059_/A1 _09073_/A2 _09059_/B _09883_/D vdd vdd vss vss
+ gf180mcu_fd_sc_mcu7t5v0__aoi21_1
X_06760_ _06760_/A1 _06760_/A2 _06760_/B _06761_/A2 vdd vdd vss vss
+ gf180mcu_fd_sc_mcu7t5v0__oai21_1
X_05711_ _05711_/I _05835_/A2 vdd vdd vss vss gf180mcu_fd_sc_mcu7t5v0__inv_1
X_06691_ _06692_/A1 _06690_/Z _06732_/A2 vdd vdd vss vss gf180mcu_fd_sc_mcu7t5v0__nand2_1
X_08430_ _08430_/A1 _08430_/A2 _08430_/B _08466_/B vdd vdd vss vss
+ gf180mcu_fd_sc_mcu7t5v0__aoi21_1
X_05642_ _06679_/A1 _09570_/Q _05976_/A1 _05644_/A2 vdd vdd vss vss
+ gf180mcu_fd_sc_mcu7t5v0__nor3_2
X_05573_ _09002_/A2 _05573_/A2 _05573_/B1 _05632_/C2 _05573_/C1 _05631_/C1 _05575_/A2
+ vdd vdd vss vss gf180mcu_fd_sc_mcu7t5v0__aoi222_1
X_08361_ _09717_/Q _08361_/A2 _08361_/B _08362_/B vdd vdd vss vss
+ gf180mcu_fd_sc_mcu7t5v0__oai21_1
X_08292_ _09711_/Q _08354_/A2 _08334_/A1 vdd vdd vss vss gf180mcu_fd_sc_mcu7t5v0__nand2_1
X_07312_ _09409_/A1 _07312_/A2 _07312_/B1 _07312_/B2 _09646_/D vdd vdd
+ vss vss gf180mcu_fd_sc_mcu7t5v0__oai22_1
X_07243_ _07243_/A1 _07241_/Z _07284_/B _07249_/A2 vdd vdd vss vss
+ gf180mcu_fd_sc_mcu7t5v0__oai21_1
X_07174_ _09631_/Q _07173_/Z _07194_/B vdd vdd vss vss gf180mcu_fd_sc_mcu7t5v0__nand2_1
X_06125_ _09887_/Q _09630_/Q _09596_/Q _09562_/Q _09582_/Q _09583_/Q _06125_/Z vdd
+ vdd vss vss gf180mcu_fd_sc_mcu7t5v0__mux4_4
X_06056_ _06056_/A1 _06056_/A2 _06056_/Z vdd vdd vss vss gf180mcu_fd_sc_mcu7t5v0__xor2_1
X_05007_ _09904_/Q _09111_/B2 vdd vdd vss vss gf180mcu_fd_sc_mcu7t5v0__clkinv_1
X_09815_ _09815_/D clk _09815_/Q vdd vdd vss vss gf180mcu_fd_sc_mcu7t5v0__dffq_1
X_06958_ _06958_/A1 _06954_/Z _06958_/B _06959_/B vdd vdd vss vss
+ gf180mcu_fd_sc_mcu7t5v0__aoi21_1
X_09746_ _09746_/D clk _09746_/Q vdd vdd vss vss gf180mcu_fd_sc_mcu7t5v0__dffq_1
XTAP_2005 vdd vss gf180mcu_fd_sc_mcu7t5v0__filltie
XTAP_2016 vdd vss gf180mcu_fd_sc_mcu7t5v0__filltie
X_05909_ _05939_/A1 _05909_/A2 _05906_/Z _05909_/Z vdd vdd vss vss
+ gf180mcu_fd_sc_mcu7t5v0__xor3_1
X_09677_ _09677_/D clk _09677_/Q vdd vdd vss vss gf180mcu_fd_sc_mcu7t5v0__dffq_2
XTAP_2027 vdd vss gf180mcu_fd_sc_mcu7t5v0__filltie
X_08628_ _09711_/Q _08689_/A2 _08630_/A3 vdd vdd vss vss gf180mcu_fd_sc_mcu7t5v0__nand2_1
X_06889_ _06889_/A1 _06889_/A2 _06939_/B2 _06889_/Z vdd vdd vss vss
+ gf180mcu_fd_sc_mcu7t5v0__xor3_1
XTAP_1304 vdd vss gf180mcu_fd_sc_mcu7t5v0__filltie
XTAP_1315 vdd vss gf180mcu_fd_sc_mcu7t5v0__filltie
XTAP_1326 vdd vss gf180mcu_fd_sc_mcu7t5v0__filltie
XTAP_1337 vdd vss gf180mcu_fd_sc_mcu7t5v0__filltie
XTAP_1348 vdd vss gf180mcu_fd_sc_mcu7t5v0__filltie
X_08559_ _09719_/Q _09718_/Q _08699_/A2 _08626_/A2 _08560_/A2 vdd vdd
+ vss vss gf180mcu_fd_sc_mcu7t5v0__aoi22_1
XTAP_1359 vdd vss gf180mcu_fd_sc_mcu7t5v0__filltie
XTAP_1860 vdd vss gf180mcu_fd_sc_mcu7t5v0__filltie
XTAP_1893 vdd vss gf180mcu_fd_sc_mcu7t5v0__filltie
XTAP_1882 vdd vss gf180mcu_fd_sc_mcu7t5v0__filltie
XTAP_1871 vdd vss gf180mcu_fd_sc_mcu7t5v0__filltie
X_07930_ _07930_/A1 _07930_/A2 _07930_/B _07979_/A2 vdd vdd vss vss
+ gf180mcu_fd_sc_mcu7t5v0__aoi21_1
X_07861_ _09714_/Q _07830_/I _07861_/B _07862_/C vdd vdd vss vss gf180mcu_fd_sc_mcu7t5v0__oai21_1
X_09600_ _09600_/D clk _09600_/Q vdd vdd vss vss gf180mcu_fd_sc_mcu7t5v0__dffq_2
X_07792_ _07792_/A1 _07834_/A1 _07794_/A3 vdd vdd vss vss gf180mcu_fd_sc_mcu7t5v0__xnor2_1
X_06812_ _06910_/B _06910_/A2 _06813_/A2 vdd vdd vss vss gf180mcu_fd_sc_mcu7t5v0__nand2_1
X_09531_ _09531_/D clk _09531_/Q vdd vdd vss vss gf180mcu_fd_sc_mcu7t5v0__dffq_1
X_06743_ _08670_/B _06743_/A2 _09615_/D vdd vdd vss vss gf180mcu_fd_sc_mcu7t5v0__nor2_1
X_06674_ _06672_/C _06669_/I _06674_/B _06676_/B vdd vdd vss vss gf180mcu_fd_sc_mcu7t5v0__oai21_1
X_09462_ _09462_/D clk _09462_/Q vdd vdd vss vss gf180mcu_fd_sc_mcu7t5v0__dffq_1
X_05625_ _09449_/Q _05628_/A2 _05628_/B1 _09433_/Q _05626_/A2 vdd vdd
+ vss vss gf180mcu_fd_sc_mcu7t5v0__aoi22_1
X_08413_ _09720_/Q _09719_/Q _08727_/A1 _08476_/C vdd vdd vss vss
+ gf180mcu_fd_sc_mcu7t5v0__nand3_4
X_09393_ _09393_/A1 _09399_/A2 _09393_/B _09399_/C _10015_/D vdd vdd vss
+ vss gf180mcu_fd_sc_mcu7t5v0__aoi211_1
X_05556_ _05556_/A1 _05556_/A2 _05573_/A2 vdd vdd vss vss gf180mcu_fd_sc_mcu7t5v0__nand2_1
X_08344_ _08344_/A1 _08344_/A2 _08344_/Z vdd vdd vss vss gf180mcu_fd_sc_mcu7t5v0__xor2_1
X_08275_ _08275_/A1 _08275_/A2 _08275_/B _08327_/A1 vdd vdd vss vss
+ gf180mcu_fd_sc_mcu7t5v0__aoi21_1
X_05487_ _09105_/A2 _05487_/A2 _05487_/B1 _09400_/A2 _05487_/C1 _05631_/B2 _05488_/A3
+ vdd vdd vss vss gf180mcu_fd_sc_mcu7t5v0__aoi222_2
X_07226_ _07227_/A1 _07225_/Z _07254_/B vdd vdd vss vss gf180mcu_fd_sc_mcu7t5v0__nand2_1
X_07157_ _07157_/A1 _07269_/A1 _07159_/A2 vdd vdd vss vss gf180mcu_fd_sc_mcu7t5v0__xnor2_1
X_06108_ _06296_/A1 _06150_/A2 _06107_/Z _06114_/B vdd vdd vss vss
+ gf180mcu_fd_sc_mcu7t5v0__and3_1
X_07088_ _09713_/Q _07065_/Z _07092_/B2 vdd vdd vss vss gf180mcu_fd_sc_mcu7t5v0__nor2_1
X_06039_ _06039_/A1 _06039_/A2 _06040_/A2 vdd vdd vss vss gf180mcu_fd_sc_mcu7t5v0__xnor2_1
X_09729_ _09729_/D clk _09729_/Q vdd vdd vss vss gf180mcu_fd_sc_mcu7t5v0__dffq_1
XTAP_1101 vdd vss gf180mcu_fd_sc_mcu7t5v0__filltie
XTAP_1112 vdd vss gf180mcu_fd_sc_mcu7t5v0__filltie
XTAP_1123 vdd vss gf180mcu_fd_sc_mcu7t5v0__filltie
XTAP_1134 vdd vss gf180mcu_fd_sc_mcu7t5v0__filltie
XTAP_1156 vdd vss gf180mcu_fd_sc_mcu7t5v0__filltie
XTAP_1145 vdd vss gf180mcu_fd_sc_mcu7t5v0__filltie
XTAP_1167 vdd vss gf180mcu_fd_sc_mcu7t5v0__filltie
XTAP_1178 vdd vss gf180mcu_fd_sc_mcu7t5v0__filltie
XTAP_1189 vdd vss gf180mcu_fd_sc_mcu7t5v0__filltie
XTAP_907 vdd vss gf180mcu_fd_sc_mcu7t5v0__filltie
XTAP_918 vdd vss gf180mcu_fd_sc_mcu7t5v0__filltie
XTAP_929 vdd vss gf180mcu_fd_sc_mcu7t5v0__filltie
X_05410_ _09450_/Q _05627_/A2 _05627_/B1 _09434_/Q _05412_/A1 vdd vdd
+ vss vss gf180mcu_fd_sc_mcu7t5v0__aoi22_1
X_06390_ _09710_/Q _06603_/A2 _06422_/B2 vdd vdd vss vss gf180mcu_fd_sc_mcu7t5v0__nand2_1
XTAP_1690 vdd vss gf180mcu_fd_sc_mcu7t5v0__filltie
X_05341_ _09401_/A1 _05349_/A2 _05349_/B1 vdd vdd vss vss gf180mcu_fd_sc_mcu7t5v0__nand2_2
X_05272_ _09407_/A1 _05274_/A2 _05274_/B1 _05272_/B2 _09431_/D vdd vdd
+ vss vss gf180mcu_fd_sc_mcu7t5v0__oai22_1
X_08060_ _08375_/A1 _08060_/A2 _08060_/B1 _09692_/Q _08074_/A3 vdd vdd
+ vss vss gf180mcu_fd_sc_mcu7t5v0__oai22_4
X_07011_ _09711_/Q _07000_/Z _07011_/Z vdd vdd vss vss gf180mcu_fd_sc_mcu7t5v0__and2_1
X_08962_ _09823_/Q _08958_/Z _08968_/B _08963_/A2 vdd vdd vss vss
+ gf180mcu_fd_sc_mcu7t5v0__oai21_1
X_07913_ _07913_/I _07914_/B vdd vdd vss vss gf180mcu_fd_sc_mcu7t5v0__clkinv_1
X_08893_ _09791_/Q _08899_/A2 _09226_/B _08896_/A1 vdd vdd vss vss
+ gf180mcu_fd_sc_mcu7t5v0__oai21_1
X_07844_ _07869_/B2 _07869_/B3 _07843_/Z _07848_/A2 vdd vdd vss vss
+ gf180mcu_fd_sc_mcu7t5v0__nor3_2
X_07775_ _07775_/A1 _07775_/A2 _08670_/B _09670_/D vdd vdd vss vss
+ gf180mcu_fd_sc_mcu7t5v0__aoi21_1
X_04987_ _09430_/Q _05271_/B2 vdd vdd vss vss gf180mcu_fd_sc_mcu7t5v0__clkinv_1
X_09514_ _09514_/D clk _09514_/Q vdd vdd vss vss gf180mcu_fd_sc_mcu7t5v0__dffq_1
X_06726_ _09615_/Q _06713_/Z _06740_/A2 _06726_/Z vdd vdd vss vss
+ gf180mcu_fd_sc_mcu7t5v0__xor3_1
X_09445_ _09445_/D clk _09445_/Q vdd vdd vss vss gf180mcu_fd_sc_mcu7t5v0__dffq_1
X_06657_ _09558_/Q _09626_/Q _09668_/Q _09875_/Q _09625_/Q _09624_/Q _06658_/I vdd
+ vdd vss vss gf180mcu_fd_sc_mcu7t5v0__mux4_4
XPHY_206 vdd vss gf180mcu_fd_sc_mcu7t5v0__endcap
XPHY_239 vdd vss gf180mcu_fd_sc_mcu7t5v0__endcap
XPHY_228 vdd vss gf180mcu_fd_sc_mcu7t5v0__endcap
XPHY_217 vdd vss gf180mcu_fd_sc_mcu7t5v0__endcap
X_05608_ _05608_/A1 _05608_/A2 _05630_/A2 vdd vdd vss vss gf180mcu_fd_sc_mcu7t5v0__nand2_1
X_06588_ _06367_/B _06587_/Z _06593_/A3 vdd vdd vss vss gf180mcu_fd_sc_mcu7t5v0__nand2_1
X_09376_ _10008_/Q _09377_/A2 _09377_/B vdd vdd vss vss gf180mcu_fd_sc_mcu7t5v0__nor2_1
X_08327_ _08327_/A1 _08327_/A2 _08327_/B _08347_/A1 vdd vdd vss vss
+ gf180mcu_fd_sc_mcu7t5v0__oai21_1
X_05539_ _09831_/Q _05628_/A2 _05628_/B1 _10023_/Q _05540_/A2 vdd vdd
+ vss vss gf180mcu_fd_sc_mcu7t5v0__aoi22_1
X_08258_ _08335_/A2 _08312_/B _08260_/A2 vdd vdd vss vss gf180mcu_fd_sc_mcu7t5v0__xnor2_1
X_07209_ _09711_/Q _07160_/Z _07222_/A2 vdd vdd vss vss gf180mcu_fd_sc_mcu7t5v0__nand2_1
X_08189_ _08229_/A1 _08229_/A2 _08189_/A3 _08189_/Z vdd vdd vss vss
+ gf180mcu_fd_sc_mcu7t5v0__or3_1
XTAP_715 vdd vss gf180mcu_fd_sc_mcu7t5v0__filltie
XTAP_704 vdd vss gf180mcu_fd_sc_mcu7t5v0__filltie
XTAP_759 vdd vss gf180mcu_fd_sc_mcu7t5v0__filltie
XTAP_748 vdd vss gf180mcu_fd_sc_mcu7t5v0__filltie
XTAP_737 vdd vss gf180mcu_fd_sc_mcu7t5v0__filltie
XTAP_726 vdd vss gf180mcu_fd_sc_mcu7t5v0__filltie
X_04910_ _09852_/Q _09005_/B2 vdd vdd vss vss gf180mcu_fd_sc_mcu7t5v0__clkinv_1
X_05890_ _09881_/Q _09570_/Q _09569_/Q _05890_/Z vdd vdd vss vss gf180mcu_fd_sc_mcu7t5v0__and3_1
X_04841_ _09565_/Q _05968_/A1 vdd vdd vss vss gf180mcu_fd_sc_mcu7t5v0__clkinv_1
X_04772_ _09691_/Q _08371_/A1 vdd vdd vss vss gf180mcu_fd_sc_mcu7t5v0__clkinv_3
X_07560_ _07341_/B _07546_/Z _08565_/C _07561_/B2 vdd vdd vss vss
+ gf180mcu_fd_sc_mcu7t5v0__aoi21_1
X_06511_ _09713_/Q _06603_/A2 _06559_/B2 vdd vdd vss vss gf180mcu_fd_sc_mcu7t5v0__nand2_1
X_09230_ _09246_/A2 _09244_/A2 _09230_/B _09943_/D vdd vdd vss vss
+ gf180mcu_fd_sc_mcu7t5v0__aoi21_1
X_07491_ _07515_/B2 _07515_/B3 _07490_/Z _07495_/A2 vdd vdd vss vss
+ gf180mcu_fd_sc_mcu7t5v0__nor3_2
X_06442_ _06442_/I _06487_/A1 vdd vdd vss vss gf180mcu_fd_sc_mcu7t5v0__clkinv_1
X_06373_ _09711_/Q _06608_/A2 _06373_/Z vdd vdd vss vss gf180mcu_fd_sc_mcu7t5v0__and2_1
X_09161_ _09137_/Z _09161_/A2 _09162_/C vdd vdd vss vss gf180mcu_fd_sc_mcu7t5v0__nor2_1
X_05324_ _09404_/A1 _05329_/A2 _05329_/B1 _05324_/B2 _09484_/D vdd vdd
+ vss vss gf180mcu_fd_sc_mcu7t5v0__oai22_1
X_08112_ _09712_/Q _08110_/Z _08112_/Z vdd vdd vss vss gf180mcu_fd_sc_mcu7t5v0__xor2_1
X_09092_ _09962_/Q _08706_/B _09096_/B1 _09972_/Q _09092_/C _09094_/A2 vdd vdd
+ vss vss gf180mcu_fd_sc_mcu7t5v0__aoi221_2
X_08043_ _08371_/A1 _08044_/A2 _08359_/A2 vdd vdd vss vss gf180mcu_fd_sc_mcu7t5v0__nor2_4
X_05255_ _09404_/A1 _05260_/A2 _05260_/B1 _05255_/B2 _09420_/D vdd vdd
+ vss vss gf180mcu_fd_sc_mcu7t5v0__oai22_1
X_05186_ _09259_/B _05186_/A2 _05186_/A3 _05186_/A4 _09458_/D vdd vdd
+ vss vss gf180mcu_fd_sc_mcu7t5v0__nand4_1
X_09994_ _09994_/D clk _09994_/Q vdd vdd vss vss gf180mcu_fd_sc_mcu7t5v0__dffq_1
X_08945_ _08927_/I _08945_/A2 _08944_/Z _09817_/D vdd vdd vss vss
+ gf180mcu_fd_sc_mcu7t5v0__nor3_1
X_08876_ _09788_/Q _09523_/Q _08876_/B _08878_/A2 vdd vdd vss vss
+ gf180mcu_fd_sc_mcu7t5v0__aoi21_1
X_07827_ _09879_/Q _09680_/Q _07828_/B vdd vdd vss vss gf180mcu_fd_sc_mcu7t5v0__nand2_1
X_07758_ _09670_/Q _07756_/Z _07777_/B vdd vdd vss vss gf180mcu_fd_sc_mcu7t5v0__and2_1
X_06709_ _06781_/C _06708_/Z _06710_/A2 vdd vdd vss vss gf180mcu_fd_sc_mcu7t5v0__nand2_1
X_07689_ _09677_/Q _09676_/Q _07725_/A3 vdd vdd vss vss gf180mcu_fd_sc_mcu7t5v0__nand2_4
X_09428_ _09428_/D clk _09428_/Q vdd vdd vss vss gf180mcu_fd_sc_mcu7t5v0__dffq_1
X_09359_ _10000_/Q _09366_/A2 _09360_/B vdd vdd vss vss gf180mcu_fd_sc_mcu7t5v0__nor2_1
X_05040_ _09872_/Q _09029_/B2 vdd vdd vss vss gf180mcu_fd_sc_mcu7t5v0__clkinv_1
XTAP_512 vdd vss gf180mcu_fd_sc_mcu7t5v0__filltie
XTAP_501 vdd vss gf180mcu_fd_sc_mcu7t5v0__filltie
XTAP_523 vdd vss gf180mcu_fd_sc_mcu7t5v0__filltie
XTAP_534 vdd vss gf180mcu_fd_sc_mcu7t5v0__filltie
XTAP_567 vdd vss gf180mcu_fd_sc_mcu7t5v0__filltie
XTAP_556 vdd vss gf180mcu_fd_sc_mcu7t5v0__filltie
XTAP_545 vdd vss gf180mcu_fd_sc_mcu7t5v0__filltie
X_06991_ _06994_/A2 _07247_/A1 _07053_/A2 _07284_/B vdd vdd vss vss
+ gf180mcu_fd_sc_mcu7t5v0__and3_2
XTAP_578 vdd vss gf180mcu_fd_sc_mcu7t5v0__filltie
XTAP_589 vdd vss gf180mcu_fd_sc_mcu7t5v0__filltie
X_08730_ _09976_/Q _09073_/A2 _08734_/B _08731_/B vdd vdd vss vss
+ gf180mcu_fd_sc_mcu7t5v0__oai21_1
X_05942_ _09712_/Q _05836_/Z _05947_/A1 vdd vdd vss vss gf180mcu_fd_sc_mcu7t5v0__nand2_1
X_08661_ _09716_/Q _08662_/A2 _08702_/B vdd vdd vss vss gf180mcu_fd_sc_mcu7t5v0__and2_1
X_05873_ _05964_/B2 _05873_/A2 _05873_/B _05874_/B vdd vdd vss vss
+ gf180mcu_fd_sc_mcu7t5v0__oai21_1
X_07612_ _09716_/Q _07644_/A2 _07612_/B _07613_/A3 vdd vdd vss vss
+ gf180mcu_fd_sc_mcu7t5v0__aoi21_1
X_04824_ _09599_/Q _06632_/A1 vdd vdd vss vss gf180mcu_fd_sc_mcu7t5v0__clkinv_1
X_08592_ _08524_/Z _08616_/B2 _08617_/A2 _08592_/Z vdd vdd vss vss
+ gf180mcu_fd_sc_mcu7t5v0__xor3_1
X_04755_ _09718_/Q _08727_/A1 vdd vdd vss vss gf180mcu_fd_sc_mcu7t5v0__inv_4
X_07543_ _07543_/A1 _07541_/Z _07543_/Z vdd vdd vss vss gf180mcu_fd_sc_mcu7t5v0__xor2_2
X_07474_ _07474_/A1 _07627_/B1 _07474_/B1 _07474_/B2 _07475_/I vdd vdd
+ vss vss gf180mcu_fd_sc_mcu7t5v0__aoi22_4
X_06425_ _09713_/Q _06562_/A2 _06468_/A2 vdd vdd vss vss gf180mcu_fd_sc_mcu7t5v0__nand2_1
X_09213_ _09246_/A2 _09176_/B _09213_/B _09935_/D vdd vdd vss vss
+ gf180mcu_fd_sc_mcu7t5v0__aoi21_1
X_09144_ _09952_/Q _09461_/Q _09145_/A2 vdd vdd vss vss gf180mcu_fd_sc_mcu7t5v0__nand2_1
X_06356_ _08291_/B _06608_/A2 _06367_/A1 vdd vdd vss vss gf180mcu_fd_sc_mcu7t5v0__nand2_1
X_06287_ _06287_/A1 _06287_/A2 _06286_/Z _06287_/Z vdd vdd vss vss
+ gf180mcu_fd_sc_mcu7t5v0__xor3_1
X_05307_ _05413_/A1 _05307_/A2 _05631_/C1 vdd vdd vss vss gf180mcu_fd_sc_mcu7t5v0__nor2_4
X_09075_ _09899_/Q _09103_/A1 _09095_/A2 vdd vdd vss vss gf180mcu_fd_sc_mcu7t5v0__nor2_4
X_08026_ _08026_/A1 _09104_/A2 _08026_/B _09680_/D vdd vdd vss vss
+ gf180mcu_fd_sc_mcu7t5v0__aoi21_1
X_05238_ _09922_/Q _09074_/B _05239_/B vdd vdd vss vss gf180mcu_fd_sc_mcu7t5v0__and2_1
X_05169_ _09734_/Q _08801_/A1 _08851_/A1 vdd vdd vss vss gf180mcu_fd_sc_mcu7t5v0__nand2_4
X_09977_ _09977_/D clk _09977_/Q vdd vdd vss vss gf180mcu_fd_sc_mcu7t5v0__dffq_1
X_08928_ _09811_/Q _08927_/I _09811_/D vdd vdd vss vss gf180mcu_fd_sc_mcu7t5v0__nor2_1
X_08859_ _08862_/B _08866_/B2 _08859_/B _08859_/C _08860_/B vdd vdd vss
+ vss gf180mcu_fd_sc_mcu7t5v0__aoi211_4
X_06210_ _09577_/Q _08565_/C _06264_/A1 vdd vdd vss vss gf180mcu_fd_sc_mcu7t5v0__nand2_1
X_07190_ _07289_/B _07190_/A2 _07190_/A3 _07190_/A4 _07191_/B vdd vdd
+ vss vss gf180mcu_fd_sc_mcu7t5v0__nand4_1
X_06141_ _06142_/A2 _06142_/A3 _06141_/B _06160_/A2 vdd vdd vss vss
+ gf180mcu_fd_sc_mcu7t5v0__oai21_1
X_06072_ _06260_/A1 _06072_/A2 _06072_/B _06072_/C _06073_/C vdd vdd vss
+ vss gf180mcu_fd_sc_mcu7t5v0__oai211_1
X_05023_ _09479_/Q _05315_/B2 vdd vdd vss vss gf180mcu_fd_sc_mcu7t5v0__clkinv_1
X_09900_ _09900_/D clk _09900_/Q vdd vdd vss vss gf180mcu_fd_sc_mcu7t5v0__dffq_1
X_09831_ _09831_/D clk _09831_/Q vdd vdd vss vss gf180mcu_fd_sc_mcu7t5v0__dffq_1
XTAP_342 vdd vss gf180mcu_fd_sc_mcu7t5v0__filltie
XTAP_331 vdd vss gf180mcu_fd_sc_mcu7t5v0__filltie
XTAP_320 vdd vss gf180mcu_fd_sc_mcu7t5v0__filltie
XTAP_364 vdd vss gf180mcu_fd_sc_mcu7t5v0__filltie
XTAP_353 vdd vss gf180mcu_fd_sc_mcu7t5v0__filltie
XTAP_375 vdd vss gf180mcu_fd_sc_mcu7t5v0__filltie
X_09762_ _09762_/D clk _09762_/Q vdd vdd vss vss gf180mcu_fd_sc_mcu7t5v0__dffq_1
X_06974_ _07298_/A1 _06985_/A2 _07248_/B vdd vdd vss vss gf180mcu_fd_sc_mcu7t5v0__nor2_2
XTAP_386 vdd vss gf180mcu_fd_sc_mcu7t5v0__filltie
XTAP_397 vdd vss gf180mcu_fd_sc_mcu7t5v0__filltie
X_08713_ _08430_/B _09073_/A2 _08713_/B _09711_/D vdd vdd vss vss
+ gf180mcu_fd_sc_mcu7t5v0__aoi21_1
X_05925_ _05925_/I _05926_/B vdd vdd vss vss gf180mcu_fd_sc_mcu7t5v0__clkinv_1
X_09693_ _09693_/D clk _09693_/Q vdd vdd vss vss gf180mcu_fd_sc_mcu7t5v0__dffq_4
X_05856_ _05802_/Z _05857_/A2 _05857_/B _05856_/Z vdd vdd vss vss
+ gf180mcu_fd_sc_mcu7t5v0__or3_1
X_08644_ _08645_/A1 _08643_/Z _08673_/B vdd vdd vss vss gf180mcu_fd_sc_mcu7t5v0__nand2_1
XPHY_15 vdd vss gf180mcu_fd_sc_mcu7t5v0__endcap
XPHY_26 vdd vss gf180mcu_fd_sc_mcu7t5v0__endcap
XPHY_37 vdd vss gf180mcu_fd_sc_mcu7t5v0__endcap
X_08575_ _09711_/Q _08626_/A2 _08621_/A1 vdd vdd vss vss gf180mcu_fd_sc_mcu7t5v0__nand2_1
X_04807_ _09627_/Q _07348_/A2 vdd vdd vss vss gf180mcu_fd_sc_mcu7t5v0__clkinv_4
X_05787_ _05787_/A1 _09570_/Q _05976_/A1 _05787_/B _05792_/A2 vdd vdd
+ vss vss gf180mcu_fd_sc_mcu7t5v0__oai31_4
XTAP_1519 vdd vss gf180mcu_fd_sc_mcu7t5v0__filltie
XTAP_1508 vdd vss gf180mcu_fd_sc_mcu7t5v0__filltie
XPHY_59 vdd vss gf180mcu_fd_sc_mcu7t5v0__endcap
XPHY_48 vdd vss gf180mcu_fd_sc_mcu7t5v0__endcap
X_04738_ _09759_/Q _08794_/A1 vdd vdd vss vss gf180mcu_fd_sc_mcu7t5v0__clkinv_1
X_07526_ _07421_/Z _07526_/A2 _07526_/B _09712_/Q _07635_/A1 vdd vdd vss
+ vss gf180mcu_fd_sc_mcu7t5v0__oai211_2
X_07457_ _07396_/B _07457_/A2 _07457_/A3 _07457_/A4 _07458_/B vdd vdd
+ vss vss gf180mcu_fd_sc_mcu7t5v0__nand4_1
X_06408_ _09712_/Q _06603_/A2 _06411_/B2 vdd vdd vss vss gf180mcu_fd_sc_mcu7t5v0__nor2_1
X_07388_ _07388_/A1 _07417_/A3 _07467_/A1 _07388_/Z vdd vdd vss vss
+ gf180mcu_fd_sc_mcu7t5v0__xor3_1
X_06339_ _06413_/A1 _06413_/A2 _06367_/B vdd vdd vss vss gf180mcu_fd_sc_mcu7t5v0__nor2_4
X_09127_ _09938_/Q _09116_/I _09136_/A2 _09911_/Q _09128_/A2 vdd vdd vss
+ vss gf180mcu_fd_sc_mcu7t5v0__aoi22_1
X_09058_ _09550_/Q _09104_/A2 _09072_/B _09059_/B vdd vdd vss vss
+ gf180mcu_fd_sc_mcu7t5v0__oai21_1
X_08009_ _08009_/A1 _08009_/A2 _08009_/B _08013_/A1 vdd vdd vss vss
+ gf180mcu_fd_sc_mcu7t5v0__aoi21_1
X_06690_ _09711_/Q _06941_/A2 _06687_/Z _06690_/Z vdd vdd vss vss
+ gf180mcu_fd_sc_mcu7t5v0__xor3_1
X_05710_ _09885_/Q _09615_/Q _09573_/Q _09877_/Q _09569_/Q _09570_/Q _05711_/I vdd
+ vdd vss vss gf180mcu_fd_sc_mcu7t5v0__mux4_4
X_05641_ _05990_/A1 _05978_/A1 _09569_/Q _05644_/A1 vdd vdd vss vss
+ gf180mcu_fd_sc_mcu7t5v0__nor3_2
X_08360_ _08358_/Z _08360_/A2 _08361_/B vdd vdd vss vss gf180mcu_fd_sc_mcu7t5v0__nand2_1
X_05572_ _09400_/A2 _05572_/A2 _05572_/B1 _09012_/A1 _05575_/A1 vdd vdd
+ vss vss gf180mcu_fd_sc_mcu7t5v0__aoi22_1
X_07311_ _09408_/A1 _07312_/A2 _07312_/B1 _07311_/B2 _09645_/D vdd vdd
+ vss vss gf180mcu_fd_sc_mcu7t5v0__oai22_1
X_08291_ _08291_/A1 _08291_/A2 _08291_/B _08294_/A2 vdd vdd vss vss
+ gf180mcu_fd_sc_mcu7t5v0__aoi21_1
X_07242_ _07243_/A1 _07241_/Z _07242_/Z vdd vdd vss vss gf180mcu_fd_sc_mcu7t5v0__and2_1
X_07173_ _07195_/A1 _07195_/A2 _07173_/Z vdd vdd vss vss gf180mcu_fd_sc_mcu7t5v0__xor2_1
X_06124_ _06124_/A1 _06089_/Z _06163_/A1 _06124_/Z vdd vdd vss vss
+ gf180mcu_fd_sc_mcu7t5v0__xor3_1
X_06055_ _06055_/I _06139_/A1 vdd vdd vss vss gf180mcu_fd_sc_mcu7t5v0__clkinv_1
X_05006_ _09855_/Q _09008_/B2 vdd vdd vss vss gf180mcu_fd_sc_mcu7t5v0__clkinv_1
X_09814_ _09814_/D clk _09814_/Q vdd vdd vss vss gf180mcu_fd_sc_mcu7t5v0__dffq_1
X_06957_ _06957_/A1 _06957_/A2 _06957_/B _06957_/C _06958_/B vdd vdd vss
+ vss gf180mcu_fd_sc_mcu7t5v0__oai211_1
X_09745_ _09745_/D clk _09745_/Q vdd vdd vss vss gf180mcu_fd_sc_mcu7t5v0__dffq_1
XTAP_2006 vdd vss gf180mcu_fd_sc_mcu7t5v0__filltie
X_05908_ _05909_/A2 _05906_/Z _05939_/A2 vdd vdd vss vss gf180mcu_fd_sc_mcu7t5v0__nand2_1
X_09676_ _09676_/D clk _09676_/Q vdd vdd vss vss gf180mcu_fd_sc_mcu7t5v0__dffq_4
X_06888_ _06889_/A1 _06889_/A2 _06888_/Z vdd vdd vss vss gf180mcu_fd_sc_mcu7t5v0__and2_1
XTAP_2028 vdd vss gf180mcu_fd_sc_mcu7t5v0__filltie
XTAP_2017 vdd vss gf180mcu_fd_sc_mcu7t5v0__filltie
X_05839_ _05839_/A1 _05839_/A2 _05839_/B _09712_/Q _05843_/A3 vdd vdd
+ vss vss gf180mcu_fd_sc_mcu7t5v0__oai211_2
X_08627_ _09715_/Q _08688_/A2 _08630_/A2 vdd vdd vss vss gf180mcu_fd_sc_mcu7t5v0__nand2_1
XTAP_1305 vdd vss gf180mcu_fd_sc_mcu7t5v0__filltie
XTAP_1316 vdd vss gf180mcu_fd_sc_mcu7t5v0__filltie
XTAP_1327 vdd vss gf180mcu_fd_sc_mcu7t5v0__filltie
XTAP_1338 vdd vss gf180mcu_fd_sc_mcu7t5v0__filltie
X_08558_ _08558_/A1 _08556_/Z _08558_/Z vdd vdd vss vss gf180mcu_fd_sc_mcu7t5v0__xor2_1
XTAP_1349 vdd vss gf180mcu_fd_sc_mcu7t5v0__filltie
X_08489_ _08551_/A1 _08488_/Z _08489_/Z vdd vdd vss vss gf180mcu_fd_sc_mcu7t5v0__xor2_1
X_07509_ _07509_/A1 _07493_/Z _07504_/Z _07649_/A1 _07509_/C _07510_/A2 vdd
+ vdd vss vss gf180mcu_fd_sc_mcu7t5v0__oai221_1
XTAP_1861 vdd vss gf180mcu_fd_sc_mcu7t5v0__filltie
XTAP_1850 vdd vss gf180mcu_fd_sc_mcu7t5v0__filltie
XTAP_1894 vdd vss gf180mcu_fd_sc_mcu7t5v0__filltie
XTAP_1883 vdd vss gf180mcu_fd_sc_mcu7t5v0__filltie
XTAP_1872 vdd vss gf180mcu_fd_sc_mcu7t5v0__filltie
X_07860_ _08011_/A1 _07860_/A2 _07860_/B _07861_/B vdd vdd vss vss
+ gf180mcu_fd_sc_mcu7t5v0__oai21_1
X_07791_ _07792_/A1 _07834_/A1 _07871_/A2 vdd vdd vss vss gf180mcu_fd_sc_mcu7t5v0__nor2_2
X_06811_ _06811_/A1 _06941_/A2 _06839_/A2 _06811_/A4 _06910_/A2 vdd vdd
+ vss vss gf180mcu_fd_sc_mcu7t5v0__nand4_2
X_09530_ _09530_/D clk _09530_/Q vdd vdd vss vss gf180mcu_fd_sc_mcu7t5v0__dffq_1
X_06742_ _09615_/Q _08565_/C _06742_/B _06743_/A2 vdd vdd vss vss
+ gf180mcu_fd_sc_mcu7t5v0__aoi21_1
X_09461_ _09461_/D clk _09461_/Q vdd vdd vss vss gf180mcu_fd_sc_mcu7t5v0__dffq_4
X_06673_ _06955_/A1 _06958_/A1 _06676_/A2 vdd vdd vss vss gf180mcu_fd_sc_mcu7t5v0__nor2_1
X_08412_ _08731_/A1 _08412_/A2 _08667_/C vdd vdd vss vss gf180mcu_fd_sc_mcu7t5v0__nor2_4
X_05624_ _09457_/Q _05627_/A2 _05627_/B1 _09441_/Q _05626_/A1 vdd vdd
+ vss vss gf180mcu_fd_sc_mcu7t5v0__aoi22_1
X_09392_ _10015_/Q _09399_/A2 _09393_/B vdd vdd vss vss gf180mcu_fd_sc_mcu7t5v0__nor2_1
X_05555_ _09423_/Q _05628_/A2 _05628_/B1 _09610_/Q _05556_/A2 vdd vdd
+ vss vss gf180mcu_fd_sc_mcu7t5v0__aoi22_1
X_08343_ _09716_/Q _08061_/Z _08344_/A2 vdd vdd vss vss gf180mcu_fd_sc_mcu7t5v0__nand2_1
X_08274_ _08274_/A1 _08274_/A2 _08245_/Z _08274_/B1 _08274_/B2 _08304_/A1 vdd
+ vdd vss vss gf180mcu_fd_sc_mcu7t5v0__oai32_2
X_05486_ _09002_/A2 _05486_/A2 _05486_/B1 _05631_/C1 _05486_/C1 _05632_/C2 _05488_/A2
+ vdd vdd vss vss gf180mcu_fd_sc_mcu7t5v0__aoi222_2
X_07225_ _07204_/Z _07224_/Z _07225_/Z vdd vdd vss vss gf180mcu_fd_sc_mcu7t5v0__xor2_1
X_07156_ _07156_/A1 _07208_/A2 _07201_/A1 vdd vdd vss vss gf180mcu_fd_sc_mcu7t5v0__nor2_1
X_06107_ _06107_/A1 _06107_/A2 _06106_/B _06107_/Z vdd vdd vss vss
+ gf180mcu_fd_sc_mcu7t5v0__or3_1
X_07087_ _07284_/B _07085_/Z _07131_/A2 _07094_/B1 vdd vdd vss vss
+ gf180mcu_fd_sc_mcu7t5v0__nand3_1
X_06038_ _09571_/Q _06005_/B _06039_/A2 _06043_/A2 vdd vdd vss vss
+ gf180mcu_fd_sc_mcu7t5v0__nand3_1
X_07989_ _07989_/I0 _09712_/Q _07989_/S _07989_/Z vdd vdd vss vss
+ gf180mcu_fd_sc_mcu7t5v0__mux2_1
X_09728_ _09728_/D clk _09728_/Q vdd vdd vss vss gf180mcu_fd_sc_mcu7t5v0__dffq_1
XTAP_1102 vdd vss gf180mcu_fd_sc_mcu7t5v0__filltie
XTAP_1113 vdd vss gf180mcu_fd_sc_mcu7t5v0__filltie
X_09659_ _09659_/D clk _09659_/Q vdd vdd vss vss gf180mcu_fd_sc_mcu7t5v0__dffq_4
XTAP_1124 vdd vss gf180mcu_fd_sc_mcu7t5v0__filltie
XTAP_1135 vdd vss gf180mcu_fd_sc_mcu7t5v0__filltie
XTAP_1146 vdd vss gf180mcu_fd_sc_mcu7t5v0__filltie
XTAP_1157 vdd vss gf180mcu_fd_sc_mcu7t5v0__filltie
XTAP_1168 vdd vss gf180mcu_fd_sc_mcu7t5v0__filltie
XTAP_1179 vdd vss gf180mcu_fd_sc_mcu7t5v0__filltie
XTAP_908 vdd vss gf180mcu_fd_sc_mcu7t5v0__filltie
XTAP_919 vdd vss gf180mcu_fd_sc_mcu7t5v0__filltie
XTAP_1691 vdd vss gf180mcu_fd_sc_mcu7t5v0__filltie
XTAP_1680 vdd vss gf180mcu_fd_sc_mcu7t5v0__filltie
X_05340_ _09400_/A1 _05632_/C2 _05349_/A2 vdd vdd vss vss gf180mcu_fd_sc_mcu7t5v0__nand2_4
X_05271_ _09406_/A1 _05274_/A2 _05274_/B1 _05271_/B2 _09430_/D vdd vdd
+ vss vss gf180mcu_fd_sc_mcu7t5v0__oai22_1
X_07010_ _09711_/Q _07000_/Z _07022_/A1 vdd vdd vss vss gf180mcu_fd_sc_mcu7t5v0__nor2_1
X_08961_ _09823_/Q _08958_/Z _08961_/Z vdd vdd vss vss gf180mcu_fd_sc_mcu7t5v0__and2_1
X_07912_ _09715_/Q _07912_/A2 _07913_/I vdd vdd vss vss gf180mcu_fd_sc_mcu7t5v0__xor2_1
X_08892_ _09792_/Q _09523_/Q _08894_/A2 vdd vdd vss vss gf180mcu_fd_sc_mcu7t5v0__nand2_1
X_07843_ _07870_/A1 _07869_/A1 _07839_/Z _07843_/Z vdd vdd vss vss
+ gf180mcu_fd_sc_mcu7t5v0__xor3_1
X_04986_ _09414_/Q _05237_/A1 vdd vdd vss vss gf180mcu_fd_sc_mcu7t5v0__clkinv_1
X_07774_ _07771_/C _07759_/Z _07774_/B1 _07774_/B2 _08706_/B _07775_/A2 vdd
+ vdd vss vss gf180mcu_fd_sc_mcu7t5v0__oai221_1
X_09513_ _09513_/D clk _09513_/Q vdd vdd vss vss gf180mcu_fd_sc_mcu7t5v0__dffq_1
X_06725_ _09615_/Q _06740_/A2 _06745_/B vdd vdd vss vss gf180mcu_fd_sc_mcu7t5v0__nand2_1
X_09444_ _09444_/D clk _09444_/Q vdd vdd vss vss gf180mcu_fd_sc_mcu7t5v0__dffq_1
X_06656_ _09623_/Q _06667_/A2 _06739_/C vdd vdd vss vss gf180mcu_fd_sc_mcu7t5v0__nand2_2
XPHY_207 vdd vss gf180mcu_fd_sc_mcu7t5v0__endcap
XPHY_229 vdd vss gf180mcu_fd_sc_mcu7t5v0__endcap
XPHY_218 vdd vss gf180mcu_fd_sc_mcu7t5v0__endcap
X_05607_ _09667_/Q _05628_/A2 _05628_/B1 _09730_/Q _05608_/A2 vdd vdd
+ vss vss gf180mcu_fd_sc_mcu7t5v0__aoi22_1
X_06587_ _07611_/B _06624_/A1 _06587_/A3 _06587_/Z vdd vdd vss vss
+ gf180mcu_fd_sc_mcu7t5v0__xor3_1
X_09375_ _09397_/A1 _09377_/A2 _09375_/B _09399_/C _10007_/D vdd vdd vss
+ vss gf180mcu_fd_sc_mcu7t5v0__aoi211_1
X_08326_ _08326_/A1 _08326_/A2 _08348_/A1 vdd vdd vss vss gf180mcu_fd_sc_mcu7t5v0__nand2_1
X_05538_ _09839_/Q _05627_/A2 _05627_/B1 _09807_/Q _05540_/A1 vdd vdd
+ vss vss gf180mcu_fd_sc_mcu7t5v0__aoi22_1
X_05469_ _05469_/A1 _05469_/A2 _05485_/B1 vdd vdd vss vss gf180mcu_fd_sc_mcu7t5v0__nand2_1
X_08257_ _08257_/A1 _08257_/A2 _08257_/B _08312_/B vdd vdd vss vss
+ gf180mcu_fd_sc_mcu7t5v0__aoi21_1
X_08188_ _08188_/A1 _08237_/A1 _08229_/B vdd vdd vss vss gf180mcu_fd_sc_mcu7t5v0__or2_1
X_07208_ _07208_/A1 _07208_/A2 _07269_/B2 _07208_/Z vdd vdd vss vss
+ gf180mcu_fd_sc_mcu7t5v0__xor3_1
X_07139_ _07289_/B _07124_/Z _07139_/B _08706_/B _07140_/A2 vdd vdd vss
+ vss gf180mcu_fd_sc_mcu7t5v0__oai211_1
XTAP_716 vdd vss gf180mcu_fd_sc_mcu7t5v0__filltie
XTAP_705 vdd vss gf180mcu_fd_sc_mcu7t5v0__filltie
XTAP_749 vdd vss gf180mcu_fd_sc_mcu7t5v0__filltie
XTAP_738 vdd vss gf180mcu_fd_sc_mcu7t5v0__filltie
XTAP_727 vdd vss gf180mcu_fd_sc_mcu7t5v0__filltie
X_04840_ _09566_/Q _05970_/A1 vdd vdd vss vss gf180mcu_fd_sc_mcu7t5v0__clkinv_3
X_04771_ _09692_/Q _08180_/B vdd vdd vss vss gf180mcu_fd_sc_mcu7t5v0__inv_4
X_06510_ _06510_/A1 _06510_/A2 _06515_/A1 _06510_/B2 _06517_/A1 vdd vdd
+ vss vss gf180mcu_fd_sc_mcu7t5v0__oai22_1
X_07490_ _07516_/A1 _07515_/A1 _07486_/Z _07490_/Z vdd vdd vss vss
+ gf180mcu_fd_sc_mcu7t5v0__xor3_1
X_06441_ _09713_/Q _06440_/Z _06442_/I vdd vdd vss vss gf180mcu_fd_sc_mcu7t5v0__nand2_1
X_06372_ _09710_/Q _06562_/A2 _06372_/Z vdd vdd vss vss gf180mcu_fd_sc_mcu7t5v0__and2_1
X_09160_ _09956_/Q _09461_/Q _09161_/A2 vdd vdd vss vss gf180mcu_fd_sc_mcu7t5v0__nand2_1
X_05323_ _09403_/A1 _05329_/A2 _05329_/B1 _05323_/B2 _09483_/D vdd vdd
+ vss vss gf180mcu_fd_sc_mcu7t5v0__oai22_1
X_08111_ _09712_/Q _08110_/Z _08159_/A1 vdd vdd vss vss gf180mcu_fd_sc_mcu7t5v0__nand2_1
X_09091_ _09967_/Q _09095_/A2 _09092_/C vdd vdd vss vss gf180mcu_fd_sc_mcu7t5v0__and2_1
X_05254_ _09403_/A1 _05260_/A2 _05260_/B1 _05254_/B2 _09419_/D vdd vdd
+ vss vss gf180mcu_fd_sc_mcu7t5v0__oai22_1
X_08042_ _08358_/I0 _08217_/A1 _08045_/A2 vdd vdd vss vss gf180mcu_fd_sc_mcu7t5v0__nand2_1
X_05185_ _09464_/Q _09473_/Q _09469_/Q _05185_/A4 _05186_/A4 vdd vdd vss
+ vss gf180mcu_fd_sc_mcu7t5v0__nor4_1
X_09993_ _09993_/D clk _09993_/Q vdd vdd vss vss gf180mcu_fd_sc_mcu7t5v0__dffq_1
X_08944_ _09817_/Q _08941_/Z _08944_/Z vdd vdd vss vss gf180mcu_fd_sc_mcu7t5v0__and2_1
X_08875_ _09395_/A1 _09523_/Q _08876_/B vdd vdd vss vss gf180mcu_fd_sc_mcu7t5v0__nor2_1
X_07826_ _09680_/Q _09617_/Q _07828_/A2 vdd vdd vss vss gf180mcu_fd_sc_mcu7t5v0__nor2_1
X_04969_ _09663_/Q _07672_/B2 vdd vdd vss vss gf180mcu_fd_sc_mcu7t5v0__clkinv_1
X_07757_ _09670_/Q _07756_/Z _07757_/Z vdd vdd vss vss gf180mcu_fd_sc_mcu7t5v0__or2_1
X_06708_ _06708_/A1 _06706_/Z _06708_/Z vdd vdd vss vss gf180mcu_fd_sc_mcu7t5v0__xor2_1
X_07688_ _09678_/Q _09677_/Q _07715_/A2 vdd vdd vss vss gf180mcu_fd_sc_mcu7t5v0__nor2_1
X_09427_ _09427_/D clk _09427_/Q vdd vdd vss vss gf180mcu_fd_sc_mcu7t5v0__dffq_1
X_06639_ _10007_/Q _09073_/A2 _08734_/B _06640_/B vdd vdd vss vss
+ gf180mcu_fd_sc_mcu7t5v0__oai21_1
X_09358_ _09391_/A1 _09366_/A2 _09358_/B _09399_/C _09999_/D vdd vdd vss
+ vss gf180mcu_fd_sc_mcu7t5v0__aoi211_1
X_08309_ _08325_/A1 _08308_/Z _08309_/Z vdd vdd vss vss gf180mcu_fd_sc_mcu7t5v0__xor2_1
X_09289_ _09969_/Q _09298_/A2 _09290_/B vdd vdd vss vss gf180mcu_fd_sc_mcu7t5v0__nor2_1
XTAP_502 vdd vss gf180mcu_fd_sc_mcu7t5v0__filltie
XTAP_513 vdd vss gf180mcu_fd_sc_mcu7t5v0__filltie
XTAP_524 vdd vss gf180mcu_fd_sc_mcu7t5v0__filltie
XTAP_557 vdd vss gf180mcu_fd_sc_mcu7t5v0__filltie
XTAP_546 vdd vss gf180mcu_fd_sc_mcu7t5v0__filltie
XTAP_535 vdd vss gf180mcu_fd_sc_mcu7t5v0__filltie
X_06990_ _09636_/Q _09635_/Q _07002_/A2 vdd vdd vss vss gf180mcu_fd_sc_mcu7t5v0__nor2_1
X_05941_ _05941_/A1 _05941_/A2 _05941_/B _05953_/A2 vdd vdd vss vss
+ gf180mcu_fd_sc_mcu7t5v0__aoi21_1
XTAP_579 vdd vss gf180mcu_fd_sc_mcu7t5v0__filltie
XTAP_568 vdd vss gf180mcu_fd_sc_mcu7t5v0__filltie
X_08660_ _08703_/A1 _08703_/A2 _08662_/A2 vdd vdd vss vss gf180mcu_fd_sc_mcu7t5v0__xnor2_1
X_05872_ _09715_/Q _05638_/B _05930_/B2 _05873_/A2 _05930_/C _05873_/B vdd vdd
+ vss vss gf180mcu_fd_sc_mcu7t5v0__aoi221_1
X_04823_ _09600_/Q _06634_/A1 vdd vdd vss vss gf180mcu_fd_sc_mcu7t5v0__clkinv_3
X_07611_ _07611_/A1 _07611_/A2 _07611_/B _07613_/A2 vdd vdd vss vss
+ gf180mcu_fd_sc_mcu7t5v0__aoi21_1
X_08591_ _08524_/Z _08617_/A2 _08616_/B1 vdd vdd vss vss gf180mcu_fd_sc_mcu7t5v0__xnor2_1
X_04754_ _09719_/Q _08729_/A1 vdd vdd vss vss gf180mcu_fd_sc_mcu7t5v0__clkinv_3
X_07542_ _07543_/A1 _07541_/Z _07542_/Z vdd vdd vss vss gf180mcu_fd_sc_mcu7t5v0__and2_1
X_07473_ _07474_/A1 _07627_/B1 _07527_/B vdd vdd vss vss gf180mcu_fd_sc_mcu7t5v0__nand2_1
X_06424_ _09713_/Q _06608_/A2 _06510_/B2 vdd vdd vss vss gf180mcu_fd_sc_mcu7t5v0__nand2_1
X_09212_ _09935_/Q _09176_/B _09226_/B _09213_/B vdd vdd vss vss gf180mcu_fd_sc_mcu7t5v0__oai21_1
X_09143_ _09399_/C _09143_/A2 _09917_/D vdd vdd vss vss gf180mcu_fd_sc_mcu7t5v0__nor2_1
X_06355_ _06355_/I _09592_/D vdd vdd vss vss gf180mcu_fd_sc_mcu7t5v0__clkinv_1
X_05306_ _09409_/A1 _05306_/A2 _05306_/B1 _05306_/B2 _09457_/D vdd vdd
+ vss vss gf180mcu_fd_sc_mcu7t5v0__oai22_1
X_06286_ _06286_/A1 _06286_/A2 _06285_/Z _06286_/Z vdd vdd vss vss
+ gf180mcu_fd_sc_mcu7t5v0__xor3_1
X_09074_ _09077_/A1 _09077_/A3 _09074_/B _09101_/A2 vdd vdd vss vss
+ gf180mcu_fd_sc_mcu7t5v0__oai21_1
X_05237_ _05237_/A1 _05246_/A2 _09406_/A1 _05246_/B2 _09414_/D vdd vdd
+ vss vss gf180mcu_fd_sc_mcu7t5v0__oai22_1
X_08025_ _09988_/Q _09104_/A2 _09089_/B _08026_/B vdd vdd vss vss
+ gf180mcu_fd_sc_mcu7t5v0__oai21_1
X_05168_ _05168_/A1 _05168_/A2 _05168_/B1 _08801_/A1 _09734_/D vdd vdd
+ vss vss gf180mcu_fd_sc_mcu7t5v0__oai22_1
X_05099_ _09612_/Q _06652_/B2 vdd vdd vss vss gf180mcu_fd_sc_mcu7t5v0__clkinv_1
X_09976_ _09976_/D clk _09976_/Q vdd vdd vss vss gf180mcu_fd_sc_mcu7t5v0__dffq_1
X_08927_ _08927_/I _08968_/B vdd vdd vss vss gf180mcu_fd_sc_mcu7t5v0__clkinv_2
X_08858_ _09522_/Q _08897_/A2 _08858_/B _08859_/B vdd vdd vss vss
+ gf180mcu_fd_sc_mcu7t5v0__aoi21_2
X_07809_ _07920_/A1 _07856_/A2 _07815_/B2 vdd vdd vss vss gf180mcu_fd_sc_mcu7t5v0__nor2_1
X_08789_ _09749_/Q _08851_/A1 _08791_/B _08790_/B vdd vdd vss vss
+ gf180mcu_fd_sc_mcu7t5v0__oai21_1
X_06140_ _06142_/A2 _06142_/A3 _06144_/A2 vdd vdd vss vss gf180mcu_fd_sc_mcu7t5v0__nor2_1
X_06071_ _09712_/Q _09581_/Q _05996_/B _06072_/B vdd vdd vss vss gf180mcu_fd_sc_mcu7t5v0__nand3_1
X_05022_ _09455_/Q _05304_/B2 vdd vdd vss vss gf180mcu_fd_sc_mcu7t5v0__clkinv_1
X_09830_ _09830_/D clk _09830_/Q vdd vdd vss vss gf180mcu_fd_sc_mcu7t5v0__dffq_1
XTAP_332 vdd vss gf180mcu_fd_sc_mcu7t5v0__filltie
XTAP_321 vdd vss gf180mcu_fd_sc_mcu7t5v0__filltie
XTAP_310 vdd vss gf180mcu_fd_sc_mcu7t5v0__filltie
XTAP_343 vdd vss gf180mcu_fd_sc_mcu7t5v0__filltie
XTAP_365 vdd vss gf180mcu_fd_sc_mcu7t5v0__filltie
XTAP_354 vdd vss gf180mcu_fd_sc_mcu7t5v0__filltie
XTAP_376 vdd vss gf180mcu_fd_sc_mcu7t5v0__filltie
X_06973_ _09635_/Q _07294_/A1 _06985_/A2 vdd vdd vss vss gf180mcu_fd_sc_mcu7t5v0__nand2_1
X_09761_ _09761_/D clk _09761_/Q vdd vdd vss vss gf180mcu_fd_sc_mcu7t5v0__dffq_1
XTAP_387 vdd vss gf180mcu_fd_sc_mcu7t5v0__filltie
XTAP_398 vdd vss gf180mcu_fd_sc_mcu7t5v0__filltie
X_08712_ _09876_/Q _09073_/A2 _09278_/C _08713_/B vdd vdd vss vss
+ gf180mcu_fd_sc_mcu7t5v0__oai21_1
X_05924_ _09716_/Q _05923_/Z _05925_/I vdd vdd vss vss gf180mcu_fd_sc_mcu7t5v0__xor2_1
X_09692_ _09692_/D clk _09692_/Q vdd vdd vss vss gf180mcu_fd_sc_mcu7t5v0__dffq_4
X_05855_ _05855_/A1 _05855_/A2 _05851_/Z _05857_/B vdd vdd vss vss
+ gf180mcu_fd_sc_mcu7t5v0__xor3_1
X_08643_ _08643_/A1 _08625_/I _08640_/Z _08643_/Z vdd vdd vss vss
+ gf180mcu_fd_sc_mcu7t5v0__xor3_1
XPHY_16 vdd vss gf180mcu_fd_sc_mcu7t5v0__endcap
XPHY_27 vdd vss gf180mcu_fd_sc_mcu7t5v0__endcap
XPHY_38 vdd vss gf180mcu_fd_sc_mcu7t5v0__endcap
X_08574_ _08587_/A1 _08572_/Z _08574_/Z vdd vdd vss vss gf180mcu_fd_sc_mcu7t5v0__and2_1
X_04806_ _09629_/Q _08139_/B2 vdd vdd vss vss gf180mcu_fd_sc_mcu7t5v0__inv_1
XTAP_1509 vdd vss gf180mcu_fd_sc_mcu7t5v0__filltie
X_05786_ _06141_/B _09570_/Q _09569_/Q _05792_/A1 vdd vdd vss vss
+ gf180mcu_fd_sc_mcu7t5v0__aoi21_4
XPHY_49 vdd vss gf180mcu_fd_sc_mcu7t5v0__endcap
X_04737_ _09752_/Q _08780_/A1 vdd vdd vss vss gf180mcu_fd_sc_mcu7t5v0__clkinv_1
X_07525_ _09713_/Q _07575_/A2 _07575_/A3 _07570_/B2 vdd vdd vss vss
+ gf180mcu_fd_sc_mcu7t5v0__nand3_1
X_07456_ _09713_/Q _07651_/A2 _07457_/A4 vdd vdd vss vss gf180mcu_fd_sc_mcu7t5v0__nand2_1
X_06407_ _06407_/A1 _06406_/B _06407_/Z vdd vdd vss vss gf180mcu_fd_sc_mcu7t5v0__xor2_1
X_07387_ _07464_/A1 _07380_/Z _07467_/A1 _07464_/A2 vdd vdd vss vss
+ gf180mcu_fd_sc_mcu7t5v0__nor3_2
X_06338_ _06591_/A1 _06491_/A1 _06413_/A2 vdd vdd vss vss gf180mcu_fd_sc_mcu7t5v0__nand2_1
X_09126_ _09399_/C _09126_/A2 _09910_/D vdd vdd vss vss gf180mcu_fd_sc_mcu7t5v0__nor2_1
X_06269_ _06269_/A1 _06240_/Z _06286_/A2 vdd vdd vss vss gf180mcu_fd_sc_mcu7t5v0__nor2_1
X_09057_ _09057_/A1 _09057_/A2 _09399_/C _09882_/D vdd vdd vss vss
+ gf180mcu_fd_sc_mcu7t5v0__aoi21_1
X_08008_ _08009_/A1 _08009_/A2 _08009_/B _08010_/A2 vdd vdd vss vss
+ gf180mcu_fd_sc_mcu7t5v0__nand3_1
X_09959_ _09959_/D clk _09959_/Q vdd vdd vss vss gf180mcu_fd_sc_mcu7t5v0__dffq_1
X_05640_ _09875_/Q _09570_/Q _09569_/Q _05643_/A2 vdd vdd vss vss
+ gf180mcu_fd_sc_mcu7t5v0__nand3_1
X_05571_ _05571_/A1 _05571_/A2 _05573_/C1 vdd vdd vss vss gf180mcu_fd_sc_mcu7t5v0__nand2_1
X_07310_ _09407_/A1 _07312_/A2 _07312_/B1 _07310_/B2 _09644_/D vdd vdd
+ vss vss gf180mcu_fd_sc_mcu7t5v0__oai22_1
X_08290_ _08291_/A1 _08291_/A2 _08354_/A2 vdd vdd vss vss gf180mcu_fd_sc_mcu7t5v0__nand2_2
X_07241_ _09716_/Q _07239_/Z _07241_/Z vdd vdd vss vss gf180mcu_fd_sc_mcu7t5v0__xor2_1
X_07172_ _07172_/A1 _07170_/Z _07195_/A2 vdd vdd vss vss gf180mcu_fd_sc_mcu7t5v0__xnor2_1
X_06123_ _06124_/A1 _06123_/A2 _06163_/A2 vdd vdd vss vss gf180mcu_fd_sc_mcu7t5v0__nor2_1
X_06054_ _06056_/A1 _06056_/A2 _06055_/I vdd vdd vss vss gf180mcu_fd_sc_mcu7t5v0__nand2_2
X_05005_ _09422_/Q _05257_/B2 vdd vdd vss vss gf180mcu_fd_sc_mcu7t5v0__clkinv_1
X_09813_ _09813_/D clk _09813_/Q vdd vdd vss vss gf180mcu_fd_sc_mcu7t5v0__dffq_1
X_06956_ _09717_/Q _06956_/A2 _06949_/Z _06918_/C _06957_/C vdd vdd vss
+ vss gf180mcu_fd_sc_mcu7t5v0__aoi22_1
X_09744_ _09744_/D clk _09744_/Q vdd vdd vss vss gf180mcu_fd_sc_mcu7t5v0__dffq_1
XTAP_2007 vdd vss gf180mcu_fd_sc_mcu7t5v0__filltie
X_05907_ _05909_/A2 _05906_/Z _05939_/B vdd vdd vss vss gf180mcu_fd_sc_mcu7t5v0__nor2_1
X_09675_ _09675_/D clk _09675_/Q vdd vdd vss vss gf180mcu_fd_sc_mcu7t5v0__dffq_1
X_06887_ _09713_/Q _06792_/Z _06939_/A2 vdd vdd vss vss gf180mcu_fd_sc_mcu7t5v0__nand2_1
XTAP_2029 vdd vss gf180mcu_fd_sc_mcu7t5v0__filltie
XTAP_2018 vdd vss gf180mcu_fd_sc_mcu7t5v0__filltie
X_08626_ _09712_/Q _08626_/A2 _08676_/B1 vdd vdd vss vss gf180mcu_fd_sc_mcu7t5v0__nand2_1
X_05838_ _08715_/A1 _05943_/A2 _05950_/A1 vdd vdd vss vss gf180mcu_fd_sc_mcu7t5v0__nor2_1
XTAP_1306 vdd vss gf180mcu_fd_sc_mcu7t5v0__filltie
XTAP_1317 vdd vss gf180mcu_fd_sc_mcu7t5v0__filltie
XTAP_1328 vdd vss gf180mcu_fd_sc_mcu7t5v0__filltie
XTAP_1339 vdd vss gf180mcu_fd_sc_mcu7t5v0__filltie
X_05769_ _05810_/A1 _05767_/Z _05769_/B _05775_/B2 vdd vdd vss vss
+ gf180mcu_fd_sc_mcu7t5v0__aoi21_1
X_08557_ _08558_/A1 _08556_/Z _08605_/A2 vdd vdd vss vss gf180mcu_fd_sc_mcu7t5v0__nor2_1
X_08488_ _09713_/Q _08485_/Z _08488_/Z vdd vdd vss vss gf180mcu_fd_sc_mcu7t5v0__xor2_1
X_07508_ _07651_/B _07508_/A2 _07508_/A3 _07475_/I _09714_/Q _07509_/C vdd vdd
+ vss vss gf180mcu_fd_sc_mcu7t5v0__oai32_1
X_07439_ _07464_/A1 _07390_/I _07436_/Z _07439_/Z vdd vdd vss vss
+ gf180mcu_fd_sc_mcu7t5v0__xor3_2
X_09109_ _09404_/A1 _09114_/A2 _09114_/B1 _09109_/B2 _09902_/D vdd vdd
+ vss vss gf180mcu_fd_sc_mcu7t5v0__oai22_1
XTAP_1851 vdd vss gf180mcu_fd_sc_mcu7t5v0__filltie
XTAP_1840 vdd vss gf180mcu_fd_sc_mcu7t5v0__filltie
XTAP_1884 vdd vss gf180mcu_fd_sc_mcu7t5v0__filltie
XTAP_1862 vdd vss gf180mcu_fd_sc_mcu7t5v0__filltie
XTAP_1873 vdd vss gf180mcu_fd_sc_mcu7t5v0__filltie
XTAP_1895 vdd vss gf180mcu_fd_sc_mcu7t5v0__filltie
X_07790_ _09711_/Q _07788_/Z _07835_/A2 vdd vdd vss vss gf180mcu_fd_sc_mcu7t5v0__nand2_1
X_06810_ _06669_/I _06806_/Z _06824_/A2 vdd vdd vss vss gf180mcu_fd_sc_mcu7t5v0__nand2_1
X_06741_ _06781_/C _06726_/Z _06741_/B1 _06741_/B2 _08565_/C _06742_/B vdd vdd
+ vss vss gf180mcu_fd_sc_mcu7t5v0__aoi221_1
X_09460_ _09460_/D clk _09460_/Q vdd vdd vss vss gf180mcu_fd_sc_mcu7t5v0__dffq_1
X_08411_ _08411_/A1 _08411_/A2 _08414_/B vdd vdd vss vss gf180mcu_fd_sc_mcu7t5v0__nand2_1
X_06672_ _09623_/Q _06965_/A1 _06672_/B _06672_/C _06958_/A1 vdd vdd vss
+ vss gf180mcu_fd_sc_mcu7t5v0__aoi211_4
X_05623_ _05623_/A1 _05623_/A2 _05632_/B1 vdd vdd vss vss gf180mcu_fd_sc_mcu7t5v0__nand2_1
X_09391_ _09391_/A1 _09399_/A2 _09391_/B _09399_/C _10014_/D vdd vdd vss
+ vss gf180mcu_fd_sc_mcu7t5v0__aoi211_1
X_05554_ _09856_/Q _05627_/A2 _05627_/B1 _09589_/Q _05556_/A1 vdd vdd
+ vss vss gf180mcu_fd_sc_mcu7t5v0__aoi22_1
X_08342_ _09717_/Q _08030_/Z _08344_/A1 vdd vdd vss vss gf180mcu_fd_sc_mcu7t5v0__nand2_1
X_08273_ _08306_/A1 _08251_/Z _08308_/A2 vdd vdd vss vss gf180mcu_fd_sc_mcu7t5v0__nor2_1
X_05485_ _09012_/A1 _05485_/A2 _05485_/B1 _08736_/A2 _05488_/A1 vdd vdd
+ vss vss gf180mcu_fd_sc_mcu7t5v0__aoi22_1
X_07224_ _07224_/A1 _07222_/Z _07224_/Z vdd vdd vss vss gf180mcu_fd_sc_mcu7t5v0__xor2_1
X_07155_ _09712_/Q _07106_/Z _07208_/A2 vdd vdd vss vss gf180mcu_fd_sc_mcu7t5v0__nand2_1
X_06106_ _06107_/A1 _06107_/A2 _06106_/B _06150_/A2 vdd vdd vss vss
+ gf180mcu_fd_sc_mcu7t5v0__oai21_1
X_07086_ _07086_/A1 _07084_/Z _07131_/A2 vdd vdd vss vss gf180mcu_fd_sc_mcu7t5v0__nand2_1
X_06037_ _09572_/Q _06033_/B _06037_/A3 _06039_/A2 vdd vdd vss vss
+ gf180mcu_fd_sc_mcu7t5v0__xnor3_1
X_07988_ _09712_/Q _07988_/A2 _07989_/I0 vdd vdd vss vss gf180mcu_fd_sc_mcu7t5v0__nand2_1
X_09727_ _09727_/D clk _09727_/Q vdd vdd vss vss gf180mcu_fd_sc_mcu7t5v0__dffq_1
X_06939_ _06939_/A1 _06939_/A2 _06888_/Z _06939_/B2 _06942_/A1 vdd vdd
+ vss vss gf180mcu_fd_sc_mcu7t5v0__oai22_1
XTAP_1103 vdd vss gf180mcu_fd_sc_mcu7t5v0__filltie
XTAP_1114 vdd vss gf180mcu_fd_sc_mcu7t5v0__filltie
X_09658_ _09658_/D clk _09658_/Q vdd vdd vss vss gf180mcu_fd_sc_mcu7t5v0__dffq_4
X_09589_ _09589_/D clk _09589_/Q vdd vdd vss vss gf180mcu_fd_sc_mcu7t5v0__dffq_1
X_08609_ _08561_/B _08611_/B1 _08610_/B1 vdd vdd vss vss gf180mcu_fd_sc_mcu7t5v0__nor2_1
XTAP_1125 vdd vss gf180mcu_fd_sc_mcu7t5v0__filltie
XTAP_1136 vdd vss gf180mcu_fd_sc_mcu7t5v0__filltie
XTAP_1147 vdd vss gf180mcu_fd_sc_mcu7t5v0__filltie
XTAP_1158 vdd vss gf180mcu_fd_sc_mcu7t5v0__filltie
XTAP_1169 vdd vss gf180mcu_fd_sc_mcu7t5v0__filltie
XTAP_909 vdd vss gf180mcu_fd_sc_mcu7t5v0__filltie
XTAP_1692 vdd vss gf180mcu_fd_sc_mcu7t5v0__filltie
XTAP_1681 vdd vss gf180mcu_fd_sc_mcu7t5v0__filltie
XTAP_1670 vdd vss gf180mcu_fd_sc_mcu7t5v0__filltie
X_05270_ _09405_/A1 _05274_/A2 _05274_/B1 _05270_/B2 _09429_/D vdd vdd
+ vss vss gf180mcu_fd_sc_mcu7t5v0__oai22_1
X_08960_ _08958_/Z _08960_/A2 _09822_/D vdd vdd vss vss gf180mcu_fd_sc_mcu7t5v0__nor2_1
X_07911_ _09715_/Q _07912_/A2 _07911_/Z vdd vdd vss vss gf180mcu_fd_sc_mcu7t5v0__and2_1
X_08891_ _08891_/A1 _08891_/A2 _09790_/D vdd vdd vss vss gf180mcu_fd_sc_mcu7t5v0__nor2_1
X_07842_ _07870_/A1 _07869_/A1 _07839_/Z _07845_/B vdd vdd vss vss
+ gf180mcu_fd_sc_mcu7t5v0__xnor3_1
X_09512_ _09512_/D clk _09512_/Q vdd vdd vss vss gf180mcu_fd_sc_mcu7t5v0__dffq_1
X_04985_ _09546_/Q _05396_/B2 vdd vdd vss vss gf180mcu_fd_sc_mcu7t5v0__clkinv_1
X_07773_ _07920_/A1 _07766_/Z _07773_/B _07774_/B2 vdd vdd vss vss
+ gf180mcu_fd_sc_mcu7t5v0__oai21_1
X_06724_ _09615_/Q _06740_/A2 _06745_/A2 vdd vdd vss vss gf180mcu_fd_sc_mcu7t5v0__nor2_1
X_09443_ _09443_/D clk _09443_/Q vdd vdd vss vss gf180mcu_fd_sc_mcu7t5v0__dffq_1
X_06655_ _06967_/A1 _06666_/A2 _06781_/C vdd vdd vss vss gf180mcu_fd_sc_mcu7t5v0__nor2_4
XPHY_219 vdd vss gf180mcu_fd_sc_mcu7t5v0__endcap
X_05606_ _09646_/Q _05627_/A2 _05627_/B1 _09701_/Q _05608_/A1 vdd vdd
+ vss vss gf180mcu_fd_sc_mcu7t5v0__aoi22_1
X_09374_ _10007_/Q _09377_/A2 _09375_/B vdd vdd vss vss gf180mcu_fd_sc_mcu7t5v0__nor2_1
XPHY_208 vdd vss gf180mcu_fd_sc_mcu7t5v0__endcap
X_06586_ _09716_/Q _06587_/A3 _06624_/A2 vdd vdd vss vss gf180mcu_fd_sc_mcu7t5v0__nor2_1
X_08325_ _08325_/A1 _08308_/Z _08325_/B _08349_/A2 vdd vdd vss vss
+ gf180mcu_fd_sc_mcu7t5v0__aoi21_1
X_05537_ _09012_/A1 _05537_/A2 _05537_/B1 _09002_/A2 _05546_/A1 vdd vdd
+ vss vss gf180mcu_fd_sc_mcu7t5v0__aoi22_1
X_05468_ _09662_/Q _05628_/A2 _05628_/B1 _09725_/Q _05469_/A2 vdd vdd
+ vss vss gf180mcu_fd_sc_mcu7t5v0__aoi22_1
X_08256_ _08256_/A1 _08256_/A2 _08311_/A1 vdd vdd vss vss gf180mcu_fd_sc_mcu7t5v0__nand2_1
X_08187_ _08188_/A1 _08237_/A1 _08189_/A3 vdd vdd vss vss gf180mcu_fd_sc_mcu7t5v0__nor2_1
X_07207_ _07208_/A1 _07208_/A2 _07207_/Z vdd vdd vss vss gf180mcu_fd_sc_mcu7t5v0__and2_1
X_05399_ _09409_/A1 _05399_/A2 _05399_/B1 _05399_/B2 _09549_/D vdd vdd
+ vss vss gf180mcu_fd_sc_mcu7t5v0__oai22_1
X_07138_ _07289_/B _07138_/A2 _07133_/Z _07138_/A4 _07139_/B vdd vdd vss
+ vss gf180mcu_fd_sc_mcu7t5v0__nand4_1
X_07069_ _07069_/A1 _07110_/A1 _07071_/A2 vdd vdd vss vss gf180mcu_fd_sc_mcu7t5v0__xnor2_1
XTAP_706 vdd vss gf180mcu_fd_sc_mcu7t5v0__filltie
XTAP_739 vdd vss gf180mcu_fd_sc_mcu7t5v0__filltie
XTAP_717 vdd vss gf180mcu_fd_sc_mcu7t5v0__filltie
XTAP_728 vdd vss gf180mcu_fd_sc_mcu7t5v0__filltie
X_04770_ _09693_/Q _08375_/A1 vdd vdd vss vss gf180mcu_fd_sc_mcu7t5v0__inv_3
X_06440_ _06601_/A2 _06482_/A1 _06440_/Z vdd vdd vss vss gf180mcu_fd_sc_mcu7t5v0__xor2_1
X_06371_ _06628_/B2 _06394_/A1 _06371_/B _06590_/C _06378_/B2 vdd vdd
+ vss vss gf180mcu_fd_sc_mcu7t5v0__aoi211_1
X_05322_ _09402_/A1 _05329_/A2 _05329_/B1 _05322_/B2 _09482_/D vdd vdd
+ vss vss gf180mcu_fd_sc_mcu7t5v0__oai22_1
X_08110_ _08096_/Z _08110_/A2 _08110_/Z vdd vdd vss vss gf180mcu_fd_sc_mcu7t5v0__xor2_1
X_09090_ _09098_/A1 _09090_/A2 _09090_/B _09893_/D vdd vdd vss vss
+ gf180mcu_fd_sc_mcu7t5v0__aoi21_1
X_05253_ _09402_/A1 _05260_/A2 _05260_/B1 _05253_/B2 _09418_/D vdd vdd
+ vss vss gf180mcu_fd_sc_mcu7t5v0__oai22_1
X_08041_ _09691_/Q _08369_/A1 _09689_/Q _08217_/A1 vdd vdd vss vss
+ gf180mcu_fd_sc_mcu7t5v0__nand3_2
X_05184_ _09926_/Q _09175_/A3 _05184_/B _05185_/A4 vdd vdd vss vss
+ gf180mcu_fd_sc_mcu7t5v0__aoi21_1
X_09992_ _09992_/D clk _09992_/Q vdd vdd vss vss gf180mcu_fd_sc_mcu7t5v0__dffq_1
X_08943_ _09817_/Q _08941_/Z _08945_/A2 vdd vdd vss vss gf180mcu_fd_sc_mcu7t5v0__nor2_1
X_08874_ _08899_/A2 _08874_/A2 _08874_/B _09786_/D vdd vdd vss vss
+ gf180mcu_fd_sc_mcu7t5v0__aoi21_1
X_07825_ _08202_/B _09680_/Q _08024_/A1 _07882_/A2 vdd vdd vss vss
+ gf180mcu_fd_sc_mcu7t5v0__nand3_2
X_07756_ _07756_/A1 _07753_/Z _07756_/Z vdd vdd vss vss gf180mcu_fd_sc_mcu7t5v0__xor2_1
X_04968_ _09697_/Q _08381_/B2 vdd vdd vss vss gf180mcu_fd_sc_mcu7t5v0__clkinv_1
X_06707_ _09613_/Q _06674_/B _06706_/Z _06713_/A2 vdd vdd vss vss
+ gf180mcu_fd_sc_mcu7t5v0__nand3_1
X_04899_ _09499_/Q _05343_/B2 vdd vdd vss vss gf180mcu_fd_sc_mcu7t5v0__clkinv_1
X_07687_ _08022_/A1 _09677_/Q _08018_/A1 _08011_/A1 vdd vdd vss vss
+ gf180mcu_fd_sc_mcu7t5v0__nand3_4
X_09426_ _09426_/D clk _09426_/Q vdd vdd vss vss gf180mcu_fd_sc_mcu7t5v0__dffq_1
X_06638_ _06638_/A1 _09073_/A2 _06638_/B _09602_/D vdd vdd vss vss
+ gf180mcu_fd_sc_mcu7t5v0__aoi21_1
X_06569_ _06570_/A1 _06570_/A2 _06618_/S vdd vdd vss vss gf180mcu_fd_sc_mcu7t5v0__nor2_1
X_09357_ _09999_/Q _09366_/A2 _09358_/B vdd vdd vss vss gf180mcu_fd_sc_mcu7t5v0__nor2_1
X_08308_ _08308_/A1 _08308_/A2 _08306_/B _08308_/Z vdd vdd vss vss
+ gf180mcu_fd_sc_mcu7t5v0__xor3_1
X_09288_ _09300_/A1 _09334_/A1 _09298_/A2 vdd vdd vss vss gf180mcu_fd_sc_mcu7t5v0__nor2_4
X_08239_ _09673_/Q _08132_/Z _08331_/B1 _09631_/Q _08287_/A2 vdd vdd vss
+ vss gf180mcu_fd_sc_mcu7t5v0__aoi22_2
XTAP_503 vdd vss gf180mcu_fd_sc_mcu7t5v0__filltie
XTAP_514 vdd vss gf180mcu_fd_sc_mcu7t5v0__filltie
XTAP_525 vdd vss gf180mcu_fd_sc_mcu7t5v0__filltie
XTAP_558 vdd vss gf180mcu_fd_sc_mcu7t5v0__filltie
XTAP_547 vdd vss gf180mcu_fd_sc_mcu7t5v0__filltie
XTAP_536 vdd vss gf180mcu_fd_sc_mcu7t5v0__filltie
X_05940_ _09717_/Q _05940_/A2 _05953_/A1 vdd vdd vss vss gf180mcu_fd_sc_mcu7t5v0__nand2_1
XTAP_569 vdd vss gf180mcu_fd_sc_mcu7t5v0__filltie
X_05871_ _09715_/Q _05836_/Z _05873_/A2 vdd vdd vss vss gf180mcu_fd_sc_mcu7t5v0__nand2_1
X_04822_ _09601_/Q _06636_/A1 vdd vdd vss vss gf180mcu_fd_sc_mcu7t5v0__clkinv_1
X_08590_ _08524_/Z _08617_/A2 _08590_/Z vdd vdd vss vss gf180mcu_fd_sc_mcu7t5v0__or2_1
X_07610_ _07610_/A1 _07644_/A2 _07611_/A2 vdd vdd vss vss gf180mcu_fd_sc_mcu7t5v0__nand2_1
X_07541_ _07541_/A1 _07566_/B2 _07537_/Z _07541_/Z vdd vdd vss vss
+ gf180mcu_fd_sc_mcu7t5v0__xor3_1
X_04753_ _09720_/Q _08731_/A1 vdd vdd vss vss gf180mcu_fd_sc_mcu7t5v0__clkinv_3
X_07472_ _09706_/Q _07664_/A1 _07472_/B _07474_/B2 vdd vdd vss vss
+ gf180mcu_fd_sc_mcu7t5v0__oai21_2
X_06423_ _09711_/Q _06603_/A2 _06464_/A1 vdd vdd vss vss gf180mcu_fd_sc_mcu7t5v0__nand2_1
X_09211_ _09173_/B _09260_/A2 _09211_/B _09934_/D vdd vdd vss vss
+ gf180mcu_fd_sc_mcu7t5v0__aoi21_1
X_09142_ _09943_/Q _09137_/Z _09170_/B1 _09917_/Q _09142_/C _09143_/A2 vdd vdd
+ vss vss gf180mcu_fd_sc_mcu7t5v0__aoi221_1
X_06354_ _09592_/Q _08706_/B _08708_/B _06354_/C _06355_/I vdd vdd vss
+ vss gf180mcu_fd_sc_mcu7t5v0__oai211_1
X_05305_ _09408_/A1 _05306_/A2 _05306_/B1 _05305_/B2 _09456_/D vdd vdd
+ vss vss gf180mcu_fd_sc_mcu7t5v0__oai22_1
X_06285_ _06285_/A1 _06277_/Z _06284_/Z _06285_/Z vdd vdd vss vss
+ gf180mcu_fd_sc_mcu7t5v0__xor3_1
X_09073_ _09073_/A1 _09073_/A2 _09073_/B _09890_/D vdd vdd vss vss
+ gf180mcu_fd_sc_mcu7t5v0__aoi21_1
X_08024_ _08024_/A1 _09104_/A2 _08024_/B _09679_/D vdd vdd vss vss
+ gf180mcu_fd_sc_mcu7t5v0__aoi21_1
X_05236_ _09562_/Q _05217_/S _05236_/B _09406_/A1 vdd vdd vss vss
+ gf180mcu_fd_sc_mcu7t5v0__aoi21_4
X_05167_ _09226_/B _09734_/Q _05168_/B1 vdd vdd vss vss gf180mcu_fd_sc_mcu7t5v0__nand2_1
X_09975_ _09975_/D clk _09975_/Q vdd vdd vss vss gf180mcu_fd_sc_mcu7t5v0__dffq_1
X_05098_ _09646_/Q _07312_/B2 vdd vdd vss vss gf180mcu_fd_sc_mcu7t5v0__clkinv_1
X_08926_ _09525_/Q _09523_/Q _09524_/Q _08926_/B _08927_/I vdd vdd vss
+ vss gf180mcu_fd_sc_mcu7t5v0__oai31_4
X_08857_ _09523_/Q _05121_/Z _08866_/B2 vdd vdd vss vss gf180mcu_fd_sc_mcu7t5v0__nand2_2
X_07808_ _07808_/A1 _07808_/A2 _07807_/B _07815_/B1 vdd vdd vss vss
+ gf180mcu_fd_sc_mcu7t5v0__nand3_1
X_08788_ _08788_/A1 _08851_/A1 _08788_/B _09756_/D vdd vdd vss vss
+ gf180mcu_fd_sc_mcu7t5v0__aoi21_1
X_07739_ _09670_/Q _08565_/C _07775_/A1 vdd vdd vss vss gf180mcu_fd_sc_mcu7t5v0__nand2_1
X_09409_ _09409_/A1 _09409_/A2 _09409_/B1 _09409_/B2 _10026_/D vdd vdd
+ vss vss gf180mcu_fd_sc_mcu7t5v0__oai22_1
X_06070_ _09712_/Q _06050_/I _06069_/Z _06259_/C _06074_/B1 vdd vdd vss
+ vss gf180mcu_fd_sc_mcu7t5v0__oai22_1
X_05021_ _09447_/Q _05294_/B2 vdd vdd vss vss gf180mcu_fd_sc_mcu7t5v0__clkinv_1
XTAP_333 vdd vss gf180mcu_fd_sc_mcu7t5v0__filltie
XTAP_322 vdd vss gf180mcu_fd_sc_mcu7t5v0__filltie
XTAP_311 vdd vss gf180mcu_fd_sc_mcu7t5v0__filltie
XTAP_300 vdd vss gf180mcu_fd_sc_mcu7t5v0__filltie
XTAP_344 vdd vss gf180mcu_fd_sc_mcu7t5v0__filltie
XTAP_366 vdd vss gf180mcu_fd_sc_mcu7t5v0__filltie
XTAP_355 vdd vss gf180mcu_fd_sc_mcu7t5v0__filltie
X_06972_ _07296_/A1 _09634_/Q _06986_/A2 vdd vdd vss vss gf180mcu_fd_sc_mcu7t5v0__nor2_2
X_09760_ _09760_/D clk _09760_/Q vdd vdd vss vss gf180mcu_fd_sc_mcu7t5v0__dffq_1
XTAP_377 vdd vss gf180mcu_fd_sc_mcu7t5v0__filltie
XTAP_388 vdd vss gf180mcu_fd_sc_mcu7t5v0__filltie
XTAP_399 vdd vss gf180mcu_fd_sc_mcu7t5v0__filltie
X_09691_ _09691_/D clk _09691_/Q vdd vdd vss vss gf180mcu_fd_sc_mcu7t5v0__dffq_2
X_08711_ _08291_/B _09104_/A2 _08711_/B _09710_/D vdd vdd vss vss
+ gf180mcu_fd_sc_mcu7t5v0__aoi21_1
X_05923_ _05932_/A2 _05962_/B _05923_/Z vdd vdd vss vss gf180mcu_fd_sc_mcu7t5v0__xor2_1
X_08642_ _08643_/A1 _08640_/Z _08674_/A2 vdd vdd vss vss gf180mcu_fd_sc_mcu7t5v0__nor2_1
X_05854_ _05855_/A2 _05852_/Z _05882_/A2 _05915_/A1 vdd vdd vss vss
+ gf180mcu_fd_sc_mcu7t5v0__nand3_1
XPHY_17 vdd vss gf180mcu_fd_sc_mcu7t5v0__endcap
XPHY_28 vdd vss gf180mcu_fd_sc_mcu7t5v0__endcap
X_08573_ _08587_/A1 _08572_/Z _08618_/B vdd vdd vss vss gf180mcu_fd_sc_mcu7t5v0__nor2_1
X_04805_ _09630_/Q _08182_/A1 vdd vdd vss vss gf180mcu_fd_sc_mcu7t5v0__inv_1
X_05785_ _09879_/Q _09570_/Q _09569_/Q _05787_/B vdd vdd vss vss gf180mcu_fd_sc_mcu7t5v0__nand3_2
XPHY_39 vdd vss gf180mcu_fd_sc_mcu7t5v0__endcap
X_04736_ _09760_/Q _08796_/A1 vdd vdd vss vss gf180mcu_fd_sc_mcu7t5v0__clkinv_1
X_07524_ _07519_/I _07522_/B _07524_/A3 _07524_/Z vdd vdd vss vss
+ gf180mcu_fd_sc_mcu7t5v0__xor3_1
X_07455_ _07610_/A1 _07577_/B _07457_/A3 vdd vdd vss vss gf180mcu_fd_sc_mcu7t5v0__nand2_1
X_06406_ _06406_/A1 _06366_/Z _06406_/B _06445_/A2 vdd vdd vss vss
+ gf180mcu_fd_sc_mcu7t5v0__oai21_1
X_07386_ _09710_/Q _07575_/A2 _07575_/A3 _07467_/A1 vdd vdd vss vss
+ gf180mcu_fd_sc_mcu7t5v0__nand3_2
X_06337_ _09601_/Q _09600_/Q _06491_/A1 vdd vdd vss vss gf180mcu_fd_sc_mcu7t5v0__nand2_2
X_09125_ _09937_/Q _09116_/I _09136_/A2 _09910_/Q _09126_/A2 vdd vdd vss
+ vss gf180mcu_fd_sc_mcu7t5v0__aoi22_1
X_06268_ _06268_/A1 _06219_/Z _06268_/B _06286_/A1 vdd vdd vss vss
+ gf180mcu_fd_sc_mcu7t5v0__oai21_1
X_09056_ _09882_/Q _09103_/A2 _09057_/A2 vdd vdd vss vss gf180mcu_fd_sc_mcu7t5v0__nand2_1
X_08007_ _08011_/B1 _08007_/A2 _08009_/B vdd vdd vss vss gf180mcu_fd_sc_mcu7t5v0__xnor2_1
X_05219_ _05250_/A2 _05276_/A3 _05627_/A2 vdd vdd vss vss gf180mcu_fd_sc_mcu7t5v0__nor2_4
X_06199_ _06148_/Z _06200_/A2 _06200_/B _06199_/Z vdd vdd vss vss
+ gf180mcu_fd_sc_mcu7t5v0__or3_1
X_09958_ _09958_/D clk _09958_/Q vdd vdd vss vss gf180mcu_fd_sc_mcu7t5v0__dffq_1
X_08909_ _09405_/A1 _08913_/A2 _08913_/B1 _08909_/B2 _09797_/D vdd vdd
+ vss vss gf180mcu_fd_sc_mcu7t5v0__oai22_1
X_09889_ _09889_/D clk _09889_/Q vdd vdd vss vss gf180mcu_fd_sc_mcu7t5v0__dffq_2
X_10029_ clk_PU vdd vdd vss vss gf180mcu_fd_sc_mcu7t5v0__tiel
X_05570_ _09519_/Q _05628_/A2 _05628_/B1 _09479_/Q _05571_/A2 vdd vdd
+ vss vss gf180mcu_fd_sc_mcu7t5v0__aoi22_1
X_07240_ _09716_/Q _07239_/Z _07240_/Z vdd vdd vss vss gf180mcu_fd_sc_mcu7t5v0__and2_1
X_07171_ _07172_/A1 _07170_/Z _07195_/B vdd vdd vss vss gf180mcu_fd_sc_mcu7t5v0__nand2_1
X_06122_ _06124_/A1 _06123_/A2 _06163_/B vdd vdd vss vss gf180mcu_fd_sc_mcu7t5v0__nand2_1
X_06053_ _06026_/S _06048_/B _06089_/A1 _06056_/A2 vdd vdd vss vss
+ gf180mcu_fd_sc_mcu7t5v0__xnor3_1
X_05004_ _09588_/Q _06320_/B2 vdd vdd vss vss gf180mcu_fd_sc_mcu7t5v0__clkinv_1
X_09812_ _09812_/D clk _09812_/Q vdd vdd vss vss gf180mcu_fd_sc_mcu7t5v0__dffq_1
X_06955_ _06955_/A1 _06951_/Z _06957_/B vdd vdd vss vss gf180mcu_fd_sc_mcu7t5v0__nand2_1
X_09743_ _09743_/D clk _09743_/Q vdd vdd vss vss gf180mcu_fd_sc_mcu7t5v0__dffq_1
X_05906_ _05898_/I _05906_/A2 _05906_/A3 _05906_/Z vdd vdd vss vss
+ gf180mcu_fd_sc_mcu7t5v0__xor3_1
X_09674_ _09674_/D clk _09674_/Q vdd vdd vss vss gf180mcu_fd_sc_mcu7t5v0__dffq_2
X_06886_ _09714_/Q _06719_/I _06939_/B2 vdd vdd vss vss gf180mcu_fd_sc_mcu7t5v0__nand2_1
XTAP_2008 vdd vss gf180mcu_fd_sc_mcu7t5v0__filltie
XTAP_2019 vdd vss gf180mcu_fd_sc_mcu7t5v0__filltie
X_05837_ _09710_/Q _05836_/Z _05837_/Z vdd vdd vss vss gf180mcu_fd_sc_mcu7t5v0__and2_1
X_08625_ _08625_/I _08674_/A1 vdd vdd vss vss gf180mcu_fd_sc_mcu7t5v0__clkinv_1
X_08556_ _07506_/B _08554_/Z _08556_/Z vdd vdd vss vss gf180mcu_fd_sc_mcu7t5v0__xor2_1
XTAP_1307 vdd vss gf180mcu_fd_sc_mcu7t5v0__filltie
XTAP_1318 vdd vss gf180mcu_fd_sc_mcu7t5v0__filltie
XTAP_1329 vdd vss gf180mcu_fd_sc_mcu7t5v0__filltie
X_05768_ _05810_/A1 _05767_/Z _05768_/Z vdd vdd vss vss gf180mcu_fd_sc_mcu7t5v0__or2_1
X_07507_ _09714_/Q _07475_/I _07612_/B _07508_/A3 vdd vdd vss vss
+ gf180mcu_fd_sc_mcu7t5v0__aoi21_1
X_08487_ _08487_/I _08551_/B vdd vdd vss vss gf180mcu_fd_sc_mcu7t5v0__clkinv_1
X_04719_ _09912_/Q _05137_/A4 vdd vdd vss vss gf180mcu_fd_sc_mcu7t5v0__clkinv_1
X_05699_ _05693_/Z _05699_/A2 _05699_/B _05699_/C _05700_/B vdd vdd
+ vss vss gf180mcu_fd_sc_mcu7t5v0__oai211_1
X_07438_ _07464_/A1 _07436_/Z _07515_/B3 vdd vdd vss vss gf180mcu_fd_sc_mcu7t5v0__xnor2_1
X_07369_ _07369_/A1 _07369_/A2 _07396_/B _07376_/B1 vdd vdd vss vss
+ gf180mcu_fd_sc_mcu7t5v0__oai21_1
X_09108_ _09403_/A1 _09114_/A2 _09114_/B1 _09108_/B2 _09901_/D vdd vdd
+ vss vss gf180mcu_fd_sc_mcu7t5v0__oai22_1
X_09039_ _09039_/A1 _09039_/A2 _09399_/C _09876_/D vdd vdd vss vss
+ gf180mcu_fd_sc_mcu7t5v0__aoi21_1
XTAP_1852 vdd vss gf180mcu_fd_sc_mcu7t5v0__filltie
XTAP_1841 vdd vss gf180mcu_fd_sc_mcu7t5v0__filltie
XTAP_1830 vdd vss gf180mcu_fd_sc_mcu7t5v0__filltie
XTAP_1885 vdd vss gf180mcu_fd_sc_mcu7t5v0__filltie
XTAP_1863 vdd vss gf180mcu_fd_sc_mcu7t5v0__filltie
XTAP_1874 vdd vss gf180mcu_fd_sc_mcu7t5v0__filltie
XTAP_1896 vdd vss gf180mcu_fd_sc_mcu7t5v0__filltie
X_06740_ _06669_/I _06740_/A2 _06740_/B1 _06958_/A1 _06740_/C _06741_/B2 vdd
+ vdd vss vss gf180mcu_fd_sc_mcu7t5v0__aoi221_1
X_06671_ _09623_/Q _09622_/Q _06728_/A2 vdd vdd vss vss gf180mcu_fd_sc_mcu7t5v0__nor2_2
X_05622_ _09834_/Q _05628_/A2 _05628_/B1 _10026_/Q _05623_/A2 vdd vdd
+ vss vss gf180mcu_fd_sc_mcu7t5v0__aoi22_1
X_08410_ _09710_/Q _08700_/A2 _08510_/B _08411_/A2 vdd vdd vss vss
+ gf180mcu_fd_sc_mcu7t5v0__aoi21_1
X_09390_ _10014_/Q _09399_/A2 _09391_/B vdd vdd vss vss gf180mcu_fd_sc_mcu7t5v0__nor2_1
X_08341_ _08341_/A1 _08341_/A2 _08285_/Z _08341_/B2 _08345_/A2 vdd vdd
+ vss vss gf180mcu_fd_sc_mcu7t5v0__oai22_1
X_05553_ _05553_/A1 _05553_/A2 _05574_/A2 vdd vdd vss vss gf180mcu_fd_sc_mcu7t5v0__nand2_1
X_08272_ _08272_/A1 _08272_/A2 _08272_/B _08325_/A1 vdd vdd vss vss
+ gf180mcu_fd_sc_mcu7t5v0__oai21_1
X_05484_ _05484_/A1 _05484_/A2 _05487_/C1 vdd vdd vss vss gf180mcu_fd_sc_mcu7t5v0__nand2_1
X_07223_ _07224_/A1 _07222_/Z _07256_/B vdd vdd vss vss gf180mcu_fd_sc_mcu7t5v0__and2_1
X_07154_ _09712_/Q _07065_/Z _07269_/A1 vdd vdd vss vss gf180mcu_fd_sc_mcu7t5v0__nand2_1
X_06105_ _09713_/Q _06085_/Z _06105_/A3 _06106_/B vdd vdd vss vss
+ gf180mcu_fd_sc_mcu7t5v0__xor3_1
X_07085_ _07086_/A1 _07084_/Z _07085_/Z vdd vdd vss vss gf180mcu_fd_sc_mcu7t5v0__or2_1
X_06036_ _09572_/Q _06036_/A2 _06036_/A3 _06043_/A1 vdd vdd vss vss
+ gf180mcu_fd_sc_mcu7t5v0__nand3_1
X_07987_ _09716_/Q _07712_/Z _07991_/A2 vdd vdd vss vss gf180mcu_fd_sc_mcu7t5v0__nand2_1
X_09726_ _09726_/D clk _09726_/Q vdd vdd vss vss gf180mcu_fd_sc_mcu7t5v0__dffq_1
X_06938_ _06934_/Z _06938_/A2 _06937_/Z _06938_/Z vdd vdd vss vss
+ gf180mcu_fd_sc_mcu7t5v0__xor3_1
XTAP_1104 vdd vss gf180mcu_fd_sc_mcu7t5v0__filltie
X_06869_ _09715_/Q _06845_/Z _06871_/A2 vdd vdd vss vss gf180mcu_fd_sc_mcu7t5v0__nand2_1
X_09657_ _09657_/D clk _09657_/Q vdd vdd vss vss gf180mcu_fd_sc_mcu7t5v0__dffq_2
X_09588_ _09588_/D clk _09588_/Q vdd vdd vss vss gf180mcu_fd_sc_mcu7t5v0__dffq_1
X_08608_ _08608_/I _08611_/B1 vdd vdd vss vss gf180mcu_fd_sc_mcu7t5v0__clkinv_1
XTAP_1115 vdd vss gf180mcu_fd_sc_mcu7t5v0__filltie
XTAP_1126 vdd vss gf180mcu_fd_sc_mcu7t5v0__filltie
XTAP_1137 vdd vss gf180mcu_fd_sc_mcu7t5v0__filltie
X_08539_ _08541_/A1 _08538_/Z _08569_/B vdd vdd vss vss gf180mcu_fd_sc_mcu7t5v0__nor2_1
XTAP_1159 vdd vss gf180mcu_fd_sc_mcu7t5v0__filltie
XTAP_1148 vdd vss gf180mcu_fd_sc_mcu7t5v0__filltie
XTAP_1660 vdd vss gf180mcu_fd_sc_mcu7t5v0__filltie
XTAP_1693 vdd vss gf180mcu_fd_sc_mcu7t5v0__filltie
XTAP_1682 vdd vss gf180mcu_fd_sc_mcu7t5v0__filltie
XTAP_1671 vdd vss gf180mcu_fd_sc_mcu7t5v0__filltie
X_07910_ _07988_/A2 _07962_/B _07912_/A2 vdd vdd vss vss gf180mcu_fd_sc_mcu7t5v0__xnor2_1
X_08890_ _09922_/Q _08897_/A2 _08890_/B _08891_/A2 vdd vdd vss vss
+ gf180mcu_fd_sc_mcu7t5v0__aoi21_1
X_07841_ _07870_/A1 _07870_/B _07841_/Z vdd vdd vss vss gf180mcu_fd_sc_mcu7t5v0__and2_1
X_07772_ _08001_/A1 _07756_/Z _07772_/B _07773_/B vdd vdd vss vss
+ gf180mcu_fd_sc_mcu7t5v0__aoi21_1
X_04984_ _09847_/Q _08998_/B2 vdd vdd vss vss gf180mcu_fd_sc_mcu7t5v0__clkinv_1
X_09511_ _09511_/D clk _09511_/Q vdd vdd vss vss gf180mcu_fd_sc_mcu7t5v0__dffq_1
X_06723_ _06723_/A1 _06721_/Z _06740_/A2 vdd vdd vss vss gf180mcu_fd_sc_mcu7t5v0__xnor2_1
X_09442_ _09442_/D clk _09442_/Q vdd vdd vss vss gf180mcu_fd_sc_mcu7t5v0__dffq_1
X_06654_ _09622_/Q _06963_/A1 _06666_/A2 vdd vdd vss vss gf180mcu_fd_sc_mcu7t5v0__nand2_2
X_06585_ _09716_/Q _06587_/A3 _06624_/B vdd vdd vss vss gf180mcu_fd_sc_mcu7t5v0__nand2_1
X_05605_ _09278_/C _05605_/A2 _09556_/D vdd vdd vss vss gf180mcu_fd_sc_mcu7t5v0__and2_1
X_09373_ _09395_/A1 _09377_/A2 _09373_/B _09399_/C _10006_/D vdd vdd vss
+ vss gf180mcu_fd_sc_mcu7t5v0__aoi211_1
XPHY_209 vdd vss gf180mcu_fd_sc_mcu7t5v0__endcap
X_08324_ _08324_/A1 _08324_/A2 _08670_/B _09687_/D vdd vdd vss vss
+ gf180mcu_fd_sc_mcu7t5v0__aoi21_1
X_05536_ _05536_/A1 _05536_/A2 _05537_/B1 vdd vdd vss vss gf180mcu_fd_sc_mcu7t5v0__nand2_1
X_08255_ _09686_/Q _08272_/A1 _08252_/Z _08255_/Z vdd vdd vss vss
+ gf180mcu_fd_sc_mcu7t5v0__xor3_1
X_05467_ _09641_/Q _05627_/A2 _05627_/B1 _09696_/Q _05469_/A1 vdd vdd
+ vss vss gf180mcu_fd_sc_mcu7t5v0__aoi22_1
X_05398_ _09408_/A1 _05399_/A2 _05399_/B1 _05398_/B2 _09548_/D vdd vdd
+ vss vss gf180mcu_fd_sc_mcu7t5v0__oai22_1
X_08186_ _08177_/Z _08235_/A2 _08235_/B _09711_/Q _08237_/A1 vdd vdd vss
+ vss gf180mcu_fd_sc_mcu7t5v0__oai211_2
X_07206_ _09713_/Q _07106_/Z _07269_/A2 vdd vdd vss vss gf180mcu_fd_sc_mcu7t5v0__nand2_1
X_07137_ _09714_/Q _07106_/Z _07137_/B _07138_/A4 vdd vdd vss vss
+ gf180mcu_fd_sc_mcu7t5v0__oai21_1
X_07068_ _09711_/Q _09710_/Q _07033_/Z _07065_/Z _07103_/A2 vdd vdd vss
+ vss gf180mcu_fd_sc_mcu7t5v0__nand4_2
X_06019_ _06016_/I _06018_/Z _06019_/Z vdd vdd vss vss gf180mcu_fd_sc_mcu7t5v0__xor2_1
X_09709_ _09709_/D clk _09709_/Q vdd vdd vss vss gf180mcu_fd_sc_mcu7t5v0__dffq_1
XTAP_707 vdd vss gf180mcu_fd_sc_mcu7t5v0__filltie
XTAP_718 vdd vss gf180mcu_fd_sc_mcu7t5v0__filltie
XTAP_729 vdd vss gf180mcu_fd_sc_mcu7t5v0__filltie
X_06370_ _06591_/A1 _06394_/A1 _06371_/B vdd vdd vss vss gf180mcu_fd_sc_mcu7t5v0__nor2_1
XTAP_1490 vdd vss gf180mcu_fd_sc_mcu7t5v0__filltie
X_05321_ _09401_/A1 _05329_/A2 _05329_/B1 vdd vdd vss vss gf180mcu_fd_sc_mcu7t5v0__nand2_2
X_05252_ _09013_/A1 _05260_/A2 _05260_/B1 vdd vdd vss vss gf180mcu_fd_sc_mcu7t5v0__nand2_2
X_08040_ _08367_/A1 _08040_/A2 _08351_/A1 vdd vdd vss vss gf180mcu_fd_sc_mcu7t5v0__nor2_4
X_05183_ _09470_/Q _09257_/B _05184_/B vdd vdd vss vss gf180mcu_fd_sc_mcu7t5v0__nand2_1
X_09991_ _09991_/D clk _09991_/Q vdd vdd vss vss gf180mcu_fd_sc_mcu7t5v0__dffq_1
X_08942_ _08927_/I _08942_/A2 _08941_/Z _09816_/D vdd vdd vss vss
+ gf180mcu_fd_sc_mcu7t5v0__nor3_1
X_08873_ _09786_/Q _08899_/A2 _09226_/B _08874_/B vdd vdd vss vss
+ gf180mcu_fd_sc_mcu7t5v0__oai21_1
X_07824_ _07780_/I _07871_/A2 _07824_/A3 _07839_/A2 vdd vdd vss vss
+ gf180mcu_fd_sc_mcu7t5v0__xnor3_1
X_07755_ _07755_/I _07869_/B2 vdd vdd vss vss gf180mcu_fd_sc_mcu7t5v0__clkinv_1
X_04967_ _09726_/Q _08741_/B2 vdd vdd vss vss gf180mcu_fd_sc_mcu7t5v0__clkinv_1
X_07686_ _09678_/Q _08020_/A1 _08018_/A1 _08011_/B2 vdd vdd vss vss
+ gf180mcu_fd_sc_mcu7t5v0__nand3_1
X_06706_ _09614_/Q _06706_/A2 _06706_/Z vdd vdd vss vss gf180mcu_fd_sc_mcu7t5v0__xor2_1
X_04898_ _09527_/Q _05373_/B2 vdd vdd vss vss gf180mcu_fd_sc_mcu7t5v0__clkinv_1
X_09425_ _09425_/D clk _09425_/Q vdd vdd vss vss gf180mcu_fd_sc_mcu7t5v0__dffq_1
X_06637_ _10006_/Q _09073_/A2 _08734_/B _06638_/B vdd vdd vss vss
+ gf180mcu_fd_sc_mcu7t5v0__oai21_1
X_06568_ _06568_/A1 _06566_/Z _06570_/A2 vdd vdd vss vss gf180mcu_fd_sc_mcu7t5v0__xnor2_1
X_09356_ _05108_/Z _09356_/A2 _09366_/A2 vdd vdd vss vss gf180mcu_fd_sc_mcu7t5v0__nor2_4
X_06499_ _06499_/A1 _06499_/A2 _06499_/B _06520_/A1 vdd vdd vss vss
+ gf180mcu_fd_sc_mcu7t5v0__aoi21_1
X_08307_ _09687_/Q _08305_/Z _08326_/A2 _08325_/B vdd vdd vss vss
+ gf180mcu_fd_sc_mcu7t5v0__and3_1
X_05519_ _09530_/Q _05627_/A2 _05627_/B1 _09538_/Q _05521_/A1 vdd vdd
+ vss vss gf180mcu_fd_sc_mcu7t5v0__aoi22_1
X_09287_ _09378_/A2 _09262_/Z _09334_/A1 vdd vdd vss vss gf180mcu_fd_sc_mcu7t5v0__nand2_2
X_08238_ _09707_/Q _09693_/Q _08180_/B _08287_/A1 vdd vdd vss vss
+ gf180mcu_fd_sc_mcu7t5v0__nand3_2
X_08169_ _08706_/B _08169_/A2 _08169_/A3 _08170_/A2 vdd vdd vss vss
+ gf180mcu_fd_sc_mcu7t5v0__nand3_1
XTAP_504 vdd vss gf180mcu_fd_sc_mcu7t5v0__filltie
XTAP_515 vdd vss gf180mcu_fd_sc_mcu7t5v0__filltie
XTAP_548 vdd vss gf180mcu_fd_sc_mcu7t5v0__filltie
XTAP_537 vdd vss gf180mcu_fd_sc_mcu7t5v0__filltie
XTAP_526 vdd vss gf180mcu_fd_sc_mcu7t5v0__filltie
XTAP_559 vdd vss gf180mcu_fd_sc_mcu7t5v0__filltie
X_05870_ _05870_/A1 _05867_/Z _05870_/B _05877_/A2 vdd vdd vss vss
+ gf180mcu_fd_sc_mcu7t5v0__aoi21_1
X_04821_ _09602_/Q _06638_/A1 vdd vdd vss vss gf180mcu_fd_sc_mcu7t5v0__clkinv_3
X_04752_ _09721_/Q _08733_/A1 vdd vdd vss vss gf180mcu_fd_sc_mcu7t5v0__clkinv_1
X_07540_ _07541_/A1 _07539_/Z _07596_/A1 vdd vdd vss vss gf180mcu_fd_sc_mcu7t5v0__nor2_1
X_07471_ _08546_/A1 _09658_/Q _09659_/Q _07527_/A2 vdd vdd vss vss
+ gf180mcu_fd_sc_mcu7t5v0__aoi21_2
X_06422_ _06422_/A1 _06430_/A1 _06422_/B1 _06422_/B2 _06432_/A1 vdd vdd
+ vss vss gf180mcu_fd_sc_mcu7t5v0__oai22_1
X_09210_ _09934_/Q _09173_/B _09257_/B _09211_/B vdd vdd vss vss gf180mcu_fd_sc_mcu7t5v0__oai21_1
X_06353_ _06351_/Z _06353_/A2 _08706_/B _06353_/C _06354_/C vdd vdd
+ vss vss gf180mcu_fd_sc_mcu7t5v0__oai211_1
X_09141_ _09137_/Z _09141_/A2 _09142_/C vdd vdd vss vss gf180mcu_fd_sc_mcu7t5v0__nor2_1
X_05304_ _09407_/A1 _05306_/A2 _05306_/B1 _05304_/B2 _09455_/D vdd vdd
+ vss vss gf180mcu_fd_sc_mcu7t5v0__oai22_1
X_09072_ _09557_/Q _09073_/A2 _09072_/B _09073_/B vdd vdd vss vss
+ gf180mcu_fd_sc_mcu7t5v0__oai21_1
X_06284_ _06284_/A1 _06279_/Z _06284_/A3 _06284_/Z vdd vdd vss vss
+ gf180mcu_fd_sc_mcu7t5v0__xor3_1
X_08023_ _09987_/Q _09104_/A2 _09089_/B _08024_/B vdd vdd vss vss
+ gf180mcu_fd_sc_mcu7t5v0__oai21_1
X_05235_ _09399_/A1 _05217_/S _05236_/B vdd vdd vss vss gf180mcu_fd_sc_mcu7t5v0__nor2_1
X_05166_ _09226_/B _05166_/A2 _09733_/D vdd vdd vss vss gf180mcu_fd_sc_mcu7t5v0__and2_1
X_05097_ _09667_/Q _07676_/B2 vdd vdd vss vss gf180mcu_fd_sc_mcu7t5v0__clkinv_1
X_09974_ _09974_/D clk _09974_/Q vdd vdd vss vss gf180mcu_fd_sc_mcu7t5v0__dffq_1
X_08925_ _09409_/A1 _08925_/A2 _08925_/B1 _08925_/B2 _09810_/D vdd vdd
+ vss vss gf180mcu_fd_sc_mcu7t5v0__oai22_1
X_08856_ _09522_/Q _08897_/A2 _08862_/B vdd vdd vss vss gf180mcu_fd_sc_mcu7t5v0__nand2_2
X_07807_ _07808_/A1 _07808_/A2 _07807_/B _07856_/A2 vdd vdd vss vss
+ gf180mcu_fd_sc_mcu7t5v0__aoi21_2
X_05999_ _06309_/A1 _09580_/Q _06152_/A3 vdd vdd vss vss gf180mcu_fd_sc_mcu7t5v0__nor2_1
X_08787_ _09748_/Q _08851_/A1 _08791_/B _08788_/B vdd vdd vss vss
+ gf180mcu_fd_sc_mcu7t5v0__oai21_1
X_07738_ _08060_/A2 _08565_/C _07738_/B1 _07738_/B2 _08670_/B _09669_/D vdd
+ vdd vss vss gf180mcu_fd_sc_mcu7t5v0__aoi221_1
X_07669_ _09402_/A1 _07676_/A2 _07676_/B1 _07669_/B2 _09660_/D vdd vdd
+ vss vss gf180mcu_fd_sc_mcu7t5v0__oai22_1
X_09408_ _09408_/A1 _09409_/A2 _09409_/B1 _09408_/B2 _10025_/D vdd vdd
+ vss vss gf180mcu_fd_sc_mcu7t5v0__oai22_1
X_09339_ _09991_/Q _09344_/A2 _09340_/B vdd vdd vss vss gf180mcu_fd_sc_mcu7t5v0__nor2_1
X_05020_ _09439_/Q _05284_/B2 vdd vdd vss vss gf180mcu_fd_sc_mcu7t5v0__clkinv_1
XTAP_323 vdd vss gf180mcu_fd_sc_mcu7t5v0__filltie
XTAP_312 vdd vss gf180mcu_fd_sc_mcu7t5v0__filltie
XTAP_301 vdd vss gf180mcu_fd_sc_mcu7t5v0__filltie
XTAP_345 vdd vss gf180mcu_fd_sc_mcu7t5v0__filltie
XTAP_334 vdd vss gf180mcu_fd_sc_mcu7t5v0__filltie
XTAP_367 vdd vss gf180mcu_fd_sc_mcu7t5v0__filltie
XTAP_356 vdd vss gf180mcu_fd_sc_mcu7t5v0__filltie
X_06971_ _06971_/A1 _09104_/A2 _06971_/B _09625_/D vdd vdd vss vss
+ gf180mcu_fd_sc_mcu7t5v0__aoi21_1
XTAP_378 vdd vss gf180mcu_fd_sc_mcu7t5v0__filltie
XTAP_389 vdd vss gf180mcu_fd_sc_mcu7t5v0__filltie
X_09690_ _09690_/D clk _09690_/Q vdd vdd vss vss gf180mcu_fd_sc_mcu7t5v0__dffq_2
X_08710_ _09875_/Q _09104_/A2 _09072_/B _08711_/B vdd vdd vss vss
+ gf180mcu_fd_sc_mcu7t5v0__oai21_1
X_05922_ _05922_/A1 _05836_/Z _05922_/B _05962_/B vdd vdd vss vss
+ gf180mcu_fd_sc_mcu7t5v0__oai21_1
X_05853_ _05855_/A1 _05851_/Z _05882_/A2 vdd vdd vss vss gf180mcu_fd_sc_mcu7t5v0__nand2_1
X_08641_ _08643_/A1 _08640_/Z _08674_/B vdd vdd vss vss gf180mcu_fd_sc_mcu7t5v0__nand2_1
X_04804_ _09631_/Q _07531_/A2 vdd vdd vss vss gf180mcu_fd_sc_mcu7t5v0__inv_1
X_05784_ _05784_/A1 _05781_/Z _05830_/A1 vdd vdd vss vss gf180mcu_fd_sc_mcu7t5v0__xnor2_1
XPHY_18 vdd vss gf180mcu_fd_sc_mcu7t5v0__endcap
XPHY_29 vdd vss gf180mcu_fd_sc_mcu7t5v0__endcap
X_08572_ _08572_/I0 _08678_/A2 _08572_/S _08572_/Z vdd vdd vss vss
+ gf180mcu_fd_sc_mcu7t5v0__mux2_1
X_04735_ _09753_/Q _08782_/A1 vdd vdd vss vss gf180mcu_fd_sc_mcu7t5v0__clkinv_1
X_07523_ _07521_/B _07481_/Z _07522_/B _07567_/A2 vdd vdd vss vss
+ gf180mcu_fd_sc_mcu7t5v0__nand3_1
X_07454_ _09713_/Q _07623_/A2 _07454_/B1 _07651_/B _07457_/A2 vdd vdd
+ vss vss gf180mcu_fd_sc_mcu7t5v0__oai22_1
X_06405_ _09712_/Q _06603_/A2 _06405_/A3 _06406_/B vdd vdd vss vss
+ gf180mcu_fd_sc_mcu7t5v0__xor3_1
X_07385_ _07575_/A2 _07575_/A3 _07385_/Z vdd vdd vss vss gf180mcu_fd_sc_mcu7t5v0__and2_2
X_06336_ _09602_/Q _09601_/Q _06361_/A2 vdd vdd vss vss gf180mcu_fd_sc_mcu7t5v0__nor2_1
X_09124_ _09124_/A1 _09124_/A2 _09399_/C _09909_/D vdd vdd vss vss
+ gf180mcu_fd_sc_mcu7t5v0__aoi21_1
X_06267_ _06267_/A1 _06240_/Z _06267_/A3 _06242_/Z _06267_/B2 _06287_/A2 vdd
+ vdd vss vss gf180mcu_fd_sc_mcu7t5v0__oai32_1
X_09055_ _09557_/Q _09033_/I _09057_/A1 vdd vdd vss vss gf180mcu_fd_sc_mcu7t5v0__nand2_1
X_08006_ _08006_/A1 _08006_/A2 _08007_/A2 vdd vdd vss vss gf180mcu_fd_sc_mcu7t5v0__nand2_1
X_05218_ _05218_/I _05276_/A3 vdd vdd vss vss gf180mcu_fd_sc_mcu7t5v0__inv_3
X_06198_ _09715_/Q _06198_/A2 _06200_/B vdd vdd vss vss gf180mcu_fd_sc_mcu7t5v0__xor2_1
X_05149_ _09762_/Q _09765_/Q _05150_/A4 vdd vdd vss vss gf180mcu_fd_sc_mcu7t5v0__nor2_1
X_09957_ _09957_/D clk _09957_/Q vdd vdd vss vss gf180mcu_fd_sc_mcu7t5v0__dffq_1
X_08908_ _09404_/A1 _08913_/A2 _08913_/B1 _08908_/B2 _09796_/D vdd vdd
+ vss vss gf180mcu_fd_sc_mcu7t5v0__oai22_1
XTAP_890 vdd vss gf180mcu_fd_sc_mcu7t5v0__filltie
X_09888_ _09888_/D clk _09888_/Q vdd vdd vss vss gf180mcu_fd_sc_mcu7t5v0__dffq_1
X_08839_ _09774_/Q _08835_/Z _08845_/B _08840_/A2 vdd vdd vss vss
+ gf180mcu_fd_sc_mcu7t5v0__oai21_1
X_10028_ clk_PD vdd vdd vss vss gf180mcu_fd_sc_mcu7t5v0__tiel
X_07170_ _07170_/A1 _07170_/A2 _07170_/Z vdd vdd vss vss gf180mcu_fd_sc_mcu7t5v0__xor2_1
X_06121_ _09714_/Q _05987_/I _06163_/A1 vdd vdd vss vss gf180mcu_fd_sc_mcu7t5v0__nand2_1
X_06052_ _09710_/Q _06047_/Z _06052_/A3 _06050_/I _06052_/Z vdd vdd vss
+ vss gf180mcu_fd_sc_mcu7t5v0__and4_1
X_05003_ _09609_/Q _06649_/B2 vdd vdd vss vss gf180mcu_fd_sc_mcu7t5v0__clkinv_1
X_09811_ _09811_/D clk _09811_/Q vdd vdd vss vss gf180mcu_fd_sc_mcu7t5v0__dffq_1
X_09742_ _09742_/D clk _09742_/Q vdd vdd vss vss gf180mcu_fd_sc_mcu7t5v0__dffq_1
X_06954_ _06954_/A1 _06951_/Z _06954_/A3 _06954_/Z vdd vdd vss vss
+ gf180mcu_fd_sc_mcu7t5v0__xor3_1
X_05905_ _05906_/A2 _05906_/A3 _05941_/A2 vdd vdd vss vss gf180mcu_fd_sc_mcu7t5v0__nand2_1
X_09673_ _09673_/D clk _09673_/Q vdd vdd vss vss gf180mcu_fd_sc_mcu7t5v0__dffq_2
X_06885_ _06929_/A1 _06884_/Z _06885_/Z vdd vdd vss vss gf180mcu_fd_sc_mcu7t5v0__xor2_1
XTAP_2009 vdd vss gf180mcu_fd_sc_mcu7t5v0__filltie
X_08624_ _08509_/I _08624_/A2 _08623_/B _08625_/I vdd vdd vss vss
+ gf180mcu_fd_sc_mcu7t5v0__xor3_1
X_05836_ _09888_/Q _09618_/Q _09576_/Q _09880_/Q _09569_/Q _09570_/Q _05836_/Z vdd
+ vdd vss vss gf180mcu_fd_sc_mcu7t5v0__mux4_4
X_05767_ _07452_/C _05767_/A2 _05767_/Z vdd vdd vss vss gf180mcu_fd_sc_mcu7t5v0__xor2_1
X_08555_ _09714_/Q _08554_/Z _08555_/Z vdd vdd vss vss gf180mcu_fd_sc_mcu7t5v0__and2_1
XTAP_1308 vdd vss gf180mcu_fd_sc_mcu7t5v0__filltie
XTAP_1319 vdd vss gf180mcu_fd_sc_mcu7t5v0__filltie
X_07506_ _07611_/A1 _07506_/A2 _07506_/B _07508_/A2 vdd vdd vss vss
+ gf180mcu_fd_sc_mcu7t5v0__aoi21_1
X_08486_ _09713_/Q _08485_/Z _08487_/I vdd vdd vss vss gf180mcu_fd_sc_mcu7t5v0__nand2_1
X_04718_ _09914_/Q _05137_/A2 vdd vdd vss vss gf180mcu_fd_sc_mcu7t5v0__inv_1
X_05698_ _09711_/Q _05965_/A2 _05698_/B1 _05862_/A1 _05698_/C _05699_/C vdd
+ vdd vss vss gf180mcu_fd_sc_mcu7t5v0__aoi221_1
X_07437_ _07464_/A1 _07436_/Z _07437_/Z vdd vdd vss vss gf180mcu_fd_sc_mcu7t5v0__xor2_1
X_07368_ _07357_/Z _07359_/Z _07371_/A2 _07509_/A1 _07368_/C _07369_/A2 vdd
+ vdd vss vss gf180mcu_fd_sc_mcu7t5v0__oai221_1
X_06319_ _09405_/A1 _06323_/A2 _06323_/B1 _06319_/B2 _09587_/D vdd vdd
+ vss vss gf180mcu_fd_sc_mcu7t5v0__oai22_1
X_09107_ _09402_/A1 _09114_/A2 _09114_/B1 _09107_/B2 _09900_/D vdd vdd
+ vss vss gf180mcu_fd_sc_mcu7t5v0__oai22_1
X_07299_ _09997_/Q _09073_/A2 _08734_/B _07300_/B vdd vdd vss vss
+ gf180mcu_fd_sc_mcu7t5v0__oai21_1
X_09038_ _09876_/Q _09103_/A2 _09039_/A2 vdd vdd vss vss gf180mcu_fd_sc_mcu7t5v0__nand2_1
XTAP_1842 vdd vss gf180mcu_fd_sc_mcu7t5v0__filltie
XTAP_1831 vdd vss gf180mcu_fd_sc_mcu7t5v0__filltie
XTAP_1820 vdd vss gf180mcu_fd_sc_mcu7t5v0__filltie
XTAP_1864 vdd vss gf180mcu_fd_sc_mcu7t5v0__filltie
XTAP_1875 vdd vss gf180mcu_fd_sc_mcu7t5v0__filltie
XTAP_1853 vdd vss gf180mcu_fd_sc_mcu7t5v0__filltie
XTAP_1897 vdd vss gf180mcu_fd_sc_mcu7t5v0__filltie
XTAP_1886 vdd vss gf180mcu_fd_sc_mcu7t5v0__filltie
X_06670_ _06967_/A1 _09622_/Q _09621_/Q _06955_/A1 vdd vdd vss vss
+ gf180mcu_fd_sc_mcu7t5v0__nor3_4
X_05621_ _09842_/Q _05627_/A2 _05627_/B1 _09810_/Q _05623_/A1 vdd vdd
+ vss vss gf180mcu_fd_sc_mcu7t5v0__aoi22_1
X_08340_ _08334_/Z _08336_/Z _08339_/Z _08340_/Z vdd vdd vss vss gf180mcu_fd_sc_mcu7t5v0__xor3_1
X_05552_ _09447_/Q _05628_/A2 _05628_/B1 _09431_/Q _05553_/A2 vdd vdd
+ vss vss gf180mcu_fd_sc_mcu7t5v0__aoi22_1
X_08271_ _09687_/Q _08565_/C _08324_/A1 vdd vdd vss vss gf180mcu_fd_sc_mcu7t5v0__nand2_1
X_05483_ _09444_/Q _05628_/A2 _05628_/B1 _09428_/Q _05484_/A2 vdd vdd
+ vss vss gf180mcu_fd_sc_mcu7t5v0__aoi22_1
X_07222_ _07208_/Z _07222_/A2 _07220_/B _07222_/Z vdd vdd vss vss
+ gf180mcu_fd_sc_mcu7t5v0__xor3_1
X_07153_ _09713_/Q _07033_/Z _07159_/A1 vdd vdd vss vss gf180mcu_fd_sc_mcu7t5v0__nand2_1
X_06104_ _09713_/Q _06103_/Z _06150_/A1 vdd vdd vss vss gf180mcu_fd_sc_mcu7t5v0__nand2_1
X_07084_ _09713_/Q _07084_/A2 _07084_/Z vdd vdd vss vss gf180mcu_fd_sc_mcu7t5v0__xor2_1
X_06035_ _06072_/C _06035_/A2 _06035_/A3 _06035_/A4 _06040_/B vdd vdd
+ vss vss gf180mcu_fd_sc_mcu7t5v0__nand4_1
X_07986_ _09717_/Q _07681_/Z _07991_/A1 vdd vdd vss vss gf180mcu_fd_sc_mcu7t5v0__nand2_1
X_09725_ _09725_/D clk _09725_/Q vdd vdd vss vss gf180mcu_fd_sc_mcu7t5v0__dffq_1
X_06937_ _06937_/I0 _09712_/Q _06937_/S _06937_/Z vdd vdd vss vss
+ gf180mcu_fd_sc_mcu7t5v0__mux2_1
X_09656_ _09656_/D clk _09656_/Q vdd vdd vss vss gf180mcu_fd_sc_mcu7t5v0__dffq_4
X_08607_ _09715_/Q _08689_/A2 _08608_/I vdd vdd vss vss gf180mcu_fd_sc_mcu7t5v0__nand2_1
XTAP_1105 vdd vss gf180mcu_fd_sc_mcu7t5v0__filltie
X_06868_ _06958_/A1 _06866_/Z _06914_/A2 _06873_/A3 vdd vdd vss vss
+ gf180mcu_fd_sc_mcu7t5v0__nand3_1
X_09587_ _09587_/D clk _09587_/Q vdd vdd vss vss gf180mcu_fd_sc_mcu7t5v0__dffq_1
XTAP_1116 vdd vss gf180mcu_fd_sc_mcu7t5v0__filltie
XTAP_1127 vdd vss gf180mcu_fd_sc_mcu7t5v0__filltie
X_06799_ _06791_/I _06797_/Z _06802_/A2 vdd vdd vss vss gf180mcu_fd_sc_mcu7t5v0__xnor2_1
XTAP_1138 vdd vss gf180mcu_fd_sc_mcu7t5v0__filltie
X_05819_ _07506_/B _05901_/A2 _05819_/Z vdd vdd vss vss gf180mcu_fd_sc_mcu7t5v0__or2_1
X_08538_ _08498_/Z _08526_/I _08535_/Z _08538_/Z vdd vdd vss vss gf180mcu_fd_sc_mcu7t5v0__xor3_1
XTAP_1149 vdd vss gf180mcu_fd_sc_mcu7t5v0__filltie
X_08469_ _09712_/Q _08468_/Z _08481_/B vdd vdd vss vss gf180mcu_fd_sc_mcu7t5v0__nand2_1
XTAP_1650 vdd vss gf180mcu_fd_sc_mcu7t5v0__filltie
XTAP_1694 vdd vss gf180mcu_fd_sc_mcu7t5v0__filltie
XTAP_1683 vdd vss gf180mcu_fd_sc_mcu7t5v0__filltie
XTAP_1672 vdd vss gf180mcu_fd_sc_mcu7t5v0__filltie
XTAP_1661 vdd vss gf180mcu_fd_sc_mcu7t5v0__filltie
X_07840_ _07870_/A1 _07839_/Z _07869_/A2 vdd vdd vss vss gf180mcu_fd_sc_mcu7t5v0__nor2_1
X_07771_ _08011_/A1 _07877_/A1 _07771_/B _07771_/C _07772_/B vdd vdd vss
+ vss gf180mcu_fd_sc_mcu7t5v0__oai211_1
X_09510_ _09510_/D clk _09510_/Q vdd vdd vss vss gf180mcu_fd_sc_mcu7t5v0__dffq_1
X_04983_ _09863_/Q _09018_/B2 vdd vdd vss vss gf180mcu_fd_sc_mcu7t5v0__clkinv_1
X_06722_ _06674_/B _06722_/A2 _06721_/Z _06830_/A1 vdd vdd vss vss
+ gf180mcu_fd_sc_mcu7t5v0__nand3_2
X_09441_ _09441_/D clk _09441_/Q vdd vdd vss vss gf180mcu_fd_sc_mcu7t5v0__dffq_1
X_06653_ _06965_/A1 _09621_/Q _06667_/A2 vdd vdd vss vss gf180mcu_fd_sc_mcu7t5v0__nor2_2
X_06584_ _06626_/A2 _06626_/B _06587_/A3 vdd vdd vss vss gf180mcu_fd_sc_mcu7t5v0__xnor2_1
X_05604_ _05604_/A1 _05604_/A2 _05604_/A3 _05605_/A2 vdd vdd vss vss
+ gf180mcu_fd_sc_mcu7t5v0__nand3_1
X_09372_ _10006_/Q _09377_/A2 _09373_/B vdd vdd vss vss gf180mcu_fd_sc_mcu7t5v0__nor2_1
X_08323_ _08107_/B _08309_/Z _08323_/B _08706_/B _08324_/A2 vdd vdd vss
+ vss gf180mcu_fd_sc_mcu7t5v0__oai211_1
X_05535_ _09422_/Q _05628_/A2 _05628_/B1 _09609_/Q _05536_/A2 vdd vdd
+ vss vss gf180mcu_fd_sc_mcu7t5v0__aoi22_1
X_08254_ _09686_/Q _08252_/Z _08272_/B vdd vdd vss vss gf180mcu_fd_sc_mcu7t5v0__nand2_1
X_05466_ _05466_/A1 _05466_/A2 _05486_/A2 vdd vdd vss vss gf180mcu_fd_sc_mcu7t5v0__nand2_1
X_05397_ _09407_/A1 _05399_/A2 _05399_/B1 _05397_/B2 _09547_/D vdd vdd
+ vss vss gf180mcu_fd_sc_mcu7t5v0__oai22_1
X_08185_ _09711_/Q _08338_/A2 _08284_/A2 _09710_/Q _08229_/A2 vdd vdd
+ vss vss gf180mcu_fd_sc_mcu7t5v0__aoi22_1
X_07205_ _09714_/Q _07033_/Z _07269_/B2 vdd vdd vss vss gf180mcu_fd_sc_mcu7t5v0__nand2_1
X_07136_ _07247_/A1 _07136_/A2 _07136_/B _07137_/B vdd vdd vss vss
+ gf180mcu_fd_sc_mcu7t5v0__oai21_1
X_07067_ _09711_/Q _07065_/Z _07156_/A1 vdd vdd vss vss gf180mcu_fd_sc_mcu7t5v0__nand2_1
X_06018_ _05987_/I _06146_/B _06018_/Z vdd vdd vss vss gf180mcu_fd_sc_mcu7t5v0__and2_1
X_07969_ _09716_/Q _08005_/A2 _07971_/A2 vdd vdd vss vss gf180mcu_fd_sc_mcu7t5v0__nand2_1
X_09708_ _09708_/D clk _09708_/Q vdd vdd vss vss gf180mcu_fd_sc_mcu7t5v0__dffq_2
X_09639_ _09639_/D clk _09639_/Q vdd vdd vss vss gf180mcu_fd_sc_mcu7t5v0__dffq_1
XTAP_719 vdd vss gf180mcu_fd_sc_mcu7t5v0__filltie
XTAP_708 vdd vss gf180mcu_fd_sc_mcu7t5v0__filltie
X_05320_ _08972_/A1 _05632_/C2 _05329_/A2 vdd vdd vss vss gf180mcu_fd_sc_mcu7t5v0__nand2_4
XTAP_1480 vdd vss gf180mcu_fd_sc_mcu7t5v0__filltie
XTAP_1491 vdd vss gf180mcu_fd_sc_mcu7t5v0__filltie
X_05251_ _09002_/A2 _08972_/A1 _05260_/A2 vdd vdd vss vss gf180mcu_fd_sc_mcu7t5v0__nand2_4
X_05182_ _09257_/B _09460_/Q _05200_/A2 _05193_/A1 _05186_/A3 vdd vdd
+ vss vss gf180mcu_fd_sc_mcu7t5v0__nand4_1
X_09990_ _09990_/D clk _09990_/Q vdd vdd vss vss gf180mcu_fd_sc_mcu7t5v0__dffq_1
X_08941_ _09816_/Q _08938_/Z _08941_/Z vdd vdd vss vss gf180mcu_fd_sc_mcu7t5v0__and2_1
X_08872_ _09787_/Q _09523_/Q _08872_/B _08874_/A2 vdd vdd vss vss
+ gf180mcu_fd_sc_mcu7t5v0__aoi21_1
X_07823_ _07824_/A3 _07822_/Z _07871_/B vdd vdd vss vss gf180mcu_fd_sc_mcu7t5v0__nor2_1
X_07754_ _07756_/A1 _07753_/Z _07755_/I vdd vdd vss vss gf180mcu_fd_sc_mcu7t5v0__nor2_2
X_04966_ _09493_/Q _05335_/B2 vdd vdd vss vss gf180mcu_fd_sc_mcu7t5v0__clkinv_1
X_07685_ _09676_/Q _07692_/A2 _07970_/B2 vdd vdd vss vss gf180mcu_fd_sc_mcu7t5v0__nor2_2
X_06705_ _09614_/Q _06706_/A2 _06713_/A1 vdd vdd vss vss gf180mcu_fd_sc_mcu7t5v0__nand2_1
X_06636_ _06636_/A1 _09073_/A2 _06636_/B _09601_/D vdd vdd vss vss
+ gf180mcu_fd_sc_mcu7t5v0__aoi21_1
X_04897_ _09515_/Q _05363_/B2 vdd vdd vss vss gf180mcu_fd_sc_mcu7t5v0__clkinv_1
X_09424_ _09424_/D clk _09424_/Q vdd vdd vss vss gf180mcu_fd_sc_mcu7t5v0__dffq_1
X_06567_ _06568_/A1 _06566_/Z _06599_/A2 vdd vdd vss vss gf180mcu_fd_sc_mcu7t5v0__nand2_1
X_09355_ _09399_/A1 _09355_/A2 _09355_/B _09399_/C _09998_/D vdd vdd vss
+ vss gf180mcu_fd_sc_mcu7t5v0__aoi211_1
X_06498_ _06498_/A1 _06498_/A2 _06498_/B _06545_/A1 vdd vdd vss vss
+ gf180mcu_fd_sc_mcu7t5v0__oai21_1
X_08306_ _08306_/A1 _08251_/Z _08306_/B _08326_/A2 vdd vdd vss vss
+ gf180mcu_fd_sc_mcu7t5v0__oai21_1
X_05518_ _08791_/B _05518_/A2 _09553_/D vdd vdd vss vss gf180mcu_fd_sc_mcu7t5v0__and2_1
X_09286_ _09399_/A1 _09286_/A2 _09286_/B _09399_/C _09968_/D vdd vdd vss
+ vss gf180mcu_fd_sc_mcu7t5v0__aoi211_1
X_08237_ _08237_/A1 _08278_/B2 _08341_/A1 _08243_/A1 vdd vdd vss vss
+ gf180mcu_fd_sc_mcu7t5v0__xnor3_1
X_05449_ _05449_/A1 _05449_/A2 _05456_/B1 vdd vdd vss vss gf180mcu_fd_sc_mcu7t5v0__nand2_1
X_08168_ _08168_/A1 _08168_/A2 _08169_/A3 vdd vdd vss vss gf180mcu_fd_sc_mcu7t5v0__nand2_1
X_08099_ _08099_/A1 _08129_/A3 _08099_/A3 _08099_/Z vdd vdd vss vss
+ gf180mcu_fd_sc_mcu7t5v0__xor3_1
X_07119_ _07100_/I _07117_/Z _07119_/Z vdd vdd vss vss gf180mcu_fd_sc_mcu7t5v0__xor2_1
XTAP_505 vdd vss gf180mcu_fd_sc_mcu7t5v0__filltie
XTAP_516 vdd vss gf180mcu_fd_sc_mcu7t5v0__filltie
XTAP_549 vdd vss gf180mcu_fd_sc_mcu7t5v0__filltie
XTAP_538 vdd vss gf180mcu_fd_sc_mcu7t5v0__filltie
XTAP_527 vdd vss gf180mcu_fd_sc_mcu7t5v0__filltie
X_04820_ _09603_/Q _06640_/A1 vdd vdd vss vss gf180mcu_fd_sc_mcu7t5v0__clkinv_3
X_04751_ _09722_/Q _08735_/A1 vdd vdd vss vss gf180mcu_fd_sc_mcu7t5v0__clkinv_1
X_07470_ _09630_/Q _07420_/Z _07474_/B1 vdd vdd vss vss gf180mcu_fd_sc_mcu7t5v0__nand2_1
X_06421_ _06421_/I _06463_/A1 vdd vdd vss vss gf180mcu_fd_sc_mcu7t5v0__clkinv_1
X_09140_ _09951_/Q _09461_/Q _09141_/A2 vdd vdd vss vss gf180mcu_fd_sc_mcu7t5v0__nand2_1
X_06352_ _09592_/Q _06329_/Z _06450_/C _06353_/A2 vdd vdd vss vss
+ gf180mcu_fd_sc_mcu7t5v0__oai21_1
X_06283_ _09710_/Q _06299_/A2 _06284_/A3 vdd vdd vss vss gf180mcu_fd_sc_mcu7t5v0__nand2_1
X_05303_ _09406_/A1 _05306_/A2 _05306_/B1 _05303_/B2 _09454_/D vdd vdd
+ vss vss gf180mcu_fd_sc_mcu7t5v0__oai22_1
X_09071_ _09071_/A1 _09104_/A2 _09071_/B _09889_/D vdd vdd vss vss
+ gf180mcu_fd_sc_mcu7t5v0__aoi21_1
X_08022_ _08022_/A1 _09104_/A2 _08022_/B _09678_/D vdd vdd vss vss
+ gf180mcu_fd_sc_mcu7t5v0__aoi21_1
X_05234_ _05234_/A1 _05246_/A2 _09405_/A1 _05246_/B2 _09413_/D vdd vdd
+ vss vss gf180mcu_fd_sc_mcu7t5v0__oai22_1
X_05165_ _09780_/Q _08757_/A2 _05165_/B _05166_/A2 vdd vdd vss vss
+ gf180mcu_fd_sc_mcu7t5v0__oai21_1
X_05096_ _09701_/Q _08385_/B2 vdd vdd vss vss gf180mcu_fd_sc_mcu7t5v0__clkinv_1
X_09973_ _09973_/D clk _09973_/Q vdd vdd vss vss gf180mcu_fd_sc_mcu7t5v0__dffq_1
X_08924_ _09408_/A1 _08925_/A2 _08925_/B1 _08924_/B2 _09809_/D vdd vdd
+ vss vss gf180mcu_fd_sc_mcu7t5v0__oai22_1
X_08855_ _08901_/A2 _08855_/A2 _09781_/D vdd vdd vss vss gf180mcu_fd_sc_mcu7t5v0__nand2_1
X_07806_ _07452_/C _07804_/Z _07807_/B vdd vdd vss vss gf180mcu_fd_sc_mcu7t5v0__xor2_1
X_08786_ _08786_/A1 _08851_/A1 _08786_/B _09755_/D vdd vdd vss vss
+ gf180mcu_fd_sc_mcu7t5v0__aoi21_1
X_05998_ _06309_/A1 _05998_/A2 _06260_/A1 vdd vdd vss vss gf180mcu_fd_sc_mcu7t5v0__nand2_2
X_07737_ _08565_/C _07737_/A2 _07738_/B2 vdd vdd vss vss gf180mcu_fd_sc_mcu7t5v0__nor2_1
X_04949_ _09830_/Q _08977_/B2 vdd vdd vss vss gf180mcu_fd_sc_mcu7t5v0__clkinv_1
X_07668_ _09089_/B _07676_/A2 _07676_/B1 vdd vdd vss vss gf180mcu_fd_sc_mcu7t5v0__nand2_2
X_06619_ _06619_/A1 _06616_/Z _06618_/Z _06630_/A2 vdd vdd vss vss
+ gf180mcu_fd_sc_mcu7t5v0__xnor3_1
X_09407_ _09407_/A1 _09409_/A2 _09409_/B1 _09407_/B2 _10024_/D vdd vdd
+ vss vss gf180mcu_fd_sc_mcu7t5v0__oai22_1
X_07599_ _07600_/A1 _07598_/Z _07617_/B vdd vdd vss vss gf180mcu_fd_sc_mcu7t5v0__and2_1
X_09338_ _09393_/A1 _09344_/A2 _09338_/B _09399_/C _09990_/D vdd vdd vss
+ vss gf180mcu_fd_sc_mcu7t5v0__aoi211_1
X_09269_ _09961_/Q _09274_/A2 _09270_/B vdd vdd vss vss gf180mcu_fd_sc_mcu7t5v0__nor2_1
XTAP_324 vdd vss gf180mcu_fd_sc_mcu7t5v0__filltie
XTAP_313 vdd vss gf180mcu_fd_sc_mcu7t5v0__filltie
XTAP_302 vdd vss gf180mcu_fd_sc_mcu7t5v0__filltie
XTAP_346 vdd vss gf180mcu_fd_sc_mcu7t5v0__filltie
XTAP_335 vdd vss gf180mcu_fd_sc_mcu7t5v0__filltie
XTAP_357 vdd vss gf180mcu_fd_sc_mcu7t5v0__filltie
X_06970_ _10003_/Q _09104_/A2 _09278_/C _06971_/B vdd vdd vss vss
+ gf180mcu_fd_sc_mcu7t5v0__oai21_1
XTAP_368 vdd vss gf180mcu_fd_sc_mcu7t5v0__filltie
XTAP_379 vdd vss gf180mcu_fd_sc_mcu7t5v0__filltie
X_05921_ _05926_/A1 _05868_/Z _05927_/A1 vdd vdd vss vss gf180mcu_fd_sc_mcu7t5v0__nand2_1
X_05852_ _05855_/A1 _05851_/Z _05852_/Z vdd vdd vss vss gf180mcu_fd_sc_mcu7t5v0__or2_1
X_08640_ _08639_/C _08638_/B _08640_/A3 _08640_/Z vdd vdd vss vss
+ gf180mcu_fd_sc_mcu7t5v0__xor3_1
X_04803_ _09634_/Q _07294_/A1 vdd vdd vss vss gf180mcu_fd_sc_mcu7t5v0__inv_2
X_05783_ _05784_/A1 _05781_/Z _05855_/A1 vdd vdd vss vss gf180mcu_fd_sc_mcu7t5v0__nor2_1
X_08571_ _09713_/Q _08678_/A2 _08572_/I0 vdd vdd vss vss gf180mcu_fd_sc_mcu7t5v0__nand2_1
XPHY_19 vdd vss gf180mcu_fd_sc_mcu7t5v0__endcap
X_04734_ _09761_/Q _08798_/A1 vdd vdd vss vss gf180mcu_fd_sc_mcu7t5v0__clkinv_1
X_07522_ _07521_/B _07481_/Z _07522_/B _07567_/B vdd vdd vss vss gf180mcu_fd_sc_mcu7t5v0__aoi21_1
X_07453_ _07612_/B _07577_/B _07454_/B1 vdd vdd vss vss gf180mcu_fd_sc_mcu7t5v0__nor2_1
X_06404_ _09712_/Q _06403_/Z _06445_/A1 vdd vdd vss vss gf180mcu_fd_sc_mcu7t5v0__nand2_1
X_07384_ _09659_/Q _07384_/A2 _07384_/B _07575_/A3 vdd vdd vss vss
+ gf180mcu_fd_sc_mcu7t5v0__oai21_2
X_09123_ _09936_/Q _09116_/I _09463_/Q _09458_/Q _09124_/A2 vdd vdd vss
+ vss gf180mcu_fd_sc_mcu7t5v0__aoi211_1
X_06335_ _06638_/A1 _09601_/Q _06634_/A1 _06591_/A1 vdd vdd vss vss
+ gf180mcu_fd_sc_mcu7t5v0__nand3_4
X_06266_ _06266_/A1 _06266_/A2 _06266_/B _06287_/A1 vdd vdd vss vss
+ gf180mcu_fd_sc_mcu7t5v0__oai21_1
X_09054_ _09054_/A1 _09054_/A2 _09399_/C _09881_/D vdd vdd vss vss
+ gf180mcu_fd_sc_mcu7t5v0__aoi21_1
X_08005_ _07803_/B _08005_/A2 _08006_/A2 vdd vdd vss vss gf180mcu_fd_sc_mcu7t5v0__nand2_1
X_05217_ _09908_/Q _09891_/Q _05217_/S _05218_/I vdd vdd vss vss gf180mcu_fd_sc_mcu7t5v0__mux2_4
X_06197_ _09715_/Q _06198_/A2 _06255_/A1 vdd vdd vss vss gf180mcu_fd_sc_mcu7t5v0__nand2_1
X_05148_ _05148_/A1 _05148_/A2 _05161_/A1 vdd vdd vss vss gf180mcu_fd_sc_mcu7t5v0__nand2_1
X_05079_ _09866_/Q _09021_/B2 vdd vdd vss vss gf180mcu_fd_sc_mcu7t5v0__clkinv_1
X_09956_ _09956_/D clk _09956_/Q vdd vdd vss vss gf180mcu_fd_sc_mcu7t5v0__dffq_1
XTAP_880 vdd vss gf180mcu_fd_sc_mcu7t5v0__filltie
X_08907_ _09403_/A1 _08913_/A2 _08913_/B1 _08907_/B2 _09795_/D vdd vdd
+ vss vss gf180mcu_fd_sc_mcu7t5v0__oai22_1
X_09887_ _09887_/D clk _09887_/Q vdd vdd vss vss gf180mcu_fd_sc_mcu7t5v0__dffq_1
XTAP_891 vdd vss gf180mcu_fd_sc_mcu7t5v0__filltie
X_08838_ _09774_/Q _08835_/Z _08838_/Z vdd vdd vss vss gf180mcu_fd_sc_mcu7t5v0__and2_1
X_08769_ _09748_/Q _08782_/A2 _08791_/B _08770_/B vdd vdd vss vss
+ gf180mcu_fd_sc_mcu7t5v0__oai21_1
X_10027_ _10027_/Z vdd vdd vss vss gf180mcu_fd_sc_mcu7t5v0__tieh
XPHY_190 vdd vss gf180mcu_fd_sc_mcu7t5v0__endcap
X_06120_ _06120_/A1 _06052_/Z _06120_/B _06161_/A1 vdd vdd vss vss
+ gf180mcu_fd_sc_mcu7t5v0__oai21_2
X_06051_ _09710_/Q _06050_/I _06089_/A1 vdd vdd vss vss gf180mcu_fd_sc_mcu7t5v0__nand2_1
X_05002_ _09643_/Q _07309_/B2 vdd vdd vss vss gf180mcu_fd_sc_mcu7t5v0__clkinv_1
X_09810_ _09810_/D clk _09810_/Q vdd vdd vss vss gf180mcu_fd_sc_mcu7t5v0__dffq_1
X_06953_ _06953_/A1 _06953_/A2 _06954_/A3 vdd vdd vss vss gf180mcu_fd_sc_mcu7t5v0__nand2_1
X_09741_ _09741_/D clk _09741_/Q vdd vdd vss vss gf180mcu_fd_sc_mcu7t5v0__dffq_1
X_05904_ _05906_/A2 _05906_/A3 _05941_/B vdd vdd vss vss gf180mcu_fd_sc_mcu7t5v0__nor2_1
X_09672_ _09672_/D clk _09672_/Q vdd vdd vss vss gf180mcu_fd_sc_mcu7t5v0__dffq_2
X_06884_ _06884_/A1 _06884_/A2 _06884_/Z vdd vdd vss vss gf180mcu_fd_sc_mcu7t5v0__xor2_1
X_05835_ _07452_/C _05835_/A2 _05888_/A1 vdd vdd vss vss gf180mcu_fd_sc_mcu7t5v0__nor2_1
X_08623_ _09714_/Q _08678_/A2 _08623_/B _08675_/A2 vdd vdd vss vss
+ gf180mcu_fd_sc_mcu7t5v0__aoi21_1
X_05766_ _09713_/Q _05767_/A2 _05810_/B vdd vdd vss vss gf180mcu_fd_sc_mcu7t5v0__nand2_1
X_08554_ _08626_/A2 _08554_/A2 _08554_/Z vdd vdd vss vss gf180mcu_fd_sc_mcu7t5v0__xor2_1
XTAP_1309 vdd vss gf180mcu_fd_sc_mcu7t5v0__filltie
X_07505_ _07610_/A1 _07475_/I _07506_/A2 vdd vdd vss vss gf180mcu_fd_sc_mcu7t5v0__nand2_1
X_04717_ _09915_/Q _09136_/A1 vdd vdd vss vss gf180mcu_fd_sc_mcu7t5v0__clkinv_1
X_08485_ _08677_/A2 _08485_/A2 _08485_/Z vdd vdd vss vss gf180mcu_fd_sc_mcu7t5v0__xor2_1
X_05697_ _09711_/Q _05689_/B _05697_/B _05699_/B vdd vdd vss vss gf180mcu_fd_sc_mcu7t5v0__oai21_1
X_07436_ _07464_/A2 _07464_/B _07436_/Z vdd vdd vss vss gf180mcu_fd_sc_mcu7t5v0__xor2_1
X_07367_ _08430_/B _07662_/A1 _07611_/A1 _07388_/A1 _07650_/I0 _07369_/A1 vdd
+ vdd vss vss gf180mcu_fd_sc_mcu7t5v0__oai32_1
X_06318_ _09404_/A1 _06323_/A2 _06323_/B1 _06318_/B2 _09586_/D vdd vdd
+ vss vss gf180mcu_fd_sc_mcu7t5v0__oai22_1
X_09106_ _09401_/A1 _09114_/A2 _09114_/B1 vdd vdd vss vss gf180mcu_fd_sc_mcu7t5v0__nand2_2
X_07298_ _07298_/A1 _09073_/A2 _07298_/B _09636_/D vdd vdd vss vss
+ gf180mcu_fd_sc_mcu7t5v0__aoi21_1
X_09037_ _09551_/Q _09033_/I _09039_/A1 vdd vdd vss vss gf180mcu_fd_sc_mcu7t5v0__nand2_1
X_06249_ _09577_/Q _06265_/A1 _06246_/Z _06249_/Z vdd vdd vss vss
+ gf180mcu_fd_sc_mcu7t5v0__xor3_1
X_09939_ _09939_/D clk _09939_/Q vdd vdd vss vss gf180mcu_fd_sc_mcu7t5v0__dffq_1
XTAP_1843 vdd vss gf180mcu_fd_sc_mcu7t5v0__filltie
XTAP_1832 vdd vss gf180mcu_fd_sc_mcu7t5v0__filltie
XTAP_1821 vdd vss gf180mcu_fd_sc_mcu7t5v0__filltie
XTAP_1810 vdd vss gf180mcu_fd_sc_mcu7t5v0__filltie
XTAP_1865 vdd vss gf180mcu_fd_sc_mcu7t5v0__filltie
XTAP_1876 vdd vss gf180mcu_fd_sc_mcu7t5v0__filltie
XTAP_1854 vdd vss gf180mcu_fd_sc_mcu7t5v0__filltie
XTAP_1898 vdd vss gf180mcu_fd_sc_mcu7t5v0__filltie
XTAP_1887 vdd vss gf180mcu_fd_sc_mcu7t5v0__filltie
X_05620_ _05620_/A1 _05620_/A2 _05631_/A2 vdd vdd vss vss gf180mcu_fd_sc_mcu7t5v0__nand2_1
X_05551_ _09455_/Q _05627_/A2 _05627_/B1 _09439_/Q _05553_/A1 vdd vdd
+ vss vss gf180mcu_fd_sc_mcu7t5v0__aoi22_1
X_08270_ _08670_/B _08270_/A2 _09686_/D vdd vdd vss vss gf180mcu_fd_sc_mcu7t5v0__nor2_1
X_05482_ _09452_/Q _05627_/A2 _05627_/B1 _09436_/Q _05484_/A1 vdd vdd
+ vss vss gf180mcu_fd_sc_mcu7t5v0__aoi22_1
X_07221_ _07208_/Z _07267_/S _07221_/A3 _07273_/A1 vdd vdd vss vss
+ gf180mcu_fd_sc_mcu7t5v0__nor3_1
X_07152_ _07197_/A1 _07152_/A2 _07152_/A3 _07152_/Z vdd vdd vss vss
+ gf180mcu_fd_sc_mcu7t5v0__xor3_1
X_06103_ _06085_/Z _06105_/A3 _06103_/Z vdd vdd vss vss gf180mcu_fd_sc_mcu7t5v0__xor2_1
X_07083_ _09713_/Q _07084_/A2 _07131_/A1 vdd vdd vss vss gf180mcu_fd_sc_mcu7t5v0__nand2_1
X_06034_ _06290_/A1 _06036_/A2 _06036_/A3 _06035_/A4 vdd vdd vss vss
+ gf180mcu_fd_sc_mcu7t5v0__nand3_1
X_07985_ _07985_/A1 _07985_/A2 _07985_/Z vdd vdd vss vss gf180mcu_fd_sc_mcu7t5v0__xor2_1
X_09724_ _09724_/D clk _09724_/Q vdd vdd vss vss gf180mcu_fd_sc_mcu7t5v0__dffq_1
X_06936_ _09712_/Q _06845_/Z _06937_/I0 vdd vdd vss vss gf180mcu_fd_sc_mcu7t5v0__nand2_1
X_06867_ _06814_/Z _06867_/A2 _06867_/B _06914_/A2 vdd vdd vss vss
+ gf180mcu_fd_sc_mcu7t5v0__oai21_1
X_09655_ _09655_/D clk _09655_/Q vdd vdd vss vss gf180mcu_fd_sc_mcu7t5v0__dffq_2
X_08606_ _08432_/B _08657_/A2 _08605_/Z _08612_/A2 vdd vdd vss vss
+ gf180mcu_fd_sc_mcu7t5v0__nand3_1
X_05818_ _05964_/B2 _05901_/A2 _05928_/B _05820_/A2 vdd vdd vss vss
+ gf180mcu_fd_sc_mcu7t5v0__oai21_1
X_09586_ _09586_/D clk _09586_/Q vdd vdd vss vss gf180mcu_fd_sc_mcu7t5v0__dffq_1
XTAP_1106 vdd vss gf180mcu_fd_sc_mcu7t5v0__filltie
XTAP_1117 vdd vss gf180mcu_fd_sc_mcu7t5v0__filltie
XTAP_1128 vdd vss gf180mcu_fd_sc_mcu7t5v0__filltie
X_06798_ _06798_/A1 _06797_/Z _06853_/A1 vdd vdd vss vss gf180mcu_fd_sc_mcu7t5v0__nor2_1
X_05749_ _05839_/A1 _05839_/A2 _05839_/B _09710_/Q _05793_/A1 vdd vdd
+ vss vss gf180mcu_fd_sc_mcu7t5v0__oai211_2
X_08537_ _08498_/Z _08535_/Z _08570_/A2 vdd vdd vss vss gf180mcu_fd_sc_mcu7t5v0__nand2_1
XTAP_1139 vdd vss gf180mcu_fd_sc_mcu7t5v0__filltie
X_08468_ _08678_/A2 _08468_/A2 _08468_/Z vdd vdd vss vss gf180mcu_fd_sc_mcu7t5v0__xor2_1
X_07419_ _09711_/Q _07575_/A2 _07575_/A3 _07433_/A1 vdd vdd vss vss
+ gf180mcu_fd_sc_mcu7t5v0__nand3_1
X_08399_ _08731_/A1 _09719_/Q _08727_/A1 _08476_/A1 vdd vdd vss vss
+ gf180mcu_fd_sc_mcu7t5v0__nand3_1
XTAP_1651 vdd vss gf180mcu_fd_sc_mcu7t5v0__filltie
XTAP_1640 vdd vss gf180mcu_fd_sc_mcu7t5v0__filltie
XTAP_1684 vdd vss gf180mcu_fd_sc_mcu7t5v0__filltie
XTAP_1673 vdd vss gf180mcu_fd_sc_mcu7t5v0__filltie
XTAP_1662 vdd vss gf180mcu_fd_sc_mcu7t5v0__filltie
XTAP_1695 vdd vss gf180mcu_fd_sc_mcu7t5v0__filltie
X_04982_ _09839_/Q _08988_/B2 vdd vdd vss vss gf180mcu_fd_sc_mcu7t5v0__clkinv_1
X_07770_ _09712_/Q _08012_/A2 _07771_/B vdd vdd vss vss gf180mcu_fd_sc_mcu7t5v0__nand2_1
X_06721_ _06760_/A1 _06760_/A2 _06721_/Z vdd vdd vss vss gf180mcu_fd_sc_mcu7t5v0__xor2_1
X_09440_ _09440_/D clk _09440_/Q vdd vdd vss vss gf180mcu_fd_sc_mcu7t5v0__dffq_1
X_06652_ _09409_/A1 _06652_/A2 _06652_/B1 _06652_/B2 _09612_/D vdd vdd
+ vss vss gf180mcu_fd_sc_mcu7t5v0__oai22_1
X_06583_ _06583_/A1 _06583_/A2 _06626_/B vdd vdd vss vss gf180mcu_fd_sc_mcu7t5v0__nand2_1
X_05603_ _09012_/A1 _05603_/A2 _05603_/B1 _09105_/A2 _05603_/C1 _05632_/C2 _05604_/A3
+ vdd vdd vss vss gf180mcu_fd_sc_mcu7t5v0__aoi222_2
X_09371_ _09393_/A1 _09377_/A2 _09371_/B _09399_/C _10005_/D vdd vdd vss
+ vss gf180mcu_fd_sc_mcu7t5v0__aoi211_1
X_05534_ _09855_/Q _05627_/A2 _05627_/B1 _09588_/Q _05536_/A1 vdd vdd
+ vss vss gf180mcu_fd_sc_mcu7t5v0__aoi22_1
X_08322_ _08107_/B _08322_/A2 _08322_/A3 _08322_/A4 _08323_/B vdd vdd
+ vss vss gf180mcu_fd_sc_mcu7t5v0__nand4_1
X_08253_ _09686_/Q _08252_/Z _08272_/A2 vdd vdd vss vss gf180mcu_fd_sc_mcu7t5v0__nor2_1
X_05465_ _09420_/Q _05628_/A2 _05628_/B1 _09607_/Q _05466_/A2 vdd vdd
+ vss vss gf180mcu_fd_sc_mcu7t5v0__aoi22_1
X_07204_ _07255_/A1 _07204_/A2 _07204_/A3 _07204_/Z vdd vdd vss vss
+ gf180mcu_fd_sc_mcu7t5v0__xor3_1
X_05396_ _09406_/A1 _05399_/A2 _05399_/B1 _05396_/B2 _09546_/D vdd vdd
+ vss vss gf180mcu_fd_sc_mcu7t5v0__oai22_1
X_08184_ _09710_/Q _08284_/A2 _08190_/A3 vdd vdd vss vss gf180mcu_fd_sc_mcu7t5v0__nand2_1
X_07135_ _09714_/Q _06984_/B _07286_/I1 _07136_/A2 _07287_/C _07136_/B vdd vdd
+ vss vss gf180mcu_fd_sc_mcu7t5v0__aoi221_1
X_07066_ _09710_/Q _07065_/Z _07110_/A1 vdd vdd vss vss gf180mcu_fd_sc_mcu7t5v0__nand2_1
X_06017_ _09579_/Q _06293_/A2 _06146_/B vdd vdd vss vss gf180mcu_fd_sc_mcu7t5v0__nand2_2
X_07968_ _07721_/B _07966_/Z _08009_/A2 _07973_/A3 vdd vdd vss vss
+ gf180mcu_fd_sc_mcu7t5v0__nand3_1
X_09707_ _09707_/D clk _09707_/Q vdd vdd vss vss gf180mcu_fd_sc_mcu7t5v0__dffq_1
X_06919_ _06957_/A1 _06919_/A2 _06919_/B _06920_/B vdd vdd vss vss
+ gf180mcu_fd_sc_mcu7t5v0__oai21_1
X_07899_ _07900_/A1 _07898_/Z _07957_/A1 vdd vdd vss vss gf180mcu_fd_sc_mcu7t5v0__nor2_1
X_09638_ _09638_/D clk _09638_/Q vdd vdd vss vss gf180mcu_fd_sc_mcu7t5v0__dffq_4
X_09569_ _09569_/D clk _09569_/Q vdd vdd vss vss gf180mcu_fd_sc_mcu7t5v0__dffq_4
XTAP_709 vdd vss gf180mcu_fd_sc_mcu7t5v0__filltie
XTAP_1470 vdd vss gf180mcu_fd_sc_mcu7t5v0__filltie
XTAP_1481 vdd vss gf180mcu_fd_sc_mcu7t5v0__filltie
XTAP_1492 vdd vss gf180mcu_fd_sc_mcu7t5v0__filltie
X_05250_ _05276_/A1 _05250_/A2 _05218_/I _08972_/A1 vdd vdd vss vss
+ gf180mcu_fd_sc_mcu7t5v0__nor3_4
X_05181_ _09257_/B _09460_/Q _05200_/A3 vdd vdd vss vss gf180mcu_fd_sc_mcu7t5v0__nand2_1
X_08940_ _09816_/Q _08938_/Z _08942_/A2 vdd vdd vss vss gf180mcu_fd_sc_mcu7t5v0__nor2_1
X_08871_ _09393_/A1 _09523_/Q _08872_/B vdd vdd vss vss gf180mcu_fd_sc_mcu7t5v0__nor2_1
X_07822_ _07780_/I _07871_/A2 _07822_/Z vdd vdd vss vss gf180mcu_fd_sc_mcu7t5v0__xor2_1
X_04965_ _09485_/Q _05325_/B2 vdd vdd vss vss gf180mcu_fd_sc_mcu7t5v0__clkinv_1
X_07753_ _07753_/A1 _07781_/A3 _07753_/A3 _07753_/Z vdd vdd vss vss
+ gf180mcu_fd_sc_mcu7t5v0__xor3_1
X_04896_ _09535_/Q _05383_/B2 vdd vdd vss vss gf180mcu_fd_sc_mcu7t5v0__clkinv_1
X_07684_ _09678_/Q _08020_/A1 _07692_/A2 vdd vdd vss vss gf180mcu_fd_sc_mcu7t5v0__nand2_2
X_06704_ _06704_/A1 _06704_/A2 _06704_/B _06710_/A1 vdd vdd vss vss
+ gf180mcu_fd_sc_mcu7t5v0__oai21_1
X_09423_ _09423_/D clk _09423_/Q vdd vdd vss vss gf180mcu_fd_sc_mcu7t5v0__dffq_1
X_06635_ _10005_/Q _09073_/A2 _08734_/B _06636_/B vdd vdd vss vss
+ gf180mcu_fd_sc_mcu7t5v0__oai21_1
X_09354_ _09998_/Q _09355_/A2 _09355_/B vdd vdd vss vss gf180mcu_fd_sc_mcu7t5v0__nor2_1
X_06566_ _06566_/A1 _06566_/A2 _06566_/Z vdd vdd vss vss gf180mcu_fd_sc_mcu7t5v0__xor2_1
X_08305_ _08306_/A1 _08251_/Z _08306_/B _08305_/Z vdd vdd vss vss
+ gf180mcu_fd_sc_mcu7t5v0__or3_1
X_06497_ _09597_/Q _08565_/C _06543_/A1 vdd vdd vss vss gf180mcu_fd_sc_mcu7t5v0__nand2_1
X_05517_ _05517_/A1 _05517_/A2 _05517_/A3 _05518_/A2 vdd vdd vss vss
+ gf180mcu_fd_sc_mcu7t5v0__nand3_1
X_09285_ _09968_/Q _09286_/A2 _09286_/B vdd vdd vss vss gf180mcu_fd_sc_mcu7t5v0__nor2_1
X_08236_ _08237_/A1 _08341_/A1 _08236_/Z vdd vdd vss vss gf180mcu_fd_sc_mcu7t5v0__and2_1
X_05448_ _09661_/Q _05628_/A2 _05628_/B1 _09724_/Q _05449_/A2 vdd vdd
+ vss vss gf180mcu_fd_sc_mcu7t5v0__aoi22_1
X_08167_ _08351_/A1 _08149_/Z _08167_/B _08167_/C _08168_/A2 vdd vdd vss
+ vss gf180mcu_fd_sc_mcu7t5v0__aoi211_1
X_05379_ _09409_/A1 _05379_/A2 _05379_/B1 _05379_/B2 _09533_/D vdd vdd
+ vss vss gf180mcu_fd_sc_mcu7t5v0__oai22_1
X_07118_ _07118_/A1 _07117_/Z _07143_/A1 vdd vdd vss vss gf180mcu_fd_sc_mcu7t5v0__nor2_1
X_08098_ _08172_/A1 _08091_/Z _08099_/A3 _08172_/A2 vdd vdd vss vss
+ gf180mcu_fd_sc_mcu7t5v0__nor3_2
X_07049_ _08715_/A1 _07044_/Z _07046_/Z _07049_/Z vdd vdd vss vss
+ gf180mcu_fd_sc_mcu7t5v0__xor3_1
XTAP_506 vdd vss gf180mcu_fd_sc_mcu7t5v0__filltie
XTAP_539 vdd vss gf180mcu_fd_sc_mcu7t5v0__filltie
XTAP_517 vdd vss gf180mcu_fd_sc_mcu7t5v0__filltie
XTAP_528 vdd vss gf180mcu_fd_sc_mcu7t5v0__filltie
X_04750_ _09743_/Q _08761_/A1 vdd vdd vss vss gf180mcu_fd_sc_mcu7t5v0__clkinv_1
X_06420_ _09710_/Q _06601_/A2 _06421_/I vdd vdd vss vss gf180mcu_fd_sc_mcu7t5v0__nand2_1
X_06351_ _09592_/Q _06329_/Z _06351_/Z vdd vdd vss vss gf180mcu_fd_sc_mcu7t5v0__and2_1
X_05302_ _09405_/A1 _05306_/A2 _05306_/B1 _05302_/B2 _09453_/D vdd vdd
+ vss vss gf180mcu_fd_sc_mcu7t5v0__oai22_1
X_06282_ _09073_/A1 _06282_/A2 _06282_/B1 _06282_/B2 _06299_/A2 vdd vdd
+ vss vss gf180mcu_fd_sc_mcu7t5v0__aoi22_4
X_09070_ _09556_/Q _09104_/A2 _09072_/B _09071_/B vdd vdd vss vss
+ gf180mcu_fd_sc_mcu7t5v0__oai21_1
X_08021_ _09986_/Q _09104_/A2 _09089_/B _08022_/B vdd vdd vss vss
+ gf180mcu_fd_sc_mcu7t5v0__oai21_1
X_05233_ _09561_/Q _05217_/S _05233_/B _09405_/A1 vdd vdd vss vss
+ gf180mcu_fd_sc_mcu7t5v0__aoi21_4
X_05164_ _09733_/Q _05161_/Z _05165_/B vdd vdd vss vss gf180mcu_fd_sc_mcu7t5v0__nand2_1
X_05095_ _09730_/Q _08745_/B2 vdd vdd vss vss gf180mcu_fd_sc_mcu7t5v0__clkinv_1
X_09972_ _09972_/D clk _09972_/Q vdd vdd vss vss gf180mcu_fd_sc_mcu7t5v0__dffq_1
X_08923_ _09407_/A1 _08925_/A2 _08925_/B1 _08923_/B2 _09808_/D vdd vdd
+ vss vss gf180mcu_fd_sc_mcu7t5v0__oai22_1
X_08854_ _09785_/Q _09523_/Q _09525_/Q _09399_/C _08855_/A2 vdd vdd vss
+ vss gf180mcu_fd_sc_mcu7t5v0__aoi211_1
X_05997_ _09581_/Q _05997_/A2 _06297_/I0 vdd vdd vss vss gf180mcu_fd_sc_mcu7t5v0__nor2_2
X_07805_ _09713_/Q _07804_/Z _07805_/Z vdd vdd vss vss gf180mcu_fd_sc_mcu7t5v0__and2_1
X_08785_ _09747_/Q _08851_/A1 _09226_/B _08786_/B vdd vdd vss vss
+ gf180mcu_fd_sc_mcu7t5v0__oai21_1
X_04948_ _09806_/Q _08921_/B2 vdd vdd vss vss gf180mcu_fd_sc_mcu7t5v0__clkinv_1
X_07736_ _07771_/C _07736_/A2 _07735_/Z _07737_/A2 vdd vdd vss vss
+ gf180mcu_fd_sc_mcu7t5v0__nor3_1
X_04879_ _09900_/Q _09107_/B2 vdd vdd vss vss gf180mcu_fd_sc_mcu7t5v0__clkinv_1
X_07667_ _08972_/A1 _08736_/A2 _07676_/A2 vdd vdd vss vss gf180mcu_fd_sc_mcu7t5v0__nand2_4
X_06618_ _06618_/I0 _06617_/B _06618_/S _06618_/Z vdd vdd vss vss
+ gf180mcu_fd_sc_mcu7t5v0__mux2_1
X_09406_ _09406_/A1 _09409_/A2 _09409_/B1 _09406_/B2 _10023_/D vdd vdd
+ vss vss gf180mcu_fd_sc_mcu7t5v0__oai22_1
X_07598_ _08633_/A1 _07598_/A2 _07596_/B _07598_/Z vdd vdd vss vss
+ gf180mcu_fd_sc_mcu7t5v0__xor3_1
X_06549_ _09710_/Q _06626_/A2 _06552_/A1 vdd vdd vss vss gf180mcu_fd_sc_mcu7t5v0__nand2_1
X_09337_ _09990_/Q _09344_/A2 _09338_/B vdd vdd vss vss gf180mcu_fd_sc_mcu7t5v0__nor2_1
X_09268_ _09393_/A1 _09274_/A2 _09268_/B _09399_/C _09960_/D vdd vdd vss
+ vss gf180mcu_fd_sc_mcu7t5v0__aoi211_1
X_08219_ _08167_/C _08204_/Z _08219_/B _08220_/B vdd vdd vss vss gf180mcu_fd_sc_mcu7t5v0__aoi21_1
X_09199_ _09555_/Q _09209_/A2 _09199_/B1 _09209_/B2 _09256_/A2 vdd vdd
+ vss vss gf180mcu_fd_sc_mcu7t5v0__aoi22_4
XTAP_314 vdd vss gf180mcu_fd_sc_mcu7t5v0__filltie
XTAP_303 vdd vss gf180mcu_fd_sc_mcu7t5v0__filltie
XTAP_347 vdd vss gf180mcu_fd_sc_mcu7t5v0__filltie
XTAP_336 vdd vss gf180mcu_fd_sc_mcu7t5v0__filltie
XTAP_325 vdd vss gf180mcu_fd_sc_mcu7t5v0__filltie
XTAP_358 vdd vss gf180mcu_fd_sc_mcu7t5v0__filltie
XTAP_369 vdd vss gf180mcu_fd_sc_mcu7t5v0__filltie
X_05920_ _05698_/C _05919_/Z _05934_/B vdd vdd vss vss gf180mcu_fd_sc_mcu7t5v0__nand2_1
X_05851_ _05851_/A1 _05849_/Z _05851_/Z vdd vdd vss vss gf180mcu_fd_sc_mcu7t5v0__xor2_1
X_08570_ _08570_/A1 _08570_/A2 _08570_/B _08589_/A1 vdd vdd vss vss
+ gf180mcu_fd_sc_mcu7t5v0__aoi21_1
X_04802_ _09635_/Q _07296_/A1 vdd vdd vss vss gf180mcu_fd_sc_mcu7t5v0__clkinv_2
X_05782_ _09714_/Q _05689_/B _05833_/A1 vdd vdd vss vss gf180mcu_fd_sc_mcu7t5v0__nand2_1
X_07521_ _07521_/A1 _07521_/A2 _07521_/B _07524_/A3 vdd vdd vss vss
+ gf180mcu_fd_sc_mcu7t5v0__oai21_1
X_04733_ _09782_/Q _08859_/C vdd vdd vss vss gf180mcu_fd_sc_mcu7t5v0__inv_1
X_07452_ _07452_/A1 _07452_/A2 _07452_/B _07452_/C _07577_/B vdd vdd vss
+ vss gf180mcu_fd_sc_mcu7t5v0__aoi211_4
X_06403_ _06603_/A2 _06405_/A3 _06403_/Z vdd vdd vss vss gf180mcu_fd_sc_mcu7t5v0__xor2_1
X_07383_ _09658_/Q _09628_/Q _07384_/B vdd vdd vss vss gf180mcu_fd_sc_mcu7t5v0__nand2_1
X_06334_ _09602_/Q _06348_/A2 _06628_/A1 vdd vdd vss vss gf180mcu_fd_sc_mcu7t5v0__nor2_1
X_09122_ _09909_/Q _09136_/A2 _09124_/A1 vdd vdd vss vss gf180mcu_fd_sc_mcu7t5v0__nand2_1
X_06265_ _06265_/A1 _06248_/Z _06265_/B _06288_/A2 vdd vdd vss vss
+ gf180mcu_fd_sc_mcu7t5v0__aoi21_1
X_09053_ _09881_/Q _09103_/A2 _09054_/A2 vdd vdd vss vss gf180mcu_fd_sc_mcu7t5v0__nand2_1
X_06196_ _06178_/Z _06251_/B _06198_/A2 vdd vdd vss vss gf180mcu_fd_sc_mcu7t5v0__xnor2_1
X_08004_ _08012_/B2 _08011_/A2 _08011_/B1 vdd vdd vss vss gf180mcu_fd_sc_mcu7t5v0__nand2_1
X_05216_ _05216_/I _05250_/A2 vdd vdd vss vss gf180mcu_fd_sc_mcu7t5v0__inv_3
X_05147_ _09771_/Q _09770_/Q _09773_/Q _09772_/Q _05148_/A2 vdd vdd vss
+ vss gf180mcu_fd_sc_mcu7t5v0__nor4_1
X_05078_ _09842_/Q _08991_/B2 vdd vdd vss vss gf180mcu_fd_sc_mcu7t5v0__clkinv_1
X_09955_ _09955_/D clk _09955_/Q vdd vdd vss vss gf180mcu_fd_sc_mcu7t5v0__dffq_1
XTAP_870 vdd vss gf180mcu_fd_sc_mcu7t5v0__filltie
X_08906_ _09402_/A1 _08913_/A2 _08913_/B1 _08906_/B2 _09794_/D vdd vdd
+ vss vss gf180mcu_fd_sc_mcu7t5v0__oai22_1
X_09886_ _09886_/D clk _09886_/Q vdd vdd vss vss gf180mcu_fd_sc_mcu7t5v0__dffq_1
XTAP_881 vdd vss gf180mcu_fd_sc_mcu7t5v0__filltie
XTAP_892 vdd vss gf180mcu_fd_sc_mcu7t5v0__filltie
X_08837_ _08835_/Z _08837_/A2 _09773_/D vdd vdd vss vss gf180mcu_fd_sc_mcu7t5v0__nor2_1
X_08768_ _08768_/A1 _08782_/A2 _08768_/B _09746_/D vdd vdd vss vss
+ gf180mcu_fd_sc_mcu7t5v0__aoi21_1
X_07719_ _09711_/Q _07717_/Z _07719_/Z vdd vdd vss vss gf180mcu_fd_sc_mcu7t5v0__xor2_1
X_08699_ _09717_/Q _08699_/A2 _08699_/A3 _08701_/B vdd vdd vss vss
+ gf180mcu_fd_sc_mcu7t5v0__nand3_1
X_10026_ _10026_/D clk _10026_/Q vdd vdd vss vss gf180mcu_fd_sc_mcu7t5v0__dffq_1
XPHY_180 vdd vss gf180mcu_fd_sc_mcu7t5v0__endcap
XPHY_191 vdd vss gf180mcu_fd_sc_mcu7t5v0__endcap
X_06050_ _06050_/I _06101_/A3 vdd vdd vss vss gf180mcu_fd_sc_mcu7t5v0__clkinv_1
X_05001_ _09664_/Q _07673_/B2 vdd vdd vss vss gf180mcu_fd_sc_mcu7t5v0__clkinv_1
X_06952_ _06910_/B _06890_/Z _06953_/A2 vdd vdd vss vss gf180mcu_fd_sc_mcu7t5v0__nand2_1
X_09740_ _09740_/D clk _09740_/Q vdd vdd vss vss gf180mcu_fd_sc_mcu7t5v0__dffq_1
.ends
